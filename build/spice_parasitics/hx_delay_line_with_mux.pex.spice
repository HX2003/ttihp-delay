* NGSPICE file created from hx_delay_line_with_mux.ext - technology: ihp-sg13g2

.subckt hx_delay_line_with_mux VSS VDD DELAY_OUT_LAST DELAY_IN MUX_SEL0 MUX_SEL1 MUX_OUT
+ MUX_SEL4 MUX_SEL2 MUX_SEL3 DELAY_VBIASN DELAY_VBIASP
X0 VDD a_4003_1842# a_4437_1842# VDD sg13_lv_pmos ad=0.2128p pd=1.5u as=0.3808p ps=2.92u w=1.12u l=0.13u
X1 VSS.t379 a_15077_1842# a_15545_1044# VSS.t378 sg13_lv_nmos ad=0.1665p pd=1.19u as=0.2516p ps=2.16u w=0.74u l=0.13u
X2 a_27915_1044# a_27705_1044# VDD VDD sg13_lv_pmos ad=0.2128p pd=1.5u as=0.252p ps=1.57u w=1.12u l=0.13u
X3 VSS.t282 VDD VSS.t280 VSS.t281 sg13_lv_nmos ad=79.8f pd=0.8u as=0 ps=0 w=0.42u l=1u
X4 a_10951_2470# a_10713_1842# a_10843_1842# VDD sg13_lv_pmos ad=0.2128p pd=1.5u as=0.3808p ps=2.92u w=1.12u l=0.2u
X5 VSS.t139 a_3171_1047.t7 a_11924_1008# VSS.t138 sg13_lv_nmos ad=0.2516p pd=2.16u as=0.2516p ps=2.16u w=0.74u l=0.13u
X6 VDD VSS.t572 VDD VDD sg13_lv_pmos ad=0.34p pd=2.68u as=0.30484n ps=1.54979m w=1u l=1u
X7 VSS.t157 a_1256_1044# a_2967_1395# VSS.t156 sg13_lv_nmos ad=0.1331p pd=1.12u as=0.1216p ps=1.02u w=0.64u l=0.13u
X8 VSS.t285 VDD VSS.t284 VSS.t283 sg13_lv_nmos ad=0.1428p pd=1.52u as=0 ps=0 w=0.42u l=1u
X9 a_25153_1842# a_24957_1842# VSS.t172 VSS.t193 sg13_lv_nmos ad=0.2516p pd=2.16u as=0.1406p ps=1.12u w=0.74u l=0.13u
X10 VDD VSS.t586 VDD VDD sg13_lv_pmos ad=0.34p pd=2.68u as=0 ps=0 w=1u l=1u
X11 a_25630_1044# a_2019_1047.t2 a_25528_1044# VSS.t217 sg13_lv_nmos ad=0.2516p pd=2.16u as=0.1406p ps=1.12u w=0.74u l=0.13u
X12 VDD DELAY_VBIASP.t11 a_19311_2470# VDD sg13_lv_pmos ad=0.3808p pd=2.92u as=0.2128p ps=1.5u w=1.12u l=0.6u
X13 a_16108_289# a_2019_311# a_16510_1044# VSS.t390 sg13_lv_nmos ad=0.2516p pd=2.16u as=0.2516p ps=2.16u w=0.74u l=0.13u
X14 VDD DELAY_VBIASP.t24 a_9431_2470# VDD sg13_lv_pmos ad=0.3808p pd=2.92u as=0.2128p ps=1.5u w=1.12u l=0.6u
X15 VSS.t350 VDD VSS.t349 VSS.t348 sg13_lv_nmos ad=0.1428p pd=1.52u as=0 ps=0 w=0.42u l=1u
X16 VDD DELAY_VBIASP.t6 a_23111_2470# VDD sg13_lv_pmos ad=0.3808p pd=2.92u as=0.2128p ps=1.5u w=1.12u l=0.6u
X17 a_7390_1044# a_8231_1008# a_8155_1044# VDD sg13_lv_pmos ad=0.3808p pd=2.92u as=0.2128p ps=1.5u w=1.12u l=0.13u
X18 VSS.t244 a_2595_311.t3 a_8745_519# VSS.t243 sg13_lv_nmos ad=0.2516p pd=2.16u as=0.2516p ps=2.16u w=0.74u l=0.13u
X19 a_17791_1842# a_17553_1842# a_17683_1842# VSS.t558 sg13_lv_nmos ad=0.1406p pd=1.12u as=0.2516p ps=2.16u w=0.74u l=0.2u
X20 VDD a_12037_1842# a_12505_1044# VDD sg13_lv_pmos ad=0.252p pd=1.57u as=0.3808p ps=2.92u w=1.12u l=0.13u
X21 a_16510_1044# a_2019_1047.t5 a_16408_1044# VSS.t111 sg13_lv_nmos ad=0.2516p pd=2.16u as=0.1406p ps=1.12u w=0.74u l=0.13u
X22 a_21591_1842# a_21353_1842# a_21483_1842# VSS.t500 sg13_lv_nmos ad=0.1406p pd=1.12u as=0.2516p ps=2.16u w=0.74u l=0.2u
X23 a_6153_1842# a_5957_1842# VSS.t190 VSS.t394 sg13_lv_nmos ad=0.2516p pd=2.16u as=0.1406p ps=1.12u w=0.74u l=0.13u
X24 VSS.t516 a_16163_1842# a_16597_1842# VSS.t515 sg13_lv_nmos ad=0.1406p pd=1.12u as=0.2516p ps=2.16u w=0.74u l=0.13u
X25 VSS.t151 a_3171_1047.t2 a_27124_1008# VSS.t150 sg13_lv_nmos ad=0.2516p pd=2.16u as=0.2516p ps=2.16u w=0.74u l=0.13u
X26 VDD a_11603_1842# a_12037_1842# VDD sg13_lv_pmos ad=0.2128p pd=1.5u as=0.3808p ps=2.92u w=1.12u l=0.13u
X27 VDD a_3171_311.t3 a_11785_519# VDD sg13_lv_pmos ad=0.3808p pd=2.92u as=0.3808p ps=2.92u w=1.12u l=0.13u
X28 a_24393_1842# a_24197_1842# VDD VDD sg13_lv_pmos ad=0.3808p pd=2.92u as=0.2128p ps=1.5u w=1.12u l=0.13u
X29 a_5731_289# a_2595_311.t3 a_7390_1044# VSS.t242 sg13_lv_nmos ad=0.2516p pd=2.16u as=0.2516p ps=2.16u w=0.74u l=0.13u
X30 a_10430_1044# a_2595_1047.t7 a_11195_1044# VSS.t254 sg13_lv_nmos ad=0.2516p pd=2.16u as=0.1406p ps=1.12u w=0.74u l=0.13u
X31 a_23355_1044# a_23145_1044# VSS.t226 VSS.t225 sg13_lv_nmos ad=0.1406p pd=1.12u as=0.1665p ps=1.19u w=0.74u l=0.13u
X32 VDD DELAY_VBIASP.t17 a_14751_2470# VDD sg13_lv_pmos ad=0.3808p pd=2.92u as=0.2128p ps=1.5u w=1.12u l=0.6u
X33 VSS.t430 DELAY_VBIASN.t23 a_10191_1842# VSS.t429 sg13_lv_nmos ad=0.2516p pd=2.16u as=0.1406p ps=1.12u w=0.74u l=0.6u
X34 VSS.t154 a_3747_1047.t4 a_21911_1008# VSS.t153 sg13_lv_nmos ad=0.2516p pd=2.16u as=0.2516p ps=2.16u w=0.74u l=0.13u
X35 VSS.t61 a_19963_1842# a_20397_1842# VSS.t60 sg13_lv_nmos ad=0.1406p pd=1.12u as=0.2516p ps=2.16u w=0.74u l=0.13u
X36 VDD DELAY_VBIASP.t31 a_4111_2470# VDD sg13_lv_pmos ad=0.3808p pd=2.92u as=0.2128p ps=1.5u w=1.12u l=0.6u
X37 a_10328_1044# a_9757_1842# VDD VDD sg13_lv_pmos ad=0.2128p pd=1.5u as=0.3808p ps=2.92u w=1.12u l=0.13u
X38 a_20968_1044# a_20397_1842# VSS.t89 VSS.t88 sg13_lv_nmos ad=0.1406p pd=1.12u as=0.2516p ps=2.16u w=0.74u l=0.13u
X39 a_22590_1044# a_22564_1008# a_22488_1044# VDD sg13_lv_pmos ad=0.3808p pd=2.92u as=0.2128p ps=1.5u w=1.12u l=0.13u
X40 VDD VSS.t589 VDD VDD sg13_lv_pmos ad=0.19p pd=1.38u as=0 ps=0 w=1u l=1u
X41 a_8808_1044# a_8237_1842# VDD VDD sg13_lv_pmos ad=0.2128p pd=1.5u as=0.3808p ps=2.92u w=1.12u l=0.13u
X42 a_4157_1313# DELAY_IN VDD VDD sg13_lv_pmos ad=0.3808p pd=2.92u as=0.3808p ps=2.92u w=1.12u l=0.13u
X43 a_17031_2470# a_16793_1842# a_16923_1842# VDD sg13_lv_pmos ad=0.2128p pd=1.5u as=0.3808p ps=2.92u w=1.12u l=0.2u
X44 a_11473_1842# a_11277_1842# VSS.t490 VSS.t489 sg13_lv_nmos ad=0.2516p pd=2.16u as=0.1406p ps=1.12u w=0.74u l=0.13u
X45 VSS.t342 VDD VSS.t340 VSS.t341 sg13_lv_nmos ad=79.8f pd=0.8u as=0 ps=0 w=0.42u l=1u
X46 a_19448_1044# a_18877_1842# VSS.t209 VSS.t208 sg13_lv_nmos ad=0.1406p pd=1.12u as=0.2516p ps=2.16u w=0.74u l=0.13u
X47 a_10430_1044# a_3171_1047.t7 a_11848_1044# VSS.t137 sg13_lv_nmos ad=0.2516p pd=2.16u as=0.1406p ps=1.12u w=0.74u l=0.13u
X48 a_20831_2470# a_20593_1842# a_20723_1842# VDD sg13_lv_pmos ad=0.2128p pd=1.5u as=0.3808p ps=2.92u w=1.12u l=0.2u
X49 VSS.t307 VDD VSS.t305 VSS.t306 sg13_lv_nmos ad=79.8f pd=0.8u as=0 ps=0 w=0.42u l=1u
X50 VDD a_27237_1842# a_27705_1044# VDD sg13_lv_pmos ad=0.252p pd=1.57u as=0.3808p ps=2.92u w=1.12u l=0.13u
X51 a_5393_1842# a_5197_1842# VDD VDD sg13_lv_pmos ad=0.3808p pd=2.92u as=0.2128p ps=1.5u w=1.12u l=0.13u
X52 VDD DELAY_VBIASP.t14 a_17031_2470# VDD sg13_lv_pmos ad=0.3808p pd=2.92u as=0.2128p ps=1.5u w=1.12u l=0.6u
X53 VDD a_26803_1842# a_27237_1842# VDD sg13_lv_pmos ad=0.2128p pd=1.5u as=0.3808p ps=2.92u w=1.12u l=0.13u
X54 VDD MUX_SEL1 a_3449_1395# VDD sg13_lv_pmos ad=0.1918p pd=1.5u as=0.1596p ps=1.22u w=0.84u l=0.13u
X55 a_25630_1044# a_2595_1047.t2 a_26395_1044# VSS.t24 sg13_lv_nmos ad=0.2516p pd=2.16u as=0.1406p ps=1.12u w=0.74u l=0.13u
X56 VSS.t474 DELAY_VBIASN.t3 a_25391_1842# VSS.t473 sg13_lv_nmos ad=0.2516p pd=2.16u as=0.1406p ps=1.12u w=0.74u l=0.6u
X57 a_6635_1044# a_6425_1044# VDD VDD sg13_lv_pmos ad=0.2128p pd=1.5u as=0.252p ps=1.57u w=1.12u l=0.13u
X58 a_20315_1044# a_20105_1044# VDD VDD sg13_lv_pmos ad=0.2128p pd=1.5u as=0.252p ps=1.57u w=1.12u l=0.13u
X59 VDD a_2595_1047.t9 a_5191_1008# VDD sg13_lv_pmos ad=0.3808p pd=2.92u as=0.3808p ps=2.92u w=1.12u l=0.13u
X60 a_19311_2470# a_19073_1842# a_19203_1842# VDD sg13_lv_pmos ad=0.2128p pd=1.5u as=0.3808p ps=2.92u w=1.12u l=0.2u
X61 VSS.t53 a_1721_1395# a_2019_1047.t1 VSS.t52 sg13_lv_nmos ad=0.2812p pd=2.24u as=0.1406p ps=1.12u w=0.74u l=0.13u
X62 a_25528_1044# a_24957_1842# VDD VDD sg13_lv_pmos ad=0.2128p pd=1.5u as=0.3808p ps=2.92u w=1.12u l=0.13u
X63 VSS.t159 a_5957_1842# a_6425_1044# VSS.t393 sg13_lv_nmos ad=0.1665p pd=1.19u as=0.2516p ps=2.16u w=0.74u l=0.13u
X64 VSS.t520 a_2019_1047.t6 a_13444_1008# VSS.t519 sg13_lv_nmos ad=0.2516p pd=2.16u as=0.2516p ps=2.16u w=0.74u l=0.13u
X65 a_23111_2470# a_22873_1842# a_23003_1842# VDD sg13_lv_pmos ad=0.2128p pd=1.5u as=0.3808p ps=2.92u w=1.12u l=0.2u
X66 VSS.t280 VDD VSS.t279 VSS.t278 sg13_lv_nmos ad=0.1428p pd=1.52u as=0 ps=0 w=0.42u l=1u
X67 VSS.t98 a_15964_289# a_16851_309# VSS.t101 sg13_lv_nmos ad=0.1371p pd=1.12u as=0.2176p ps=1.96u w=0.64u l=0.13u
X68 a_10713_1842# a_10517_1842# VDD VDD sg13_lv_pmos ad=0.3808p pd=2.92u as=0.2128p ps=1.5u w=1.12u l=0.13u
X69 VDD a_17683_1842# a_18117_1842# VDD sg13_lv_pmos ad=0.2128p pd=1.5u as=0.3808p ps=2.92u w=1.12u l=0.13u
X70 a_16108_289# a_17865_519# a_16510_1044# VDD sg13_lv_pmos ad=0.3808p pd=2.92u as=0.3808p ps=2.92u w=1.12u l=0.13u
X71 a_26673_1842# a_26477_1842# VSS.t504 VSS.t503 sg13_lv_nmos ad=0.2516p pd=2.16u as=0.1406p ps=1.12u w=0.74u l=0.13u
X72 VDD a_7803_1842# a_8237_1842# VDD sg13_lv_pmos ad=0.2128p pd=1.5u as=0.3808p ps=2.92u w=1.12u l=0.13u
X73 a_4248_1044# a_4157_1313# VSS.t509 VSS.t508 sg13_lv_nmos ad=0.1406p pd=1.12u as=0.2516p ps=2.16u w=0.74u l=0.13u
X74 a_16108_289# a_3171_311.t2 a_22590_1044# VSS.t33 sg13_lv_nmos ad=0.2516p pd=2.16u as=0.2516p ps=2.16u w=0.74u l=0.13u
X75 VSS.t420 DELAY_VBIASN.t28 a_6391_1842# VSS.t419 sg13_lv_nmos ad=0.2516p pd=2.16u as=0.1406p ps=1.12u w=0.74u l=0.6u
X76 a_16408_1044# a_15837_1842# VDD VDD sg13_lv_pmos ad=0.2128p pd=1.5u as=0.3808p ps=2.92u w=1.12u l=0.13u
X77 a_19550_1044# a_3747_1047.t4 a_21835_1044# VSS.t152 sg13_lv_nmos ad=0.2516p pd=2.16u as=0.1406p ps=1.12u w=0.74u l=0.13u
X78 VSS.t446 DELAY_VBIASN.t9 a_20831_1842# VSS.t445 sg13_lv_nmos ad=0.2516p pd=2.16u as=0.1406p ps=1.12u w=0.74u l=0.6u
X79 a_3171_311.t0 a_2873_331# VDD VDD sg13_lv_pmos ad=0.2128p pd=1.5u as=0.1918p ps=1.5u w=1.12u l=0.13u
X80 a_3747_311.t0 a_3449_331# VDD VDD sg13_lv_pmos ad=0.2128p pd=1.5u as=0.1918p ps=1.5u w=1.12u l=0.13u
X81 a_7390_1044# a_9751_1008# a_9675_1044# VDD sg13_lv_pmos ad=0.3808p pd=2.92u as=0.2128p ps=1.5u w=1.12u l=0.13u
X82 a_10191_1842# a_9953_1842# a_10083_1842# VSS.t399 sg13_lv_nmos ad=0.1406p pd=1.12u as=0.2516p ps=2.16u w=0.74u l=0.2u
X83 VSS.t226 a_22677_1842# a_23145_1044# VSS.t264 sg13_lv_nmos ad=0.1665p pd=1.19u as=0.2516p ps=2.16u w=0.74u l=0.13u
X84 a_14751_2470# a_14513_1842# a_14643_1842# VDD sg13_lv_pmos ad=0.2128p pd=1.5u as=0.3808p ps=2.92u w=1.12u l=0.2u
X85 a_5731_289# a_8745_519# a_7390_1044# VDD sg13_lv_pmos ad=0.3808p pd=2.92u as=0.3808p ps=2.92u w=1.12u l=0.13u
X86 VDD VDD VDD VDD sg13_lv_pmos ad=0.2128p pd=1.5u as=0 ps=0 w=1.12u l=0.13u
X87 a_4111_2470# DELAY_IN a_4003_1842# VDD sg13_lv_pmos ad=0.2128p pd=1.5u as=0.3808p ps=2.92u w=1.12u l=0.2u
X88 a_7673_1842# a_7477_1842# VSS.t385 VSS.t541 sg13_lv_nmos ad=0.2516p pd=2.16u as=0.1406p ps=1.12u w=0.74u l=0.13u
X89 VDD a_3171_1047.t5 a_18004_1008# VDD sg13_lv_pmos ad=0.3808p pd=2.92u as=0.3808p ps=2.92u w=1.12u l=0.13u
X90 VDD a_13123_1842# a_13557_1842# VDD sg13_lv_pmos ad=0.2128p pd=1.5u as=0.3808p ps=2.92u w=1.12u l=0.13u
X91 VDD a_3747_311.t2 a_26985_519# VDD sg13_lv_pmos ad=0.3808p pd=2.92u as=0.3808p ps=2.92u w=1.12u l=0.13u
X92 a_25913_1842# a_25717_1842# VDD VDD sg13_lv_pmos ad=0.3808p pd=2.92u as=0.2128p ps=1.5u w=1.12u l=0.13u
X93 a_10430_1044# a_3747_1047.t7 a_12715_1044# VSS.t126 sg13_lv_nmos ad=0.2516p pd=2.16u as=0.1406p ps=1.12u w=0.74u l=0.13u
X94 a_14235_1044# a_14025_1044# VDD VDD sg13_lv_pmos ad=0.2128p pd=1.5u as=0.252p ps=1.57u w=1.12u l=0.13u
X95 a_24875_1044# a_24665_1044# VSS.t174 VSS.t173 sg13_lv_nmos ad=0.1406p pd=1.12u as=0.1665p ps=1.19u w=0.74u l=0.13u
X96 VSS.t442 DELAY_VBIASN.t21 a_11711_1842# VSS.t441 sg13_lv_nmos ad=0.2516p pd=2.16u as=0.1406p ps=1.12u w=0.74u l=0.6u
X97 VDD a_3747_1047.t7 a_12791_1008# VDD sg13_lv_pmos ad=0.3808p pd=2.92u as=0.3808p ps=2.92u w=1.12u l=0.13u
X98 VSS.t32 a_2595_1047.t3 a_23431_1008# VSS.t31 sg13_lv_nmos ad=0.2516p pd=2.16u as=0.2516p ps=2.16u w=0.74u l=0.13u
X99 VSS.t262 a_21483_1842# a_21917_1842# VSS.t261 sg13_lv_nmos ad=0.1406p pd=1.12u as=0.2516p ps=2.16u w=0.74u l=0.13u
X100 VSS.t230 a_13557_1842# a_14025_1044# VSS.t257 sg13_lv_nmos ad=0.1665p pd=1.19u as=0.2516p ps=2.16u w=0.74u l=0.13u
X101 a_11848_1044# a_11277_1842# VDD VDD sg13_lv_pmos ad=0.2128p pd=1.5u as=0.3808p ps=2.92u w=1.12u l=0.13u
X102 VDD VSS.t565 VDD VDD sg13_lv_pmos ad=0.19p pd=1.38u as=0 ps=0 w=1u l=1u
X103 a_25391_1842# a_25153_1842# a_25283_1842# VSS.t8 sg13_lv_nmos ad=0.1406p pd=1.12u as=0.2516p ps=2.16u w=0.74u l=0.2u
X104 a_12993_1842# a_12797_1842# VSS.t405 VSS.t404 sg13_lv_nmos ad=0.2516p pd=2.16u as=0.1406p ps=1.12u w=0.74u l=0.13u
X105 DELAY_OUT_LAST a_27997_1842# VDD VDD sg13_lv_pmos ad=0.3808p pd=2.92u as=0.2128p ps=1.5u w=1.12u l=0.13u
X106 VDD VSS.t564 VDD VDD sg13_lv_pmos ad=0.34p pd=2.68u as=0 ps=0 w=1u l=1u
X107 VDD a_19637_1842# a_20105_1044# VDD sg13_lv_pmos ad=0.252p pd=1.57u as=0.3808p ps=2.92u w=1.12u l=0.13u
X108 VSS.t454 DELAY_VBIASN.t18 a_13991_1842# VSS.t453 sg13_lv_nmos ad=0.2516p pd=2.16u as=0.1406p ps=1.12u w=0.74u l=0.6u
X109 VSS.t340 VDD VSS.t339 VSS.t338 sg13_lv_nmos ad=0.1428p pd=1.52u as=0 ps=0 w=0.42u l=1u
X110 a_22590_1044# a_3171_1047.t3 a_24008_1044# VSS.t530 sg13_lv_nmos ad=0.2516p pd=2.16u as=0.1406p ps=1.12u w=0.74u l=0.13u
X111 a_6913_1842# a_6717_1842# VDD VDD sg13_lv_pmos ad=0.3808p pd=2.92u as=0.2128p ps=1.5u w=1.12u l=0.13u
X112 VDD DELAY_VBIASP.t12 a_18551_2470# VDD sg13_lv_pmos ad=0.3808p pd=2.92u as=0.2128p ps=1.5u w=1.12u l=0.6u
X113 VSS.t204 a_23763_1842# a_24197_1842# VSS.t203 sg13_lv_nmos ad=0.1406p pd=1.12u as=0.2516p ps=2.16u w=0.74u l=0.13u
X114 VSS.t305 VDD VSS.t304 VSS.t303 sg13_lv_nmos ad=0.1428p pd=1.52u as=0 ps=0 w=0.42u l=1u
X115 VDD a_1256_1044# a_2873_1395# VDD sg13_lv_pmos ad=0.1918p pd=1.5u as=0.1596p ps=1.22u w=0.84u l=0.13u
X116 a_3171_311.t1 a_2873_331# VSS.t119 VSS.t118 sg13_lv_nmos ad=0.1406p pd=1.12u as=0.1331p ps=1.12u w=0.74u l=0.13u
X117 VDD a_2873_331# a_3171_311.t0 VDD sg13_lv_pmos ad=0.4256p pd=3u as=0.2128p ps=1.5u w=1.12u l=0.13u
X118 a_16510_1044# a_17351_1008# a_17275_1044# VDD sg13_lv_pmos ad=0.3808p pd=2.92u as=0.2128p ps=1.5u w=1.12u l=0.13u
X119 a_25630_1044# a_3747_1047.t2 a_27915_1044# VSS.t123 sg13_lv_nmos ad=0.2516p pd=2.16u as=0.1406p ps=1.12u w=0.74u l=0.13u
X120 VSS.t478 DELAY_VBIASN.t1 a_26911_1842# VSS.t477 sg13_lv_nmos ad=0.2516p pd=2.16u as=0.1406p ps=1.12u w=0.74u l=0.6u
X121 a_3747_311.t1 a_3449_331# VSS.t115 VSS.t114 sg13_lv_nmos ad=0.1406p pd=1.12u as=0.1331p ps=1.12u w=0.74u l=0.13u
X122 VDD a_3449_331# a_3747_311.t0 VDD sg13_lv_pmos ad=0.4256p pd=3u as=0.2128p ps=1.5u w=1.12u l=0.13u
X123 VDD DELAY_VBIASP.t7 a_22351_2470# VDD sg13_lv_pmos ad=0.3808p pd=2.92u as=0.2128p ps=1.5u w=1.12u l=0.6u
X124 VDD a_3747_1047.t2 a_27991_1008# VDD sg13_lv_pmos ad=0.3808p pd=2.92u as=0.3808p ps=2.92u w=1.12u l=0.13u
X125 VDD VSS.t597 VDD VDD sg13_lv_pmos ad=0.19p pd=1.38u as=0 ps=0 w=1u l=1u
X126 VDD a_3747_1047.t9 a_6711_1008# VDD sg13_lv_pmos ad=0.3808p pd=2.92u as=0.3808p ps=2.92u w=1.12u l=0.13u
X127 a_6391_1842# a_6153_1842# a_6283_1842# VSS.t272 sg13_lv_nmos ad=0.1406p pd=1.12u as=0.2516p ps=2.16u w=0.74u l=0.2u
X128 a_15273_1842# a_15077_1842# VSS.t96 VSS.t377 sg13_lv_nmos ad=0.2516p pd=2.16u as=0.1406p ps=1.12u w=0.74u l=0.13u
X129 a_19833_1842# a_19637_1842# VDD VDD sg13_lv_pmos ad=0.3808p pd=2.92u as=0.2128p ps=1.5u w=1.12u l=0.13u
X130 a_16108_289# a_23945_519# a_22590_1044# VDD sg13_lv_pmos ad=0.3808p pd=2.92u as=0.3808p ps=2.92u w=1.12u l=0.13u
X131 a_9193_1842# a_8997_1842# VDD VDD sg13_lv_pmos ad=0.3808p pd=2.92u as=0.2128p ps=1.5u w=1.12u l=0.13u
X132 a_24631_2470# a_24393_1842# a_24523_1842# VDD sg13_lv_pmos ad=0.2128p pd=1.5u as=0.3808p ps=2.92u w=1.12u l=0.2u
X133 VSS.t514 a_15403_1842# a_15837_1842# VSS.t513 sg13_lv_nmos ad=0.1406p pd=1.12u as=0.2516p ps=2.16u w=0.74u l=0.13u
X134 a_8155_1044# a_7945_1044# VSS.t536 VSS.t535 sg13_lv_nmos ad=0.1406p pd=1.12u as=0.1665p ps=1.19u w=0.74u l=0.13u
X135 a_23633_1842# a_23437_1842# VDD VDD sg13_lv_pmos ad=0.3808p pd=2.92u as=0.2128p ps=1.5u w=1.12u l=0.13u
X136 VSS.t266 a_4763_1842# a_5197_1842# VSS.t409 sg13_lv_nmos ad=0.1406p pd=1.12u as=0.2516p ps=2.16u w=0.74u l=0.13u
X137 a_27048_1044# a_26477_1842# VSS.t502 VSS.t501 sg13_lv_nmos ad=0.1406p pd=1.12u as=0.2516p ps=2.16u w=0.74u l=0.13u
X138 VDD a_9323_1842# a_9757_1842# VDD sg13_lv_pmos ad=0.2128p pd=1.5u as=0.3808p ps=2.92u w=1.12u l=0.13u
X139 a_5768_1044# a_5197_1842# VSS.t268 VSS.t267 sg13_lv_nmos ad=0.1406p pd=1.12u as=0.2516p ps=2.16u w=0.74u l=0.13u
X140 a_7390_1044# a_7364_1008# a_7288_1044# VDD sg13_lv_pmos ad=0.3808p pd=2.92u as=0.2128p ps=1.5u w=1.12u l=0.13u
X141 VSS.t432 DELAY_VBIASN.t26 a_7911_1842# VSS.t431 sg13_lv_nmos ad=0.2516p pd=2.16u as=0.1406p ps=1.12u w=0.74u l=0.6u
X142 VDD VSS.t581 VDD VDD sg13_lv_pmos ad=0.19p pd=1.38u as=0 ps=0 w=1u l=1u
X143 a_11711_1842# a_11473_1842# a_11603_1842# VSS.t122 sg13_lv_nmos ad=0.1406p pd=1.12u as=0.2516p ps=2.16u w=0.74u l=0.2u
X144 VSS.t174 a_24197_1842# a_24665_1044# VSS.t493 sg13_lv_nmos ad=0.1665p pd=1.19u as=0.2516p ps=2.16u w=0.74u l=0.13u
X145 a_16510_1044# a_3171_1047.t5 a_17928_1044# VSS.t248 sg13_lv_nmos ad=0.2516p pd=2.16u as=0.1406p ps=1.12u w=0.74u l=0.13u
X146 VSS.t297 VDD VSS.t295 VSS.t296 sg13_lv_nmos ad=79.8f pd=0.8u as=0 ps=0 w=0.42u l=1u
X147 a_5631_2470# a_5393_1842# a_5523_1842# VDD sg13_lv_pmos ad=0.2128p pd=1.5u as=0.3808p ps=2.92u w=1.12u l=0.2u
X148 a_14513_1842# a_14317_1842# VDD VDD sg13_lv_pmos ad=0.3808p pd=2.92u as=0.2128p ps=1.5u w=1.12u l=0.13u
X149 a_4633_1842# a_4437_1842# VDD VDD sg13_lv_pmos ad=0.3808p pd=2.92u as=0.2128p ps=1.5u w=1.12u l=0.13u
X150 VSS.t10 a_10083_1842# a_10517_1842# VSS.t412 sg13_lv_nmos ad=0.1406p pd=1.12u as=0.2516p ps=2.16u w=0.74u l=0.13u
X151 VDD a_2019_1047.t4 a_19524_1008# VDD sg13_lv_pmos ad=0.3808p pd=2.92u as=0.3808p ps=2.92u w=1.12u l=0.13u
X152 VSS.t148 a_3171_1047.t4 a_21044_1008# VSS.t147 sg13_lv_nmos ad=0.2516p pd=2.16u as=0.2516p ps=2.16u w=0.74u l=0.13u
X153 VSS.t121 a_2873_331# a_3171_311.t1 VSS.t120 sg13_lv_nmos ad=0.2812p pd=2.24u as=0.1406p ps=1.12u w=0.74u l=0.13u
X154 VSS.t117 a_3449_331# a_3747_311.t1 VSS.t116 sg13_lv_nmos ad=0.2812p pd=2.24u as=0.1406p ps=1.12u w=0.74u l=0.13u
X155 a_15755_1044# a_15545_1044# VDD VDD sg13_lv_pmos ad=0.2128p pd=1.5u as=0.252p ps=1.57u w=1.12u l=0.13u
X156 VDD a_2595_1047.t6 a_14311_1008# VDD sg13_lv_pmos ad=0.3808p pd=2.92u as=0.3808p ps=2.92u w=1.12u l=0.13u
X157 VSS.t476 DELAY_VBIASN.t4 a_24631_1842# VSS.t475 sg13_lv_nmos ad=0.2516p pd=2.16u as=0.1406p ps=1.12u w=0.74u l=0.6u
X158 a_5115_1044# a_4905_1044# VDD VDD sg13_lv_pmos ad=0.2128p pd=1.5u as=0.252p ps=1.57u w=1.12u l=0.13u
X159 a_18551_2470# a_18313_1842# a_18443_1842# VDD sg13_lv_pmos ad=0.2128p pd=1.5u as=0.3808p ps=2.92u w=1.12u l=0.2u
X160 VDD VSS.t573 VDD VDD sg13_lv_pmos ad=0.19p pd=1.38u as=0 ps=0 w=1u l=1u
X161 a_3171_1047.t1 a_2873_1395# VSS.t157 VSS.t220 sg13_lv_nmos ad=0.1406p pd=1.12u as=0.1331p ps=1.12u w=0.74u l=0.13u
X162 VSS.t132 a_2297_1395# a_2595_1047.t1 VSS.t131 sg13_lv_nmos ad=0.2812p pd=2.24u as=0.1406p ps=1.12u w=0.74u l=0.13u
X163 a_22351_2470# a_22113_1842# a_22243_1842# VDD sg13_lv_pmos ad=0.2128p pd=1.5u as=0.3808p ps=2.92u w=1.12u l=0.2u
X164 VSS.t366 VSS.t363 VSS.t365 VSS.t364 sg13_lv_nmos ad=0.2516p pd=2.16u as=0 ps=0 w=0.74u l=0.13u
X165 a_26911_1842# a_26673_1842# a_26803_1842# VSS.t386 sg13_lv_nmos ad=0.1406p pd=1.12u as=0.2516p ps=2.16u w=0.74u l=0.2u
X166 VSS.t235 a_3171_311.t3 a_11785_519# VSS.t234 sg13_lv_nmos ad=0.2516p pd=2.16u as=0.2516p ps=2.16u w=0.74u l=0.13u
X167 VDD a_1721_1395# a_2019_1047.t0 VDD sg13_lv_pmos ad=0.4256p pd=3u as=0.2128p ps=1.5u w=1.12u l=0.13u
X168 VDD a_16923_1842# a_17357_1842# VDD sg13_lv_pmos ad=0.2128p pd=1.5u as=0.3808p ps=2.92u w=1.12u l=0.13u
X169 a_2391_1395# MUX_SEL0 a_2297_1395# VSS.t487 sg13_lv_nmos ad=0.1216p pd=1.02u as=0.2176p ps=1.96u w=0.64u l=0.13u
X170 VSS.t51 a_1544_1044# a_1815_1395# VSS.t227 sg13_lv_nmos ad=0.1331p pd=1.12u as=0.1216p ps=1.02u w=0.64u l=0.13u
X171 a_13368_1044# a_12797_1842# VSS.t407 VSS.t406 sg13_lv_nmos ad=0.1406p pd=1.12u as=0.2516p ps=2.16u w=0.74u l=0.13u
X172 a_5731_289# a_3171_311.t3 a_10430_1044# VSS.t233 sg13_lv_nmos ad=0.2516p pd=2.16u as=0.2516p ps=2.16u w=0.74u l=0.13u
X173 VDD a_21157_1842# a_21625_1044# VDD sg13_lv_pmos ad=0.252p pd=1.57u as=0.3808p ps=2.92u w=1.12u l=0.13u
X174 VDD DELAY_VBIASP.t22 a_10951_2470# VDD sg13_lv_pmos ad=0.3808p pd=2.92u as=0.2128p ps=1.5u w=1.12u l=0.6u
X175 VSS.t456 DELAY_VBIASN.t16 a_15511_1842# VSS.t455 sg13_lv_nmos ad=0.2516p pd=2.16u as=0.1406p ps=1.12u w=0.74u l=0.6u
X176 VDD a_20723_1842# a_21157_1842# VDD sg13_lv_pmos ad=0.2128p pd=1.5u as=0.3808p ps=2.92u w=1.12u l=0.13u
X177 VSS.t82 a_25283_1842# a_25717_1842# VSS.t207 sg13_lv_nmos ad=0.1406p pd=1.12u as=0.2516p ps=2.16u w=0.74u l=0.13u
X178 a_4350_1044# a_3747_1047.t9 a_6635_1044# VSS.t21 sg13_lv_nmos ad=0.2516p pd=2.16u as=0.1406p ps=1.12u w=0.74u l=0.13u
X179 VSS.t434 DELAY_VBIASN.t29 a_5631_1842# VSS.t433 sg13_lv_nmos ad=0.2516p pd=2.16u as=0.1406p ps=1.12u w=0.74u l=0.6u
X180 VDD a_2019_1047.t9 a_4324_1008# VDD sg13_lv_pmos ad=0.3808p pd=2.92u as=0.3808p ps=2.92u w=1.12u l=0.13u
X181 a_16510_1044# a_18871_1008# a_18795_1044# VDD sg13_lv_pmos ad=0.3808p pd=2.92u as=0.2128p ps=1.5u w=1.12u l=0.13u
X182 a_19550_1044# a_2595_1047.t4 a_20315_1044# VSS.t143 sg13_lv_nmos ad=0.2516p pd=2.16u as=0.1406p ps=1.12u w=0.74u l=0.13u
X183 VDD DELAY_VBIASP.t5 a_23871_2470# VDD sg13_lv_pmos ad=0.3808p pd=2.92u as=0.2128p ps=1.5u w=1.12u l=0.6u
X184 VSS.t536 a_7477_1842# a_7945_1044# VSS.t542 sg13_lv_nmos ad=0.1665p pd=1.19u as=0.2516p ps=2.16u w=0.74u l=0.13u
X185 a_13231_2470# a_12993_1842# a_13123_1842# VDD sg13_lv_pmos ad=0.2128p pd=1.5u as=0.3808p ps=2.92u w=1.12u l=0.2u
X186 VDD VSS.t598 VDD VDD sg13_lv_pmos ad=0.34p pd=2.68u as=0 ps=0 w=1u l=1u
X187 a_12233_1842# a_12037_1842# VDD VDD sg13_lv_pmos ad=0.3808p pd=2.92u as=0.2128p ps=1.5u w=1.12u l=0.13u
X188 a_7911_1842# a_7673_1842# a_7803_1842# VSS.t40 sg13_lv_nmos ad=0.1406p pd=1.12u as=0.2516p ps=2.16u w=0.74u l=0.2u
X189 a_16793_1842# a_16597_1842# VSS.t516 VSS.t556 sg13_lv_nmos ad=0.2516p pd=2.16u as=0.1406p ps=1.12u w=0.74u l=0.13u
X190 VDD a_3747_311.t3 a_14825_519# VDD sg13_lv_pmos ad=0.3808p pd=2.92u as=0.3808p ps=2.92u w=1.12u l=0.13u
X191 VSS.t206 a_27563_1842# a_27997_1842# VSS.t413 sg13_lv_nmos ad=0.1406p pd=1.12u as=0.2516p ps=2.16u w=0.74u l=0.13u
X192 a_9675_1044# a_9465_1044# VSS.t76 VSS.t75 sg13_lv_nmos ad=0.1406p pd=1.12u as=0.1665p ps=1.19u w=0.74u l=0.13u
X193 a_20593_1842# a_20397_1842# VSS.t61 VSS.t87 sg13_lv_nmos ad=0.2516p pd=2.16u as=0.1406p ps=1.12u w=0.74u l=0.13u
X194 VSS.t49 a_2595_1047.t8 a_8231_1008# VSS.t48 sg13_lv_nmos ad=0.2516p pd=2.16u as=0.2516p ps=2.16u w=0.74u l=0.13u
X195 VSS.t43 a_6283_1842# a_6717_1842# VSS.t42 sg13_lv_nmos ad=0.1406p pd=1.12u as=0.2516p ps=2.16u w=0.74u l=0.13u
X196 a_10430_1044# a_10404_1008# a_10328_1044# VDD sg13_lv_pmos ad=0.3808p pd=2.92u as=0.2128p ps=1.5u w=1.12u l=0.13u
X197 VDD DELAY_VBIASP.t2 a_26151_2470# VDD sg13_lv_pmos ad=0.3808p pd=2.92u as=0.2128p ps=1.5u w=1.12u l=0.6u
X198 a_7390_1044# a_8884_1008# a_8808_1044# VDD sg13_lv_pmos ad=0.3808p pd=2.92u as=0.2128p ps=1.5u w=1.12u l=0.13u
X199 VDD DELAY_VBIASP.t30 a_4871_2470# VDD sg13_lv_pmos ad=0.3808p pd=2.92u as=0.2128p ps=1.5u w=1.12u l=0.6u
X200 a_3449_331# MUX_SEL2 VDD VDD sg13_lv_pmos ad=0.1596p pd=1.22u as=0.2856p ps=2.36u w=0.84u l=0.13u
X201 VDD VSS.t575 VDD VDD sg13_lv_pmos ad=0.19p pd=1.38u as=0 ps=0 w=1u l=1u
X202 a_19073_1842# a_18877_1842# VSS.t211 VSS.t210 sg13_lv_nmos ad=0.2516p pd=2.16u as=0.1406p ps=1.12u w=0.74u l=0.13u
X203 VDD a_15077_1842# a_15545_1044# VDD sg13_lv_pmos ad=0.252p pd=1.57u as=0.3808p ps=2.92u w=1.12u l=0.13u
X204 a_19550_1044# a_2019_1047.t4 a_19448_1044# VSS.t524 sg13_lv_nmos ad=0.2516p pd=2.16u as=0.1406p ps=1.12u w=0.74u l=0.13u
X205 VDD VDD VDD VDD sg13_lv_pmos ad=0.3808p pd=2.92u as=0 ps=0 w=1.12u l=0.6u
X206 VSS.t357 VDD VSS.t355 VSS.t356 sg13_lv_nmos ad=79.8f pd=0.8u as=0 ps=0 w=0.42u l=1u
X207 VSS.t94 a_19203_1842# a_19637_1842# VSS.t93 sg13_lv_nmos ad=0.1406p pd=1.12u as=0.2516p ps=2.16u w=0.74u l=0.13u
X208 VDD VSS.t577 VDD VDD sg13_lv_pmos ad=0.19p pd=1.38u as=0 ps=0 w=1u l=1u
X209 VDD VSS.t588 VDD VDD sg13_lv_pmos ad=0.34p pd=2.68u as=0 ps=0 w=1u l=1u
X210 a_27433_1842# a_27237_1842# VDD VDD sg13_lv_pmos ad=0.3808p pd=2.92u as=0.2128p ps=1.5u w=1.12u l=0.13u
X211 VDD a_1256_289# a_2873_331# VDD sg13_lv_pmos ad=0.1918p pd=1.5u as=0.1596p ps=1.22u w=0.84u l=0.13u
X212 a_13470_1044# a_2595_1047.t6 a_14235_1044# VSS.t27 sg13_lv_nmos ad=0.2516p pd=2.16u as=0.1406p ps=1.12u w=0.74u l=0.13u
X213 VSS.t168 a_8563_1842# a_8997_1842# VSS.t551 sg13_lv_nmos ad=0.1406p pd=1.12u as=0.2516p ps=2.16u w=0.74u l=0.13u
X214 VSS.t452 DELAY_VBIASN.t19 a_13231_1842# VSS.t451 sg13_lv_nmos ad=0.2516p pd=2.16u as=0.1406p ps=1.12u w=0.74u l=0.6u
X215 VDD a_3171_1047.t7 a_11924_1008# VDD sg13_lv_pmos ad=0.3808p pd=2.92u as=0.3808p ps=2.92u w=1.12u l=0.13u
X216 VSS.t523 a_2019_1047.t3 a_22564_1008# VSS.t522 sg13_lv_nmos ad=0.2516p pd=2.16u as=0.2516p ps=2.16u w=0.74u l=0.13u
X217 VSS.t86 a_23003_1842# a_23437_1842# VSS.t540 sg13_lv_nmos ad=0.1406p pd=1.12u as=0.2516p ps=2.16u w=0.74u l=0.13u
X218 VSS.t360 VDD VSS.t359 VSS.t358 sg13_lv_nmos ad=0.1428p pd=1.52u as=0 ps=0 w=0.42u l=1u
X219 VDD DELAY_VBIASP.t27 a_7151_2470# VDD sg13_lv_pmos ad=0.3808p pd=2.92u as=0.2128p ps=1.5u w=1.12u l=0.6u
X220 a_25630_1044# a_25604_1008# a_25528_1044# VDD sg13_lv_pmos ad=0.3808p pd=2.92u as=0.2128p ps=1.5u w=1.12u l=0.13u
X221 a_15511_1842# a_15273_1842# a_15403_1842# VSS.t414 sg13_lv_nmos ad=0.1406p pd=1.12u as=0.2516p ps=2.16u w=0.74u l=0.2u
X222 a_18313_1842# a_18117_1842# VDD VDD sg13_lv_pmos ad=0.3808p pd=2.92u as=0.2128p ps=1.5u w=1.12u l=0.13u
X223 a_5731_289# a_11785_519# a_10430_1044# VDD sg13_lv_pmos ad=0.3808p pd=2.92u as=0.3808p ps=2.92u w=1.12u l=0.13u
X224 VSS.t277 VDD VSS.t275 VSS.t276 sg13_lv_nmos ad=79.8f pd=0.8u as=0 ps=0 w=0.42u l=1u
X225 a_9431_2470# a_9193_1842# a_9323_1842# VDD sg13_lv_pmos ad=0.2128p pd=1.5u as=0.3808p ps=2.92u w=1.12u l=0.2u
X226 a_17275_1044# a_17065_1044# VSS.t232 VSS.t231 sg13_lv_nmos ad=0.1406p pd=1.12u as=0.1665p ps=1.19u w=0.74u l=0.13u
X227 VDD VSS.t574 VDD VDD sg13_lv_pmos ad=0.34p pd=2.68u as=0 ps=0 w=1u l=1u
X228 VSS.t92 a_3747_1047.t6 a_15831_1008# VSS.t91 sg13_lv_nmos ad=0.2516p pd=2.16u as=0.2516p ps=2.16u w=0.74u l=0.13u
X229 a_23871_2470# a_23633_1842# a_23763_1842# VDD sg13_lv_pmos ad=0.2128p pd=1.5u as=0.3808p ps=2.92u w=1.12u l=0.2u
X230 VSS.t17 a_13883_1842# a_14317_1842# VSS.t170 sg13_lv_nmos ad=0.1406p pd=1.12u as=0.2516p ps=2.16u w=0.74u l=0.13u
X231 VSS.t187 a_3747_311.t2 a_26985_519# VSS.t186 sg13_lv_nmos ad=0.2516p pd=2.16u as=0.2516p ps=2.16u w=0.74u l=0.13u
X232 a_8433_1842# a_8237_1842# VDD VDD sg13_lv_pmos ad=0.3808p pd=2.92u as=0.2128p ps=1.5u w=1.12u l=0.13u
X233 VDD a_18443_1842# a_18877_1842# VDD sg13_lv_pmos ad=0.2128p pd=1.5u as=0.3808p ps=2.92u w=1.12u l=0.13u
X234 a_22113_1842# a_21917_1842# VDD VDD sg13_lv_pmos ad=0.3808p pd=2.92u as=0.2128p ps=1.5u w=1.12u l=0.13u
X235 a_4350_1044# a_2019_1047.t9 a_4248_1044# VSS.t236 sg13_lv_nmos ad=0.2516p pd=2.16u as=0.1406p ps=1.12u w=0.74u l=0.13u
X236 a_14888_1044# a_14317_1842# VSS.t15 VSS.t14 sg13_lv_nmos ad=0.1406p pd=1.12u as=0.2516p ps=2.16u w=0.74u l=0.13u
X237 a_16108_289# a_3747_311.t2 a_25630_1044# VSS.t185 sg13_lv_nmos ad=0.2516p pd=2.16u as=0.2516p ps=2.16u w=0.74u l=0.13u
X238 VDD DELAY_VBIASP.t20 a_12471_2470# VDD sg13_lv_pmos ad=0.3808p pd=2.92u as=0.2128p ps=1.5u w=1.12u l=0.6u
X239 VSS.t78 a_4003_1842# a_4437_1842# VSS.t77 sg13_lv_nmos ad=0.1406p pd=1.12u as=0.2516p ps=2.16u w=0.74u l=0.13u
X240 a_16510_1044# a_16484_1008# a_16408_1044# VDD sg13_lv_pmos ad=0.3808p pd=2.92u as=0.2128p ps=1.5u w=1.12u l=0.13u
X241 VDD a_22243_1842# a_22677_1842# VDD sg13_lv_pmos ad=0.2128p pd=1.5u as=0.3808p ps=2.92u w=1.12u l=0.13u
X242 VDD a_3171_1047.t2 a_27124_1008# VDD sg13_lv_pmos ad=0.3808p pd=2.92u as=0.3808p ps=2.92u w=1.12u l=0.13u
X243 VDD MUX_SEL3 a_3449_331# VDD sg13_lv_pmos ad=0.1918p pd=1.5u as=0.1596p ps=1.22u w=0.84u l=0.13u
X244 a_2595_311.t0 a_2297_331# VDD VDD sg13_lv_pmos ad=0.2128p pd=1.5u as=0.1918p ps=1.5u w=1.12u l=0.13u
X245 a_10430_1044# a_11271_1008# a_11195_1044# VDD sg13_lv_pmos ad=0.3808p pd=2.92u as=0.2128p ps=1.5u w=1.12u l=0.13u
X246 a_23355_1044# a_23145_1044# VDD VDD sg13_lv_pmos ad=0.2128p pd=1.5u as=0.252p ps=1.57u w=1.12u l=0.13u
X247 VDD a_3747_1047.t4 a_21911_1008# VDD sg13_lv_pmos ad=0.3808p pd=2.92u as=0.3808p ps=2.92u w=1.12u l=0.13u
X248 VSS.t76 a_8997_1842# a_9465_1044# VSS.t166 sg13_lv_nmos ad=0.1665p pd=1.19u as=0.2516p ps=2.16u w=0.74u l=0.13u
X249 a_20968_1044# a_20397_1842# VDD VDD sg13_lv_pmos ad=0.2128p pd=1.5u as=0.3808p ps=2.92u w=1.12u l=0.13u
X250 a_10951_1842# a_10713_1842# a_10843_1842# VSS.t191 sg13_lv_nmos ad=0.1406p pd=1.12u as=0.2516p ps=2.16u w=0.74u l=0.2u
X251 VSS.t113 a_2019_1047.t5 a_16484_1008# VSS.t112 sg13_lv_nmos ad=0.2516p pd=2.16u as=0.2516p ps=2.16u w=0.74u l=0.13u
X252 a_26151_2470# a_25913_1842# a_26043_1842# VDD sg13_lv_pmos ad=0.2128p pd=1.5u as=0.3808p ps=2.92u w=1.12u l=0.2u
X253 a_13753_1842# a_13557_1842# VDD VDD sg13_lv_pmos ad=0.3808p pd=2.92u as=0.2128p ps=1.5u w=1.12u l=0.13u
X254 VDD a_1721_331# a_2019_311# VDD sg13_lv_pmos ad=0.4256p pd=3u as=0.2128p ps=1.5u w=1.12u l=0.13u
X255 a_4871_2470# a_4633_1842# a_4763_1842# VDD sg13_lv_pmos ad=0.2128p pd=1.5u as=0.3808p ps=2.92u w=1.12u l=0.2u
X256 VSS.t142 a_3171_1047.t9 a_5844_1008# VSS.t141 sg13_lv_nmos ad=0.2516p pd=2.16u as=0.2516p ps=2.16u w=0.74u l=0.13u
X257 VSS.t317 VDD VSS.t315 VSS.t316 sg13_lv_nmos ad=79.8f pd=0.8u as=0 ps=0 w=0.42u l=1u
X258 VDD a_2595_311.t2 a_20905_519# VDD sg13_lv_pmos ad=0.3808p pd=2.92u as=0.3808p ps=2.92u w=1.12u l=0.13u
X259 VDD a_2297_331# a_2595_311.t0 VDD sg13_lv_pmos ad=0.4256p pd=3u as=0.2128p ps=1.5u w=1.12u l=0.13u
X260 VSS.t256 a_2595_1047.t7 a_11271_1008# VSS.t255 sg13_lv_nmos ad=0.2516p pd=2.16u as=0.2516p ps=2.16u w=0.74u l=0.13u
X261 VSS.t450 DELAY_VBIASN.t11 a_19311_1842# VSS.t449 sg13_lv_nmos ad=0.2516p pd=2.16u as=0.1406p ps=1.12u w=0.74u l=0.6u
X262 VDD a_24523_1842# a_24957_1842# VDD sg13_lv_pmos ad=0.2128p pd=1.5u as=0.3808p ps=2.92u w=1.12u l=0.13u
X263 VSS.t241 a_3747_1047.t8 a_9751_1008# VSS.t240 sg13_lv_nmos ad=0.2516p pd=2.16u as=0.2516p ps=2.16u w=0.74u l=0.13u
X264 VSS.t438 DELAY_VBIASN.t24 a_9431_1842# VSS.t437 sg13_lv_nmos ad=0.2516p pd=2.16u as=0.1406p ps=1.12u w=0.74u l=0.6u
X265 a_19448_1044# a_18877_1842# VDD VDD sg13_lv_pmos ad=0.2128p pd=1.5u as=0.3808p ps=2.92u w=1.12u l=0.13u
X266 VSS.t472 DELAY_VBIASN.t6 a_23111_1842# VSS.t471 sg13_lv_nmos ad=0.2516p pd=2.16u as=0.1406p ps=1.12u w=0.74u l=0.6u
X267 a_10430_1044# a_11924_1008# a_11848_1044# VDD sg13_lv_pmos ad=0.3808p pd=2.92u as=0.2128p ps=1.5u w=1.12u l=0.13u
X268 VDD DELAY_VBIASP.t0 a_27671_2470# VDD sg13_lv_pmos ad=0.3808p pd=2.92u as=0.2128p ps=1.5u w=1.12u l=0.6u
X269 a_25630_1044# a_26471_1008# a_26395_1044# VDD sg13_lv_pmos ad=0.3808p pd=2.92u as=0.2128p ps=1.5u w=1.12u l=0.13u
X270 a_7151_2470# a_6913_1842# a_7043_1842# VDD sg13_lv_pmos ad=0.2128p pd=1.5u as=0.3808p ps=2.92u w=1.12u l=0.2u
X271 a_16033_1842# a_15837_1842# VDD VDD sg13_lv_pmos ad=0.3808p pd=2.92u as=0.2128p ps=1.5u w=1.12u l=0.13u
X272 VDD a_15964_289# a_16851_309# VDD sg13_lv_pmos ad=0.2086p pd=1.5u as=0.34p ps=2.68u w=1u l=0.13u
X273 VDD VSS.t576 VDD VDD sg13_lv_pmos ad=0.34p pd=2.68u as=0 ps=0 w=1u l=1u
X274 VSS.t65 a_11603_1842# a_12037_1842# VSS.t64 sg13_lv_nmos ad=0.1406p pd=1.12u as=0.2516p ps=2.16u w=0.74u l=0.13u
X275 VSS.t337 VDD VSS.t335 VSS.t336 sg13_lv_nmos ad=79.8f pd=0.8u as=0 ps=0 w=0.42u l=1u
X276 VDD VSS.t590 VDD VDD sg13_lv_pmos ad=0.34p pd=2.68u as=0 ps=0 w=1u l=1u
X277 VDD a_5957_1842# a_6425_1044# VDD sg13_lv_pmos ad=0.252p pd=1.57u as=0.3808p ps=2.92u w=1.12u l=0.13u
X278 a_24393_1842# a_24197_1842# VSS.t204 VSS.t494 sg13_lv_nmos ad=0.2516p pd=2.16u as=0.1406p ps=1.12u w=0.74u l=0.13u
X279 a_3747_1047.t1 a_3449_1395# VSS.t1 VSS.t0 sg13_lv_nmos ad=0.1406p pd=1.12u as=0.1331p ps=1.12u w=0.74u l=0.13u
X280 a_1544_1044# MUX_SEL1 VSS.t497 VSS.t496 sg13_lv_nmos ad=0.2516p pd=2.16u as=0.2516p ps=2.16u w=0.74u l=0.13u
X281 VDD VSS.t578 VDD VDD sg13_lv_pmos ad=0.34p pd=2.68u as=0 ps=0 w=1u l=1u
X282 a_3171_1047.t0 a_2873_1395# VDD VDD sg13_lv_pmos ad=0.2128p pd=1.5u as=0.1918p ps=1.5u w=1.12u l=0.13u
X283 a_13470_1044# a_3747_1047.t6 a_15755_1044# VSS.t90 sg13_lv_nmos ad=0.2516p pd=2.16u as=0.1406p ps=1.12u w=0.74u l=0.13u
X284 VDD a_5523_1842# a_5957_1842# VDD sg13_lv_pmos ad=0.2128p pd=1.5u as=0.3808p ps=2.92u w=1.12u l=0.13u
X285 VDD a_2297_1395# a_2595_1047.t0 VDD sg13_lv_pmos ad=0.4256p pd=3u as=0.2128p ps=1.5u w=1.12u l=0.13u
X286 VSS.t448 DELAY_VBIASN.t17 a_14751_1842# VSS.t447 sg13_lv_nmos ad=0.2516p pd=2.16u as=0.1406p ps=1.12u w=0.74u l=0.6u
X287 a_2967_1395# MUX_SEL1 a_2873_1395# VSS.t498 sg13_lv_nmos ad=0.1216p pd=1.02u as=0.2176p ps=1.96u w=0.64u l=0.13u
X288 a_4350_1044# a_2595_1047.t9 a_5115_1044# VSS.t108 sg13_lv_nmos ad=0.2516p pd=2.16u as=0.1406p ps=1.12u w=0.74u l=0.13u
X289 VDD a_2019_1047.t6 a_13444_1008# VDD sg13_lv_pmos ad=0.3808p pd=2.92u as=0.3808p ps=2.92u w=1.12u l=0.13u
X290 VSS.t26 a_2595_1047.t2 a_26471_1008# VSS.t25 sg13_lv_nmos ad=0.2516p pd=2.16u as=0.2516p ps=2.16u w=0.74u l=0.13u
X291 a_2595_311.t1 a_2297_331# VSS.t37 VSS.t36 sg13_lv_nmos ad=0.1406p pd=1.12u as=0.1331p ps=1.12u w=0.74u l=0.13u
X292 VSS.t422 DELAY_VBIASN.t31 a_4111_1842# VSS.t421 sg13_lv_nmos ad=0.2516p pd=2.16u as=0.1406p ps=1.12u w=0.74u l=0.6u
X293 a_2297_1395# MUX_SEL0 VDD VDD sg13_lv_pmos ad=0.1596p pd=1.22u as=0.2856p ps=2.36u w=0.84u l=0.13u
X294 VSS.t232 a_16597_1842# a_17065_1044# VSS.t557 sg13_lv_nmos ad=0.1665p pd=1.19u as=0.2516p ps=2.16u w=0.74u l=0.13u
X295 VDD DELAY_VBIASP.t25 a_8671_2470# VDD sg13_lv_pmos ad=0.3808p pd=2.92u as=0.2128p ps=1.5u w=1.12u l=0.6u
X296 VDD VSS.t591 VDD VDD sg13_lv_pmos ad=0.19p pd=1.38u as=0 ps=0 w=1u l=1u
X297 VDD a_1544_1044# a_1721_1395# VDD sg13_lv_pmos ad=0.1918p pd=1.5u as=0.1596p ps=1.22u w=0.84u l=0.13u
X298 a_4248_1044# a_4157_1313# VDD VDD sg13_lv_pmos ad=0.2128p pd=1.5u as=0.3808p ps=2.92u w=1.12u l=0.13u
X299 a_12471_2470# a_12233_1842# a_12363_1842# VDD sg13_lv_pmos ad=0.2128p pd=1.5u as=0.3808p ps=2.92u w=1.12u l=0.2u
X300 a_17031_1842# a_16793_1842# a_16923_1842# VSS.t192 sg13_lv_nmos ad=0.1406p pd=1.12u as=0.2516p ps=2.16u w=0.74u l=0.2u
X301 VSS.t7 a_1721_331# a_2019_311# VSS.t6 sg13_lv_nmos ad=0.2812p pd=2.24u as=0.1406p ps=1.12u w=0.74u l=0.13u
X302 a_19550_1044# a_21911_1008# a_21835_1044# VDD sg13_lv_pmos ad=0.3808p pd=2.92u as=0.2128p ps=1.5u w=1.12u l=0.13u
X303 a_16108_289# a_26985_519# a_25630_1044# VDD sg13_lv_pmos ad=0.3808p pd=2.92u as=0.3808p ps=2.92u w=1.12u l=0.13u
X304 VSS.t39 a_2297_331# a_2595_311.t1 VSS.t38 sg13_lv_nmos ad=0.2812p pd=2.24u as=0.1406p ps=1.12u w=0.74u l=0.13u
X305 a_18795_1044# a_18585_1044# VSS.t55 VSS.t160 sg13_lv_nmos ad=0.1406p pd=1.12u as=0.1665p ps=1.19u w=0.74u l=0.13u
X306 a_20831_1842# a_20593_1842# a_20723_1842# VSS.t163 sg13_lv_nmos ad=0.1406p pd=1.12u as=0.2516p ps=2.16u w=0.74u l=0.2u
X307 VSS.t275 VDD VSS.t274 VSS.t273 sg13_lv_nmos ad=0.1428p pd=1.52u as=0 ps=0 w=0.42u l=1u
X308 VDD a_22677_1842# a_23145_1044# VDD sg13_lv_pmos ad=0.252p pd=1.57u as=0.3808p ps=2.92u w=1.12u l=0.13u
X309 VSS.t46 a_2595_1047.t5 a_17351_1008# VSS.t45 sg13_lv_nmos ad=0.2516p pd=2.16u as=0.2516p ps=2.16u w=0.74u l=0.13u
X310 a_5393_1842# a_5197_1842# VSS.t266 VSS.t265 sg13_lv_nmos ad=0.2516p pd=2.16u as=0.1406p ps=1.12u w=0.74u l=0.13u
X311 VSS.t460 DELAY_VBIASN.t14 a_17031_1842# VSS.t459 sg13_lv_nmos ad=0.2516p pd=2.16u as=0.1406p ps=1.12u w=0.74u l=0.6u
X312 a_25630_1044# a_3171_1047.t2 a_27048_1044# VSS.t149 sg13_lv_nmos ad=0.2516p pd=2.16u as=0.1406p ps=1.12u w=0.74u l=0.13u
X313 a_9953_1842# a_9757_1842# VDD VDD sg13_lv_pmos ad=0.3808p pd=2.92u as=0.2128p ps=1.5u w=1.12u l=0.13u
X314 VDD a_10843_1842# a_11277_1842# VDD sg13_lv_pmos ad=0.2128p pd=1.5u as=0.3808p ps=2.92u w=1.12u l=0.13u
X315 VSS.t198 a_26803_1842# a_27237_1842# VSS.t197 sg13_lv_nmos ad=0.1406p pd=1.12u as=0.2516p ps=2.16u w=0.74u l=0.13u
X316 a_4350_1044# a_3171_1047.t9 a_5768_1044# VSS.t140 sg13_lv_nmos ad=0.2516p pd=2.16u as=0.1406p ps=1.12u w=0.74u l=0.13u
X317 a_10430_1044# a_12791_1008# a_12715_1044# VDD sg13_lv_pmos ad=0.3808p pd=2.92u as=0.2128p ps=1.5u w=1.12u l=0.13u
X318 a_19311_1842# a_19073_1842# a_19203_1842# VSS.t550 sg13_lv_nmos ad=0.1406p pd=1.12u as=0.2516p ps=2.16u w=0.74u l=0.2u
X319 a_24875_1044# a_24665_1044# VDD VDD sg13_lv_pmos ad=0.2128p pd=1.5u as=0.252p ps=1.57u w=1.12u l=0.13u
X320 VDD a_2595_1047.t3 a_23431_1008# VDD sg13_lv_pmos ad=0.3808p pd=2.92u as=0.3808p ps=2.92u w=1.12u l=0.13u
X321 VDD a_13557_1842# a_14025_1044# VDD sg13_lv_pmos ad=0.252p pd=1.57u as=0.3808p ps=2.92u w=1.12u l=0.13u
X322 a_23111_1842# a_22873_1842# a_23003_1842# VSS.t188 sg13_lv_nmos ad=0.1406p pd=1.12u as=0.2516p ps=2.16u w=0.74u l=0.2u
X323 a_27671_2470# a_27433_1842# a_27563_1842# VDD sg13_lv_pmos ad=0.2128p pd=1.5u as=0.3808p ps=2.92u w=1.12u l=0.2u
X324 VSS.t57 a_17683_1842# a_18117_1842# VSS.t176 sg13_lv_nmos ad=0.1406p pd=1.12u as=0.2516p ps=2.16u w=0.74u l=0.13u
X325 VSS.t332 VDD VSS.t330 VSS.t331 sg13_lv_nmos ad=79.8f pd=0.8u as=0 ps=0 w=0.42u l=1u
X326 a_10713_1842# a_10517_1842# VSS.t10 VSS.t9 sg13_lv_nmos ad=0.2516p pd=2.16u as=0.1406p ps=1.12u w=0.74u l=0.13u
X327 VSS.t512 a_2019_1047.t8 a_7364_1008# VSS.t511 sg13_lv_nmos ad=0.2516p pd=2.16u as=0.2516p ps=2.16u w=0.74u l=0.13u
X328 VSS.t480 a_7803_1842# a_8237_1842# VSS.t505 sg13_lv_nmos ad=0.1406p pd=1.12u as=0.2516p ps=2.16u w=0.74u l=0.13u
X329 VDD DELAY_VBIASP.t15 a_16271_2470# VDD sg13_lv_pmos ad=0.3808p pd=2.92u as=0.2128p ps=1.5u w=1.12u l=0.6u
X330 VSS.t327 VDD VSS.t325 VSS.t326 sg13_lv_nmos ad=79.8f pd=0.8u as=0 ps=0 w=0.42u l=1u
X331 VSS.t300 VDD VSS.t299 VSS.t298 sg13_lv_nmos ad=0.1428p pd=1.52u as=0 ps=0 w=0.42u l=1u
X332 VDD a_26043_1842# a_26477_1842# VDD sg13_lv_pmos ad=0.2128p pd=1.5u as=0.3808p ps=2.92u w=1.12u l=0.13u
X333 a_3543_331# MUX_SEL2 a_3449_331# VSS.t383 sg13_lv_nmos ad=0.1216p pd=1.02u as=0.2176p ps=1.96u w=0.64u l=0.13u
X334 a_22488_1044# a_21917_1842# VSS.t398 VSS.t397 sg13_lv_nmos ad=0.1406p pd=1.12u as=0.2516p ps=2.16u w=0.74u l=0.13u
X335 VDD VSS.t593 VDD VDD sg13_lv_pmos ad=0.19p pd=1.38u as=0 ps=0 w=1u l=1u
X336 a_22590_1044# a_24084_1008# a_24008_1044# VDD sg13_lv_pmos ad=0.3808p pd=2.92u as=0.2128p ps=1.5u w=1.12u l=0.13u
X337 VDD DELAY_VBIASP.t10 a_20071_2470# VDD sg13_lv_pmos ad=0.3808p pd=2.92u as=0.2128p ps=1.5u w=1.12u l=0.6u
X338 a_14751_1842# a_14513_1842# a_14643_1842# VSS.t212 sg13_lv_nmos ad=0.1406p pd=1.12u as=0.2516p ps=2.16u w=0.74u l=0.2u
X339 VSS.t222 a_2873_1395# a_3171_1047.t1 VSS.t221 sg13_lv_nmos ad=0.2812p pd=2.24u as=0.1406p ps=1.12u w=0.74u l=0.13u
X340 VDD VSS.t567 VDD VDD sg13_lv_pmos ad=0.19p pd=1.38u as=0 ps=0 w=1u l=1u
X341 a_25630_1044# a_27991_1008# a_27915_1044# VDD sg13_lv_pmos ad=0.3808p pd=2.92u as=0.2128p ps=1.5u w=1.12u l=0.13u
X342 VSS.t369 VSS.t367 VSS.t365 VSS.t368 sg13_lv_nmos ad=0.1406p pd=1.12u as=0 ps=0 w=0.74u l=0.13u
X343 a_4111_1842# DELAY_IN a_4003_1842# VSS.t269 sg13_lv_nmos ad=0.1406p pd=1.12u as=0.2516p ps=2.16u w=0.74u l=0.2u
X344 a_8671_2470# a_8433_1842# a_8563_1842# VDD sg13_lv_pmos ad=0.2128p pd=1.5u as=0.3808p ps=2.92u w=1.12u l=0.2u
X345 a_17553_1842# a_17357_1842# VDD VDD sg13_lv_pmos ad=0.3808p pd=2.92u as=0.2128p ps=1.5u w=1.12u l=0.13u
X346 VSS.t130 a_1544_1044# a_2391_1395# VSS.t228 sg13_lv_nmos ad=0.1331p pd=1.12u as=0.1216p ps=1.02u w=0.64u l=0.13u
X347 VSS.t74 a_3747_311.t3 a_14825_519# VSS.t73 sg13_lv_nmos ad=0.2516p pd=2.16u as=0.2516p ps=2.16u w=0.74u l=0.13u
X348 VSS.t119 a_1256_289# a_2967_331# VSS.t162 sg13_lv_nmos ad=0.1331p pd=1.12u as=0.1216p ps=1.02u w=0.64u l=0.13u
X349 a_2019_1047.t1 a_1721_1395# VSS.t51 VSS.t50 sg13_lv_nmos ad=0.1406p pd=1.12u as=0.1331p ps=1.12u w=0.74u l=0.13u
X350 a_15964_289# a_15765_463# a_5731_289# VSS.t175 sg13_lv_nmos ad=0.2183p pd=1.33u as=0.2516p ps=2.16u w=0.74u l=0.13u
X351 a_13470_1044# a_2019_1047.t6 a_13368_1044# VSS.t518 sg13_lv_nmos ad=0.2516p pd=2.16u as=0.1406p ps=1.12u w=0.74u l=0.13u
X352 VSS.t165 a_13123_1842# a_13557_1842# VSS.t164 sg13_lv_nmos ad=0.1406p pd=1.12u as=0.2516p ps=2.16u w=0.74u l=0.13u
X353 VDD VSS.t566 VDD VDD sg13_lv_pmos ad=0.34p pd=2.68u as=0 ps=0 w=1u l=1u
X354 VSS.t532 a_3171_1047.t3 a_24084_1008# VSS.t531 sg13_lv_nmos ad=0.2516p pd=2.16u as=0.2516p ps=2.16u w=0.74u l=0.13u
X355 a_25913_1842# a_25717_1842# VSS.t82 VSS.t81 sg13_lv_nmos ad=0.2516p pd=2.16u as=0.1406p ps=1.12u w=0.74u l=0.13u
X356 a_21353_1842# a_21157_1842# VDD VDD sg13_lv_pmos ad=0.3808p pd=2.92u as=0.2128p ps=1.5u w=1.12u l=0.13u
X357 VSS.t335 VDD VSS.t334 VSS.t333 sg13_lv_nmos ad=0.1428p pd=1.52u as=0 ps=0 w=0.42u l=1u
X358 a_2297_331# MUX_SEL2 VDD VDD sg13_lv_pmos ad=0.1596p pd=1.22u as=0.2856p ps=2.36u w=0.84u l=0.13u
X359 VDD a_7043_1842# a_7477_1842# VDD sg13_lv_pmos ad=0.2128p pd=1.5u as=0.3808p ps=2.92u w=1.12u l=0.13u
X360 a_2873_331# MUX_SEL3 VDD VDD sg13_lv_pmos ad=0.1596p pd=1.22u as=0.2856p ps=2.36u w=0.84u l=0.13u
X361 a_8155_1044# a_7945_1044# VDD VDD sg13_lv_pmos ad=0.2128p pd=1.5u as=0.252p ps=1.57u w=1.12u l=0.13u
X362 VSS.t55 a_18117_1842# a_18585_1044# VSS.t54 sg13_lv_nmos ad=0.1665p pd=1.19u as=0.2516p ps=2.16u w=0.74u l=0.13u
X363 a_27048_1044# a_26477_1842# VDD VDD sg13_lv_pmos ad=0.2128p pd=1.5u as=0.3808p ps=2.92u w=1.12u l=0.13u
X364 a_5768_1044# a_5197_1842# VDD VDD sg13_lv_pmos ad=0.2128p pd=1.5u as=0.3808p ps=2.92u w=1.12u l=0.13u
X365 a_13991_2470# a_13753_1842# a_13883_1842# VDD sg13_lv_pmos ad=0.2128p pd=1.5u as=0.3808p ps=2.92u w=1.12u l=0.2u
X366 VSS.t529 a_3171_1047.t6 a_14964_1008# VSS.t528 sg13_lv_nmos ad=0.2516p pd=2.16u as=0.2516p ps=2.16u w=0.74u l=0.13u
X367 VDD a_2019_311# a_17865_519# VDD sg13_lv_pmos ad=0.3808p pd=2.92u as=0.3808p ps=2.92u w=1.12u l=0.13u
X368 DELAY_OUT_LAST a_27997_1842# VSS.t206 VSS.t205 sg13_lv_nmos ad=0.2516p pd=2.16u as=0.1406p ps=1.12u w=0.74u l=0.13u
X369 a_11195_1044# a_10985_1044# VSS.t12 VSS.t534 sg13_lv_nmos ad=0.1406p pd=1.12u as=0.1665p ps=1.19u w=0.74u l=0.13u
X370 VDD a_24197_1842# a_24665_1044# VDD sg13_lv_pmos ad=0.252p pd=1.57u as=0.3808p ps=2.92u w=1.12u l=0.13u
X371 a_6913_1842# a_6717_1842# VSS.t43 VSS.t547 sg13_lv_nmos ad=0.2516p pd=2.16u as=0.1406p ps=1.12u w=0.74u l=0.13u
X372 VSS.t462 DELAY_VBIASN.t12 a_18551_1842# VSS.t461 sg13_lv_nmos ad=0.2516p pd=2.16u as=0.1406p ps=1.12u w=0.74u l=0.6u
X373 a_16510_1044# a_18004_1008# a_17928_1044# VDD sg13_lv_pmos ad=0.3808p pd=2.92u as=0.2128p ps=1.5u w=1.12u l=0.13u
X374 VDD a_12363_1842# a_12797_1842# VDD sg13_lv_pmos ad=0.2128p pd=1.5u as=0.3808p ps=2.92u w=1.12u l=0.13u
X375 VSS.t115 MUX_SEL3 a_3543_331# VSS.t555 sg13_lv_nmos ad=0.1331p pd=1.12u as=0.1216p ps=1.02u w=0.64u l=0.13u
X376 a_22590_1044# a_2595_1047.t3 a_23355_1044# VSS.t30 sg13_lv_nmos ad=0.2516p pd=2.16u as=0.1406p ps=1.12u w=0.74u l=0.13u
X377 VSS.t468 DELAY_VBIASN.t7 a_22351_1842# VSS.t467 sg13_lv_nmos ad=0.2516p pd=2.16u as=0.1406p ps=1.12u w=0.74u l=0.6u
X378 VDD a_3171_1047.t4 a_21044_1008# VDD sg13_lv_pmos ad=0.3808p pd=2.92u as=0.3808p ps=2.92u w=1.12u l=0.13u
X379 VDD VSS.t569 VDD VDD sg13_lv_pmos ad=0.19p pd=1.38u as=0 ps=0 w=1u l=1u
X380 a_16271_2470# a_16033_1842# a_16163_1842# VDD sg13_lv_pmos ad=0.2128p pd=1.5u as=0.3808p ps=2.92u w=1.12u l=0.2u
X381 VDD VSS.t583 VDD VDD sg13_lv_pmos ad=0.19p pd=1.38u as=0 ps=0 w=1u l=1u
X382 a_19833_1842# a_19637_1842# VSS.t94 VSS.t181 sg13_lv_nmos ad=0.2516p pd=2.16u as=0.1406p ps=1.12u w=0.74u l=0.13u
X383 VDD a_2019_311# a_5705_519# VDD sg13_lv_pmos ad=0.3808p pd=2.92u as=0.3808p ps=2.92u w=1.12u l=0.13u
X384 a_20071_2470# a_19833_1842# a_19963_1842# VDD sg13_lv_pmos ad=0.2128p pd=1.5u as=0.3808p ps=2.92u w=1.12u l=0.2u
X385 a_9193_1842# a_8997_1842# VSS.t168 VSS.t167 sg13_lv_nmos ad=0.2516p pd=2.16u as=0.1406p ps=1.12u w=0.74u l=0.13u
X386 a_24631_1842# a_24393_1842# a_24523_1842# VSS.t260 sg13_lv_nmos ad=0.1406p pd=1.12u as=0.2516p ps=2.16u w=0.74u l=0.2u
X387 VDD VSS.t582 VDD VDD sg13_lv_pmos ad=0.34p pd=2.68u as=0 ps=0 w=1u l=1u
X388 VSS.t107 a_2019_1047.t7 a_10404_1008# VSS.t106 sg13_lv_nmos ad=0.2516p pd=2.16u as=0.2516p ps=2.16u w=0.74u l=0.13u
X389 VDD a_14643_1842# a_15077_1842# VDD sg13_lv_pmos ad=0.2128p pd=1.5u as=0.3808p ps=2.92u w=1.12u l=0.13u
X390 VDD a_1544_289# a_2297_331# VDD sg13_lv_pmos ad=0.1918p pd=1.5u as=0.1596p ps=1.22u w=0.84u l=0.13u
X391 a_23633_1842# a_23437_1842# VSS.t86 VSS.t85 sg13_lv_nmos ad=0.2516p pd=2.16u as=0.1406p ps=1.12u w=0.74u l=0.13u
X392 VSS.t330 VDD VSS.t329 VSS.t328 sg13_lv_nmos ad=0.1428p pd=1.52u as=0 ps=0 w=0.42u l=1u
X393 a_2019_311# a_1721_331# VDD VDD sg13_lv_pmos ad=0.2128p pd=1.5u as=0.1918p ps=1.5u w=1.12u l=0.13u
X394 VSS.t71 a_9323_1842# a_9757_1842# VSS.t408 sg13_lv_nmos ad=0.1406p pd=1.12u as=0.2516p ps=2.16u w=0.74u l=0.13u
X395 a_26395_1044# a_26185_1044# VSS.t80 VSS.t136 sg13_lv_nmos ad=0.1406p pd=1.12u as=0.1665p ps=1.19u w=0.74u l=0.13u
X396 VDD DELAY_VBIASP.t13 a_17791_2470# VDD sg13_lv_pmos ad=0.3808p pd=2.92u as=0.2128p ps=1.5u w=1.12u l=0.6u
X397 VSS.t20 a_3747_1047.t3 a_24951_1008# VSS.t19 sg13_lv_nmos ad=0.2516p pd=2.16u as=0.2516p ps=2.16u w=0.74u l=0.13u
X398 VSS.t295 VDD VSS.t294 VSS.t293 sg13_lv_nmos ad=0.1428p pd=1.52u as=0 ps=0 w=0.42u l=1u
X399 VSS.t325 VDD VSS.t324 VSS.t323 sg13_lv_nmos ad=0.1428p pd=1.52u as=0 ps=0 w=0.42u l=1u
X400 a_3747_1047.t0 a_3449_1395# VDD VDD sg13_lv_pmos ad=0.2128p pd=1.5u as=0.1918p ps=1.5u w=1.12u l=0.13u
X401 a_13368_1044# a_12797_1842# VDD VDD sg13_lv_pmos ad=0.2128p pd=1.5u as=0.3808p ps=2.92u w=1.12u l=0.13u
X402 a_24008_1044# a_23437_1842# VSS.t84 VSS.t83 sg13_lv_nmos ad=0.1406p pd=1.12u as=0.2516p ps=2.16u w=0.74u l=0.13u
X403 VDD DELAY_VBIASP.t8 a_21591_2470# VDD sg13_lv_pmos ad=0.3808p pd=2.92u as=0.2128p ps=1.5u w=1.12u l=0.6u
X404 a_15964_289# MUX_SEL4 a_5731_289# VDD sg13_lv_pmos ad=0.3304p pd=1.71u as=0.3808p ps=2.92u w=1.12u l=0.13u
X405 a_4350_1044# a_6711_1008# a_6635_1044# VDD sg13_lv_pmos ad=0.3808p pd=2.92u as=0.2128p ps=1.5u w=1.12u l=0.13u
X406 a_2873_1395# MUX_SEL1 VDD VDD sg13_lv_pmos ad=0.1596p pd=1.22u as=0.2856p ps=2.36u w=0.84u l=0.13u
X407 a_1256_1044# MUX_SEL0 VSS.t486 VSS.t485 sg13_lv_nmos ad=0.2516p pd=2.16u as=0.2516p ps=2.16u w=0.74u l=0.13u
X408 VSS.t292 VDD VSS.t290 VSS.t291 sg13_lv_nmos ad=79.8f pd=0.8u as=0 ps=0 w=0.42u l=1u
X409 a_19550_1044# a_20391_1008# a_20315_1044# VDD sg13_lv_pmos ad=0.3808p pd=2.92u as=0.2128p ps=1.5u w=1.12u l=0.13u
X410 VDD VDD VDD VDD sg13_lv_pmos ad=0.2128p pd=1.5u as=0 ps=0 w=1.12u l=0.2u
X411 a_5631_1842# a_5393_1842# a_5523_1842# VSS.t59 sg13_lv_nmos ad=0.1406p pd=1.12u as=0.2516p ps=2.16u w=0.74u l=0.2u
X412 a_14513_1842# a_14317_1842# VSS.t17 VSS.t16 sg13_lv_nmos ad=0.2516p pd=2.16u as=0.1406p ps=1.12u w=0.74u l=0.13u
X413 VSS.t247 a_2595_311.t2 a_20905_519# VSS.t246 sg13_lv_nmos ad=0.2516p pd=2.16u as=0.2516p ps=2.16u w=0.74u l=0.13u
X414 VDD a_7477_1842# a_7945_1044# VDD sg13_lv_pmos ad=0.252p pd=1.57u as=0.3808p ps=2.92u w=1.12u l=0.13u
X415 a_13470_1044# a_3171_1047.t6 a_14888_1044# VSS.t527 sg13_lv_nmos ad=0.2516p pd=2.16u as=0.1406p ps=1.12u w=0.74u l=0.13u
X416 a_4633_1842# a_4437_1842# VSS.t78 VSS.t484 sg13_lv_nmos ad=0.2516p pd=2.16u as=0.1406p ps=1.12u w=0.74u l=0.13u
X417 a_1256_289# MUX_SEL2 VSS.t381 VSS.t380 sg13_lv_nmos ad=0.2516p pd=2.16u as=0.2516p ps=2.16u w=0.74u l=0.13u
X418 VSS.t219 a_2019_1047.t2 a_25604_1008# VSS.t218 sg13_lv_nmos ad=0.2516p pd=2.16u as=0.2516p ps=2.16u w=0.74u l=0.13u
X419 a_16108_289# MUX_SEL4 a_15964_289# VSS.t177 sg13_lv_nmos ad=0.2516p pd=2.16u as=0.2183p ps=1.33u w=0.74u l=0.13u
X420 a_22873_1842# a_22677_1842# VDD VDD sg13_lv_pmos ad=0.3808p pd=2.92u as=0.2128p ps=1.5u w=1.12u l=0.13u
X421 a_21835_1044# a_21625_1044# VSS.t202 VSS.t537 sg13_lv_nmos ad=0.1406p pd=1.12u as=0.1665p ps=1.19u w=0.74u l=0.13u
X422 VSS.t145 a_2595_1047.t4 a_20391_1008# VSS.t144 sg13_lv_nmos ad=0.2516p pd=2.16u as=0.2516p ps=2.16u w=0.74u l=0.13u
X423 a_9675_1044# a_9465_1044# VDD VDD sg13_lv_pmos ad=0.2128p pd=1.5u as=0.252p ps=1.57u w=1.12u l=0.13u
X424 VSS.t12 a_10517_1842# a_10985_1044# VSS.t11 sg13_lv_nmos ad=0.1665p pd=1.19u as=0.2516p ps=2.16u w=0.74u l=0.13u
X425 VDD a_2595_1047.t8 a_8231_1008# VDD sg13_lv_pmos ad=0.3808p pd=2.92u as=0.3808p ps=2.92u w=1.12u l=0.13u
X426 a_18551_1842# a_18313_1842# a_18443_1842# VSS.t395 sg13_lv_nmos ad=0.1406p pd=1.12u as=0.2516p ps=2.16u w=0.74u l=0.2u
X427 a_22351_1842# a_22113_1842# a_22243_1842# VSS.t517 sg13_lv_nmos ad=0.1406p pd=1.12u as=0.2516p ps=2.16u w=0.74u l=0.2u
X428 VSS.t216 a_3747_1047.t5 a_18871_1008# VSS.t215 sg13_lv_nmos ad=0.2516p pd=2.16u as=0.2516p ps=2.16u w=0.74u l=0.13u
X429 VSS.t67 a_16923_1842# a_17357_1842# VSS.t66 sg13_lv_nmos ad=0.1406p pd=1.12u as=0.2516p ps=2.16u w=0.74u l=0.13u
X430 VDD a_3171_311.t2 a_23945_519# VDD sg13_lv_pmos ad=0.3808p pd=2.92u as=0.3808p ps=2.92u w=1.12u l=0.13u
X431 a_2019_311# a_1721_331# VSS.t5 VSS.t4 sg13_lv_nmos ad=0.1406p pd=1.12u as=0.1331p ps=1.12u w=0.74u l=0.13u
X432 a_25153_1842# a_24957_1842# VDD VDD sg13_lv_pmos ad=0.3808p pd=2.92u as=0.2128p ps=1.5u w=1.12u l=0.13u
X433 a_17928_1044# a_17357_1842# VSS.t401 VSS.t400 sg13_lv_nmos ad=0.1406p pd=1.12u as=0.2516p ps=2.16u w=0.74u l=0.13u
X434 a_12715_1044# a_12505_1044# VSS.t104 VSS.t135 sg13_lv_nmos ad=0.1406p pd=1.12u as=0.1665p ps=1.19u w=0.74u l=0.13u
X435 VDD MUX_SEL4 a_15765_463# VDD sg13_lv_pmos ad=0.3808p pd=2.92u as=0.3808p ps=2.92u w=1.12u l=0.13u
X436 a_19550_1044# a_3171_1047.t4 a_20968_1044# VSS.t146 sg13_lv_nmos ad=0.2516p pd=2.16u as=0.1406p ps=1.12u w=0.74u l=0.13u
X437 VSS.t440 DELAY_VBIASN.t22 a_10951_1842# VSS.t439 sg13_lv_nmos ad=0.2516p pd=2.16u as=0.1406p ps=1.12u w=0.74u l=0.6u
X438 a_19550_1044# a_19524_1008# a_19448_1044# VDD sg13_lv_pmos ad=0.3808p pd=2.92u as=0.2128p ps=1.5u w=1.12u l=0.13u
X439 a_7288_1044# a_6717_1842# VSS.t549 VSS.t548 sg13_lv_nmos ad=0.1406p pd=1.12u as=0.2516p ps=2.16u w=0.74u l=0.13u
X440 VSS.t200 a_20723_1842# a_21157_1842# VSS.t539 sg13_lv_nmos ad=0.1406p pd=1.12u as=0.2516p ps=2.16u w=0.74u l=0.13u
X441 a_1544_289# MUX_SEL3 VSS.t553 VSS.t552 sg13_lv_nmos ad=0.2516p pd=2.16u as=0.2516p ps=2.16u w=0.74u l=0.13u
X442 a_13470_1044# a_14311_1008# a_14235_1044# VDD sg13_lv_pmos ad=0.3808p pd=2.92u as=0.2128p ps=1.5u w=1.12u l=0.13u
X443 a_22590_1044# a_3747_1047.t3 a_24875_1044# VSS.t18 sg13_lv_nmos ad=0.2516p pd=2.16u as=0.1406p ps=1.12u w=0.74u l=0.13u
X444 VSS.t418 DELAY_VBIASN.t5 a_23871_1842# VSS.t417 sg13_lv_nmos ad=0.2516p pd=2.16u as=0.1406p ps=1.12u w=0.74u l=0.6u
X445 VDD a_2019_1047.t3 a_22564_1008# VDD sg13_lv_pmos ad=0.3808p pd=2.92u as=0.3808p ps=2.92u w=1.12u l=0.13u
X446 VSS.t80 a_25717_1842# a_26185_1044# VSS.t79 sg13_lv_nmos ad=0.1665p pd=1.19u as=0.2516p ps=2.16u w=0.74u l=0.13u
X447 a_13231_1842# a_12993_1842# a_13123_1842# VSS.t41 sg13_lv_nmos ad=0.1406p pd=1.12u as=0.2516p ps=2.16u w=0.74u l=0.2u
X448 VSS.t287 VDD VSS.t285 VSS.t286 sg13_lv_nmos ad=79.8f pd=0.8u as=0 ps=0 w=0.42u l=1u
X449 a_17791_2470# a_17553_1842# a_17683_1842# VDD sg13_lv_pmos ad=0.2128p pd=1.5u as=0.3808p ps=2.92u w=1.12u l=0.2u
X450 VSS.t134 a_4437_1842# a_4905_1044# VSS.t483 sg13_lv_nmos ad=0.1665p pd=1.19u as=0.2516p ps=2.16u w=0.74u l=0.13u
X451 VDD VSS.t570 VDD VDD sg13_lv_pmos ad=0.34p pd=2.68u as=0 ps=0 w=1u l=1u
X452 a_12233_1842# a_12037_1842# VSS.t65 VSS.t102 sg13_lv_nmos ad=0.2516p pd=2.16u as=0.1406p ps=1.12u w=0.74u l=0.13u
X453 VSS.t3 a_3449_1395# a_3747_1047.t1 VSS.t2 sg13_lv_nmos ad=0.2812p pd=2.24u as=0.1406p ps=1.12u w=0.74u l=0.13u
X454 VDD VSS.t584 VDD VDD sg13_lv_pmos ad=0.34p pd=2.68u as=0 ps=0 w=1u l=1u
X455 VDD VSS.t579 VDD VDD sg13_lv_pmos ad=0.19p pd=1.38u as=0 ps=0 w=1u l=1u
X456 VSS.t352 VDD VSS.t350 VSS.t351 sg13_lv_nmos ad=79.8f pd=0.8u as=0 ps=0 w=0.42u l=1u
X457 VSS.t253 a_3171_1047.t8 a_8884_1008# VSS.t252 sg13_lv_nmos ad=0.2516p pd=2.16u as=0.2516p ps=2.16u w=0.74u l=0.13u
X458 a_21591_2470# a_21353_1842# a_21483_1842# VDD sg13_lv_pmos ad=0.2128p pd=1.5u as=0.3808p ps=2.92u w=1.12u l=0.2u
X459 VDD a_2873_1395# a_3171_1047.t0 VDD sg13_lv_pmos ad=0.4256p pd=3u as=0.2128p ps=1.5u w=1.12u l=0.13u
X460 a_6153_1842# a_5957_1842# VDD VDD sg13_lv_pmos ad=0.3808p pd=2.92u as=0.2128p ps=1.5u w=1.12u l=0.13u
X461 VDD a_16163_1842# a_16597_1842# VDD sg13_lv_pmos ad=0.2128p pd=1.5u as=0.3808p ps=2.92u w=1.12u l=0.13u
X462 a_3543_1395# MUX_SEL0 a_3449_1395# VSS.t488 sg13_lv_nmos ad=0.1216p pd=1.02u as=0.2176p ps=1.96u w=0.64u l=0.13u
X463 VDD a_1544_1044# a_2297_1395# VDD sg13_lv_pmos ad=0.1918p pd=1.5u as=0.1596p ps=1.22u w=0.84u l=0.13u
X464 VDD DELAY_VBIASP.t23 a_10191_2470# VDD sg13_lv_pmos ad=0.3808p pd=2.92u as=0.2128p ps=1.5u w=1.12u l=0.6u
X465 a_17275_1044# a_17065_1044# VDD VDD sg13_lv_pmos ad=0.2128p pd=1.5u as=0.252p ps=1.57u w=1.12u l=0.13u
X466 a_2019_1047.t0 a_1721_1395# VDD VDD sg13_lv_pmos ad=0.2128p pd=1.5u as=0.1918p ps=1.5u w=1.12u l=0.13u
X467 a_27915_1044# a_27705_1044# VSS.t224 VSS.t223 sg13_lv_nmos ad=0.1406p pd=1.12u as=0.1665p ps=1.19u w=0.74u l=0.13u
X468 VSS.t470 DELAY_VBIASN.t2 a_26151_1842# VSS.t469 sg13_lv_nmos ad=0.2516p pd=2.16u as=0.1406p ps=1.12u w=0.74u l=0.6u
X469 VDD a_3747_1047.t6 a_15831_1008# VDD sg13_lv_pmos ad=0.3808p pd=2.92u as=0.3808p ps=2.92u w=1.12u l=0.13u
X470 VDD a_19963_1842# a_20397_1842# VDD sg13_lv_pmos ad=0.2128p pd=1.5u as=0.3808p ps=2.92u w=1.12u l=0.13u
X471 VSS.t355 VDD VSS.t354 VSS.t353 sg13_lv_nmos ad=0.1428p pd=1.52u as=0 ps=0 w=0.42u l=1u
X472 VSS.t428 DELAY_VBIASN.t30 a_4871_1842# VSS.t427 sg13_lv_nmos ad=0.2516p pd=2.16u as=0.1406p ps=1.12u w=0.74u l=0.6u
X473 a_14888_1044# a_14317_1842# VDD VDD sg13_lv_pmos ad=0.2128p pd=1.5u as=0.3808p ps=2.92u w=1.12u l=0.13u
X474 a_4350_1044# a_4324_1008# a_4248_1044# VDD sg13_lv_pmos ad=0.3808p pd=2.92u as=0.2128p ps=1.5u w=1.12u l=0.13u
X475 a_1256_289# MUX_SEL2 VDD VDD sg13_lv_pmos ad=0.3808p pd=2.92u as=0.3808p ps=2.92u w=1.12u l=0.13u
X476 VSS.t373 VSS.t370 VSS.t372 VSS.t371 sg13_lv_nmos ad=0.2516p pd=2.16u as=0 ps=0 w=0.74u l=0.6u
X477 a_16108_289# a_15765_463# a_15964_289# VDD sg13_lv_pmos ad=0.3808p pd=2.92u as=0.3304p ps=1.71u w=1.12u l=0.13u
X478 a_11473_1842# a_11277_1842# VDD VDD sg13_lv_pmos ad=0.3808p pd=2.92u as=0.2128p ps=1.5u w=1.12u l=0.13u
X479 VDD a_8997_1842# a_9465_1044# VDD sg13_lv_pmos ad=0.252p pd=1.57u as=0.3808p ps=2.92u w=1.12u l=0.13u
X480 a_27433_1842# a_27237_1842# VSS.t198 VSS.t411 sg13_lv_nmos ad=0.2516p pd=2.16u as=0.1406p ps=1.12u w=0.74u l=0.13u
X481 a_2391_331# MUX_SEL2 a_2297_331# VSS.t382 sg13_lv_nmos ad=0.1216p pd=1.02u as=0.2176p ps=1.96u w=0.64u l=0.13u
X482 a_2967_331# MUX_SEL3 a_2873_331# VSS.t554 sg13_lv_nmos ad=0.1216p pd=1.02u as=0.2176p ps=1.96u w=0.64u l=0.13u
X483 VDD a_2019_1047.t5 a_16484_1008# VDD sg13_lv_pmos ad=0.3808p pd=2.92u as=0.3808p ps=2.92u w=1.12u l=0.13u
X484 a_7390_1044# a_2595_1047.t8 a_8155_1044# VSS.t47 sg13_lv_nmos ad=0.2516p pd=2.16u as=0.1406p ps=1.12u w=0.74u l=0.13u
X485 VSS.t436 DELAY_VBIASN.t27 a_7151_1842# VSS.t435 sg13_lv_nmos ad=0.2516p pd=2.16u as=0.1406p ps=1.12u w=0.74u l=0.6u
X486 VDD a_3171_1047.t9 a_5844_1008# VDD sg13_lv_pmos ad=0.3808p pd=2.92u as=0.3808p ps=2.92u w=1.12u l=0.13u
X487 VDD DELAY_VBIASP.t3 a_25391_2470# VDD sg13_lv_pmos ad=0.3808p pd=2.92u as=0.2128p ps=1.5u w=1.12u l=0.6u
X488 VDD a_2595_1047.t7 a_11271_1008# VDD sg13_lv_pmos ad=0.3808p pd=2.92u as=0.3808p ps=2.92u w=1.12u l=0.13u
X489 VDD VSS.t587 VDD VDD sg13_lv_pmos ad=0.19p pd=1.38u as=0 ps=0 w=1u l=1u
X490 VSS.t104 a_12037_1842# a_12505_1044# VSS.t103 sg13_lv_nmos ad=0.1665p pd=1.19u as=0.2516p ps=2.16u w=0.74u l=0.13u
X491 VDD a_3747_1047.t8 a_9751_1008# VDD sg13_lv_pmos ad=0.3808p pd=2.92u as=0.3808p ps=2.92u w=1.12u l=0.13u
X492 a_9431_1842# a_9193_1842# a_9323_1842# VSS.t507 sg13_lv_nmos ad=0.1406p pd=1.12u as=0.2516p ps=2.16u w=0.74u l=0.2u
X493 a_18313_1842# a_18117_1842# VSS.t57 VSS.t56 sg13_lv_nmos ad=0.2516p pd=2.16u as=0.1406p ps=1.12u w=0.74u l=0.13u
X494 MUX_OUT a_16851_309# VSS.t98 VSS.t97 sg13_lv_nmos ad=0.1406p pd=1.12u as=0.1371p ps=1.12u w=0.74u l=0.13u
X495 VSS.t347 VDD VSS.t345 VSS.t346 sg13_lv_nmos ad=79.8f pd=0.8u as=0 ps=0 w=0.42u l=1u
X496 a_23871_1842# a_23633_1842# a_23763_1842# VSS.t180 sg13_lv_nmos ad=0.1406p pd=1.12u as=0.2516p ps=2.16u w=0.74u l=0.2u
X497 a_8433_1842# a_8237_1842# VSS.t480 VSS.t479 sg13_lv_nmos ad=0.2516p pd=2.16u as=0.1406p ps=1.12u w=0.74u l=0.13u
X498 VSS.t211 a_18443_1842# a_18877_1842# VSS.t560 sg13_lv_nmos ad=0.1406p pd=1.12u as=0.2516p ps=2.16u w=0.74u l=0.13u
X499 VSS.t312 VDD VSS.t310 VSS.t311 sg13_lv_nmos ad=79.8f pd=0.8u as=0 ps=0 w=0.42u l=1u
X500 a_22113_1842# a_21917_1842# VSS.t262 VSS.t396 sg13_lv_nmos ad=0.2516p pd=2.16u as=0.1406p ps=1.12u w=0.74u l=0.13u
X501 a_1544_289# MUX_SEL3 VDD VDD sg13_lv_pmos ad=0.3808p pd=2.92u as=0.3808p ps=2.92u w=1.12u l=0.13u
X502 a_26673_1842# a_26477_1842# VDD VDD sg13_lv_pmos ad=0.3808p pd=2.92u as=0.2128p ps=1.5u w=1.12u l=0.13u
X503 a_10328_1044# a_9757_1842# VSS.t69 VSS.t68 sg13_lv_nmos ad=0.1406p pd=1.12u as=0.2516p ps=2.16u w=0.74u l=0.13u
X504 VSS.t315 VDD VSS.t314 VSS.t313 sg13_lv_nmos ad=0.1428p pd=1.52u as=0 ps=0 w=0.42u l=1u
X505 a_22590_1044# a_2019_1047.t3 a_22488_1044# VSS.t521 sg13_lv_nmos ad=0.2516p pd=2.16u as=0.1406p ps=1.12u w=0.74u l=0.13u
X506 VSS.t416 DELAY_VBIASN.t20 a_12471_1842# VSS.t415 sg13_lv_nmos ad=0.2516p pd=2.16u as=0.1406p ps=1.12u w=0.74u l=0.6u
X507 a_8808_1044# a_8237_1842# VSS.t482 VSS.t481 sg13_lv_nmos ad=0.1406p pd=1.12u as=0.2516p ps=2.16u w=0.74u l=0.13u
X508 VSS.t63 a_22243_1842# a_22677_1842# VSS.t62 sg13_lv_nmos ad=0.1406p pd=1.12u as=0.2516p ps=2.16u w=0.74u l=0.13u
X509 VDD DELAY_VBIASP.t28 a_6391_2470# VDD sg13_lv_pmos ad=0.3808p pd=2.92u as=0.2128p ps=1.5u w=1.12u l=0.6u
X510 a_13470_1044# a_15831_1008# a_15755_1044# VDD sg13_lv_pmos ad=0.3808p pd=2.92u as=0.2128p ps=1.5u w=1.12u l=0.13u
X511 a_1544_1044# MUX_SEL1 VDD VDD sg13_lv_pmos ad=0.3808p pd=2.92u as=0.3808p ps=2.92u w=1.12u l=0.13u
X512 VDD DELAY_VBIASP.t9 a_20831_2470# VDD sg13_lv_pmos ad=0.3808p pd=2.92u as=0.2128p ps=1.5u w=1.12u l=0.6u
X513 VDD a_2595_1047.t2 a_26471_1008# VDD sg13_lv_pmos ad=0.3808p pd=2.92u as=0.3808p ps=2.92u w=1.12u l=0.13u
X514 a_4350_1044# a_5191_1008# a_5115_1044# VDD sg13_lv_pmos ad=0.3808p pd=2.92u as=0.2128p ps=1.5u w=1.12u l=0.13u
X515 VDD a_16597_1842# a_17065_1044# VDD sg13_lv_pmos ad=0.252p pd=1.57u as=0.3808p ps=2.92u w=1.12u l=0.13u
X516 VSS.t224 a_27237_1842# a_27705_1044# VSS.t410 sg13_lv_nmos ad=0.1665p pd=1.19u as=0.2516p ps=2.16u w=0.74u l=0.13u
X517 a_10191_2470# a_9953_1842# a_10083_1842# VDD sg13_lv_pmos ad=0.2128p pd=1.5u as=0.3808p ps=2.92u w=1.12u l=0.2u
X518 a_2595_1047.t1 a_2297_1395# VSS.t130 VSS.t129 sg13_lv_nmos ad=0.1406p pd=1.12u as=0.1331p ps=1.12u w=0.74u l=0.13u
X519 a_26151_1842# a_25913_1842# a_26043_1842# VSS.t213 sg13_lv_nmos ad=0.1406p pd=1.12u as=0.2516p ps=2.16u w=0.74u l=0.2u
X520 VSS.t392 a_2019_311# a_17865_519# VSS.t391 sg13_lv_nmos ad=0.2516p pd=2.16u as=0.2516p ps=2.16u w=0.74u l=0.13u
X521 VSS.t37 a_1544_289# a_2391_331# VSS.t561 sg13_lv_nmos ad=0.1331p pd=1.12u as=0.1216p ps=1.02u w=0.64u l=0.13u
X522 a_4871_1842# a_4633_1842# a_4763_1842# VSS.t169 sg13_lv_nmos ad=0.1406p pd=1.12u as=0.2516p ps=2.16u w=0.74u l=0.2u
X523 a_13753_1842# a_13557_1842# VSS.t165 VSS.t258 sg13_lv_nmos ad=0.2516p pd=2.16u as=0.1406p ps=1.12u w=0.74u l=0.13u
X524 a_1815_1395# a_1256_1044# a_1721_1395# VSS.t155 sg13_lv_nmos ad=0.1216p pd=1.02u as=0.2176p ps=1.96u w=0.64u l=0.13u
X525 a_7673_1842# a_7477_1842# VDD VDD sg13_lv_pmos ad=0.3808p pd=2.92u as=0.2128p ps=1.5u w=1.12u l=0.13u
X526 VDD VSS.t580 VDD VDD sg13_lv_pmos ad=0.34p pd=2.68u as=0 ps=0 w=1u l=1u
X527 a_1721_331# a_1256_289# VDD VDD sg13_lv_pmos ad=0.1596p pd=1.22u as=0.2856p ps=2.36u w=0.84u l=0.13u
X528 VSS.t172 a_24523_1842# a_24957_1842# VSS.t171 sg13_lv_nmos ad=0.1406p pd=1.12u as=0.2516p ps=2.16u w=0.74u l=0.13u
X529 a_6635_1044# a_6425_1044# VSS.t159 VSS.t158 sg13_lv_nmos ad=0.1406p pd=1.12u as=0.1665p ps=1.19u w=0.74u l=0.13u
X530 VSS.t110 a_2595_1047.t9 a_5191_1008# VSS.t109 sg13_lv_nmos ad=0.2516p pd=2.16u as=0.2516p ps=2.16u w=0.74u l=0.13u
X531 a_20315_1044# a_20105_1044# VSS.t183 VSS.t538 sg13_lv_nmos ad=0.1406p pd=1.12u as=0.1665p ps=1.19u w=0.74u l=0.13u
X532 VDD DELAY_VBIASP.t21 a_11711_2470# VDD sg13_lv_pmos ad=0.3808p pd=2.92u as=0.2128p ps=1.5u w=1.12u l=0.6u
X533 a_18795_1044# a_18585_1044# VDD VDD sg13_lv_pmos ad=0.2128p pd=1.5u as=0.252p ps=1.57u w=1.12u l=0.13u
X534 a_25528_1044# a_24957_1842# VSS.t195 VSS.t194 sg13_lv_nmos ad=0.1406p pd=1.12u as=0.2516p ps=2.16u w=0.74u l=0.13u
X535 VSS.t466 DELAY_VBIASN.t0 a_27671_1842# VSS.t465 sg13_lv_nmos ad=0.2516p pd=2.16u as=0.1406p ps=1.12u w=0.74u l=0.6u
X536 a_5731_289# a_3747_311.t3 a_13470_1044# VSS.t72 sg13_lv_nmos ad=0.2516p pd=2.16u as=0.2516p ps=2.16u w=0.74u l=0.13u
X537 a_25630_1044# a_27124_1008# a_27048_1044# VDD sg13_lv_pmos ad=0.3808p pd=2.92u as=0.2128p ps=1.5u w=1.12u l=0.13u
X538 VDD a_2595_1047.t5 a_17351_1008# VDD sg13_lv_pmos ad=0.3808p pd=2.92u as=0.3808p ps=2.92u w=1.12u l=0.13u
X539 VDD a_21483_1842# a_21917_1842# VDD sg13_lv_pmos ad=0.2128p pd=1.5u as=0.3808p ps=2.92u w=1.12u l=0.13u
X540 a_4350_1044# a_5844_1008# a_5768_1044# VDD sg13_lv_pmos ad=0.3808p pd=2.92u as=0.2128p ps=1.5u w=1.12u l=0.13u
X541 VSS.t100 a_16851_309# MUX_OUT VSS.t99 sg13_lv_nmos ad=0.2516p pd=2.16u as=0.1406p ps=1.12u w=0.74u l=0.13u
X542 VSS.t389 a_2019_311# a_5705_519# VSS.t388 sg13_lv_nmos ad=0.2516p pd=2.16u as=0.2516p ps=2.16u w=0.74u l=0.13u
X543 VDD a_1544_289# a_1721_331# VDD sg13_lv_pmos ad=0.1918p pd=1.5u as=0.1596p ps=1.22u w=0.84u l=0.13u
X544 a_7151_1842# a_6913_1842# a_7043_1842# VSS.t13 sg13_lv_nmos ad=0.1406p pd=1.12u as=0.2516p ps=2.16u w=0.74u l=0.2u
X545 a_16033_1842# a_15837_1842# VSS.t514 VSS.t546 sg13_lv_nmos ad=0.2516p pd=2.16u as=0.1406p ps=1.12u w=0.74u l=0.13u
X546 MUX_OUT a_16851_309# VDD VDD sg13_lv_pmos ad=0.2128p pd=1.5u as=0.2086p ps=1.5u w=1.12u l=0.13u
X547 a_25391_2470# a_25153_1842# a_25283_1842# VDD sg13_lv_pmos ad=0.2128p pd=1.5u as=0.3808p ps=2.92u w=1.12u l=0.2u
X548 VDD VSS.t592 VDD VDD sg13_lv_pmos ad=0.34p pd=2.68u as=0 ps=0 w=1u l=1u
X549 a_12993_1842# a_12797_1842# VDD VDD sg13_lv_pmos ad=0.3808p pd=2.92u as=0.2128p ps=1.5u w=1.12u l=0.13u
X550 a_16408_1044# a_15837_1842# VSS.t545 VSS.t544 sg13_lv_nmos ad=0.1406p pd=1.12u as=0.2516p ps=2.16u w=0.74u l=0.13u
X551 VSS.t190 a_5523_1842# a_5957_1842# VSS.t189 sg13_lv_nmos ad=0.1406p pd=1.12u as=0.2516p ps=2.16u w=0.74u l=0.13u
X552 VDD DELAY_VBIASP.t18 a_13991_2470# VDD sg13_lv_pmos ad=0.3808p pd=2.92u as=0.2128p ps=1.5u w=1.12u l=0.6u
X553 a_5731_289# a_2019_311# a_4350_1044# VSS.t387 sg13_lv_nmos ad=0.2516p pd=2.16u as=0.2516p ps=2.16u w=0.74u l=0.13u
X554 a_7390_1044# a_3747_1047.t8 a_9675_1044# VSS.t239 sg13_lv_nmos ad=0.2516p pd=2.16u as=0.1406p ps=1.12u w=0.74u l=0.13u
X555 VDD a_23763_1842# a_24197_1842# VDD sg13_lv_pmos ad=0.2128p pd=1.5u as=0.3808p ps=2.92u w=1.12u l=0.13u
X556 VSS.t426 DELAY_VBIASN.t25 a_8671_1842# VSS.t425 sg13_lv_nmos ad=0.2516p pd=2.16u as=0.1406p ps=1.12u w=0.74u l=0.6u
X557 VDD a_2019_1047.t8 a_7364_1008# VDD sg13_lv_pmos ad=0.3808p pd=2.92u as=0.3808p ps=2.92u w=1.12u l=0.13u
X558 VDD DELAY_VBIASP.t1 a_26911_2470# VDD sg13_lv_pmos ad=0.3808p pd=2.92u as=0.2128p ps=1.5u w=1.12u l=0.6u
X559 VDD VSS.t563 VDD VDD sg13_lv_pmos ad=0.19p pd=1.38u as=0 ps=0 w=1u l=1u
X560 a_12471_1842# a_12233_1842# a_12363_1842# VSS.t58 sg13_lv_nmos ad=0.1406p pd=1.12u as=0.2516p ps=2.16u w=0.74u l=0.2u
X561 a_22488_1044# a_21917_1842# VDD VDD sg13_lv_pmos ad=0.2128p pd=1.5u as=0.3808p ps=2.92u w=1.12u l=0.13u
X562 VDD a_2595_311.t3 a_8745_519# VDD sg13_lv_pmos ad=0.3808p pd=2.92u as=0.3808p ps=2.92u w=1.12u l=0.13u
X563 VSS.t250 a_3171_1047.t5 a_18004_1008# VSS.t249 sg13_lv_nmos ad=0.2516p pd=2.16u as=0.2516p ps=2.16u w=0.74u l=0.13u
X564 a_6391_2470# a_6153_1842# a_6283_1842# VDD sg13_lv_pmos ad=0.2128p pd=1.5u as=0.3808p ps=2.92u w=1.12u l=0.2u
X565 a_15273_1842# a_15077_1842# VDD VDD sg13_lv_pmos ad=0.3808p pd=2.92u as=0.2128p ps=1.5u w=1.12u l=0.13u
X566 a_14235_1044# a_14025_1044# VSS.t230 VSS.t229 sg13_lv_nmos ad=0.1406p pd=1.12u as=0.1665p ps=1.19u w=0.74u l=0.13u
X567 VSS.t128 a_3747_1047.t7 a_12791_1008# VSS.t127 sg13_lv_nmos ad=0.2516p pd=2.16u as=0.2516p ps=2.16u w=0.74u l=0.13u
X568 a_9953_1842# a_9757_1842# VSS.t71 VSS.t70 sg13_lv_nmos ad=0.2516p pd=2.16u as=0.1406p ps=1.12u w=0.74u l=0.13u
X569 VSS.t490 a_10843_1842# a_11277_1842# VSS.t495 sg13_lv_nmos ad=0.1406p pd=1.12u as=0.2516p ps=2.16u w=0.74u l=0.13u
X570 VSS.t345 VDD VSS.t344 VSS.t343 sg13_lv_nmos ad=0.1428p pd=1.52u as=0 ps=0 w=0.42u l=1u
X571 VDD a_15403_1842# a_15837_1842# VDD sg13_lv_pmos ad=0.2128p pd=1.5u as=0.3808p ps=2.92u w=1.12u l=0.13u
X572 VSS.t310 VDD VSS.t309 VSS.t308 sg13_lv_nmos ad=0.1428p pd=1.52u as=0 ps=0 w=0.42u l=1u
X573 a_11848_1044# a_11277_1842# VSS.t492 VSS.t491 sg13_lv_nmos ad=0.1406p pd=1.12u as=0.2516p ps=2.16u w=0.74u l=0.13u
X574 VDD a_4763_1842# a_5197_1842# VDD sg13_lv_pmos ad=0.2128p pd=1.5u as=0.3808p ps=2.92u w=1.12u l=0.13u
X575 VSS.t322 VDD VSS.t320 VSS.t321 sg13_lv_nmos ad=79.8f pd=0.8u as=0 ps=0 w=0.42u l=1u
X576 a_13470_1044# a_13444_1008# a_13368_1044# VDD sg13_lv_pmos ad=0.3808p pd=2.92u as=0.2128p ps=1.5u w=1.12u l=0.13u
X577 VDD a_3449_1395# a_3747_1047.t0 VDD sg13_lv_pmos ad=0.4256p pd=3u as=0.2128p ps=1.5u w=1.12u l=0.13u
X578 VDD a_3171_1047.t3 a_24084_1008# VDD sg13_lv_pmos ad=0.3808p pd=2.92u as=0.3808p ps=2.92u w=1.12u l=0.13u
X579 a_3449_1395# MUX_SEL0 VDD VDD sg13_lv_pmos ad=0.1596p pd=1.22u as=0.2856p ps=2.36u w=0.84u l=0.13u
X580 VDD DELAY_VBIASP.t26 a_7911_2470# VDD sg13_lv_pmos ad=0.3808p pd=2.92u as=0.2128p ps=1.5u w=1.12u l=0.6u
X581 VDD VSS.t595 VDD VDD sg13_lv_pmos ad=0.19p pd=1.38u as=0 ps=0 w=1u l=1u
X582 VDD VSS.t594 VDD VDD sg13_lv_pmos ad=0.34p pd=2.68u as=0 ps=0 w=1u l=1u
X583 VDD a_16851_309# MUX_OUT VDD sg13_lv_pmos ad=0.7336p pd=3.55u as=0.2128p ps=1.5u w=1.12u l=0.13u
X584 VSS.t35 a_3171_311.t2 a_23945_519# VSS.t34 sg13_lv_nmos ad=0.2516p pd=2.16u as=0.2516p ps=2.16u w=0.74u l=0.13u
X585 VDD a_18117_1842# a_18585_1044# VDD sg13_lv_pmos ad=0.252p pd=1.57u as=0.3808p ps=2.92u w=1.12u l=0.13u
X586 VSS.t183 a_19637_1842# a_20105_1044# VSS.t182 sg13_lv_nmos ad=0.1665p pd=1.19u as=0.2516p ps=2.16u w=0.74u l=0.13u
X587 a_11711_2470# a_11473_1842# a_11603_1842# VDD sg13_lv_pmos ad=0.2128p pd=1.5u as=0.3808p ps=2.92u w=1.12u l=0.2u
X588 a_27671_1842# a_27433_1842# a_27563_1842# VSS.t403 sg13_lv_nmos ad=0.1406p pd=1.12u as=0.2516p ps=2.16u w=0.74u l=0.2u
X589 VSS.t179 MUX_SEL4 a_15765_463# VSS.t178 sg13_lv_nmos ad=0.2516p pd=2.16u as=0.2516p ps=2.16u w=0.74u l=0.13u
X590 a_5731_289# a_14825_519# a_13470_1044# VDD sg13_lv_pmos ad=0.3808p pd=2.92u as=0.3808p ps=2.92u w=1.12u l=0.13u
X591 a_16510_1044# a_2595_1047.t5 a_17275_1044# VSS.t44 sg13_lv_nmos ad=0.2516p pd=2.16u as=0.1406p ps=1.12u w=0.74u l=0.13u
X592 VSS.t458 DELAY_VBIASN.t15 a_16271_1842# VSS.t457 sg13_lv_nmos ad=0.2516p pd=2.16u as=0.1406p ps=1.12u w=0.74u l=0.6u
X593 VDD VSS.t568 VDD VDD sg13_lv_pmos ad=0.34p pd=2.68u as=0 ps=0 w=1u l=1u
X594 VDD a_3171_1047.t6 a_14964_1008# VDD sg13_lv_pmos ad=0.3808p pd=2.92u as=0.3808p ps=2.92u w=1.12u l=0.13u
X595 VDD a_10083_1842# a_10517_1842# VDD sg13_lv_pmos ad=0.2128p pd=1.5u as=0.3808p ps=2.92u w=1.12u l=0.13u
X596 VSS.t125 a_3747_1047.t2 a_27991_1008# VSS.t124 sg13_lv_nmos ad=0.2516p pd=2.16u as=0.2516p ps=2.16u w=0.74u l=0.13u
X597 VSS.t504 a_26043_1842# a_26477_1842# VSS.t543 sg13_lv_nmos ad=0.1406p pd=1.12u as=0.2516p ps=2.16u w=0.74u l=0.13u
X598 a_11195_1044# a_10985_1044# VDD VDD sg13_lv_pmos ad=0.2128p pd=1.5u as=0.252p ps=1.57u w=1.12u l=0.13u
X599 VSS.t23 a_3747_1047.t9 a_6711_1008# VSS.t22 sg13_lv_nmos ad=0.2516p pd=2.16u as=0.2516p ps=2.16u w=0.74u l=0.13u
X600 a_16108_289# a_2595_311.t2 a_19550_1044# VSS.t245 sg13_lv_nmos ad=0.2516p pd=2.16u as=0.2516p ps=2.16u w=0.74u l=0.13u
X601 VSS.t464 DELAY_VBIASN.t10 a_20071_1842# VSS.t463 sg13_lv_nmos ad=0.2516p pd=2.16u as=0.1406p ps=1.12u w=0.74u l=0.6u
X602 VDD DELAY_VBIASP.t4 a_24631_2470# VDD sg13_lv_pmos ad=0.3808p pd=2.92u as=0.2128p ps=1.5u w=1.12u l=0.6u
X603 a_22590_1044# a_23431_1008# a_23355_1044# VDD sg13_lv_pmos ad=0.3808p pd=2.92u as=0.2128p ps=1.5u w=1.12u l=0.13u
X604 VSS.t302 VDD VSS.t300 VSS.t301 sg13_lv_nmos ad=79.8f pd=0.8u as=0 ps=0 w=0.42u l=1u
X605 a_8671_1842# a_8433_1842# a_8563_1842# VSS.t196 sg13_lv_nmos ad=0.1406p pd=1.12u as=0.2516p ps=2.16u w=0.74u l=0.2u
X606 a_17553_1842# a_17357_1842# VSS.t67 VSS.t402 sg13_lv_nmos ad=0.2516p pd=2.16u as=0.1406p ps=1.12u w=0.74u l=0.13u
X607 a_5731_289# a_5705_519# a_4350_1044# VDD sg13_lv_pmos ad=0.3808p pd=2.92u as=0.3808p ps=2.92u w=1.12u l=0.13u
X608 VDD VDD VDD VDD sg13_lv_pmos ad=0.3808p pd=2.92u as=0 ps=0 w=1.12u l=0.13u
X609 a_26911_2470# a_26673_1842# a_26803_1842# VDD sg13_lv_pmos ad=0.2128p pd=1.5u as=0.3808p ps=2.92u w=1.12u l=0.2u
X610 a_7390_1044# a_2019_1047.t8 a_7288_1044# VSS.t510 sg13_lv_nmos ad=0.2516p pd=2.16u as=0.1406p ps=1.12u w=0.74u l=0.13u
X611 a_21353_1842# a_21157_1842# VSS.t200 VSS.t199 sg13_lv_nmos ad=0.2516p pd=2.16u as=0.1406p ps=1.12u w=0.74u l=0.13u
X612 VSS.t385 a_7043_1842# a_7477_1842# VSS.t384 sg13_lv_nmos ad=0.1406p pd=1.12u as=0.2516p ps=2.16u w=0.74u l=0.13u
X613 VDD DELAY_VBIASP.t16 a_15511_2470# VDD sg13_lv_pmos ad=0.3808p pd=2.92u as=0.2128p ps=1.5u w=1.12u l=0.6u
X614 VDD a_2019_1047.t7 a_10404_1008# VDD sg13_lv_pmos ad=0.3808p pd=2.92u as=0.3808p ps=2.92u w=1.12u l=0.13u
X615 VDD a_25283_1842# a_25717_1842# VDD sg13_lv_pmos ad=0.2128p pd=1.5u as=0.3808p ps=2.92u w=1.12u l=0.13u
X616 VDD DELAY_VBIASP.t29 a_5631_2470# VDD sg13_lv_pmos ad=0.3808p pd=2.92u as=0.2128p ps=1.5u w=1.12u l=0.6u
X617 a_26395_1044# a_26185_1044# VDD VDD sg13_lv_pmos ad=0.2128p pd=1.5u as=0.252p ps=1.57u w=1.12u l=0.13u
X618 VDD a_3747_1047.t3 a_24951_1008# VDD sg13_lv_pmos ad=0.3808p pd=2.92u as=0.3808p ps=2.92u w=1.12u l=0.13u
X619 VDD VSS.t571 VDD VDD sg13_lv_pmos ad=0.19p pd=1.38u as=0 ps=0 w=1u l=1u
X620 a_13991_1842# a_13753_1842# a_13883_1842# VSS.t259 sg13_lv_nmos ad=0.1406p pd=1.12u as=0.2516p ps=2.16u w=0.74u l=0.2u
X621 a_24008_1044# a_23437_1842# VDD VDD sg13_lv_pmos ad=0.2128p pd=1.5u as=0.3808p ps=2.92u w=1.12u l=0.13u
X622 VDD VSS.t585 VDD VDD sg13_lv_pmos ad=0.19p pd=1.38u as=0 ps=0 w=1u l=1u
X623 VSS.t526 a_2019_1047.t4 a_19524_1008# VSS.t525 sg13_lv_nmos ad=0.2516p pd=2.16u as=0.2516p ps=2.16u w=0.74u l=0.13u
X624 a_7911_2470# a_7673_1842# a_7803_1842# VDD sg13_lv_pmos ad=0.2128p pd=1.5u as=0.3808p ps=2.92u w=1.12u l=0.2u
X625 a_16793_1842# a_16597_1842# VDD VDD sg13_lv_pmos ad=0.3808p pd=2.92u as=0.2128p ps=1.5u w=1.12u l=0.13u
X626 VSS.t1 MUX_SEL1 a_3543_1395# VSS.t499 sg13_lv_nmos ad=0.1331p pd=1.12u as=0.1216p ps=1.02u w=0.64u l=0.13u
X627 a_15755_1044# a_15545_1044# VSS.t379 VSS.t533 sg13_lv_nmos ad=0.1406p pd=1.12u as=0.1665p ps=1.19u w=0.74u l=0.13u
X628 a_2595_1047.t0 a_2297_1395# VDD VDD sg13_lv_pmos ad=0.2128p pd=1.5u as=0.1918p ps=1.5u w=1.12u l=0.13u
X629 VSS.t29 a_2595_1047.t6 a_14311_1008# VSS.t28 sg13_lv_nmos ad=0.2516p pd=2.16u as=0.2516p ps=2.16u w=0.74u l=0.13u
X630 VSS.t405 a_12363_1842# a_12797_1842# VSS.t506 sg13_lv_nmos ad=0.1406p pd=1.12u as=0.2516p ps=2.16u w=0.74u l=0.13u
X631 a_5115_1044# a_4905_1044# VSS.t134 VSS.t133 sg13_lv_nmos ad=0.1406p pd=1.12u as=0.1665p ps=1.19u w=0.74u l=0.13u
X632 a_1256_1044# MUX_SEL0 VDD VDD sg13_lv_pmos ad=0.3808p pd=2.92u as=0.3808p ps=2.92u w=1.12u l=0.13u
X633 VDD a_27563_1842# a_27997_1842# VDD sg13_lv_pmos ad=0.2128p pd=1.5u as=0.3808p ps=2.92u w=1.12u l=0.13u
X634 a_20593_1842# a_20397_1842# VDD VDD sg13_lv_pmos ad=0.3808p pd=2.92u as=0.2128p ps=1.5u w=1.12u l=0.13u
X635 a_1721_1395# a_1256_1044# VDD VDD sg13_lv_pmos ad=0.1596p pd=1.22u as=0.2856p ps=2.36u w=0.84u l=0.13u
X636 VDD a_6283_1842# a_6717_1842# VDD sg13_lv_pmos ad=0.2128p pd=1.5u as=0.3808p ps=2.92u w=1.12u l=0.13u
X637 a_13470_1044# a_14964_1008# a_14888_1044# VDD sg13_lv_pmos ad=0.3808p pd=2.92u as=0.2128p ps=1.5u w=1.12u l=0.13u
X638 VSS.t320 VDD VSS.t319 VSS.t318 sg13_lv_nmos ad=0.1428p pd=1.52u as=0 ps=0 w=0.42u l=1u
X639 VDD a_2019_1047.t2 a_25604_1008# VDD sg13_lv_pmos ad=0.3808p pd=2.92u as=0.3808p ps=2.92u w=1.12u l=0.13u
X640 a_16271_1842# a_16033_1842# a_16163_1842# VSS.t559 sg13_lv_nmos ad=0.1406p pd=1.12u as=0.2516p ps=2.16u w=0.74u l=0.2u
X641 a_21835_1044# a_21625_1044# VDD VDD sg13_lv_pmos ad=0.2128p pd=1.5u as=0.252p ps=1.57u w=1.12u l=0.13u
X642 VDD VSS.t596 VDD VDD sg13_lv_pmos ad=0.34p pd=2.68u as=0 ps=0 w=1u l=1u
X643 VDD a_2595_1047.t4 a_20391_1008# VDD sg13_lv_pmos ad=0.3808p pd=2.92u as=0.3808p ps=2.92u w=1.12u l=0.13u
X644 a_19073_1842# a_18877_1842# VDD VDD sg13_lv_pmos ad=0.3808p pd=2.92u as=0.2128p ps=1.5u w=1.12u l=0.13u
X645 VDD a_10517_1842# a_10985_1044# VDD sg13_lv_pmos ad=0.252p pd=1.57u as=0.3808p ps=2.92u w=1.12u l=0.13u
X646 VSS.t202 a_21157_1842# a_21625_1044# VSS.t201 sg13_lv_nmos ad=0.1665p pd=1.19u as=0.2516p ps=2.16u w=0.74u l=0.13u
X647 a_20071_1842# a_19833_1842# a_19963_1842# VSS.t184 sg13_lv_nmos ad=0.1406p pd=1.12u as=0.2516p ps=2.16u w=0.74u l=0.2u
X648 VSS.t96 a_14643_1842# a_15077_1842# VSS.t95 sg13_lv_nmos ad=0.1406p pd=1.12u as=0.2516p ps=2.16u w=0.74u l=0.13u
X649 a_1815_331# a_1256_289# a_1721_331# VSS.t161 sg13_lv_nmos ad=0.1216p pd=1.02u as=0.2176p ps=1.96u w=0.64u l=0.13u
X650 VDD a_19203_1842# a_19637_1842# VDD sg13_lv_pmos ad=0.2128p pd=1.5u as=0.3808p ps=2.92u w=1.12u l=0.13u
X651 VSS.t238 a_2019_1047.t9 a_4324_1008# VSS.t237 sg13_lv_nmos ad=0.2516p pd=2.16u as=0.2516p ps=2.16u w=0.74u l=0.13u
X652 a_16108_289# a_20905_519# a_19550_1044# VDD sg13_lv_pmos ad=0.3808p pd=2.92u as=0.3808p ps=2.92u w=1.12u l=0.13u
X653 a_16510_1044# a_3747_1047.t5 a_18795_1044# VSS.t214 sg13_lv_nmos ad=0.2516p pd=2.16u as=0.1406p ps=1.12u w=0.74u l=0.13u
X654 VDD a_8563_1842# a_8997_1842# VDD sg13_lv_pmos ad=0.2128p pd=1.5u as=0.3808p ps=2.92u w=1.12u l=0.13u
X655 VDD DELAY_VBIASP.t19 a_13231_2470# VDD sg13_lv_pmos ad=0.3808p pd=2.92u as=0.2128p ps=1.5u w=1.12u l=0.6u
X656 VSS.t444 DELAY_VBIASN.t13 a_17791_1842# VSS.t443 sg13_lv_nmos ad=0.2516p pd=2.16u as=0.1406p ps=1.12u w=0.74u l=0.6u
X657 VSS.t290 VDD VSS.t289 VSS.t288 sg13_lv_nmos ad=0.1428p pd=1.52u as=0 ps=0 w=0.42u l=1u
X658 VDD a_3747_1047.t5 a_18871_1008# VDD sg13_lv_pmos ad=0.3808p pd=2.92u as=0.3808p ps=2.92u w=1.12u l=0.13u
X659 VDD a_23003_1842# a_23437_1842# VDD sg13_lv_pmos ad=0.2128p pd=1.5u as=0.3808p ps=2.92u w=1.12u l=0.13u
X660 a_12715_1044# a_12505_1044# VDD VDD sg13_lv_pmos ad=0.2128p pd=1.5u as=0.252p ps=1.57u w=1.12u l=0.13u
X661 a_19550_1044# a_21044_1008# a_20968_1044# VDD sg13_lv_pmos ad=0.3808p pd=2.92u as=0.2128p ps=1.5u w=1.12u l=0.13u
X662 a_17928_1044# a_17357_1842# VDD VDD sg13_lv_pmos ad=0.2128p pd=1.5u as=0.3808p ps=2.92u w=1.12u l=0.13u
X663 VSS.t424 DELAY_VBIASN.t8 a_21591_1842# VSS.t423 sg13_lv_nmos ad=0.2516p pd=2.16u as=0.1406p ps=1.12u w=0.74u l=0.6u
X664 VSS.t5 a_1544_289# a_1815_331# VSS.t562 sg13_lv_nmos ad=0.1331p pd=1.12u as=0.1216p ps=1.02u w=0.64u l=0.13u
X665 a_7288_1044# a_6717_1842# VDD VDD sg13_lv_pmos ad=0.2128p pd=1.5u as=0.3808p ps=2.92u w=1.12u l=0.13u
X666 a_15511_2470# a_15273_1842# a_15403_1842# VDD sg13_lv_pmos ad=0.2128p pd=1.5u as=0.3808p ps=2.92u w=1.12u l=0.2u
X667 VSS.t372 VSS.t374 VSS.t376 VSS.t375 sg13_lv_nmos ad=0.1406p pd=1.12u as=0 ps=0 w=0.74u l=0.2u
X668 a_22590_1044# a_24951_1008# a_24875_1044# VDD sg13_lv_pmos ad=0.3808p pd=2.92u as=0.2128p ps=1.5u w=1.12u l=0.13u
X669 VSS.t362 VDD VSS.t360 VSS.t361 sg13_lv_nmos ad=79.8f pd=0.8u as=0 ps=0 w=0.42u l=1u
X670 a_10430_1044# a_2019_1047.t7 a_10328_1044# VSS.t105 sg13_lv_nmos ad=0.2516p pd=2.16u as=0.1406p ps=1.12u w=0.74u l=0.13u
X671 VDD a_25717_1842# a_26185_1044# VDD sg13_lv_pmos ad=0.252p pd=1.57u as=0.3808p ps=2.92u w=1.12u l=0.13u
X672 VDD a_13883_1842# a_14317_1842# VDD sg13_lv_pmos ad=0.2128p pd=1.5u as=0.3808p ps=2.92u w=1.12u l=0.13u
X673 VDD a_4437_1842# a_4905_1044# VDD sg13_lv_pmos ad=0.252p pd=1.57u as=0.3808p ps=2.92u w=1.12u l=0.13u
X674 a_4157_1313# DELAY_IN VSS.t271 VSS.t270 sg13_lv_nmos ad=0.2516p pd=2.16u as=0.2553p ps=2.17u w=0.74u l=0.13u
X675 a_7390_1044# a_3171_1047.t8 a_8808_1044# VSS.t251 sg13_lv_nmos ad=0.2516p pd=2.16u as=0.1406p ps=1.12u w=0.74u l=0.13u
X676 a_22873_1842# a_22677_1842# VSS.t63 VSS.t263 sg13_lv_nmos ad=0.2516p pd=2.16u as=0.1406p ps=1.12u w=0.74u l=0.13u
X677 VDD a_3171_1047.t8 a_8884_1008# VDD sg13_lv_pmos ad=0.3808p pd=2.92u as=0.3808p ps=2.92u w=1.12u l=0.13u
C0 DELAY_VBIASP VDD 13.3418f
C1 a_21835_1044# VDD 0.15406f
C2 VDD a_7945_1044# 0.30409f
C3 MUX_SEL4 a_2019_311# 0.90276f
C4 a_8563_1842# a_8671_1842# 0.01163f
C5 a_19550_1044# a_20391_1008# 0.28268f
C6 a_16108_289# a_15964_289# 0.42202f
C7 a_27048_1044# VDD 0.17499f
C8 DELAY_VBIASP a_6283_1842# 0.06627f
C9 DELAY_VBIASN a_6153_1842# 0.0961f
C10 a_20397_1842# a_20723_1842# 0.01427f
C11 a_17065_1044# a_17351_1008# 0.01885f
C12 a_12797_1842# a_12993_1842# 0.76914f
C13 a_22590_1044# a_24008_1044# 0.38994f
C14 a_8884_1008# a_8997_1842# 0.02055f
C15 a_15765_463# a_5731_289# 0.23301f
C16 a_19963_1842# a_20071_1842# 0.01163f
C17 DELAY_VBIASP a_15077_1842# 0.04141f
C18 a_15837_1842# a_16033_1842# 0.76914f
C19 DELAY_VBIASN a_13883_1842# 0.07254f
C20 DELAY_VBIASP a_24197_1842# 0.04141f
C21 DELAY_VBIASN a_23003_1842# 0.07254f
C22 a_1256_1044# a_1721_1395# 0.13421f
C23 DELAY_VBIASN a_7477_1842# 0.08375f
C24 a_9953_1842# a_10083_1842# 0.70845f
C25 a_25528_1044# a_25630_1044# 0.37183f
C26 DELAY_VBIASP a_7673_1842# 0.11222f
C27 DELAY_VBIASP a_20397_1842# 0.0414f
C28 DELAY_VBIASN a_19203_1842# 0.07254f
C29 a_27237_1842# a_27433_1842# 0.77122f
C30 a_2019_311# a_1721_331# 0.18452f
C31 a_13470_1044# a_15831_1008# 0.26208f
C32 a_21625_1044# a_19550_1044# 0.03208f
C33 a_25604_1008# a_24957_1842# 0.02011f
C34 VDD a_23763_1842# 0.49671f
C35 a_8237_1842# VDD 0.86909f
C36 VDD a_19963_1842# 0.4973f
C37 a_4437_1842# a_4350_1044# 0.1088f
C38 a_17357_1842# a_16597_1842# 0.01669f
C39 a_5197_1842# VDD 0.86909f
C40 a_18313_1842# a_18443_1842# 0.70845f
C41 VDD a_8671_2470# 0.01806f
C42 a_19524_1008# a_19637_1842# 0.05157f
C43 a_14025_1044# VDD 0.30409f
C44 a_27671_1842# a_27563_1842# 0.01163f
C45 VDD a_12993_1842# 0.49426f
C46 a_16271_2470# a_16163_1842# 0.01697f
C47 a_22488_1044# a_21917_1842# 0.10864f
C48 a_5957_1842# a_5523_1842# 0.6972f
C49 a_12797_1842# a_13444_1008# 0.02011f
C50 a_17357_1842# a_17683_1842# 0.01427f
C51 a_10713_1842# a_11277_1842# 0.0114f
C52 a_5731_289# a_13470_1044# 0.41365f
C53 a_21625_1044# a_21157_1842# 0.2079f
C54 a_6635_1044# a_4350_1044# 0.39036f
C55 VDD a_11785_519# 0.29292f
C56 VDD a_2873_331# 0.46491f
C57 a_24197_1842# a_23763_1842# 0.6972f
C58 DELAY_VBIASP a_25283_1842# 0.06627f
C59 DELAY_VBIASN a_25153_1842# 0.0961f
C60 a_16851_309# a_2019_311# 0.01299f
C61 MUX_SEL1 a_1256_1044# 1.44243f
C62 a_10083_1842# DELAY_VBIASN 0.07254f
C63 MUX_SEL0 a_1544_1044# 0.07603f
C64 a_7673_1842# a_8237_1842# 0.0114f
C65 a_4350_1044# a_2019_311# 0.02042f
C66 a_16108_289# a_21917_1842# 0.0157f
C67 a_12797_1842# a_12791_1008# 0.02354f
C68 a_20397_1842# a_19963_1842# 0.6972f
C69 a_14751_2470# a_14643_1842# 0.01697f
C70 a_16510_1044# a_18443_1842# 0.01012f
C71 DELAY_VBIASP a_15837_1842# 0.0414f
C72 a_9757_1842# a_9751_1008# 0.02354f
C73 DELAY_VBIASN a_14643_1842# 0.07254f
C74 a_2297_1395# a_1256_1044# 0.04619f
C75 a_2019_311# a_5731_289# 1.15781f
C76 DELAY_VBIASN a_18443_1842# 0.07254f
C77 a_13753_1842# a_14317_1842# 0.0114f
C78 VDD a_23111_2470# 0.01806f
C79 a_12233_1842# a_12363_1842# 0.70845f
C80 a_25630_1044# a_27991_1008# 0.26208f
C81 a_25913_1842# VDD 0.49294f
C82 a_16510_1044# a_16108_289# 0.56108f
C83 a_21917_1842# a_22113_1842# 0.76914f
C84 a_4437_1842# a_4905_1044# 0.19203f
C85 MUX_SEL4 a_14825_519# 0.03307f
C86 a_23355_1044# VDD 0.15389f
C87 a_8563_1842# DELAY_VBIASP 0.06627f
C88 a_10430_1044# a_12715_1044# 0.39036f
C89 DELAY_VBIASN a_7390_1044# 0.02115f
C90 VDD a_15403_1842# 0.4973f
C91 a_8155_1044# a_7945_1044# 0.09424f
C92 a_19073_1842# a_19637_1842# 0.0114f
C93 a_11277_1842# a_11924_1008# 0.02312f
C94 DELAY_VBIASN a_27997_1842# 0.04176f
C95 a_7390_1044# a_8231_1008# 0.28268f
C96 DELAY_VBIASP a_16923_1842# 0.06627f
C97 VDD a_13444_1008# 0.28633f
C98 a_19524_1008# a_18877_1842# 0.02011f
C99 DELAY_VBIASN a_22113_1842# 0.0961f
C100 a_11277_1842# a_11603_1842# 0.01427f
C101 DELAY_VBIASP a_22243_1842# 0.06627f
C102 a_20905_519# VDD 0.29292f
C103 a_9193_1842# VDD 0.49285f
C104 MUX_SEL1 a_3449_1395# 0.29404f
C105 a_22590_1044# a_24875_1044# 0.39036f
C106 a_16510_1044# a_17275_1044# 0.39037f
C107 a_5115_1044# VDD 0.15389f
C108 DELAY_VBIASP a_12233_1842# 0.11222f
C109 DELAY_VBIASN a_12037_1842# 0.09156f
C110 a_19550_1044# a_16108_289# 0.58202f
C111 VDD a_4871_2470# 0.01806f
C112 a_23145_1044# a_23431_1008# 0.01885f
C113 a_17553_1842# VDD 0.49417f
C114 a_25153_1842# a_24957_1842# 0.76914f
C115 DELAY_IN a_3449_331# 0.01017f
C116 VDD a_12791_1008# 0.2822f
C117 VDD a_22873_1842# 0.49294f
C118 a_24084_1008# a_23437_1842# 0.02312f
C119 a_10083_1842# a_10191_2470# 0.01697f
C120 a_12797_1842# VDD 0.87771f
C121 a_15545_1044# a_15831_1008# 0.01885f
C122 a_9675_1044# a_9465_1044# 0.09424f
C123 a_25630_1044# a_27705_1044# 0.03208f
C124 a_18004_1008# VDD 0.28225f
C125 a_14888_1044# a_14317_1842# 0.10863f
C126 a_9757_1842# MUX_SEL4 0.01829f
C127 VDD a_18551_2470# 0.01806f
C128 VDD a_3449_331# 0.46596f
C129 a_16108_289# a_24957_1842# 0.0157f
C130 a_8563_1842# a_8237_1842# 0.01427f
C131 DELAY_VBIASN a_4157_1313# 0.01202f
C132 a_10328_1044# VDD 0.17274f
C133 a_2873_1395# VDD 0.46517f
C134 a_8563_1842# a_8671_2470# 0.01697f
C135 a_25630_1044# a_26185_1044# 0.03209f
C136 a_4763_1842# a_4350_1044# 0.01012f
C137 a_13470_1044# a_13883_1842# 0.01012f
C138 a_26673_1842# a_27237_1842# 0.0114f
C139 a_18877_1842# a_19073_1842# 0.76914f
C140 DELAY_VBIASN a_25630_1044# 0.02756f
C141 DELAY_IN VDD 1.33375f
C142 a_21044_1008# VDD 0.28225f
C143 MUX_SEL4 a_5705_519# 0.03556f
C144 a_12363_1842# a_12471_1842# 0.01163f
C145 a_26151_2470# a_26043_1842# 0.01697f
C146 a_19550_1044# a_20315_1044# 0.39037f
C147 a_10430_1044# MUX_SEL4 0.24983f
C148 a_25717_1842# a_26477_1842# 0.01669f
C149 a_16108_289# a_15765_463# 0.42004f
C150 a_26471_1008# VDD 0.28336f
C151 DELAY_VBIASN a_5523_1842# 0.07254f
C152 DELAY_VBIASP a_6717_1842# 0.0414f
C153 a_17065_1044# a_17275_1044# 0.09424f
C154 a_14825_519# a_5731_289# 0.28056f
C155 a_22590_1044# a_23431_1008# 0.28268f
C156 a_10843_1842# a_10951_1842# 0.01163f
C157 a_14888_1044# a_14964_1008# 0.01176f
C158 a_13991_2470# a_13883_1842# 0.01697f
C159 DELAY_VBIASP a_14513_1842# 0.11222f
C160 DELAY_VBIASN a_14317_1842# 0.09974f
C161 a_15837_1842# a_15403_1842# 0.6972f
C162 DELAY_VBIASP a_23633_1842# 0.11222f
C163 DELAY_VBIASN a_23437_1842# 0.09974f
C164 a_6283_1842# VDD 0.4973f
C165 a_9953_1842# a_10517_1842# 0.0114f
C166 DELAY_VBIASN a_6913_1842# 0.0961f
C167 a_1256_1044# a_1544_1044# 1.26509f
C168 DELAY_VBIASP a_7043_1842# 0.06627f
C169 DELAY_VBIASN a_19637_1842# 0.08375f
C170 DELAY_VBIASP a_19833_1842# 0.11222f
C171 a_21044_1008# a_20397_1842# 0.02312f
C172 a_22590_1044# a_23945_519# 0.02165f
C173 a_27237_1842# a_27705_1044# 0.2079f
C174 VDD MUX_OUT 0.35871f
C175 a_27237_1842# a_26803_1842# 0.6972f
C176 a_24665_1044# VDD 0.29722f
C177 a_13470_1044# a_15755_1044# 0.39036f
C178 a_2019_311# a_1544_289# 0.01747f
C179 MUX_SEL3 a_2873_331# 0.12606f
C180 VDD a_15077_1842# 0.85963f
C181 a_20105_1044# a_19550_1044# 0.03209f
C182 VDD a_24197_1842# 0.85848f
C183 a_7673_1842# VDD 0.49294f
C184 VDD a_20397_1842# 0.86909f
C185 a_16108_289# a_26985_519# 0.27952f
C186 VDD a_7911_2470# 0.01806f
C187 a_18313_1842# a_18877_1842# 0.0114f
C188 a_9323_1842# a_7390_1044# 0.01012f
C189 a_19550_1044# a_19637_1842# 0.1088f
C190 a_4350_1044# a_5191_1008# 0.28268f
C191 DELAY_VBIASN a_27237_1842# 0.09456f
C192 a_21911_1008# a_21917_1842# 0.02354f
C193 a_5393_1842# a_5523_1842# 0.70845f
C194 DELAY_VBIASN a_16793_1842# 0.0961f
C195 a_18443_1842# a_18551_1842# 0.01163f
C196 a_24665_1044# a_24197_1842# 0.2079f
C197 a_17357_1842# a_18117_1842# 0.03319f
C198 DELAY_VBIASN a_4633_1842# 0.0961f
C199 VDD a_2297_331# 0.46496f
C200 a_5844_1008# a_4350_1044# 0.28279f
C201 a_23633_1842# a_23763_1842# 0.70845f
C202 a_12715_1044# a_12791_1008# 0.01194f
C203 a_10517_1842# DELAY_VBIASN 0.08375f
C204 a_10713_1842# DELAY_VBIASP 0.11222f
C205 a_16108_289# a_2019_311# 0.33889f
C206 DELAY_VBIASP a_25717_1842# 0.0414f
C207 MUX_SEL0 a_1256_1044# 0.3314f
C208 a_4350_1044# a_5705_519# 0.02005f
C209 a_10517_1842# a_10985_1044# 0.19203f
C210 a_19833_1842# a_19963_1842# 0.70845f
C211 a_16510_1044# a_18877_1842# 0.02479f
C212 DELAY_VBIASP a_15273_1842# 0.11222f
C213 a_5705_519# a_5731_289# 0.28954f
C214 a_27671_2470# VDD 0.01806f
C215 a_16923_1842# a_17031_1842# 0.01163f
C216 DELAY_VBIASN a_18877_1842# 0.09992f
C217 VDD a_16408_1044# 0.17274f
C218 a_12233_1842# a_12797_1842# 0.0114f
C219 VDD a_22351_2470# 0.01806f
C220 a_10430_1044# a_5731_289# 0.41176f
C221 a_25283_1842# VDD 0.49737f
C222 a_26043_1842# a_25630_1044# 0.01012f
C223 a_4437_1842# a_4157_1313# 0.01771f
C224 a_25630_1044# a_27915_1044# 0.39036f
C225 a_21917_1842# a_21483_1842# 0.6972f
C226 a_11195_1044# a_11271_1008# 0.01194f
C227 MUX_SEL4 a_11785_519# 0.03255f
C228 a_10430_1044# a_11924_1008# 0.28279f
C229 a_22564_1008# VDD 0.28633f
C230 a_17928_1044# a_18004_1008# 0.01176f
C231 MUX_OUT a_2297_331# 0.01179f
C232 MUX_SEL4 a_2873_331# 0.04916f
C233 VDD a_15837_1842# 0.87963f
C234 a_7390_1044# a_9465_1044# 0.03208f
C235 a_11277_1842# a_11848_1044# 0.10863f
C236 a_21911_1008# a_19550_1044# 0.26208f
C237 a_5191_1008# a_4905_1044# 0.01885f
C238 DELAY_OUT_LAST a_27997_1842# 0.70955f
C239 DELAY_VBIASN a_27433_1842# 0.0961f
C240 DELAY_VBIASP a_27563_1842# 0.06629f
C241 a_5631_1842# a_5523_1842# 0.01163f
C242 MUX_SEL3 a_3449_331# 0.28429f
C243 DELAY_VBIASP a_17357_1842# 0.0414f
C244 a_11277_1842# a_12037_1842# 0.03319f
C245 DELAY_VBIASN a_21483_1842# 0.07254f
C246 DELAY_VBIASP a_22677_1842# 0.0414f
C247 a_17865_519# VDD 0.29444f
C248 a_8563_1842# VDD 0.49671f
C249 MUX_SEL0 a_3449_1395# 0.10753f
C250 a_25630_1044# a_26985_519# 0.02195f
C251 a_11271_1008# a_10985_1044# 0.01885f
C252 a_8155_1044# VDD 0.15389f
C253 a_4324_1008# VDD 0.28597f
C254 a_16510_1044# a_16484_1008# 0.277f
C255 VDD a_4111_2470# 0.01866f
C256 DELAY_VBIASP a_11603_1842# 0.06627f
C257 DELAY_VBIASN a_11473_1842# 0.0961f
C258 a_16923_1842# VDD 0.4973f
C259 VDD a_8745_519# 0.29292f
C260 a_23145_1044# a_23355_1044# 0.09424f
C261 VDD a_22243_1842# 0.49737f
C262 VDD a_12715_1044# 0.15406f
C263 a_2019_311# a_4157_1313# 0.01018f
C264 a_24008_1044# a_23437_1842# 0.10863f
C265 a_15837_1842# a_15077_1842# 0.02912f
C266 a_19550_1044# a_21483_1842# 0.01012f
C267 a_12233_1842# VDD 0.49285f
C268 a_15545_1044# a_15755_1044# 0.09424f
C269 a_17928_1044# VDD 0.17499f
C270 a_14311_1008# a_14317_1842# 0.02349f
C271 VDD a_17791_2470# 0.01806f
C272 MUX_SEL3 VDD 0.4053f
C273 a_7390_1044# a_7803_1842# 0.01012f
C274 a_9751_1008# VDD 0.2822f
C275 a_20968_1044# a_21044_1008# 0.01176f
C276 a_12363_1842# a_12471_2470# 0.01697f
C277 a_5197_1842# a_4350_1044# 0.08038f
C278 a_13470_1044# a_14317_1842# 0.08038f
C279 a_12797_1842# MUX_SEL4 0.01829f
C280 a_20968_1044# VDD 0.17499f
C281 MUX_SEL4 a_3449_331# 0.05166f
C282 VDD a_6425_1044# 0.29722f
C283 MUX_SEL3 MUX_OUT 0.79533f
C284 a_19550_1044# a_19524_1008# 0.277f
C285 a_16597_1842# a_16793_1842# 0.73897f
C286 a_10843_1842# a_10951_2470# 0.01697f
C287 DELAY_VBIASN a_24523_1842# 0.07254f
C288 a_25717_1842# a_25913_1842# 0.73897f
C289 a_26395_1044# VDD 0.15389f
C290 a_26395_1044# a_26471_1008# 0.01194f
C291 DELAY_VBIASN a_8997_1842# 0.09156f
C292 a_16408_1044# a_15837_1842# 0.10864f
C293 DELAY_VBIASN a_5957_1842# 0.09156f
C294 DELAY_VBIASP a_6153_1842# 0.11222f
C295 a_4437_1842# a_4633_1842# 0.73897f
C296 a_18585_1044# a_16510_1044# 0.03208f
C297 a_11785_519# a_5731_289# 0.28056f
C298 a_22590_1044# a_23355_1044# 0.39037f
C299 DELAY_IN MUX_SEL4 0.0663f
C300 a_21625_1044# a_21835_1044# 0.09424f
C301 DELAY_VBIASP a_13883_1842# 0.06627f
C302 DELAY_VBIASN a_13753_1842# 0.0961f
C303 a_15273_1842# a_15403_1842# 0.70845f
C304 a_5768_1044# a_5844_1008# 0.01176f
C305 DELAY_VBIASP a_23003_1842# 0.06627f
C306 a_6717_1842# VDD 0.87726f
C307 a_25283_1842# a_25391_1842# 0.01163f
C308 DELAY_VBIASN a_19073_1842# 0.0961f
C309 a_9757_1842# a_10083_1842# 0.01427f
C310 DELAY_VBIASP a_19203_1842# 0.06627f
C311 DELAY_VBIASP a_7477_1842# 0.0414f
C312 a_7477_1842# a_7945_1044# 0.19203f
C313 a_27705_1044# a_27991_1008# 0.01885f
C314 a_20968_1044# a_20397_1842# 0.10863f
C315 a_16510_1044# a_15964_289# 0.05416f
C316 a_26673_1842# a_26803_1842# 0.70845f
C317 VDD MUX_SEL4 2.63176f
C318 a_23145_1044# VDD 0.30409f
C319 a_13470_1044# a_14964_1008# 0.28279f
C320 a_2019_311# a_1256_289# 0.02904f
C321 MUX_SEL3 a_2297_331# 0.01595f
C322 MUX_SEL2 a_2873_331# 0.01422f
C323 VDD a_14513_1842# 0.49417f
C324 a_22243_1842# a_22351_2470# 0.01697f
C325 a_25528_1044# a_24957_1842# 0.10864f
C326 VDD a_23633_1842# 0.49417f
C327 a_7043_1842# VDD 0.49723f
C328 VDD a_19833_1842# 0.49294f
C329 a_6717_1842# a_6283_1842# 0.6972f
C330 a_16108_289# a_23945_519# 0.2906f
C331 VDD a_7151_2470# 0.01806f
C332 a_9757_1842# a_7390_1044# 0.02479f
C333 a_24957_1842# a_24523_1842# 0.6972f
C334 a_4350_1044# a_5115_1044# 0.39037f
C335 MUX_SEL4 MUX_OUT 0.91933f
C336 DELAY_VBIASN a_26673_1842# 0.0961f
C337 a_20723_1842# a_20831_2470# 0.01697f
C338 a_16484_1008# a_16597_1842# 0.05157f
C339 a_8433_1842# a_8997_1842# 0.0114f
C340 a_18871_1008# a_18877_1842# 0.02354f
C341 a_15511_1842# a_15403_1842# 0.01163f
C342 a_10517_1842# a_10404_1008# 0.05157f
C343 DELAY_VBIASN a_16163_1842# 0.07254f
C344 a_5393_1842# a_5957_1842# 0.0114f
C345 a_17357_1842# a_17553_1842# 0.76914f
C346 a_10517_1842# a_11277_1842# 0.01669f
C347 a_14513_1842# a_15077_1842# 0.0114f
C348 DELAY_VBIASN a_4003_1842# 0.06486f
C349 a_23633_1842# a_24197_1842# 0.0114f
C350 VDD a_1721_331# 0.45259f
C351 a_22677_1842# a_22873_1842# 0.73897f
C352 a_10083_1842# DELAY_VBIASP 0.06627f
C353 a_9953_1842# DELAY_VBIASN 0.0961f
C354 DELAY_VBIASP a_25153_1842# 0.11222f
C355 a_7477_1842# a_8237_1842# 0.01669f
C356 a_19833_1842# a_20397_1842# 0.0114f
C357 a_18004_1008# a_17357_1842# 0.02312f
C358 DELAY_VBIASP a_14643_1842# 0.06627f
C359 a_26911_2470# VDD 0.01806f
C360 DELAY_VBIASP a_18443_1842# 0.06627f
C361 DELAY_VBIASN a_18313_1842# 0.0961f
C362 VDD a_15831_1008# 0.2816f
C363 a_13557_1842# a_14317_1842# 0.01669f
C364 VDD a_21591_2470# 0.01806f
C365 a_26477_1842# a_25630_1044# 0.08038f
C366 a_25630_1044# a_27124_1008# 0.28279f
C367 a_25717_1842# VDD 0.86707f
C368 a_10713_1842# VDD 0.49294f
C369 a_21353_1842# a_21483_1842# 0.70845f
C370 a_22590_1044# VDD 0.89557f
C371 a_10430_1044# a_11848_1044# 0.38994f
C372 MUX_SEL4 a_2297_331# 0.04338f
C373 a_7043_1842# a_7151_1842# 0.01163f
C374 a_21483_1842# a_21591_1842# 0.01163f
C375 a_7390_1044# a_7945_1044# 0.03209f
C376 VDD a_15273_1842# 0.49285f
C377 a_11277_1842# a_11271_1008# 0.02349f
C378 a_5115_1044# a_4905_1044# 0.09424f
C379 a_24631_2470# a_24523_1842# 0.01697f
C380 DELAY_VBIASP a_27997_1842# 0.04001f
C381 DELAY_VBIASN a_26803_1842# 0.07254f
C382 MUX_SEL2 a_3449_331# 0.10741f
C383 a_10430_1044# a_12037_1842# 0.05231f
C384 a_5768_1044# a_5197_1842# 0.10863f
C385 a_11277_1842# a_11473_1842# 0.76914f
C386 DELAY_VBIASP a_22113_1842# 0.11222f
C387 DELAY_VBIASN a_21917_1842# 0.09992f
C388 a_19448_1044# a_18877_1842# 0.10864f
C389 a_11195_1044# a_10985_1044# 0.09424f
C390 a_16851_309# VDD 0.51536f
C391 a_7364_1008# VDD 0.28633f
C392 a_15765_463# a_15964_289# 0.061f
C393 a_4350_1044# VDD 0.87635f
C394 VDD a_27563_1842# 0.49811f
C395 DELAY_VBIASN a_10843_1842# 0.07254f
C396 DELAY_VBIASP a_12037_1842# 0.04141f
C397 DELAY_VBIASN a_16510_1044# 0.02115f
C398 a_17357_1842# VDD 0.86909f
C399 a_23111_2470# a_23003_1842# 0.01697f
C400 a_24665_1044# a_22590_1044# 0.03208f
C401 VDD a_5731_289# 0.6143f
C402 a_4763_1842# a_4633_1842# 0.70845f
C403 VDD a_11924_1008# 0.28225f
C404 VDD a_22677_1842# 0.86707f
C405 a_22590_1044# a_24197_1842# 0.05231f
C406 a_23431_1008# a_23437_1842# 0.02349f
C407 a_15273_1842# a_15077_1842# 0.77122f
C408 a_19550_1044# a_21917_1842# 0.02479f
C409 a_11603_1842# VDD 0.49671f
C410 a_6283_1842# a_4350_1044# 0.01012f
C411 a_16851_309# MUX_OUT 0.45865f
C412 a_5523_1842# a_5631_2470# 0.01697f
C413 a_17351_1008# VDD 0.28565f
C414 VDD a_17031_2470# 0.01806f
C415 MUX_SEL2 VDD 0.50938f
C416 MUX_OUT a_5731_289# 1.04829f
C417 MUX_SEL4 a_8745_519# 0.04472f
C418 DELAY_VBIASN a_19550_1044# 0.02115f
C419 a_9675_1044# VDD 0.15406f
C420 a_7390_1044# a_8237_1842# 0.08038f
C421 a_27915_1044# a_27991_1008# 0.01194f
C422 a_26477_1842# a_27237_1842# 0.03319f
C423 a_27237_1842# a_27124_1008# 0.02055f
C424 a_22873_1842# a_23003_1842# 0.70845f
C425 DELAY_VBIASP a_25630_1044# 0.01522f
C426 a_21157_1842# a_21917_1842# 0.02912f
C427 a_20391_1008# VDD 0.28336f
C428 a_18585_1044# a_18871_1008# 0.01885f
C429 a_23871_1842# a_23763_1842# 0.01163f
C430 a_24008_1044# a_24084_1008# 0.01176f
C431 VDD a_4905_1044# 0.30126f
C432 MUX_SEL2 MUX_OUT 0.08497f
C433 MUX_SEL3 MUX_SEL4 0.75489f
C434 a_19448_1044# a_19524_1008# 0.01176f
C435 a_16597_1842# a_16163_1842# 0.69698f
C436 DELAY_VBIASN a_24957_1842# 0.09992f
C437 a_25717_1842# a_25283_1842# 0.69698f
C438 DELAY_VBIASN a_8433_1842# 0.0961f
C439 DELAY_VBIASN a_21157_1842# 0.09156f
C440 a_25630_1044# a_27048_1044# 0.38994f
C441 a_25604_1008# VDD 0.28633f
C442 a_15831_1008# a_15837_1842# 0.02354f
C443 a_8997_1842# a_9465_1044# 0.2079f
C444 DELAY_VBIASN a_5393_1842# 0.0961f
C445 DELAY_VBIASP a_5523_1842# 0.06627f
C446 a_4437_1842# a_4003_1842# 0.69698f
C447 a_17065_1044# a_16510_1044# 0.03209f
C448 a_8884_1008# a_8237_1842# 0.02312f
C449 a_15964_289# a_2019_311# 0.02413f
C450 a_22590_1044# a_22564_1008# 0.277f
C451 a_13231_1842# a_13123_1842# 0.01163f
C452 DELAY_VBIASP a_14317_1842# 0.0414f
C453 DELAY_VBIASN a_13123_1842# 0.07254f
C454 a_15273_1842# a_15837_1842# 0.0114f
C455 DELAY_VBIASP a_23437_1842# 0.0414f
C456 a_27671_2470# a_27563_1842# 0.01697f
C457 a_6153_1842# VDD 0.49285f
C458 a_9757_1842# a_10517_1842# 0.06198f
C459 DELAY_VBIASP a_6913_1842# 0.11222f
C460 DELAY_VBIASP a_19637_1842# 0.0414f
C461 VDD a_12471_2470# 0.01806f
C462 a_19550_1044# a_21157_1842# 0.05231f
C463 a_20391_1008# a_20397_1842# 0.02349f
C464 a_27705_1044# a_27915_1044# 0.09424f
C465 a_21625_1044# VDD 0.29722f
C466 a_13470_1044# a_14888_1044# 0.38994f
C467 MUX_SEL2 a_2297_331# 0.10655f
C468 VDD a_13883_1842# 0.4973f
C469 a_24951_1008# a_24957_1842# 0.02354f
C470 VDD a_23003_1842# 0.4973f
C471 a_7477_1842# VDD 0.86707f
C472 a_22564_1008# a_22677_1842# 0.05157f
C473 a_6153_1842# a_6283_1842# 0.70845f
C474 VDD a_19203_1842# 0.49737f
C475 a_16108_289# a_20905_519# 0.2906f
C476 a_18117_1842# a_18877_1842# 0.02912f
C477 a_6717_1842# MUX_SEL4 0.0195f
C478 a_24393_1842# a_24523_1842# 0.70845f
C479 a_4350_1044# a_4324_1008# 0.277f
C480 DELAY_VBIASP a_27237_1842# 0.06189f
C481 DELAY_VBIASN a_26043_1842# 0.07254f
C482 a_16510_1044# a_16597_1842# 0.1088f
C483 a_6717_1842# a_7043_1842# 0.01427f
C484 a_10517_1842# a_10430_1044# 0.1088f
C485 a_18443_1842# a_18551_2470# 0.01697f
C486 DELAY_VBIASN a_16597_1842# 0.08375f
C487 a_5197_1842# a_5523_1842# 0.01427f
C488 a_5731_289# a_8745_519# 0.28635f
C489 DELAY_VBIASP a_16793_1842# 0.11222f
C490 a_17357_1842# a_16923_1842# 0.6972f
C491 a_5768_1044# VDD 0.17499f
C492 a_6635_1044# a_6711_1008# 0.01194f
C493 DELAY_VBIASN a_4437_1842# 0.08375f
C494 DELAY_VBIASP a_4633_1842# 0.11222f
C495 a_23437_1842# a_23763_1842# 0.01427f
C496 VDD a_1544_289# 0.39113f
C497 a_22677_1842# a_22243_1842# 0.69698f
C498 a_9323_1842# DELAY_VBIASN 0.07254f
C499 a_10517_1842# DELAY_VBIASP 0.0414f
C500 a_7477_1842# a_7673_1842# 0.73897f
C501 a_21911_1008# a_21835_1044# 0.01194f
C502 a_17928_1044# a_17357_1842# 0.10863f
C503 a_7043_1842# a_7151_2470# 0.01697f
C504 a_26151_2470# VDD 0.01806f
C505 a_16923_1842# a_17031_2470# 0.01697f
C506 a_13557_1842# a_13753_1842# 0.73897f
C507 DELAY_VBIASP a_18877_1842# 0.0414f
C508 DELAY_VBIASN a_17683_1842# 0.07254f
C509 VDD a_15755_1044# 0.15389f
C510 DELAY_VBIASN a_13470_1044# 0.02115f
C511 a_12037_1842# a_12797_1842# 0.02912f
C512 VDD a_20831_2470# 0.01806f
C513 a_25153_1842# VDD 0.49426f
C514 a_1721_1395# VDD 0.4533f
C515 a_10083_1842# VDD 0.49727f
C516 a_21353_1842# a_21917_1842# 0.0114f
C517 a_22488_1044# VDD 0.17274f
C518 a_10430_1044# a_11271_1008# 0.28268f
C519 MUX_SEL4 a_1721_331# 0.05813f
C520 a_16510_1044# a_18871_1008# 0.26208f
C521 MUX_OUT a_1544_289# 0.69943f
C522 a_16510_1044# a_2019_311# 0.03139f
C523 VDD a_14643_1842# 0.49671f
C524 a_4350_1044# a_6425_1044# 0.03208f
C525 DELAY_VBIASP a_27433_1842# 0.11222f
C526 a_18443_1842# VDD 0.4973f
C527 MUX_SEL2 MUX_SEL3 3.21891f
C528 DELAY_VBIASP a_21483_1842# 0.06627f
C529 DELAY_VBIASN a_21353_1842# 0.0961f
C530 a_11277_1842# a_10843_1842# 0.6972f
C531 MUX_SEL1 a_2873_1395# 0.13092f
C532 a_16108_289# VDD 1.22378f
C533 a_7390_1044# VDD 0.8686f
C534 a_10430_1044# a_12505_1044# 0.03208f
C535 a_4248_1044# VDD 0.17587f
C536 DELAY_VBIASP a_11473_1842# 0.11222f
C537 DELAY_VBIASN a_11277_1842# 0.09974f
C538 VDD a_27997_1842# 0.76025f
C539 a_9675_1044# a_9751_1008# 0.01194f
C540 a_23145_1044# a_22590_1044# 0.03209f
C541 a_5197_1842# a_4633_1842# 0.0114f
C542 a_19963_1842# a_20071_2470# 0.01697f
C543 DELAY_IN MUX_SEL1 0.01858f
C544 a_17065_1044# a_16597_1842# 0.19203f
C545 VDD a_11848_1044# 0.17499f
C546 DELAY_OUT_LAST DELAY_VBIASN 0.04786f
C547 VDD a_22113_1842# 0.49426f
C548 a_9757_1842# a_8997_1842# 0.02912f
C549 a_14643_1842# a_15077_1842# 0.6972f
C550 a_7364_1008# a_6717_1842# 0.02011f
C551 a_12037_1842# VDD 0.85848f
C552 a_6717_1842# a_4350_1044# 0.02479f
C553 a_16108_289# MUX_OUT 0.24265f
C554 a_1256_289# a_2873_331# 0.27926f
C555 a_1544_289# a_2297_331# 0.27303f
C556 a_17275_1044# VDD 0.15389f
C557 VDD a_16271_2470# 0.01806f
C558 a_4350_1044# MUX_SEL4 0.31434f
C559 MUX_SEL1 VDD 0.50267f
C560 a_9323_1842# a_9431_1842# 0.01163f
C561 MUX_SEL4 a_5731_289# 4.60702f
C562 a_8884_1008# VDD 0.28225f
C563 DELAY_IN a_4157_1313# 0.50642f
C564 a_18585_1044# a_18117_1842# 0.2079f
C565 a_2297_1395# VDD 0.46536f
C566 a_23145_1044# a_22677_1842# 0.19203f
C567 a_5844_1008# a_5957_1842# 0.02055f
C568 a_26477_1842# a_26673_1842# 0.76914f
C569 a_22873_1842# a_23437_1842# 0.0114f
C570 a_21157_1842# a_21353_1842# 0.77122f
C571 a_18585_1044# a_18795_1044# 0.09424f
C572 a_20315_1044# VDD 0.15389f
C573 VDD a_4157_1313# 0.48935f
C574 MUX_SEL1 MUX_OUT 0.09357f
C575 MUX_SEL2 MUX_SEL4 0.01978f
C576 a_19448_1044# a_19550_1044# 0.37183f
C577 a_16033_1842# a_16163_1842# 0.70845f
C578 DELAY_VBIASN a_24393_1842# 0.0961f
C579 DELAY_VBIASP a_24523_1842# 0.06627f
C580 a_25153_1842# a_25283_1842# 0.70845f
C581 DELAY_VBIASN a_7803_1842# 0.07254f
C582 DELAY_VBIASP a_8997_1842# 0.04141f
C583 a_25630_1044# a_26471_1008# 0.28268f
C584 a_25630_1044# VDD 0.89531f
C585 DELAY_VBIASN a_20593_1842# 0.0961f
C586 DELAY_VBIASN a_4763_1842# 0.07254f
C587 DELAY_VBIASP a_5957_1842# 0.04141f
C588 a_22488_1044# a_22564_1008# 0.01176f
C589 a_8808_1044# a_8237_1842# 0.10863f
C590 a_15765_463# a_2019_311# 0.05969f
C591 a_19203_1842# a_19311_1842# 0.01163f
C592 DELAY_VBIASP a_13753_1842# 0.11222f
C593 DELAY_VBIASN a_13557_1842# 0.08375f
C594 a_5523_1842# VDD 0.49671f
C595 a_24875_1044# a_24951_1008# 0.01194f
C596 a_9757_1842# a_9953_1842# 0.76914f
C597 DELAY_VBIASP a_19073_1842# 0.11222f
C598 VDD a_11711_2470# 0.01806f
C599 a_26477_1842# a_26803_1842# 0.01427f
C600 a_20105_1044# VDD 0.30409f
C601 MUX_SEL3 a_1544_289# 0.15976f
C602 MUX_SEL2 a_1721_331# 0.01315f
C603 a_13470_1044# a_14311_1008# 0.28268f
C604 VDD a_14317_1842# 0.86909f
C605 VDD a_23437_1842# 0.86909f
C606 a_6913_1842# VDD 0.49426f
C607 a_22590_1044# a_22677_1842# 0.1088f
C608 a_6153_1842# a_6717_1842# 0.0114f
C609 VDD a_19637_1842# 0.86707f
C610 a_16108_289# a_17865_519# 0.29564f
C611 a_18117_1842# a_18313_1842# 0.77122f
C612 a_7390_1044# a_8155_1044# 0.39037f
C613 a_24393_1842# a_24957_1842# 0.0114f
C614 a_26911_1842# a_26803_1842# 0.01163f
C615 a_4248_1044# a_4324_1008# 0.01176f
C616 DELAY_VBIASP a_26673_1842# 0.11222f
C617 DELAY_VBIASN a_26477_1842# 0.10224f
C618 a_7390_1044# a_8745_519# 0.01756f
C619 a_4350_1044# a_5731_289# 0.41099f
C620 a_8237_1842# a_8997_1842# 0.03319f
C621 a_6717_1842# a_7477_1842# 0.06198f
C622 a_20593_1842# a_21157_1842# 0.0114f
C623 a_15511_2470# a_15403_1842# 0.01697f
C624 DELAY_VBIASN a_16033_1842# 0.0961f
C625 DELAY_VBIASP a_16163_1842# 0.06627f
C626 a_5197_1842# a_5957_1842# 0.03319f
C627 a_14317_1842# a_15077_1842# 0.03319f
C628 DELAY_VBIASP a_4003_1842# 0.05992f
C629 a_27237_1842# VDD 0.85969f
C630 VDD a_1256_289# 0.40292f
C631 a_23437_1842# a_24197_1842# 0.03319f
C632 a_22113_1842# a_22243_1842# 0.70845f
C633 a_9953_1842# DELAY_VBIASP 0.11222f
C634 a_9757_1842# DELAY_VBIASN 0.09992f
C635 a_7477_1842# a_7043_1842# 0.69698f
C636 VDD a_16793_1842# 0.49277f
C637 a_16510_1044# a_18117_1842# 0.05231f
C638 a_17351_1008# a_17357_1842# 0.02349f
C639 a_19637_1842# a_20397_1842# 0.01669f
C640 a_25391_2470# VDD 0.01806f
C641 a_7390_1044# a_9751_1008# 0.26208f
C642 a_4633_1842# VDD 0.49285f
C643 a_13557_1842# a_13123_1842# 0.69698f
C644 DELAY_VBIASP a_18313_1842# 0.11222f
C645 DELAY_VBIASN a_18117_1842# 0.09156f
C646 VDD a_14964_1008# 0.28225f
C647 a_12037_1842# a_12233_1842# 0.77122f
C648 VDD a_20071_2470# 0.01806f
C649 a_10517_1842# VDD 0.86707f
C650 a_25717_1842# a_25604_1008# 0.05157f
C651 a_12791_1008# a_12505_1044# 0.01885f
C652 a_1544_1044# VDD 0.45079f
C653 a_10430_1044# a_11195_1044# 0.39037f
C654 a_16510_1044# a_18795_1044# 0.39036f
C655 a_21911_1008# VDD 0.2822f
C656 MUX_OUT a_1256_289# 0.1134f
C657 MUX_SEL4 a_1544_289# 0.47529f
C658 DELAY_VBIASN a_12363_1842# 0.07254f
C659 DELAY_VBIASP a_26803_1842# 0.06627f
C660 a_18877_1842# VDD 0.87825f
C661 a_4324_1008# a_4157_1313# 0.02463f
C662 a_4350_1044# a_4905_1044# 0.03209f
C663 a_10430_1044# a_10843_1842# 0.01012f
C664 DELAY_VBIASP a_21917_1842# 0.0414f
C665 DELAY_VBIASN a_20723_1842# 0.07254f
C666 a_7288_1044# VDD 0.17274f
C667 MUX_SEL0 a_2873_1395# 0.01504f
C668 DELAY_VBIASN a_10430_1044# 0.02115f
C669 a_10430_1044# a_10985_1044# 0.03209f
C670 DELAY_VBIASP a_10843_1842# 0.06627f
C671 a_1544_1044# MUX_OUT 0.04258f
C672 a_14964_1008# a_15077_1842# 0.02055f
C673 VDD a_27433_1842# 0.49285f
C674 DELAY_IN MUX_SEL0 0.14089f
C675 VDD a_21483_1842# 0.4973f
C676 VDD a_11271_1008# 0.28336f
C677 DELAY_VBIASP DELAY_VBIASN 3.50557f
C678 a_9193_1842# a_8997_1842# 0.77122f
C679 a_22590_1044# a_23003_1842# 0.01012f
C680 a_14643_1842# a_14513_1842# 0.70845f
C681 a_9323_1842# a_9431_2470# 0.01697f
C682 a_11473_1842# VDD 0.49417f
C683 a_8231_1008# a_7945_1044# 0.01885f
C684 a_1256_289# a_2297_331# 0.04261f
C685 a_1544_289# a_1721_331# 0.36963f
C686 a_16108_289# MUX_SEL4 0.1283f
C687 a_16484_1008# VDD 0.28597f
C688 a_7390_1044# MUX_SEL4 0.34655f
C689 VDD a_15511_2470# 0.01806f
C690 MUX_SEL0 VDD 0.56365f
C691 VDD a_12505_1044# 0.29722f
C692 a_8808_1044# VDD 0.17499f
C693 a_7364_1008# a_7477_1842# 0.05157f
C694 a_19550_1044# a_21835_1044# 0.39036f
C695 a_15545_1044# a_13470_1044# 0.03208f
C696 a_13470_1044# a_13557_1842# 0.1088f
C697 a_26477_1842# a_26043_1842# 0.6972f
C698 a_21157_1842# a_20723_1842# 0.6972f
C699 a_4111_1842# a_4003_1842# 0.01163f
C700 a_19524_1008# VDD 0.28633f
C701 MUX_SEL1 MUX_SEL4 0.03574f
C702 a_15755_1044# a_15831_1008# 0.01194f
C703 a_11603_1842# a_11711_1842# 0.01163f
C704 a_14825_519# a_13470_1044# 0.02058f
C705 a_25391_2470# a_25283_1842# 0.01697f
C706 a_16033_1842# a_16597_1842# 0.0114f
C707 a_5768_1044# a_4350_1044# 0.38994f
C708 DELAY_VBIASP a_24957_1842# 0.0414f
C709 DELAY_VBIASN a_23763_1842# 0.07254f
C710 a_25153_1842# a_25717_1842# 0.0114f
C711 DELAY_VBIASN a_8237_1842# 0.09974f
C712 a_25630_1044# a_26395_1044# 0.39037f
C713 DELAY_VBIASP a_8433_1842# 0.11222f
C714 a_25528_1044# VDD 0.17274f
C715 DELAY_VBIASN a_19963_1842# 0.07254f
C716 DELAY_VBIASP a_21157_1842# 0.04141f
C717 DELAY_VBIASP a_5393_1842# 0.11222f
C718 DELAY_VBIASN a_5197_1842# 0.09974f
C719 a_8231_1008# a_8237_1842# 0.02349f
C720 a_22488_1044# a_22590_1044# 0.37183f
C721 a_14235_1044# a_14311_1008# 0.01194f
C722 MUX_SEL4 a_4157_1313# 0.08229f
C723 a_13231_2470# a_13123_1842# 0.01697f
C724 VDD a_24523_1842# 0.4973f
C725 DELAY_VBIASP a_13123_1842# 0.06627f
C726 DELAY_VBIASN a_12993_1842# 0.0961f
C727 a_8997_1842# VDD 0.85848f
C728 a_16923_1842# a_16793_1842# 0.70845f
C729 a_5957_1842# VDD 0.85848f
C730 a_9757_1842# a_9323_1842# 0.6972f
C731 VDD a_10951_2470# 0.01806f
C732 a_22590_1044# a_16108_289# 0.58202f
C733 a_19550_1044# a_19963_1842# 0.01012f
C734 a_18585_1044# VDD 0.29722f
C735 MUX_SEL2 a_1544_289# 0.07405f
C736 a_13470_1044# a_14235_1044# 0.39037f
C737 MUX_SEL3 a_1256_289# 1.41161f
C738 VDD a_13753_1842# 0.49294f
C739 VDD a_19073_1842# 0.49426f
C740 a_16108_289# a_16851_309# 0.06181f
C741 a_18117_1842# a_17683_1842# 0.6972f
C742 a_16484_1008# a_16408_1044# 0.01176f
C743 a_7390_1044# a_7364_1008# 0.277f
C744 VDD a_15964_289# 0.31312f
C745 a_13368_1044# a_13470_1044# 0.37183f
C746 a_4248_1044# a_4350_1044# 0.37183f
C747 a_16108_289# a_5731_289# 0.01334f
C748 DELAY_VBIASP a_26043_1842# 0.06627f
C749 DELAY_VBIASN a_25913_1842# 0.0961f
C750 a_7390_1044# a_5731_289# 0.41331f
C751 a_27997_1842# a_27563_1842# 0.69646f
C752 a_16484_1008# a_15837_1842# 0.02011f
C753 a_8237_1842# a_8433_1842# 0.76914f
C754 a_6717_1842# a_6913_1842# 0.76914f
C755 DELAY_VBIASN a_15403_1842# 0.07254f
C756 a_2873_1395# a_1256_1044# 0.28892f
C757 DELAY_VBIASP a_16597_1842# 0.0414f
C758 a_9757_1842# a_10404_1008# 0.02011f
C759 a_5197_1842# a_5393_1842# 0.76914f
C760 a_17683_1842# a_17791_1842# 0.01163f
C761 a_14317_1842# a_14513_1842# 0.76914f
C762 DELAY_VBIASP a_4437_1842# 0.0414f
C763 DELAY_IN a_4003_1842# 0.54998f
C764 VDD a_27991_1008# 0.28201f
C765 a_26673_1842# VDD 0.49417f
C766 a_11848_1044# a_11924_1008# 0.01176f
C767 a_22113_1842# a_22677_1842# 0.0114f
C768 a_23437_1842# a_23633_1842# 0.76914f
C769 a_24084_1008# VDD 0.28225f
C770 a_9323_1842# DELAY_VBIASP 0.06627f
C771 a_18795_1044# a_18871_1008# 0.01194f
C772 a_9193_1842# DELAY_VBIASN 0.0961f
C773 MUX_OUT a_15964_289# 0.01307f
C774 a_6913_1842# a_7043_1842# 0.70845f
C775 VDD a_16163_1842# 0.4973f
C776 a_19637_1842# a_19833_1842# 0.73897f
C777 a_12037_1842# a_11924_1008# 0.02055f
C778 a_6391_1842# a_6283_1842# 0.01163f
C779 a_7390_1044# a_9675_1044# 0.39036f
C780 a_5705_519# a_2019_311# 0.13872f
C781 a_4003_1842# VDD 0.61559f
C782 DELAY_VBIASP a_17683_1842# 0.06627f
C783 DELAY_VBIASN a_17553_1842# 0.0961f
C784 a_12993_1842# a_13123_1842# 0.70845f
C785 VDD a_14888_1044# 0.17499f
C786 VDD a_19311_2470# 0.01806f
C787 DELAY_VBIASN a_22873_1842# 0.0961f
C788 a_12037_1842# a_11603_1842# 0.6972f
C789 a_9953_1842# VDD 0.49426f
C790 a_12715_1044# a_12505_1044# 0.09424f
C791 a_25717_1842# a_25630_1044# 0.1088f
C792 a_1256_1044# VDD 0.475f
C793 a_17275_1044# a_17351_1008# 0.01194f
C794 MUX_SEL4 a_1256_289# 0.65005f
C795 a_16510_1044# a_18004_1008# 0.28279f
C796 DELAY_VBIASN a_12797_1842# 0.09992f
C797 a_19550_1044# a_20905_519# 0.02165f
C798 a_10430_1044# a_10404_1008# 0.277f
C799 a_4350_1044# a_4157_1313# 0.04624f
C800 a_18313_1842# VDD 0.49285f
C801 a_4871_1842# a_4763_1842# 0.01163f
C802 a_10430_1044# a_11277_1842# 0.08038f
C803 a_24084_1008# a_24197_1842# 0.02055f
C804 DELAY_VBIASP a_21353_1842# 0.11222f
C805 a_6711_1008# VDD 0.2822f
C806 DELAY_IN a_3449_1395# 0.01058f
C807 a_27705_1044# VDD 0.29918f
C808 DELAY_VBIASP a_11277_1842# 0.0414f
C809 a_1256_1044# MUX_OUT 0.02466f
C810 a_1544_1044# MUX_SEL4 0.03407f
C811 a_25630_1044# a_27563_1842# 0.01024f
C812 VDD a_26803_1842# 0.49671f
C813 a_5197_1842# a_4437_1842# 0.01669f
C814 VDD a_11195_1044# 0.15389f
C815 VDD a_21917_1842# 0.87825f
C816 DELAY_VBIASP DELAY_OUT_LAST 0.21225f
C817 DELAY_IN DELAY_VBIASN 0.07156f
C818 a_8563_1842# a_8997_1842# 0.6972f
C819 a_22590_1044# a_23437_1842# 0.08038f
C820 a_3449_1395# VDD 0.46731f
C821 a_7288_1044# a_6717_1842# 0.10864f
C822 a_14025_1044# a_14311_1008# 0.01885f
C823 a_10843_1842# VDD 0.4973f
C824 a_26471_1008# a_26185_1044# 0.01885f
C825 a_26185_1044# VDD 0.30409f
C826 a_16510_1044# VDD 0.8795f
C827 a_1256_289# a_1721_331# 0.13421f
C828 VDD a_14751_2470# 0.01806f
C829 DELAY_VBIASN VDD 0.9333f
C830 a_15964_289# a_15837_1842# 0.02f
C831 VDD a_10985_1044# 0.30409f
C832 a_8231_1008# VDD 0.28336f
C833 a_7390_1044# a_7477_1842# 0.1088f
C834 a_19550_1044# a_21044_1008# 0.28279f
C835 a_20315_1044# a_20391_1008# 0.01194f
C836 a_14025_1044# a_13470_1044# 0.03209f
C837 a_11603_1842# a_11711_2470# 0.01697f
C838 a_25913_1842# a_26043_1842# 0.70845f
C839 a_26477_1842# a_27124_1008# 0.02312f
C840 a_22677_1842# a_23437_1842# 0.01669f
C841 DELAY_VBIASN a_6283_1842# 0.07254f
C842 a_20593_1842# a_20723_1842# 0.70845f
C843 a_19550_1044# VDD 0.89766f
C844 a_12797_1842# a_13123_1842# 0.01427f
C845 a_15837_1842# a_16163_1842# 0.01427f
C846 DELAY_VBIASN a_15077_1842# 0.09156f
C847 DELAY_VBIASP a_24393_1842# 0.11222f
C848 DELAY_VBIASN a_24197_1842# 0.09156f
C849 DELAY_VBIASN a_7673_1842# 0.0961f
C850 a_24951_1008# VDD 0.2822f
C851 a_10517_1842# a_10713_1842# 0.73897f
C852 a_26043_1842# a_26151_1842# 0.01163f
C853 a_25630_1044# a_25604_1008# 0.277f
C854 DELAY_VBIASP a_7803_1842# 0.06627f
C855 DELAY_VBIASP a_20593_1842# 0.11222f
C856 DELAY_VBIASN a_20397_1842# 0.09974f
C857 DELAY_VBIASP a_4763_1842# 0.06627f
C858 a_21044_1008# a_21157_1842# 0.02055f
C859 a_5957_1842# a_6425_1044# 0.2079f
C860 VDD a_24957_1842# 0.87825f
C861 a_20105_1044# a_20391_1008# 0.01885f
C862 DELAY_VBIASP a_13557_1842# 0.0414f
C863 a_8433_1842# VDD 0.49417f
C864 VDD a_21157_1842# 0.85848f
C865 a_17357_1842# a_16793_1842# 0.0114f
C866 a_4003_1842# a_4111_2470# 0.01697f
C867 a_5393_1842# VDD 0.49417f
C868 a_9193_1842# a_9323_1842# 0.70845f
C869 VDD a_10191_2470# 0.01806f
C870 a_13470_1044# a_15403_1842# 0.01012f
C871 a_19550_1044# a_20397_1842# 0.08038f
C872 a_24665_1044# a_24951_1008# 0.01885f
C873 a_17065_1044# VDD 0.30218f
C874 MUX_SEL2 a_1256_289# 0.33134f
C875 a_13470_1044# a_13444_1008# 0.277f
C876 VDD a_13123_1842# 0.49727f
C877 a_21483_1842# a_21591_2470# 0.01697f
C878 a_16271_1842# a_16163_1842# 0.01163f
C879 a_22564_1008# a_21917_1842# 0.02011f
C880 a_5957_1842# a_6717_1842# 0.02912f
C881 a_17553_1842# a_17683_1842# 0.70845f
C882 a_16510_1044# a_16408_1044# 0.37183f
C883 a_7288_1044# a_7364_1008# 0.01176f
C884 VDD a_15765_463# 0.35368f
C885 a_24197_1842# a_24957_1842# 0.02912f
C886 DELAY_VBIASP a_26477_1842# 0.04144f
C887 DELAY_VBIASN a_25283_1842# 0.07254f
C888 a_8237_1842# a_7803_1842# 0.6972f
C889 a_27433_1842# a_27563_1842# 0.70845f
C890 a_20397_1842# a_21157_1842# 0.03319f
C891 a_14751_1842# a_14643_1842# 0.01163f
C892 DELAY_VBIASP a_16033_1842# 0.11222f
C893 DELAY_VBIASN a_15837_1842# 0.09992f
C894 a_5197_1842# a_4763_1842# 0.6972f
C895 a_14317_1842# a_13883_1842# 0.6972f
C896 DELAY_IN a_4437_1842# 0.05007f
C897 VDD a_24631_2470# 0.01806f
C898 a_27048_1044# a_27124_1008# 0.01176f
C899 a_16510_1044# a_17865_519# 0.02165f
C900 a_26477_1842# a_27048_1044# 0.10863f
C901 a_23437_1842# a_23003_1842# 0.6972f
C902 a_26043_1842# VDD 0.4973f
C903 a_21917_1842# a_22243_1842# 0.01427f
C904 VDD a_27915_1044# 0.15389f
C905 a_7803_1842# a_7911_1842# 0.01163f
C906 MUX_SEL4 a_15964_289# 0.5544f
C907 a_9757_1842# DELAY_VBIASP 0.0414f
C908 a_24008_1044# VDD 0.17499f
C909 a_8563_1842# DELAY_VBIASN 0.07254f
C910 a_6913_1842# a_7477_1842# 0.0114f
C911 a_22243_1842# a_22351_1842# 0.01163f
C912 a_19637_1842# a_19203_1842# 0.69698f
C913 VDD a_16597_1842# 0.86876f
C914 a_16510_1044# a_16923_1842# 0.01012f
C915 a_14025_1044# a_13557_1842# 0.19203f
C916 a_8155_1044# a_8231_1008# 0.01194f
C917 a_7390_1044# a_8884_1008# 0.28279f
C918 a_3449_331# a_2019_311# 0.01176f
C919 a_10430_1044# a_12363_1842# 0.01012f
C920 a_4437_1842# VDD 0.86998f
C921 DELAY_VBIASN a_16923_1842# 0.07254f
C922 DELAY_VBIASP a_18117_1842# 0.04141f
C923 a_12993_1842# a_13557_1842# 0.0114f
C924 VDD a_14311_1008# 0.28336f
C925 DELAY_VBIASN a_22243_1842# 0.07254f
C926 a_11473_1842# a_11603_1842# 0.70845f
C927 a_9323_1842# VDD 0.4973f
C928 a_26985_519# VDD 0.29292f
C929 a_16510_1044# a_17928_1044# 0.38994f
C930 DELAY_VBIASP a_12363_1842# 0.06627f
C931 DELAY_VBIASN a_12233_1842# 0.0961f
C932 a_20723_1842# a_20831_1842# 0.01163f
C933 VDD a_6391_2470# 0.01806f
C934 a_10328_1044# a_10404_1008# 0.01176f
C935 a_6711_1008# a_6425_1044# 0.01885f
C936 a_23871_2470# a_23763_1842# 0.01697f
C937 a_4248_1044# a_4157_1313# 0.11672f
C938 a_17683_1842# VDD 0.49671f
C939 a_25283_1842# a_24957_1842# 0.01427f
C940 VDD a_13470_1044# 0.87936f
C941 MUX_SEL0 MUX_SEL2 0.01204f
C942 a_22590_1044# a_24523_1842# 0.01012f
C943 DELAY_VBIASP a_20723_1842# 0.06627f
C944 a_25630_1044# a_16108_289# 0.52614f
C945 a_6635_1044# VDD 0.15406f
C946 MUX_SEL1 a_2297_1395# 0.01995f
C947 a_1256_1044# MUX_SEL4 0.04908f
C948 a_18871_1008# VDD 0.2822f
C949 a_6283_1842# a_6391_2470# 0.01697f
C950 VDD a_2019_311# 1.43004f
C951 a_21625_1044# a_21911_1008# 0.01885f
C952 VDD a_21353_1842# 0.49285f
C953 a_8563_1842# a_8433_1842# 0.70845f
C954 a_14643_1842# a_14317_1842# 0.01427f
C955 a_10404_1008# VDD 0.28633f
C956 a_6711_1008# a_6717_1842# 0.02354f
C957 a_5197_1842# a_5191_1008# 0.02349f
C958 a_14025_1044# a_14235_1044# 0.09424f
C959 a_11277_1842# VDD 0.86909f
C960 a_5957_1842# a_4350_1044# 0.05231f
C961 a_26395_1044# a_26185_1044# 0.09424f
C962 a_13470_1044# a_15077_1842# 0.05231f
C963 a_13444_1008# a_13557_1842# 0.05157f
C964 a_4763_1842# a_4871_2470# 0.01697f
C965 a_1256_289# a_1544_289# 1.25711f
C966 a_18877_1842# a_19203_1842# 0.01427f
C967 VDD a_13991_2470# 0.01806f
C968 DELAY_OUT_LAST VDD 0.46312f
C969 VDD a_9465_1044# 0.29722f
C970 a_24631_1842# a_24523_1842# 0.01163f
C971 MUX_OUT a_2019_311# 8.45486f
C972 a_19550_1044# a_20968_1044# 0.38994f
C973 a_5844_1008# a_5197_1842# 0.02312f
C974 a_16851_309# a_15964_289# 0.16757f
C975 a_25913_1842# a_26477_1842# 0.0114f
C976 DELAY_VBIASN a_6717_1842# 0.09992f
C977 a_12797_1842# a_13557_1842# 0.06198f
C978 a_23355_1044# a_23431_1008# 0.01194f
C979 a_23111_1842# a_23003_1842# 0.01163f
C980 a_22590_1044# a_24084_1008# 0.28279f
C981 a_19448_1044# VDD 0.17274f
C982 a_15964_289# a_5731_289# 0.2778f
C983 a_13991_1842# a_13883_1842# 0.01163f
C984 a_15837_1842# a_16597_1842# 0.06198f
C985 DELAY_VBIASN a_14513_1842# 0.0961f
C986 DELAY_VBIASP a_23763_1842# 0.06627f
C987 DELAY_VBIASN a_23633_1842# 0.0961f
C988 a_25528_1044# a_25604_1008# 0.01176f
C989 a_24875_1044# VDD 0.15406f
C990 DELAY_VBIASN a_7043_1842# 0.07254f
C991 a_10517_1842# a_10083_1842# 0.69698f
C992 DELAY_VBIASP a_8237_1842# 0.0414f
C993 a_1544_1044# a_1721_1395# 0.38063f
C994 DELAY_VBIASP a_19963_1842# 0.06627f
C995 DELAY_VBIASN a_19833_1842# 0.0961f
C996 DELAY_VBIASP a_5197_1842# 0.0414f
C997 a_2019_311# a_2297_331# 0.04011f
C998 a_20105_1044# a_20315_1044# 0.09424f
C999 VDD a_24393_1842# 0.49285f
C1000 DELAY_VBIASP a_12993_1842# 0.11222f
C1001 a_7803_1842# VDD 0.4973f
C1002 a_10430_1044# a_11785_519# 0.02058f
C1003 a_26911_2470# a_26803_1842# 0.01697f
C1004 a_4437_1842# a_4324_1008# 0.05157f
C1005 VDD a_20593_1842# 0.49417f
C1006 a_4763_1842# VDD 0.4973f
C1007 a_9193_1842# a_9757_1842# 0.0114f
C1008 a_13470_1044# a_15837_1842# 0.02479f
C1009 a_18877_1842# a_18443_1842# 0.6972f
C1010 VDD a_9431_2470# 0.01806f
C1011 a_24665_1044# a_24875_1044# 0.09424f
C1012 a_13368_1044# a_13444_1008# 0.01176f
C1013 a_5115_1044# a_5191_1008# 0.01194f
C1014 a_15545_1044# VDD 0.29918f
C1015 a_18877_1842# a_16108_289# 0.0157f
C1016 VDD a_13557_1842# 0.86707f
C1017 a_5957_1842# a_6153_1842# 0.77122f
C1018 a_17553_1842# a_18117_1842# 0.0114f
C1019 a_10713_1842# a_10843_1842# 0.70845f
C1020 a_25717_1842# a_26185_1044# 0.19203f
C1021 a_7288_1044# a_7390_1044# 0.37183f
C1022 a_6711_1008# a_4350_1044# 0.26208f
C1023 VDD a_14825_519# 0.29292f
C1024 a_24197_1842# a_24393_1842# 0.77122f
C1025 DELAY_VBIASN a_25717_1842# 0.08411f
C1026 DELAY_VBIASP a_25913_1842# 0.11222f
C1027 a_17865_519# a_2019_311# 0.13959f
C1028 a_10713_1842# DELAY_VBIASN 0.0961f
C1029 MUX_SEL1 a_1544_1044# 0.1672f
C1030 MUX_SEL0 a_1721_1395# 0.01315f
C1031 a_7673_1842# a_7803_1842# 0.70845f
C1032 a_27433_1842# a_27997_1842# 0.0114f
C1033 DELAY_VBIASN a_22590_1044# 0.02115f
C1034 a_12797_1842# a_13368_1044# 0.10864f
C1035 a_20397_1842# a_20593_1842# 0.76914f
C1036 a_18004_1008# a_18117_1842# 0.02055f
C1037 a_2297_1395# a_1544_1044# 0.28651f
C1038 a_15545_1044# a_15077_1842# 0.2079f
C1039 a_9757_1842# a_10328_1044# 0.10864f
C1040 a_7803_1842# a_7911_2470# 0.01697f
C1041 DELAY_VBIASN a_15273_1842# 0.0961f
C1042 DELAY_VBIASP a_15403_1842# 0.06627f
C1043 a_17683_1842# a_17791_2470# 0.01697f
C1044 a_13753_1842# a_13883_1842# 0.70845f
C1045 a_12797_1842# a_12363_1842# 0.6972f
C1046 VDD a_23871_2470# 0.01806f
C1047 a_20105_1044# a_19637_1842# 0.19203f
C1048 a_27237_1842# a_25630_1044# 0.05253f
C1049 a_16510_1044# a_16851_309# 0.02131f
C1050 VDD a_27124_1008# 0.28225f
C1051 a_26477_1842# a_26471_1008# 0.02349f
C1052 a_26477_1842# VDD 0.86909f
C1053 a_21917_1842# a_22677_1842# 0.06198f
C1054 a_9193_1842# DELAY_VBIASP 0.11222f
C1055 a_23431_1008# VDD 0.28336f
C1056 MUX_SEL4 a_15765_463# 0.65508f
C1057 a_10430_1044# a_12791_1008# 0.26208f
C1058 DELAY_VBIASN a_4350_1044# 0.02115f
C1059 VDD a_16033_1842# 0.49413f
C1060 a_19073_1842# a_19203_1842# 0.70845f
C1061 a_16510_1044# a_17357_1842# 0.08038f
C1062 DELAY_VBIASN a_27563_1842# 0.07259f
C1063 a_7390_1044# a_8808_1044# 0.38994f
C1064 a_10430_1044# a_12797_1842# 0.02479f
C1065 DELAY_VBIASP a_17553_1842# 0.11222f
C1066 DELAY_VBIASN a_17357_1842# 0.09974f
C1067 MUX_SEL3 a_2019_311# 0.06209f
C1068 VDD a_14235_1044# 0.15389f
C1069 DELAY_VBIASN a_22677_1842# 0.08375f
C1070 DELAY_VBIASP a_22873_1842# 0.11222f
C1071 a_11473_1842# a_12037_1842# 0.0114f
C1072 a_23945_519# VDD 0.29292f
C1073 a_9757_1842# VDD 0.87771f
C1074 a_22590_1044# a_24951_1008# 0.26208f
C1075 a_16510_1044# a_17351_1008# 0.28268f
C1076 a_5191_1008# VDD 0.28565f
C1077 DELAY_VBIASP a_12797_1842# 0.0414f
C1078 DELAY_VBIASN a_11603_1842# 0.07254f
C1079 VDD a_5631_2470# 0.01806f
C1080 a_10328_1044# a_10430_1044# 0.37183f
C1081 a_12037_1842# a_12505_1044# 0.2079f
C1082 a_6635_1044# a_6425_1044# 0.09424f
C1083 a_18117_1842# VDD 0.85848f
C1084 a_25717_1842# a_24957_1842# 0.06198f
C1085 VDD a_13368_1044# 0.17274f
C1086 MUX_SEL0 MUX_SEL1 3.14917f
C1087 a_22590_1044# a_24957_1842# 0.02479f
C1088 MUX_SEL0 a_2297_1395# 0.10655f
C1089 a_5844_1008# VDD 0.28225f
C1090 a_12363_1842# VDD 0.4973f
C1091 a_9751_1008# a_9465_1044# 0.01885f
C1092 a_14964_1008# a_14317_1842# 0.02312f
C1093 a_18795_1044# VDD 0.15406f
C1094 a_8808_1044# a_8884_1008# 0.01176f
C1095 VDD a_5705_519# 0.29556f
C1096 VDD a_20723_1842# 0.49671f
C1097 DELAY_IN DELAY_VBIASP 0.07719f
C1098 a_10083_1842# a_10191_1842# 0.01163f
C1099 a_19203_1842# a_19311_2470# 0.01697f
C1100 a_10430_1044# VDD 0.88416f
C1101 a_7390_1044# a_8997_1842# 0.05231f
C1102 MUX_SEL4 a_13470_1044# 0.256f
C1103 VDD a_13231_2470# 0.01806f
C1104 a_18877_1842# a_19637_1842# 0.06198f
R0 DELAY_VBIASN.n1 DELAY_VBIASN.t31 34.3755
R1 DELAY_VBIASN.n1 DELAY_VBIASN.t30 33.0005
R2 DELAY_VBIASN.n2 DELAY_VBIASN.t29 33.0005
R3 DELAY_VBIASN.n3 DELAY_VBIASN.t28 33.0005
R4 DELAY_VBIASN.n4 DELAY_VBIASN.t27 33.0005
R5 DELAY_VBIASN.n5 DELAY_VBIASN.t26 33.0005
R6 DELAY_VBIASN.n6 DELAY_VBIASN.t25 33.0005
R7 DELAY_VBIASN.n7 DELAY_VBIASN.t24 33.0005
R8 DELAY_VBIASN.n8 DELAY_VBIASN.t23 33.0005
R9 DELAY_VBIASN.n9 DELAY_VBIASN.t22 33.0005
R10 DELAY_VBIASN.n10 DELAY_VBIASN.t21 33.0005
R11 DELAY_VBIASN.n11 DELAY_VBIASN.t20 33.0005
R12 DELAY_VBIASN.n12 DELAY_VBIASN.t19 33.0005
R13 DELAY_VBIASN.n13 DELAY_VBIASN.t18 33.0005
R14 DELAY_VBIASN.n14 DELAY_VBIASN.t17 33.0005
R15 DELAY_VBIASN.n15 DELAY_VBIASN.t16 33.0005
R16 DELAY_VBIASN.n16 DELAY_VBIASN.t15 33.0005
R17 DELAY_VBIASN.n17 DELAY_VBIASN.t14 33.0005
R18 DELAY_VBIASN.n18 DELAY_VBIASN.t13 33.0005
R19 DELAY_VBIASN.n19 DELAY_VBIASN.t12 33.0005
R20 DELAY_VBIASN.n20 DELAY_VBIASN.t11 33.0005
R21 DELAY_VBIASN.n21 DELAY_VBIASN.t10 33.0005
R22 DELAY_VBIASN.n22 DELAY_VBIASN.t9 33.0005
R23 DELAY_VBIASN.n23 DELAY_VBIASN.t8 33.0005
R24 DELAY_VBIASN.n24 DELAY_VBIASN.t7 33.0005
R25 DELAY_VBIASN.n25 DELAY_VBIASN.t6 33.0005
R26 DELAY_VBIASN.n26 DELAY_VBIASN.t5 33.0005
R27 DELAY_VBIASN.n27 DELAY_VBIASN.t4 33.0005
R28 DELAY_VBIASN.n28 DELAY_VBIASN.t3 33.0005
R29 DELAY_VBIASN.n29 DELAY_VBIASN.t2 33.0005
R30 DELAY_VBIASN.n30 DELAY_VBIASN.t1 33.0005
R31 DELAY_VBIASN.n0 DELAY_VBIASN.t0 33.0005
R32 DELAY_VBIASN DELAY_VBIASN.n0 1.55517
R33 DELAY_VBIASN.n0 DELAY_VBIASN.n30 1.3755
R34 DELAY_VBIASN.n30 DELAY_VBIASN.n29 1.3755
R35 DELAY_VBIASN.n29 DELAY_VBIASN.n28 1.3755
R36 DELAY_VBIASN.n28 DELAY_VBIASN.n27 1.3755
R37 DELAY_VBIASN.n27 DELAY_VBIASN.n26 1.3755
R38 DELAY_VBIASN.n26 DELAY_VBIASN.n25 1.3755
R39 DELAY_VBIASN.n25 DELAY_VBIASN.n24 1.3755
R40 DELAY_VBIASN.n24 DELAY_VBIASN.n23 1.3755
R41 DELAY_VBIASN.n23 DELAY_VBIASN.n22 1.3755
R42 DELAY_VBIASN.n22 DELAY_VBIASN.n21 1.3755
R43 DELAY_VBIASN.n21 DELAY_VBIASN.n20 1.3755
R44 DELAY_VBIASN.n20 DELAY_VBIASN.n19 1.3755
R45 DELAY_VBIASN.n19 DELAY_VBIASN.n18 1.3755
R46 DELAY_VBIASN.n18 DELAY_VBIASN.n17 1.3755
R47 DELAY_VBIASN.n17 DELAY_VBIASN.n16 1.3755
R48 DELAY_VBIASN.n16 DELAY_VBIASN.n15 1.3755
R49 DELAY_VBIASN.n15 DELAY_VBIASN.n14 1.3755
R50 DELAY_VBIASN.n14 DELAY_VBIASN.n13 1.3755
R51 DELAY_VBIASN.n13 DELAY_VBIASN.n12 1.3755
R52 DELAY_VBIASN.n12 DELAY_VBIASN.n11 1.3755
R53 DELAY_VBIASN.n11 DELAY_VBIASN.n10 1.3755
R54 DELAY_VBIASN.n10 DELAY_VBIASN.n9 1.3755
R55 DELAY_VBIASN.n9 DELAY_VBIASN.n8 1.3755
R56 DELAY_VBIASN.n8 DELAY_VBIASN.n7 1.3755
R57 DELAY_VBIASN.n7 DELAY_VBIASN.n6 1.3755
R58 DELAY_VBIASN.n6 DELAY_VBIASN.n5 1.3755
R59 DELAY_VBIASN.n5 DELAY_VBIASN.n4 1.3755
R60 DELAY_VBIASN.n4 DELAY_VBIASN.n3 1.3755
R61 DELAY_VBIASN.n3 DELAY_VBIASN.n2 1.3755
R62 DELAY_VBIASN.n2 DELAY_VBIASN.n1 1.3755
R63 DELAY_VBIASP.n1 DELAY_VBIASP.t31 34.3685
R64 DELAY_VBIASP.n1 DELAY_VBIASP.t30 33.0005
R65 DELAY_VBIASP.n2 DELAY_VBIASP.t29 33.0005
R66 DELAY_VBIASP.n3 DELAY_VBIASP.t28 33.0005
R67 DELAY_VBIASP.n4 DELAY_VBIASP.t27 33.0005
R68 DELAY_VBIASP.n5 DELAY_VBIASP.t26 33.0005
R69 DELAY_VBIASP.n6 DELAY_VBIASP.t25 33.0005
R70 DELAY_VBIASP.n7 DELAY_VBIASP.t24 33.0005
R71 DELAY_VBIASP.n8 DELAY_VBIASP.t23 33.0005
R72 DELAY_VBIASP.n9 DELAY_VBIASP.t22 33.0005
R73 DELAY_VBIASP.n10 DELAY_VBIASP.t21 33.0005
R74 DELAY_VBIASP.n11 DELAY_VBIASP.t20 33.0005
R75 DELAY_VBIASP.n12 DELAY_VBIASP.t19 33.0005
R76 DELAY_VBIASP.n13 DELAY_VBIASP.t18 33.0005
R77 DELAY_VBIASP.n14 DELAY_VBIASP.t17 33.0005
R78 DELAY_VBIASP.n15 DELAY_VBIASP.t16 33.0005
R79 DELAY_VBIASP.n16 DELAY_VBIASP.t15 33.0005
R80 DELAY_VBIASP.n17 DELAY_VBIASP.t14 33.0005
R81 DELAY_VBIASP.n18 DELAY_VBIASP.t13 33.0005
R82 DELAY_VBIASP.n19 DELAY_VBIASP.t12 33.0005
R83 DELAY_VBIASP.n20 DELAY_VBIASP.t11 33.0005
R84 DELAY_VBIASP.n21 DELAY_VBIASP.t10 33.0005
R85 DELAY_VBIASP.n22 DELAY_VBIASP.t9 33.0005
R86 DELAY_VBIASP.n23 DELAY_VBIASP.t8 33.0005
R87 DELAY_VBIASP.n24 DELAY_VBIASP.t7 33.0005
R88 DELAY_VBIASP.n25 DELAY_VBIASP.t6 33.0005
R89 DELAY_VBIASP.n26 DELAY_VBIASP.t5 33.0005
R90 DELAY_VBIASP.n27 DELAY_VBIASP.t4 33.0005
R91 DELAY_VBIASP.n28 DELAY_VBIASP.t3 33.0005
R92 DELAY_VBIASP.n29 DELAY_VBIASP.t2 33.0005
R93 DELAY_VBIASP.n30 DELAY_VBIASP.t1 33.0005
R94 DELAY_VBIASP.n0 DELAY_VBIASP.t0 33.0005
R95 DELAY_VBIASP DELAY_VBIASP.n0 1.70586
R96 DELAY_VBIASP.n0 DELAY_VBIASP.n30 1.36852
R97 DELAY_VBIASP.n30 DELAY_VBIASP.n29 1.36852
R98 DELAY_VBIASP.n29 DELAY_VBIASP.n28 1.36852
R99 DELAY_VBIASP.n28 DELAY_VBIASP.n27 1.36852
R100 DELAY_VBIASP.n27 DELAY_VBIASP.n26 1.36852
R101 DELAY_VBIASP.n26 DELAY_VBIASP.n25 1.36852
R102 DELAY_VBIASP.n25 DELAY_VBIASP.n24 1.36852
R103 DELAY_VBIASP.n24 DELAY_VBIASP.n23 1.36852
R104 DELAY_VBIASP.n23 DELAY_VBIASP.n22 1.36852
R105 DELAY_VBIASP.n22 DELAY_VBIASP.n21 1.36852
R106 DELAY_VBIASP.n21 DELAY_VBIASP.n20 1.36852
R107 DELAY_VBIASP.n20 DELAY_VBIASP.n19 1.36852
R108 DELAY_VBIASP.n19 DELAY_VBIASP.n18 1.36852
R109 DELAY_VBIASP.n18 DELAY_VBIASP.n17 1.36852
R110 DELAY_VBIASP.n17 DELAY_VBIASP.n16 1.36852
R111 DELAY_VBIASP.n16 DELAY_VBIASP.n15 1.36852
R112 DELAY_VBIASP.n15 DELAY_VBIASP.n14 1.36852
R113 DELAY_VBIASP.n14 DELAY_VBIASP.n13 1.36852
R114 DELAY_VBIASP.n13 DELAY_VBIASP.n12 1.36852
R115 DELAY_VBIASP.n12 DELAY_VBIASP.n11 1.36852
R116 DELAY_VBIASP.n11 DELAY_VBIASP.n10 1.36852
R117 DELAY_VBIASP.n10 DELAY_VBIASP.n9 1.36852
R118 DELAY_VBIASP.n9 DELAY_VBIASP.n8 1.36852
R119 DELAY_VBIASP.n8 DELAY_VBIASP.n7 1.36852
R120 DELAY_VBIASP.n7 DELAY_VBIASP.n6 1.36852
R121 DELAY_VBIASP.n6 DELAY_VBIASP.n5 1.36852
R122 DELAY_VBIASP.n5 DELAY_VBIASP.n4 1.36852
R123 DELAY_VBIASP.n4 DELAY_VBIASP.n3 1.36852
R124 DELAY_VBIASP.n3 DELAY_VBIASP.n2 1.36852
R125 DELAY_VBIASP.n2 DELAY_VBIASP.n1 1.36852
R126 VSS.n35 VSS.n148 7963.82
R127 VSS.n23 VSS.n471 469.783
R128 VSS.n54 VSS.n454 469.783
R129 VSS.n49 VSS.n443 469.783
R130 VSS.n44 VSS.n34 469.783
R131 VSS.t276 VSS.n25 101.74
R132 VSS.n52 VSS.t308 402.185
R133 VSS.n47 VSS.t323 402.185
R134 VSS.n15 VSS.n16 465.022
R135 VSS.n42 VSS.t353 402.185
R136 VSS.t243 VSS.n27 116.469
R137 VSS.n1 VSS.n0 0.00292781
R138 VSS.n453 VSS.n447 454.007
R139 VSS.t246 VSS.n30 116.469
R140 VSS.t120 VSS.n4 442.469
R141 VSS.t554 VSS.n475 437.62
R142 VSS.n38 VSS.n155 0.547872
R143 VSS.n37 VSS.t358 413.695
R144 VSS.t343 VSS.n17 49.8619
R145 VSS.t328 VSS.n150 413.695
R146 VSS.t313 VSS.n151 413.695
R147 VSS.n19 VSS.t301 97.2306
R148 VSS.t283 VSS.n153 413.695
R149 VSS.n479 VSS.t555 403.072
R150 VSS.n2 VSS.t293 58.3216
R151 VSS.n16 VSS.t338 402.185
R152 VSS.n156 VSS.t177 412.901
R153 VSS.n477 VSS.t36 391.555
R154 VSS.t4 VSS.n11 221.012
R155 VSS.t562 VSS.n476 357.007
R156 VSS.t561 VSS.n12 343.118
R157 VSS.t161 VSS.n8 384.904
R158 VSS.n153 VSS.t286 97.2238
R159 VSS.n151 VSS.t316 97.2238
R160 VSS.n17 VSS.t346 97.2306
R161 VSS.n37 VSS.t361 97.2238
R162 VSS.t114 VSS.n149 332.017
R163 VSS.n522 VSS.t291 305.183
R164 VSS.n52 VSS.t306 321.57
R165 VSS.n47 VSS.t321 321.57
R166 VSS.n15 VSS.t336 96.4304
R167 VSS.n42 VSS.t351 321.57
R168 VSS.n478 VSS.t118 299.425
R169 VSS.n20 VSS.n10 0.00353491
R170 VSS.n28 VSS.n21 0.0022108
R171 VSS.t303 VSS.n0 310.053
R172 VSS.t318 VSS.n447 293.666
R173 VSS.t333 VSS.n14 105.686
R174 VSS.t348 VSS.n31 310.053
R175 VSS.n36 VSS.t185 110.546
R176 VSS.n32 VSS.t34 116.468
R177 VSS.t245 VSS.n30 110.547
R178 VSS.t390 VSS.n40 110.543
R179 VSS.n29 VSS.t234 116.468
R180 VSS.t242 VSS.n27 110.547
R181 VSS.t387 VSS.n33 110.547
R182 VSS.n478 VSS.t162 287.909
R183 VSS.t383 VSS.n4 269.724
R184 VSS.t116 VSS.n149 106.362
R185 VSS.t97 VSS.n39 332.017
R186 VSS.n152 VSS.n38 0.00588066
R187 VSS.n10 VSS.n33 0.00596635
R188 VSS.n29 VSS.n1 0.00596633
R189 VSS.t391 VSS.n453 258.233
R190 VSS.n32 VSS.n13 0.00596633
R191 VSS.t38 VSS.n6 258.231
R192 VSS.t382 VSS.n12 107.931
R193 VSS.n85 VSS.t269 252.375
R194 VSS.t40 VSS.n89 252.375
R195 VSS.t507 VSS.n92 252.375
R196 VSS.n125 VSS.t403 252.375
R197 VSS.n142 VSS.t169 252.375
R198 VSS.n140 VSS.t272 252.375
R199 VSS.n95 VSS.t191 252.375
R200 VSS.n136 VSS.t58 252.375
R201 VSS.t259 VSS.n97 252.375
R202 VSS.n134 VSS.t414 252.375
R203 VSS.n133 VSS.t192 252.375
R204 VSS.n107 VSS.t395 252.375
R205 VSS.t184 VSS.n109 252.375
R206 VSS.n130 VSS.t500 252.375
R207 VSS.t188 VSS.n116 252.375
R208 VSS.n128 VSS.t260 252.375
R209 VSS.t213 VSS.n122 252.375
R210 VSS.t13 VSS.n88 252.117
R211 VSS.t212 VSS.n98 252.117
R212 VSS.t559 VSS.n101 252.117
R213 VSS.t558 VSS.n104 252.117
R214 VSS.n114 VSS.t517 252.117
R215 VSS.n118 VSS.t180 252.117
R216 VSS.t8 VSS.n119 252.117
R217 VSS.n141 VSS.t59 252.115
R218 VSS.n137 VSS.t196 252.115
R219 VSS.t399 VSS.n66 252.115
R220 VSS.t122 VSS.n69 252.115
R221 VSS.t41 VSS.n73 252.115
R222 VSS.t550 VSS.n77 252.115
R223 VSS.n131 VSS.t163 252.115
R224 VSS.t386 VSS.n82 252.115
R225 VSS.t421 VSS.n285 250.837
R226 VSS.t427 VSS.n287 250.837
R227 VSS.t433 VSS.n293 250.837
R228 VSS.t419 VSS.n295 250.837
R229 VSS.t435 VSS.n301 250.837
R230 VSS.t431 VSS.n303 250.837
R231 VSS.t425 VSS.n309 250.837
R232 VSS.t437 VSS.n311 250.837
R233 VSS.t429 VSS.n317 250.837
R234 VSS.t439 VSS.n319 250.837
R235 VSS.t441 VSS.n325 250.837
R236 VSS.t415 VSS.n327 250.837
R237 VSS.t451 VSS.n333 250.837
R238 VSS.t453 VSS.n335 250.837
R239 VSS.t447 VSS.n341 250.837
R240 VSS.t455 VSS.n343 250.837
R241 VSS.t457 VSS.n349 250.837
R242 VSS.t459 VSS.n351 250.837
R243 VSS.t443 VSS.n357 250.837
R244 VSS.t461 VSS.n359 250.837
R245 VSS.t449 VSS.n365 250.837
R246 VSS.t463 VSS.n367 250.837
R247 VSS.t445 VSS.n373 250.837
R248 VSS.t423 VSS.n375 250.837
R249 VSS.t467 VSS.n381 250.837
R250 VSS.t471 VSS.n383 250.837
R251 VSS.t417 VSS.n389 250.837
R252 VSS.t475 VSS.n391 250.837
R253 VSS.t473 VSS.n397 250.837
R254 VSS.t469 VSS.n399 250.837
R255 VSS.t477 VSS.n405 250.837
R256 VSS.t465 VSS.n407 250.837
R257 VSS.n10 VSS.n26 0.315147
R258 VSS.n22 VSS.t281 240.956
R259 VSS.n53 VSS.t311 240.956
R260 VSS.n48 VSS.t326 240.956
R261 VSS.n18 VSS.t341 117.528
R262 VSS.n43 VSS.t356 240.956
R263 VSS.n866 VSS.t265 234.114
R264 VSS.n849 VSS.t547 234.114
R265 VSS.n832 VSS.t479 234.114
R266 VSS.n815 VSS.t70 234.114
R267 VSS.n798 VSS.t489 234.114
R268 VSS.n781 VSS.t404 234.114
R269 VSS.n764 VSS.t16 234.114
R270 VSS.n747 VSS.t546 234.114
R271 VSS.n730 VSS.t402 234.114
R272 VSS.n713 VSS.t210 234.114
R273 VSS.n696 VSS.t87 234.114
R274 VSS.n679 VSS.t396 234.114
R275 VSS.n662 VSS.t85 234.114
R276 VSS.n645 VSS.t193 234.114
R277 VSS.n628 VSS.t503 234.114
R278 VSS.n611 VSS.t205 234.114
R279 VSS.t4 VSS.n476 230.327
R280 VSS.t281 VSS.n23 229.44
R281 VSS.t296 VSS.n1 117.528
R282 VSS.t311 VSS.n54 229.44
R283 VSS.t326 VSS.n49 229.44
R284 VSS.n18 VSS.n13 0.002384
R285 VSS.t356 VSS.n44 229.44
R286 VSS.t380 VSS.n26 117.216
R287 VSS.t267 VSS.n86 225.361
R288 VSS.t68 VSS.n94 225.361
R289 VSS.t14 VSS.n99 225.361
R290 VSS.t544 VSS.n102 225.361
R291 VSS.t400 VSS.n105 225.361
R292 VSS.t88 VSS.n111 225.361
R293 VSS.t194 VSS.n120 225.361
R294 VSS.t501 VSS.n124 225.361
R295 VSS.t508 VSS.n62 225.359
R296 VSS.n139 VSS.t548 225.359
R297 VSS.t481 VSS.n65 225.359
R298 VSS.t491 VSS.n70 225.359
R299 VSS.t406 VSS.n74 225.359
R300 VSS.t208 VSS.n78 225.359
R301 VSS.t397 VSS.n79 225.359
R302 VSS.t83 VSS.n80 225.359
R303 VSS.n152 VSS.t73 116.469
R304 VSS.n36 VSS.t186 116.469
R305 VSS.t140 VSS.n64 211.982
R306 VSS.t105 VSS.n67 211.982
R307 VSS.t137 VSS.n71 211.982
R308 VSS.t149 VSS.n83 211.982
R309 VSS.n143 VSS.t236 211.982
R310 VSS.n138 VSS.t510 211.982
R311 VSS.n129 VSS.t530 211.982
R312 VSS.n91 VSS.t251 211.982
R313 VSS.n96 VSS.t518 211.982
R314 VSS.n100 VSS.t527 211.982
R315 VSS.n103 VSS.t111 211.982
R316 VSS.n106 VSS.t248 211.982
R317 VSS.n108 VSS.t524 211.982
R318 VSS.n112 VSS.t146 211.982
R319 VSS.n115 VSS.t521 211.982
R320 VSS.n121 VSS.t217 211.982
R321 VSS.n10 VSS.n12 7.24297
R322 VSS.n477 VSS.t38 195.778
R323 VSS.t393 VSS.n87 195.26
R324 VSS.t542 VSS.n90 195.26
R325 VSS.t166 VSS.n93 195.26
R326 VSS.t182 VSS.n110 195.26
R327 VSS.t201 VSS.n113 195.26
R328 VSS.t264 VSS.n117 195.26
R329 VSS.t79 VSS.n123 195.26
R330 VSS.t483 VSS.n63 195.26
R331 VSS.t11 VSS.n68 195.26
R332 VSS.t103 VSS.n72 195.26
R333 VSS.n135 VSS.t257 195.26
R334 VSS.t378 VSS.n75 195.26
R335 VSS.n132 VSS.t557 195.26
R336 VSS.t54 VSS.n76 195.26
R337 VSS.t493 VSS.n81 195.26
R338 VSS.t410 VSS.n84 195.26
R339 VSS.t270 VSS.n10 114.148
R340 VSS.t99 VSS.n39 106.362
R341 VSS.n10 VSS.n149 6.82737
R342 VSS.n872 VSS.t133 187.292
R343 VSS.n855 VSS.t158 187.292
R344 VSS.n838 VSS.t535 187.292
R345 VSS.n821 VSS.t75 187.292
R346 VSS.n804 VSS.t534 187.292
R347 VSS.n787 VSS.t135 187.292
R348 VSS.n770 VSS.t229 187.292
R349 VSS.n753 VSS.t533 187.292
R350 VSS.n736 VSS.t231 187.292
R351 VSS.n719 VSS.t160 187.292
R352 VSS.n702 VSS.t538 187.292
R353 VSS.n685 VSS.t537 187.292
R354 VSS.n668 VSS.t225 187.292
R355 VSS.n651 VSS.t173 187.292
R356 VSS.n634 VSS.t136 187.292
R357 VSS.n617 VSS.t223 187.292
R358 VSS.n479 VSS.t383 184.262
R359 VSS.n38 VSS.n40 0.00954674
R360 VSS.n21 VSS.n27 0.00596634
R361 VSS.n29 VSS.t233 110.547
R362 VSS.n152 VSS.t72 110.546
R363 VSS.n32 VSS.t33 110.547
R364 VSS.n36 VSS.n35 0.00588067
R365 VSS.t109 VSS.n291 173.913
R366 VSS.t22 VSS.n299 173.913
R367 VSS.t48 VSS.n307 173.913
R368 VSS.n315 VSS.t240 173.913
R369 VSS.n323 VSS.t255 173.913
R370 VSS.n331 VSS.t127 173.913
R371 VSS.t28 VSS.n339 173.913
R372 VSS.t91 VSS.n347 173.913
R373 VSS.t45 VSS.n355 173.913
R374 VSS.n363 VSS.t215 173.913
R375 VSS.t144 VSS.n371 173.913
R376 VSS.t153 VSS.n379 173.913
R377 VSS.t31 VSS.n387 173.913
R378 VSS.t19 VSS.n395 173.913
R379 VSS.n403 VSS.t25 173.913
R380 VSS.t124 VSS.n411 173.913
R381 VSS.n148 VSS.t375 122.516
R382 VSS.t237 VSS.t484 163.881
R383 VSS.t141 VSS.t394 163.881
R384 VSS.t511 VSS.t541 163.881
R385 VSS.t252 VSS.t167 163.881
R386 VSS.t106 VSS.t9 163.881
R387 VSS.t138 VSS.t102 163.881
R388 VSS.t519 VSS.t258 163.881
R389 VSS.t528 VSS.t377 163.881
R390 VSS.t112 VSS.t556 163.881
R391 VSS.t249 VSS.t56 163.881
R392 VSS.t525 VSS.t181 163.881
R393 VSS.t147 VSS.t199 163.881
R394 VSS.t522 VSS.t263 163.881
R395 VSS.t531 VSS.t494 163.881
R396 VSS.t218 VSS.t81 163.881
R397 VSS.t150 VSS.t411 163.881
R398 VSS.n20 VSS.t273 105.688
R399 VSS.n28 VSS.t288 105.686
R400 VSS.n51 VSS.t303 160.341
R401 VSS.n46 VSS.t318 160.341
R402 VSS.n15 VSS.n14 5.37254
R403 VSS.n41 VSS.t348 160.341
R404 VSS.t498 VSS.n57 157.062
R405 VSS.t488 VSS.n58 156.429
R406 VSS.t551 VSS.n91 155.126
R407 VSS.t164 VSS.n96 155.126
R408 VSS.t95 VSS.n100 155.126
R409 VSS.t515 VSS.n103 155.126
R410 VSS.t176 VSS.n106 155.126
R411 VSS.t93 VSS.n108 155.126
R412 VSS.t539 VSS.n112 155.126
R413 VSS.t62 VSS.n115 155.126
R414 VSS.t207 VSS.n121 155.126
R415 VSS.n143 VSS.t77 155.125
R416 VSS.t189 VSS.n64 155.125
R417 VSS.n138 VSS.t384 155.125
R418 VSS.t412 VSS.n67 155.125
R419 VSS.t64 VSS.n71 155.125
R420 VSS.n129 VSS.t203 155.125
R421 VSS.t197 VSS.n83 155.125
R422 VSS.t118 VSS.n5 153.971
R423 VSS.n894 VSS.t2 153.846
R424 VSS.n872 VSS.t108 153.846
R425 VSS.n855 VSS.t21 153.846
R426 VSS.n838 VSS.t47 153.846
R427 VSS.n821 VSS.t239 153.846
R428 VSS.n804 VSS.t254 153.846
R429 VSS.n787 VSS.t126 153.846
R430 VSS.n770 VSS.t27 153.846
R431 VSS.n753 VSS.t90 153.846
R432 VSS.n736 VSS.t44 153.846
R433 VSS.n719 VSS.t214 153.846
R434 VSS.n702 VSS.t143 153.846
R435 VSS.n685 VSS.t152 153.846
R436 VSS.n668 VSS.t30 153.846
R437 VSS.n651 VSS.t18 153.846
R438 VSS.n634 VSS.t24 153.846
R439 VSS.n617 VSS.t123 153.846
R440 VSS.t221 VSS.n58 153.327
R441 VSS.t499 VSS.n59 153.236
R442 VSS.t162 VSS.n475 149.713
R443 VSS.n25 VSS.n24 0.00158419
R444 VSS.t306 VSS.n51 148.826
R445 VSS.t321 VSS.n46 148.826
R446 VSS.t351 VSS.n41 148.826
R447 VSS.t409 VSS.n290 147.157
R448 VSS.t42 VSS.n298 147.157
R449 VSS.t505 VSS.n306 147.157
R450 VSS.t408 VSS.n314 147.157
R451 VSS.t495 VSS.n322 147.157
R452 VSS.t506 VSS.n330 147.157
R453 VSS.t170 VSS.n338 147.157
R454 VSS.t513 VSS.n346 147.157
R455 VSS.t66 VSS.n354 147.157
R456 VSS.t560 VSS.n362 147.157
R457 VSS.t60 VSS.n370 147.157
R458 VSS.t261 VSS.n378 147.157
R459 VSS.t540 VSS.n386 147.157
R460 VSS.t171 VSS.n394 147.157
R461 VSS.t543 VSS.n402 147.157
R462 VSS.t413 VSS.n410 147.157
R463 VSS.n127 VSS.t375 145.093
R464 VSS.n127 VSS.t371 138.404
R465 VSS.n37 VSS.n35 0.00760728
R466 VSS.t331 VSS.n150 97.2238
R467 VSS.n151 VSS.n38 0.00760728
R468 VSS.n153 VSS.n21 0.00760728
R469 VSS.t552 VSS.n8 97.2225
R470 VSS.n144 VSS.t155 134.661
R471 VSS.t371 VSS.n126 131.974
R472 VSS.n3 VSS.t114 130.939
R473 VSS.n155 VSS.t97 131.005
R474 VSS.n904 VSS.t129 126.945
R475 VSS.n905 VSS.t52 123.212
R476 VSS.n59 VSS.t488 120.691
R477 VSS.n9 VSS.t561 119.422
R478 VSS.t496 VSS.n144 117.858
R479 VSS.t227 VSS.n177 115.745
R480 VSS.t228 VSS.n178 108.276
R481 VSS.t77 VSS.n874 107.023
R482 VSS.n866 VSS.t409 107.023
R483 VSS.n857 VSS.t189 107.023
R484 VSS.n849 VSS.t42 107.023
R485 VSS.t384 VSS.n840 107.023
R486 VSS.n832 VSS.t505 107.023
R487 VSS.n823 VSS.t551 107.023
R488 VSS.n815 VSS.t408 107.023
R489 VSS.n806 VSS.t412 107.023
R490 VSS.n798 VSS.t495 107.023
R491 VSS.n789 VSS.t64 107.023
R492 VSS.n781 VSS.t506 107.023
R493 VSS.n772 VSS.t164 107.023
R494 VSS.n764 VSS.t170 107.023
R495 VSS.n755 VSS.t95 107.023
R496 VSS.n747 VSS.t513 107.023
R497 VSS.n738 VSS.t515 107.023
R498 VSS.n730 VSS.t66 107.023
R499 VSS.n721 VSS.t176 107.023
R500 VSS.n713 VSS.t560 107.023
R501 VSS.n704 VSS.t93 107.023
R502 VSS.n696 VSS.t60 107.023
R503 VSS.n687 VSS.t539 107.023
R504 VSS.n679 VSS.t261 107.023
R505 VSS.n670 VSS.t62 107.023
R506 VSS.n662 VSS.t540 107.023
R507 VSS.t203 VSS.n653 107.023
R508 VSS.n645 VSS.t171 107.023
R509 VSS.n636 VSS.t207 107.023
R510 VSS.n628 VSS.t543 107.023
R511 VSS.n619 VSS.t197 107.023
R512 VSS.n611 VSS.t413 107.023
R513 VSS.n894 VSS.t364 100.335
R514 VSS.t108 VSS.n290 100.335
R515 VSS.t21 VSS.n298 100.335
R516 VSS.t47 VSS.n306 100.335
R517 VSS.t239 VSS.n314 100.335
R518 VSS.t254 VSS.n322 100.335
R519 VSS.t126 VSS.n330 100.335
R520 VSS.t27 VSS.n338 100.335
R521 VSS.t90 VSS.n346 100.335
R522 VSS.t44 VSS.n354 100.335
R523 VSS.t214 VSS.n362 100.335
R524 VSS.t143 VSS.n370 100.335
R525 VSS.t152 VSS.n378 100.335
R526 VSS.t30 VSS.n386 100.335
R527 VSS.t18 VSS.n394 100.335
R528 VSS.t24 VSS.n402 100.335
R529 VSS.t123 VSS.n410 100.335
R530 VSS.n903 VSS.t220 97.0758
R531 VSS.n7 VSS.t562 96.3896
R532 VSS.t131 VSS.n57 93.5889
R533 VSS.n903 VSS.t156 93.3421
R534 VSS.n126 VSS.t124 88.4945
R535 VSS.t240 VSS.n66 88.2366
R536 VSS.t255 VSS.n69 88.2366
R537 VSS.t127 VSS.n73 88.2366
R538 VSS.t215 VSS.n77 88.2366
R539 VSS.t25 VSS.n82 88.2366
R540 VSS.n141 VSS.t109 88.2366
R541 VSS.n137 VSS.t48 88.2366
R542 VSS.n131 VSS.t144 88.2366
R543 VSS.n88 VSS.t22 88.2359
R544 VSS.n98 VSS.t28 88.2359
R545 VSS.n101 VSS.t91 88.2359
R546 VSS.n104 VSS.t45 88.2359
R547 VSS.n114 VSS.t153 88.2359
R548 VSS.n118 VSS.t31 88.2359
R549 VSS.n119 VSS.t19 88.2359
R550 VSS.n145 VSS.t485 88.133
R551 VSS.t364 VSS.t0 86.957
R552 VSS.t2 VSS.t368 86.957
R553 VSS.t161 VSS.n7 84.8733
R554 VSS.t485 VSS.n176 82.7875
R555 VSS.n178 VSS.t487 82.1411
R556 VSS.t487 VSS.n56 75.0671
R557 VSS.t0 VSS.n61 74.8579
R558 VSS.t50 VSS.n177 74.6738
R559 VSS.t6 VSS.n11 59.6836
R560 VSS.n874 VSS.t237 70.2346
R561 VSS.n857 VSS.t141 70.2346
R562 VSS.n840 VSS.t511 70.2346
R563 VSS.n823 VSS.t252 70.2346
R564 VSS.n806 VSS.t106 70.2346
R565 VSS.n789 VSS.t138 70.2346
R566 VSS.n772 VSS.t519 70.2346
R567 VSS.n755 VSS.t528 70.2346
R568 VSS.n738 VSS.t112 70.2346
R569 VSS.n721 VSS.t249 70.2346
R570 VSS.n704 VSS.t525 70.2346
R571 VSS.n687 VSS.t147 70.2346
R572 VSS.n670 VSS.t522 70.2346
R573 VSS.n653 VSS.t531 70.2346
R574 VSS.n636 VSS.t218 70.2346
R575 VSS.n619 VSS.t150 70.2346
R576 VSS.t278 VSS.n22 68.211
R577 VSS.n2 VSS.n1 0.00146165
R578 VSS.t308 VSS.n53 68.211
R579 VSS.t323 VSS.n48 68.211
R580 VSS.t353 VSS.n43 68.211
R581 VSS.n905 VSS.t50 67.2065
R582 VSS.n873 VSS.t483 66.8901
R583 VSS.t133 VSS.n287 66.8901
R584 VSS.n856 VSS.t393 66.8901
R585 VSS.t158 VSS.n295 66.8901
R586 VSS.n839 VSS.t542 66.8901
R587 VSS.t535 VSS.n303 66.8901
R588 VSS.n822 VSS.t166 66.8901
R589 VSS.t75 VSS.n311 66.8901
R590 VSS.n805 VSS.t11 66.8901
R591 VSS.t534 VSS.n319 66.8901
R592 VSS.n788 VSS.t103 66.8901
R593 VSS.t135 VSS.n327 66.8901
R594 VSS.t257 VSS.n771 66.8901
R595 VSS.t229 VSS.n335 66.8901
R596 VSS.n754 VSS.t378 66.8901
R597 VSS.t533 VSS.n343 66.8901
R598 VSS.t557 VSS.n737 66.8901
R599 VSS.t231 VSS.n351 66.8901
R600 VSS.n720 VSS.t54 66.8901
R601 VSS.t160 VSS.n359 66.8901
R602 VSS.n703 VSS.t182 66.8901
R603 VSS.t538 VSS.n367 66.8901
R604 VSS.n686 VSS.t201 66.8901
R605 VSS.t537 VSS.n375 66.8901
R606 VSS.n669 VSS.t264 66.8901
R607 VSS.t225 VSS.n383 66.8901
R608 VSS.n652 VSS.t493 66.8901
R609 VSS.t173 VSS.n391 66.8901
R610 VSS.n635 VSS.t79 66.8901
R611 VSS.t136 VSS.n399 66.8901
R612 VSS.n618 VSS.t410 66.8901
R613 VSS.t223 VSS.n407 66.8901
R614 VSS.n904 VSS.t131 63.4728
R615 VSS.t156 VSS.n180 62.2523
R616 VSS.t36 VSS.n9 61.8407
R617 VSS.t220 VSS.n902 58.5186
R618 VSS.t177 VSS.n154 56.6955
R619 VSS.n471 VSS.t283 56.0825
R620 VSS.n19 VSS.t298 49.8619
R621 VSS.n454 VSS.t313 56.0825
R622 VSS.n443 VSS.t328 56.0825
R623 VSS.n13 VSS.n17 0.00185661
R624 VSS.t358 VSS.n34 56.0825
R625 VSS.n145 VSS.t496 54.532
R626 VSS.t555 VSS.n3 50.3244
R627 VSS.t101 VSS.n155 44.8755
R628 VSS.t236 VSS.n285 50.1677
R629 VSS.n293 VSS.t140 50.1677
R630 VSS.t510 VSS.n301 50.1677
R631 VSS.t251 VSS.n309 50.1677
R632 VSS.n317 VSS.t105 50.1677
R633 VSS.n325 VSS.t137 50.1677
R634 VSS.t518 VSS.n333 50.1677
R635 VSS.t527 VSS.n341 50.1677
R636 VSS.t111 VSS.n349 50.1677
R637 VSS.t248 VSS.n357 50.1677
R638 VSS.t524 VSS.n365 50.1677
R639 VSS.t146 VSS.n373 50.1677
R640 VSS.t521 VSS.n381 50.1677
R641 VSS.t530 VSS.n389 50.1677
R642 VSS.t217 VSS.n397 50.1677
R643 VSS.n405 VSS.t149 50.1677
R644 VSS.n179 VSS.t228 47.3176
R645 VSS.n906 VSS.t227 39.8503
R646 VSS.n881 VSS.t508 36.7898
R647 VSS.n865 VSS.t267 36.7898
R648 VSS.t548 VSS.n848 36.7898
R649 VSS.n831 VSS.t481 36.7898
R650 VSS.n814 VSS.t68 36.7898
R651 VSS.n797 VSS.t491 36.7898
R652 VSS.n780 VSS.t406 36.7898
R653 VSS.n763 VSS.t14 36.7898
R654 VSS.n746 VSS.t544 36.7898
R655 VSS.n729 VSS.t400 36.7898
R656 VSS.n712 VSS.t208 36.7898
R657 VSS.n695 VSS.t88 36.7898
R658 VSS.n678 VSS.t397 36.7898
R659 VSS.n661 VSS.t83 36.7898
R660 VSS.n644 VSS.t194 36.7898
R661 VSS.n627 VSS.t501 36.7898
R662 VSS.t155 VSS.n906 36.1166
R663 VSS.t52 VSS.n56 33.9948
R664 VSS.t129 VSS.n179 28.6493
R665 VSS.t484 VSS.n142 28.2938
R666 VSS.t394 VSS.n140 28.2938
R667 VSS.t9 VSS.n95 28.2938
R668 VSS.t102 VSS.n136 28.2938
R669 VSS.t258 VSS.n97 28.2938
R670 VSS.t377 VSS.n134 28.2938
R671 VSS.t556 VSS.n133 28.2938
R672 VSS.t56 VSS.n107 28.2938
R673 VSS.t181 VSS.n109 28.2938
R674 VSS.t199 VSS.n130 28.2938
R675 VSS.t263 VSS.n116 28.2938
R676 VSS.t494 VSS.n128 28.2938
R677 VSS.t81 VSS.n122 28.2938
R678 VSS.t541 VSS.n89 28.2928
R679 VSS.t167 VSS.n92 28.2928
R680 VSS.t411 VSS.n125 28.2928
R681 VSS.n61 VSS.t499 28.0359
R682 VSS.n5 VSS.t120 27.2918
R683 VSS.t178 VSS.n154 21.1052
R684 VSS.n156 VSS.t175 20.3065
R685 VSS.t368 VSS.n85 21.6039
R686 VSS.t265 VSS.n291 20.0674
R687 VSS.t547 VSS.n299 20.0674
R688 VSS.t479 VSS.n307 20.0674
R689 VSS.t70 VSS.n315 20.0674
R690 VSS.t489 VSS.n323 20.0674
R691 VSS.t404 VSS.n331 20.0674
R692 VSS.t16 VSS.n339 20.0674
R693 VSS.t546 VSS.n347 20.0674
R694 VSS.t402 VSS.n355 20.0674
R695 VSS.t210 VSS.n363 20.0674
R696 VSS.t87 VSS.n371 20.0674
R697 VSS.t396 VSS.n379 20.0674
R698 VSS.t85 VSS.n387 20.0674
R699 VSS.t193 VSS.n395 20.0674
R700 VSS.t503 VSS.n403 20.0674
R701 VSS.t205 VSS.n411 20.0674
R702 VSS.t269 VSS.n62 18.0025
R703 VSS.t169 VSS.n63 18.0025
R704 VSS.t196 VSS.n65 18.0025
R705 VSS.t191 VSS.n68 18.0025
R706 VSS.n70 VSS.t122 18.0025
R707 VSS.t58 VSS.n72 18.0025
R708 VSS.n74 VSS.t41 18.0025
R709 VSS.t414 VSS.n75 18.0025
R710 VSS.t395 VSS.n76 18.0025
R711 VSS.n78 VSS.t550 18.0025
R712 VSS.t517 VSS.n79 18.0025
R713 VSS.t180 VSS.n80 18.0025
R714 VSS.t260 VSS.n81 18.0025
R715 VSS.t403 VSS.n84 18.0025
R716 VSS.n139 VSS.t13 18.0025
R717 VSS.n135 VSS.t259 18.0025
R718 VSS.t192 VSS.n132 18.0025
R719 VSS.t59 VSS.n86 18.0017
R720 VSS.t272 VSS.n87 18.0017
R721 VSS.n90 VSS.t40 18.0017
R722 VSS.n93 VSS.t507 18.0017
R723 VSS.n94 VSS.t399 18.0017
R724 VSS.n99 VSS.t212 18.0017
R725 VSS.n102 VSS.t559 18.0017
R726 VSS.n105 VSS.t558 18.0017
R727 VSS.n110 VSS.t184 18.0017
R728 VSS.t163 VSS.n111 18.0017
R729 VSS.t500 VSS.n113 18.0017
R730 VSS.n117 VSS.t188 18.0017
R731 VSS.n120 VSS.t8 18.0017
R732 VSS.n123 VSS.t213 18.0017
R733 VSS.n124 VSS.t386 18.0017
R734 VSS.n902 VSS.t221 17.4483
R735 VSS.n920 VSS.t157 17.3368
R736 VSS.n916 VSS.t130 17.3368
R737 VSS.n912 VSS.t51 17.3368
R738 VSS.n486 VSS.t5 17.3368
R739 VSS.n490 VSS.t37 17.3368
R740 VSS.n494 VSS.t119 17.3368
R741 VSS.n498 VSS.t115 17.3368
R742 VSS.n899 VSS.t1 17.3368
R743 VSS.n554 VSS.t98 17.2607
R744 VSS.n474 VSS.t275 17.2313
R745 VSS.n511 VSS.t280 17.2313
R746 VSS.n515 VSS.t285 17.2313
R747 VSS.n465 VSS.t290 17.2313
R748 VSS.n527 VSS.t295 17.2313
R749 VSS.n531 VSS.t300 17.2313
R750 VSS.n457 VSS.t305 17.2313
R751 VSS.n542 VSS.t310 17.2313
R752 VSS.n546 VSS.t315 17.2313
R753 VSS.n446 VSS.t320 17.2313
R754 VSS.n565 VSS.t325 17.2313
R755 VSS.n569 VSS.t330 17.2313
R756 VSS.n437 VSS.t335 17.2313
R757 VSS.n580 VSS.t340 17.2313
R758 VSS.n584 VSS.t345 17.2313
R759 VSS.n429 VSS.t350 17.2313
R760 VSS.n595 VSS.t355 17.2313
R761 VSS.n599 VSS.t360 17.2313
R762 VSS.n907 VSS.n146 17.0005
R763 VSS.n146 VSS.n177 17.0005
R764 VSS.n146 VSS.n905 17.0005
R765 VSS.n146 VSS.n178 17.0005
R766 VSS.n146 VSS.n904 17.0005
R767 VSS.n146 VSS.n903 17.0005
R768 VSS.n146 VSS.n901 17.0005
R769 VSS.n146 VSS.n284 17.0005
R770 VSS.n146 VSS.n289 17.0005
R771 VSS.n146 VSS.n297 17.0005
R772 VSS.n146 VSS.n305 17.0005
R773 VSS.n146 VSS.n313 17.0005
R774 VSS.n146 VSS.n321 17.0005
R775 VSS.n146 VSS.n329 17.0005
R776 VSS.n146 VSS.n337 17.0005
R777 VSS.n146 VSS.n345 17.0005
R778 VSS.n146 VSS.n353 17.0005
R779 VSS.n146 VSS.n361 17.0005
R780 VSS.n146 VSS.n369 17.0005
R781 VSS.n146 VSS.n377 17.0005
R782 VSS.n146 VSS.n385 17.0005
R783 VSS.n146 VSS.n393 17.0005
R784 VSS.n146 VSS.n401 17.0005
R785 VSS.n146 VSS.n409 17.0005
R786 VSS.n146 VSS.n412 17.0005
R787 VSS.n146 VSS.n610 17.0005
R788 VSS.n146 VSS.n413 17.0005
R789 VSS.n146 VSS.n605 17.0005
R790 VSS.n146 VSS.n414 17.0005
R791 VSS.n146 VSS.n282 17.0005
R792 VSS.n146 VSS.n182 17.0005
R793 VSS.n45 VSS.n31 0.00107219
R794 VSS.n13 VSS.n170 5.65652
R795 VSS.n50 VSS.n447 17.0005
R796 VSS.n39 VSS.n38 6.82739
R797 VSS.n156 VSS.n38 0.800314
R798 VSS.n21 VSS.n522 17.0005
R799 VSS.n10 VSS.n479 17.0005
R800 VSS.n10 VSS.n478 17.0005
R801 VSS.n10 VSS.n475 17.0005
R802 VSS.n10 VSS.n477 17.0005
R803 VSS.n10 VSS.n11 2.67074
R804 VSS.n10 VSS.n476 17.0005
R805 VSS.n481 VSS.n10 17.0005
R806 VSS.n480 VSS.t274 17.0005
R807 VSS.n473 VSS.t277 17.0005
R808 VSS.n509 VSS.t279 17.0005
R809 VSS.n469 VSS.t282 17.0005
R810 VSS.n468 VSS.t284 17.0005
R811 VSS.n467 VSS.t287 17.0005
R812 VSS.n466 VSS.t289 17.0005
R813 VSS.n464 VSS.t292 17.0005
R814 VSS.n525 VSS.t294 17.0005
R815 VSS.n461 VSS.t297 17.0005
R816 VSS.n460 VSS.t299 17.0005
R817 VSS.n459 VSS.t302 17.0005
R818 VSS.n458 VSS.t304 17.0005
R819 VSS.n456 VSS.t307 17.0005
R820 VSS.n540 VSS.t309 17.0005
R821 VSS.n451 VSS.t312 17.0005
R822 VSS.n450 VSS.t314 17.0005
R823 VSS.n449 VSS.t317 17.0005
R824 VSS.n448 VSS.t319 17.0005
R825 VSS.n445 VSS.t322 17.0005
R826 VSS.n563 VSS.t324 17.0005
R827 VSS.n441 VSS.t327 17.0005
R828 VSS.n440 VSS.t329 17.0005
R829 VSS.n439 VSS.t332 17.0005
R830 VSS.n438 VSS.t334 17.0005
R831 VSS.n436 VSS.t337 17.0005
R832 VSS.n578 VSS.t339 17.0005
R833 VSS.n433 VSS.t342 17.0005
R834 VSS.n432 VSS.t344 17.0005
R835 VSS.n431 VSS.t347 17.0005
R836 VSS.n430 VSS.t349 17.0005
R837 VSS.n428 VSS.t352 17.0005
R838 VSS.n593 VSS.t354 17.0005
R839 VSS.n425 VSS.t357 17.0005
R840 VSS.n424 VSS.t359 17.0005
R841 VSS.n421 VSS.t362 17.0005
R842 VSS.n6 VSS.t554 16.3876
R843 VSS.n473 VSS.t597 15.3099
R844 VSS.n469 VSS.t595 15.3099
R845 VSS.n467 VSS.t593 15.3099
R846 VSS.n464 VSS.t591 15.3099
R847 VSS.n461 VSS.t589 15.3099
R848 VSS.n459 VSS.t587 15.3099
R849 VSS.n456 VSS.t585 15.3099
R850 VSS.n451 VSS.t583 15.3099
R851 VSS.n449 VSS.t581 15.3099
R852 VSS.n445 VSS.t579 15.3099
R853 VSS.n441 VSS.t577 15.3099
R854 VSS.n439 VSS.t575 15.3099
R855 VSS.n436 VSS.t573 15.3099
R856 VSS.n433 VSS.t571 15.3099
R857 VSS.n431 VSS.t569 15.3099
R858 VSS.n428 VSS.t567 15.3099
R859 VSS.n425 VSS.t565 15.3099
R860 VSS.n421 VSS.t563 15.3099
R861 VSS.n480 VSS.t598 15.2696
R862 VSS.n509 VSS.t596 15.2696
R863 VSS.n468 VSS.t594 15.2696
R864 VSS.n466 VSS.t592 15.2696
R865 VSS.n525 VSS.t590 15.2696
R866 VSS.n460 VSS.t588 15.2696
R867 VSS.n458 VSS.t586 15.2696
R868 VSS.n540 VSS.t584 15.2696
R869 VSS.n450 VSS.t582 15.2696
R870 VSS.n448 VSS.t580 15.2696
R871 VSS.n563 VSS.t578 15.2696
R872 VSS.n440 VSS.t576 15.2696
R873 VSS.n438 VSS.t574 15.2696
R874 VSS.n578 VSS.t572 15.2696
R875 VSS.n432 VSS.t570 15.2696
R876 VSS.n430 VSS.t568 15.2696
R877 VSS.n593 VSS.t566 15.2696
R878 VSS.n424 VSS.t564 15.2696
R879 VSS.n606 VSS.t370 15.1276
R880 VSS.n417 VSS.t374 15.0005
R881 VSS.n887 VSS.t367 15.0005
R882 VSS.n896 VSS.t363 15.0005
R883 VSS.n180 VSS.t498 13.7147
R884 VSS.n217 VSS.t206 8.85039
R885 VSS.n219 VSS.t198 8.85039
R886 VSS.n221 VSS.t504 8.85039
R887 VSS.n223 VSS.t82 8.85039
R888 VSS.n225 VSS.t172 8.85039
R889 VSS.n227 VSS.t204 8.85039
R890 VSS.n229 VSS.t86 8.85039
R891 VSS.n231 VSS.t63 8.85039
R892 VSS.n233 VSS.t262 8.85039
R893 VSS.n235 VSS.t200 8.85039
R894 VSS.n237 VSS.t61 8.85039
R895 VSS.n239 VSS.t94 8.85039
R896 VSS.n241 VSS.t211 8.85039
R897 VSS.n243 VSS.t57 8.85039
R898 VSS.n245 VSS.t67 8.85039
R899 VSS.n247 VSS.t516 8.85039
R900 VSS.n249 VSS.t514 8.85039
R901 VSS.n251 VSS.t96 8.85039
R902 VSS.n253 VSS.t17 8.85039
R903 VSS.n255 VSS.t165 8.85039
R904 VSS.n257 VSS.t405 8.85039
R905 VSS.n259 VSS.t65 8.85039
R906 VSS.n261 VSS.t490 8.85039
R907 VSS.n263 VSS.t10 8.85039
R908 VSS.n265 VSS.t71 8.85039
R909 VSS.n267 VSS.t168 8.85039
R910 VSS.n269 VSS.t480 8.85039
R911 VSS.n271 VSS.t385 8.85039
R912 VSS.n273 VSS.t43 8.85039
R913 VSS.n275 VSS.t190 8.85039
R914 VSS.n277 VSS.t266 8.85039
R915 VSS.n279 VSS.t78 8.85039
R916 VSS.n922 VSS.t222 8.80385
R917 VSS.n918 VSS.t132 8.80385
R918 VSS.n914 VSS.t53 8.80385
R919 VSS.n891 VSS.t3 8.80385
R920 VSS.n488 VSS.t7 8.80285
R921 VSS.n492 VSS.t39 8.80285
R922 VSS.n496 VSS.t121 8.80285
R923 VSS.n500 VSS.t117 8.80285
R924 VSS.n612 VSS.t125 8.77423
R925 VSS.n408 VSS.t224 8.77423
R926 VSS.n620 VSS.t151 8.77423
R927 VSS.n625 VSS.t502 8.77423
R928 VSS.n629 VSS.t26 8.77423
R929 VSS.n400 VSS.t80 8.77423
R930 VSS.n637 VSS.t219 8.77423
R931 VSS.n642 VSS.t195 8.77423
R932 VSS.n646 VSS.t20 8.77423
R933 VSS.n392 VSS.t174 8.77423
R934 VSS.n654 VSS.t532 8.77423
R935 VSS.n659 VSS.t84 8.77423
R936 VSS.n663 VSS.t32 8.77423
R937 VSS.n384 VSS.t226 8.77423
R938 VSS.n671 VSS.t523 8.77423
R939 VSS.n676 VSS.t398 8.77423
R940 VSS.n680 VSS.t154 8.77423
R941 VSS.n376 VSS.t202 8.77423
R942 VSS.n688 VSS.t148 8.77423
R943 VSS.n693 VSS.t89 8.77423
R944 VSS.n697 VSS.t145 8.77423
R945 VSS.n368 VSS.t183 8.77423
R946 VSS.n705 VSS.t526 8.77423
R947 VSS.n710 VSS.t209 8.77423
R948 VSS.n714 VSS.t216 8.77423
R949 VSS.n360 VSS.t55 8.77423
R950 VSS.n722 VSS.t250 8.77423
R951 VSS.n727 VSS.t401 8.77423
R952 VSS.n731 VSS.t46 8.77423
R953 VSS.n352 VSS.t232 8.77423
R954 VSS.n739 VSS.t113 8.77423
R955 VSS.n744 VSS.t545 8.77423
R956 VSS.n748 VSS.t92 8.77423
R957 VSS.n344 VSS.t379 8.77423
R958 VSS.n756 VSS.t529 8.77423
R959 VSS.n761 VSS.t15 8.77423
R960 VSS.n765 VSS.t29 8.77423
R961 VSS.n336 VSS.t230 8.77423
R962 VSS.n773 VSS.t520 8.77423
R963 VSS.n778 VSS.t407 8.77423
R964 VSS.n782 VSS.t128 8.77423
R965 VSS.n328 VSS.t104 8.77423
R966 VSS.n790 VSS.t139 8.77423
R967 VSS.n795 VSS.t492 8.77423
R968 VSS.n799 VSS.t256 8.77423
R969 VSS.n320 VSS.t12 8.77423
R970 VSS.n807 VSS.t107 8.77423
R971 VSS.n812 VSS.t69 8.77423
R972 VSS.n816 VSS.t241 8.77423
R973 VSS.n312 VSS.t76 8.77423
R974 VSS.n824 VSS.t253 8.77423
R975 VSS.n829 VSS.t482 8.77423
R976 VSS.n833 VSS.t49 8.77423
R977 VSS.n304 VSS.t536 8.77423
R978 VSS.n841 VSS.t512 8.77423
R979 VSS.n846 VSS.t549 8.77423
R980 VSS.n850 VSS.t23 8.77423
R981 VSS.n296 VSS.t159 8.77423
R982 VSS.n858 VSS.t142 8.77423
R983 VSS.n863 VSS.t268 8.77423
R984 VSS.n867 VSS.t110 8.77423
R985 VSS.n288 VSS.t134 8.77423
R986 VSS.n875 VSS.t238 8.77423
R987 VSS.n882 VSS.t509 8.77423
R988 VSS.n504 VSS.t389 8.77323
R989 VSS.n519 VSS.t244 8.77323
R990 VSS.n535 VSS.t235 8.77323
R991 VSS.n550 VSS.t74 8.77323
R992 VSS.n552 VSS.t179 8.77323
R993 VSS.n558 VSS.t392 8.77323
R994 VSS.n573 VSS.t247 8.77323
R995 VSS.n588 VSS.t35 8.77323
R996 VSS.n419 VSS.t187 8.77323
R997 VSS.n502 VSS.t271 8.76689
R998 VSS.n556 VSS.t100 8.76678
R999 VSS.n910 VSS.t497 8.75731
R1000 VSS.n908 VSS.t486 8.75731
R1001 VSS.n482 VSS.t381 8.75631
R1002 VSS.n484 VSS.t553 8.75631
R1003 VSS.n174 VSS.n35 4.22409
R1004 VSS.n173 VSS.n45 5.65652
R1005 VSS.n172 VSS.n590 0.0633111
R1006 VSS.n583 VSS.n171 0.0435295
R1007 VSS.n577 VSS.n170 0.0180497
R1008 VSS.n169 VSS.n575 0.0633111
R1009 VSS.n568 VSS.n168 0.0435295
R1010 VSS.n167 VSS.n50 5.65652
R1011 VSS.n166 VSS.n560 0.0633111
R1012 VSS.n545 VSS.n165 0.0435295
R1013 VSS.n164 VSS.n55 5.65652
R1014 VSS.n163 VSS.n537 0.0633111
R1015 VSS.n162 VSS.n1 4.22409
R1016 VSS.n161 VSS.n1 5.65652
R1017 VSS.n160 VSS.n521 0.0633111
R1018 VSS.n514 VSS.n159 0.0435295
R1019 VSS.n158 VSS.n24 5.65652
R1020 VSS.n157 VSS.n506 0.0633111
R1021 VSS.n146 VSS.n894 8.5005
R1022 VSS.n146 VSS.n881 8.5005
R1023 VSS.n146 VSS.n285 8.5005
R1024 VSS.n146 VSS.n874 8.5005
R1025 VSS.n146 VSS.n873 8.5005
R1026 VSS.n146 VSS.n287 8.5005
R1027 VSS.n146 VSS.n872 8.5005
R1028 VSS.n146 VSS.n290 8.5005
R1029 VSS.n146 VSS.n866 8.5005
R1030 VSS.n146 VSS.n291 8.5005
R1031 VSS.n146 VSS.n865 8.5005
R1032 VSS.n146 VSS.n293 8.5005
R1033 VSS.n146 VSS.n857 8.5005
R1034 VSS.n146 VSS.n856 8.5005
R1035 VSS.n146 VSS.n295 8.5005
R1036 VSS.n146 VSS.n855 8.5005
R1037 VSS.n146 VSS.n298 8.5005
R1038 VSS.n146 VSS.n849 8.5005
R1039 VSS.n146 VSS.n299 8.5005
R1040 VSS.n146 VSS.n848 8.5005
R1041 VSS.n146 VSS.n301 8.5005
R1042 VSS.n146 VSS.n840 8.5005
R1043 VSS.n146 VSS.n839 8.5005
R1044 VSS.n146 VSS.n303 8.5005
R1045 VSS.n146 VSS.n838 8.5005
R1046 VSS.n146 VSS.n306 8.5005
R1047 VSS.n146 VSS.n832 8.5005
R1048 VSS.n146 VSS.n307 8.5005
R1049 VSS.n146 VSS.n831 8.5005
R1050 VSS.n146 VSS.n309 8.5005
R1051 VSS.n146 VSS.n823 8.5005
R1052 VSS.n146 VSS.n822 8.5005
R1053 VSS.n146 VSS.n311 8.5005
R1054 VSS.n146 VSS.n821 8.5005
R1055 VSS.n146 VSS.n314 8.5005
R1056 VSS.n146 VSS.n815 8.5005
R1057 VSS.n146 VSS.n315 8.5005
R1058 VSS.n146 VSS.n814 8.5005
R1059 VSS.n146 VSS.n317 8.5005
R1060 VSS.n146 VSS.n806 8.5005
R1061 VSS.n146 VSS.n805 8.5005
R1062 VSS.n146 VSS.n319 8.5005
R1063 VSS.n146 VSS.n804 8.5005
R1064 VSS.n146 VSS.n322 8.5005
R1065 VSS.n146 VSS.n798 8.5005
R1066 VSS.n146 VSS.n323 8.5005
R1067 VSS.n146 VSS.n797 8.5005
R1068 VSS.n146 VSS.n325 8.5005
R1069 VSS.n146 VSS.n789 8.5005
R1070 VSS.n146 VSS.n788 8.5005
R1071 VSS.n146 VSS.n327 8.5005
R1072 VSS.n146 VSS.n787 8.5005
R1073 VSS.n146 VSS.n330 8.5005
R1074 VSS.n146 VSS.n781 8.5005
R1075 VSS.n146 VSS.n331 8.5005
R1076 VSS.n146 VSS.n780 8.5005
R1077 VSS.n146 VSS.n333 8.5005
R1078 VSS.n146 VSS.n772 8.5005
R1079 VSS.n146 VSS.n771 8.5005
R1080 VSS.n146 VSS.n335 8.5005
R1081 VSS.n146 VSS.n770 8.5005
R1082 VSS.n146 VSS.n338 8.5005
R1083 VSS.n146 VSS.n764 8.5005
R1084 VSS.n146 VSS.n339 8.5005
R1085 VSS.n146 VSS.n763 8.5005
R1086 VSS.n146 VSS.n341 8.5005
R1087 VSS.n146 VSS.n755 8.5005
R1088 VSS.n146 VSS.n754 8.5005
R1089 VSS.n146 VSS.n343 8.5005
R1090 VSS.n146 VSS.n753 8.5005
R1091 VSS.n146 VSS.n346 8.5005
R1092 VSS.n146 VSS.n747 8.5005
R1093 VSS.n146 VSS.n347 8.5005
R1094 VSS.n146 VSS.n746 8.5005
R1095 VSS.n146 VSS.n349 8.5005
R1096 VSS.n146 VSS.n738 8.5005
R1097 VSS.n146 VSS.n737 8.5005
R1098 VSS.n146 VSS.n351 8.5005
R1099 VSS.n146 VSS.n736 8.5005
R1100 VSS.n146 VSS.n354 8.5005
R1101 VSS.n146 VSS.n730 8.5005
R1102 VSS.n146 VSS.n355 8.5005
R1103 VSS.n146 VSS.n729 8.5005
R1104 VSS.n146 VSS.n357 8.5005
R1105 VSS.n146 VSS.n721 8.5005
R1106 VSS.n146 VSS.n720 8.5005
R1107 VSS.n146 VSS.n359 8.5005
R1108 VSS.n146 VSS.n719 8.5005
R1109 VSS.n146 VSS.n362 8.5005
R1110 VSS.n146 VSS.n713 8.5005
R1111 VSS.n146 VSS.n363 8.5005
R1112 VSS.n146 VSS.n712 8.5005
R1113 VSS.n146 VSS.n365 8.5005
R1114 VSS.n146 VSS.n704 8.5005
R1115 VSS.n146 VSS.n703 8.5005
R1116 VSS.n146 VSS.n367 8.5005
R1117 VSS.n146 VSS.n702 8.5005
R1118 VSS.n146 VSS.n370 8.5005
R1119 VSS.n146 VSS.n696 8.5005
R1120 VSS.n146 VSS.n371 8.5005
R1121 VSS.n146 VSS.n695 8.5005
R1122 VSS.n146 VSS.n373 8.5005
R1123 VSS.n146 VSS.n687 8.5005
R1124 VSS.n146 VSS.n686 8.5005
R1125 VSS.n146 VSS.n375 8.5005
R1126 VSS.n146 VSS.n685 8.5005
R1127 VSS.n146 VSS.n378 8.5005
R1128 VSS.n146 VSS.n679 8.5005
R1129 VSS.n146 VSS.n379 8.5005
R1130 VSS.n146 VSS.n678 8.5005
R1131 VSS.n146 VSS.n381 8.5005
R1132 VSS.n146 VSS.n670 8.5005
R1133 VSS.n146 VSS.n669 8.5005
R1134 VSS.n146 VSS.n383 8.5005
R1135 VSS.n146 VSS.n668 8.5005
R1136 VSS.n146 VSS.n386 8.5005
R1137 VSS.n146 VSS.n662 8.5005
R1138 VSS.n146 VSS.n387 8.5005
R1139 VSS.n146 VSS.n661 8.5005
R1140 VSS.n146 VSS.n389 8.5005
R1141 VSS.n146 VSS.n653 8.5005
R1142 VSS.n146 VSS.n652 8.5005
R1143 VSS.n146 VSS.n391 8.5005
R1144 VSS.n146 VSS.n651 8.5005
R1145 VSS.n146 VSS.n394 8.5005
R1146 VSS.n146 VSS.n645 8.5005
R1147 VSS.n146 VSS.n395 8.5005
R1148 VSS.n146 VSS.n644 8.5005
R1149 VSS.n146 VSS.n397 8.5005
R1150 VSS.n146 VSS.n636 8.5005
R1151 VSS.n146 VSS.n635 8.5005
R1152 VSS.n146 VSS.n399 8.5005
R1153 VSS.n146 VSS.n634 8.5005
R1154 VSS.n146 VSS.n402 8.5005
R1155 VSS.n146 VSS.n628 8.5005
R1156 VSS.n146 VSS.n403 8.5005
R1157 VSS.n146 VSS.n627 8.5005
R1158 VSS.n146 VSS.n405 8.5005
R1159 VSS.n146 VSS.n619 8.5005
R1160 VSS.n146 VSS.n618 8.5005
R1161 VSS.n146 VSS.n407 8.5005
R1162 VSS.n146 VSS.n617 8.5005
R1163 VSS.n146 VSS.n410 8.5005
R1164 VSS.n146 VSS.n611 8.5005
R1165 VSS.n146 VSS.n411 8.5005
R1166 VSS.n146 VSS.n148 2.77709
R1167 VSS.n597 VSS.n45 8.49319
R1168 VSS.n582 VSS.n13 8.49319
R1169 VSS.n567 VSS.n50 8.49319
R1170 VSS.n544 VSS.n55 8.49319
R1171 VSS.n529 VSS.n1 8.49319
R1172 VSS.n513 VSS.n24 8.49319
R1173 VSS.n921 VSS.n146 8.47732
R1174 VSS.n146 VSS.n283 8.47732
R1175 VSS.n146 VSS.n880 8.47732
R1176 VSS.n146 VSS.n864 8.47732
R1177 VSS.n146 VSS.n847 8.47732
R1178 VSS.n146 VSS.n830 8.47732
R1179 VSS.n146 VSS.n813 8.47732
R1180 VSS.n146 VSS.n796 8.47732
R1181 VSS.n146 VSS.n779 8.47732
R1182 VSS.n146 VSS.n762 8.47732
R1183 VSS.n146 VSS.n745 8.47732
R1184 VSS.n146 VSS.n728 8.47732
R1185 VSS.n146 VSS.n711 8.47732
R1186 VSS.n146 VSS.n694 8.47732
R1187 VSS.n146 VSS.n677 8.47732
R1188 VSS.n146 VSS.n660 8.47732
R1189 VSS.n146 VSS.n643 8.47732
R1190 VSS.n146 VSS.n626 8.47732
R1191 VSS.n146 VSS.n181 8.47732
R1192 VSS.n146 VSS.n216 8.47732
R1193 VSS.n146 VSS.n215 8.47732
R1194 VSS.n174 VSS.n599 0.176279
R1195 VSS.n591 VSS.n45 8.47732
R1196 VSS.n45 VSS.n172 4.21421
R1197 VSS.n171 VSS.n13 4.22409
R1198 VSS.n576 VSS.n14 8.47732
R1199 VSS.n14 VSS.n169 4.21421
R1200 VSS.n168 VSS.n14 4.22409
R1201 VSS.n561 VSS.n50 8.47732
R1202 VSS.n50 VSS.n166 4.21421
R1203 VSS.n165 VSS.n38 4.22409
R1204 VSS.n538 VSS.n55 8.47732
R1205 VSS.n55 VSS.n163 4.21421
R1206 VSS.n531 VSS.n162 0.176279
R1207 VSS.n523 VSS.n21 8.47732
R1208 VSS.n21 VSS.n160 4.21421
R1209 VSS.n159 VSS.n21 4.22409
R1210 VSS.n507 VSS.n24 8.47732
R1211 VSS.n24 VSS.n157 4.21421
R1212 VSS.n495 VSS.n10 8.47732
R1213 VSS.n416 VSS.t376 8.46888
R1214 VSS.n603 VSS.t372 8.46888
R1215 VSS.n608 VSS.t373 8.46631
R1216 VSS.n614 VSS.t466 8.46631
R1217 VSS.n623 VSS.t478 8.46631
R1218 VSS.n631 VSS.t470 8.46631
R1219 VSS.n640 VSS.t474 8.46631
R1220 VSS.n648 VSS.t476 8.46631
R1221 VSS.n657 VSS.t418 8.46631
R1222 VSS.n665 VSS.t472 8.46631
R1223 VSS.n674 VSS.t468 8.46631
R1224 VSS.n682 VSS.t424 8.46631
R1225 VSS.n691 VSS.t446 8.46631
R1226 VSS.n699 VSS.t464 8.46631
R1227 VSS.n708 VSS.t450 8.46631
R1228 VSS.n716 VSS.t462 8.46631
R1229 VSS.n725 VSS.t444 8.46631
R1230 VSS.n733 VSS.t460 8.46631
R1231 VSS.n742 VSS.t458 8.46631
R1232 VSS.n750 VSS.t456 8.46631
R1233 VSS.n759 VSS.t448 8.46631
R1234 VSS.n767 VSS.t454 8.46631
R1235 VSS.n776 VSS.t452 8.46631
R1236 VSS.n784 VSS.t416 8.46631
R1237 VSS.n793 VSS.t442 8.46631
R1238 VSS.n801 VSS.t440 8.46631
R1239 VSS.n810 VSS.t430 8.46631
R1240 VSS.n818 VSS.t438 8.46631
R1241 VSS.n827 VSS.t426 8.46631
R1242 VSS.n835 VSS.t432 8.46631
R1243 VSS.n844 VSS.t436 8.46631
R1244 VSS.n852 VSS.t420 8.46631
R1245 VSS.n861 VSS.t434 8.46631
R1246 VSS.n869 VSS.t428 8.46631
R1247 VSS.n878 VSS.t422 8.46631
R1248 VSS.n889 VSS.t369 8.46519
R1249 VSS.n884 VSS.t365 8.46519
R1250 VSS.n897 VSS.t366 8.46519
R1251 VSS.n924 VSS.n175 6.99673
R1252 VSS.n913 VSS.n146 5.62581
R1253 VSS.n917 VSS.n146 5.62581
R1254 VSS.n923 VSS.n146 5.62581
R1255 VSS.n146 VSS.n876 5.62581
R1256 VSS.n146 VSS.n292 5.62581
R1257 VSS.n146 VSS.n859 5.62581
R1258 VSS.n146 VSS.n300 5.62581
R1259 VSS.n146 VSS.n842 5.62581
R1260 VSS.n146 VSS.n308 5.62581
R1261 VSS.n146 VSS.n825 5.62581
R1262 VSS.n146 VSS.n316 5.62581
R1263 VSS.n146 VSS.n808 5.62581
R1264 VSS.n146 VSS.n324 5.62581
R1265 VSS.n146 VSS.n791 5.62581
R1266 VSS.n146 VSS.n332 5.62581
R1267 VSS.n146 VSS.n774 5.62581
R1268 VSS.n146 VSS.n340 5.62581
R1269 VSS.n146 VSS.n757 5.62581
R1270 VSS.n146 VSS.n348 5.62581
R1271 VSS.n146 VSS.n740 5.62581
R1272 VSS.n146 VSS.n356 5.62581
R1273 VSS.n146 VSS.n723 5.62581
R1274 VSS.n146 VSS.n364 5.62581
R1275 VSS.n146 VSS.n706 5.62581
R1276 VSS.n146 VSS.n372 5.62581
R1277 VSS.n146 VSS.n689 5.62581
R1278 VSS.n146 VSS.n380 5.62581
R1279 VSS.n146 VSS.n672 5.62581
R1280 VSS.n146 VSS.n388 5.62581
R1281 VSS.n146 VSS.n655 5.62581
R1282 VSS.n146 VSS.n396 5.62581
R1283 VSS.n146 VSS.n638 5.62581
R1284 VSS.n146 VSS.n404 5.62581
R1285 VSS.n146 VSS.n621 5.62581
R1286 VSS.n146 VSS.n280 5.62581
R1287 VSS.n146 VSS.n278 5.62581
R1288 VSS.n146 VSS.n276 5.62581
R1289 VSS.n146 VSS.n274 5.62581
R1290 VSS.n146 VSS.n272 5.62581
R1291 VSS.n146 VSS.n270 5.62581
R1292 VSS.n146 VSS.n268 5.62581
R1293 VSS.n146 VSS.n266 5.62581
R1294 VSS.n146 VSS.n264 5.62581
R1295 VSS.n146 VSS.n262 5.62581
R1296 VSS.n146 VSS.n260 5.62581
R1297 VSS.n146 VSS.n258 5.62581
R1298 VSS.n146 VSS.n256 5.62581
R1299 VSS.n146 VSS.n254 5.62581
R1300 VSS.n146 VSS.n252 5.62581
R1301 VSS.n146 VSS.n250 5.62581
R1302 VSS.n146 VSS.n248 5.62581
R1303 VSS.n146 VSS.n246 5.62581
R1304 VSS.n146 VSS.n244 5.62581
R1305 VSS.n146 VSS.n242 5.62581
R1306 VSS.n146 VSS.n240 5.62581
R1307 VSS.n146 VSS.n238 5.62581
R1308 VSS.n146 VSS.n236 5.62581
R1309 VSS.n146 VSS.n234 5.62581
R1310 VSS.n146 VSS.n232 5.62581
R1311 VSS.n146 VSS.n230 5.62581
R1312 VSS.n146 VSS.n228 5.62581
R1313 VSS.n146 VSS.n226 5.62581
R1314 VSS.n146 VSS.n224 5.62581
R1315 VSS.n146 VSS.n222 5.62581
R1316 VSS.n146 VSS.n220 5.62581
R1317 VSS.n146 VSS.n218 5.62581
R1318 VSS.n146 VSS.n214 5.62581
R1319 VSS.n35 VSS.n423 5.62581
R1320 VSS.n45 VSS.n427 5.62581
R1321 VSS.n585 VSS.n13 5.62581
R1322 VSS.n13 VSS.n435 5.62581
R1323 VSS.n570 VSS.n14 5.62581
R1324 VSS.n50 VSS.n444 5.62581
R1325 VSS.n555 VSS.n38 5.62581
R1326 VSS.n547 VSS.n38 5.62581
R1327 VSS.n55 VSS.n455 5.62581
R1328 VSS.n532 VSS.n1 5.62581
R1329 VSS.n1 VSS.n463 5.62581
R1330 VSS.n516 VSS.n21 5.62581
R1331 VSS.n24 VSS.n472 5.62581
R1332 VSS.n501 VSS.n10 5.62581
R1333 VSS.n499 VSS.n10 5.62581
R1334 VSS.n491 VSS.n10 5.62581
R1335 VSS.n487 VSS.n10 5.62581
R1336 VSS.n481 VSS.n175 4.28471
R1337 VSS.n45 VSS.n596 4.21914
R1338 VSS.n13 VSS.n581 4.21914
R1339 VSS.n50 VSS.n566 4.21914
R1340 VSS.n55 VSS.n543 4.21914
R1341 VSS.n1 VSS.n528 4.21914
R1342 VSS.n24 VSS.n512 4.21914
R1343 VSS.n146 VSS.n147 1.77244
R1344 VSS.n909 VSS.n146 4.19244
R1345 VSS.n146 VSS.n893 4.19244
R1346 VSS.n483 VSS.n10 4.19244
R1347 VSS VSS.n175 3.80469
R1348 VSS.n881 VSS.t421 3.34498
R1349 VSS.n873 VSS.t427 3.34498
R1350 VSS.n865 VSS.t433 3.34498
R1351 VSS.n856 VSS.t419 3.34498
R1352 VSS.n848 VSS.t435 3.34498
R1353 VSS.n839 VSS.t431 3.34498
R1354 VSS.n831 VSS.t425 3.34498
R1355 VSS.n822 VSS.t437 3.34498
R1356 VSS.n814 VSS.t429 3.34498
R1357 VSS.n805 VSS.t439 3.34498
R1358 VSS.n797 VSS.t441 3.34498
R1359 VSS.n788 VSS.t415 3.34498
R1360 VSS.n780 VSS.t451 3.34498
R1361 VSS.n771 VSS.t453 3.34498
R1362 VSS.n763 VSS.t447 3.34498
R1363 VSS.n754 VSS.t455 3.34498
R1364 VSS.n746 VSS.t457 3.34498
R1365 VSS.n737 VSS.t459 3.34498
R1366 VSS.n729 VSS.t443 3.34498
R1367 VSS.n720 VSS.t461 3.34498
R1368 VSS.n712 VSS.t449 3.34498
R1369 VSS.n703 VSS.t463 3.34498
R1370 VSS.n695 VSS.t445 3.34498
R1371 VSS.n686 VSS.t423 3.34498
R1372 VSS.n678 VSS.t467 3.34498
R1373 VSS.n669 VSS.t471 3.34498
R1374 VSS.n661 VSS.t417 3.34498
R1375 VSS.n652 VSS.t475 3.34498
R1376 VSS.n644 VSS.t473 3.34498
R1377 VSS.n635 VSS.t469 3.34498
R1378 VSS.n627 VSS.t477 3.34498
R1379 VSS.n618 VSS.t465 3.34498
R1380 VSS.n915 VSS.n146 3.3265
R1381 VSS.n919 VSS.n146 3.3265
R1382 VSS.n146 VSS.n871 3.3265
R1383 VSS.n146 VSS.n854 3.3265
R1384 VSS.n146 VSS.n837 3.3265
R1385 VSS.n146 VSS.n820 3.3265
R1386 VSS.n146 VSS.n803 3.3265
R1387 VSS.n146 VSS.n786 3.3265
R1388 VSS.n146 VSS.n769 3.3265
R1389 VSS.n146 VSS.n752 3.3265
R1390 VSS.n146 VSS.n735 3.3265
R1391 VSS.n146 VSS.n718 3.3265
R1392 VSS.n146 VSS.n701 3.3265
R1393 VSS.n146 VSS.n684 3.3265
R1394 VSS.n146 VSS.n667 3.3265
R1395 VSS.n146 VSS.n650 3.3265
R1396 VSS.n146 VSS.n633 3.3265
R1397 VSS.n146 VSS.n616 3.3265
R1398 VSS.n589 VSS.n13 3.3265
R1399 VSS.n574 VSS.n14 3.3265
R1400 VSS.n559 VSS.n38 3.3265
R1401 VSS.n536 VSS.n1 3.3265
R1402 VSS.n520 VSS.n21 3.3265
R1403 VSS.n505 VSS.n10 3.3265
R1404 VSS.n497 VSS.n10 3.3265
R1405 VSS.n493 VSS.n10 3.3265
R1406 VSS.n489 VSS.n10 3.3265
R1407 VSS.n900 VSS 3.16675
R1408 VSS.n601 VSS.n600 3.01826
R1409 VSS.n146 VSS.n60 2.83376
R1410 VSS.n911 VSS.n146 2.74446
R1411 VSS.n146 VSS.n286 2.74446
R1412 VSS.n146 VSS.n294 2.74446
R1413 VSS.n146 VSS.n302 2.74446
R1414 VSS.n146 VSS.n310 2.74446
R1415 VSS.n146 VSS.n318 2.74446
R1416 VSS.n146 VSS.n326 2.74446
R1417 VSS.n146 VSS.n334 2.74446
R1418 VSS.n146 VSS.n342 2.74446
R1419 VSS.n146 VSS.n350 2.74446
R1420 VSS.n146 VSS.n358 2.74446
R1421 VSS.n146 VSS.n366 2.74446
R1422 VSS.n146 VSS.n374 2.74446
R1423 VSS.n146 VSS.n382 2.74446
R1424 VSS.n146 VSS.n390 2.74446
R1425 VSS.n146 VSS.n398 2.74446
R1426 VSS.n146 VSS.n406 2.74446
R1427 VSS.n146 VSS.n281 2.74446
R1428 VSS.n485 VSS.n10 2.74446
R1429 VSS.n146 VSS.n183 2.32483
R1430 VSS.n146 VSS.n184 2.32483
R1431 VSS.n146 VSS.n185 2.32483
R1432 VSS.n146 VSS.n186 2.32483
R1433 VSS.n146 VSS.n187 2.32483
R1434 VSS.n146 VSS.n188 2.32483
R1435 VSS.n146 VSS.n189 2.32483
R1436 VSS.n146 VSS.n190 2.32483
R1437 VSS.n146 VSS.n191 2.32483
R1438 VSS.n146 VSS.n192 2.32483
R1439 VSS.n146 VSS.n193 2.32483
R1440 VSS.n146 VSS.n194 2.32483
R1441 VSS.n146 VSS.n195 2.32483
R1442 VSS.n146 VSS.n196 2.32483
R1443 VSS.n146 VSS.n197 2.32483
R1444 VSS.n146 VSS.n198 2.32483
R1445 VSS.n146 VSS.n199 2.32483
R1446 VSS.n146 VSS.n200 2.32483
R1447 VSS.n146 VSS.n201 2.32483
R1448 VSS.n146 VSS.n202 2.32483
R1449 VSS.n146 VSS.n203 2.32483
R1450 VSS.n146 VSS.n204 2.32483
R1451 VSS.n146 VSS.n205 2.32483
R1452 VSS.n146 VSS.n206 2.32483
R1453 VSS.n146 VSS.n207 2.32483
R1454 VSS.n146 VSS.n208 2.32483
R1455 VSS.n146 VSS.n209 2.32483
R1456 VSS.n146 VSS.n210 2.32483
R1457 VSS.n146 VSS.n211 2.32483
R1458 VSS.n146 VSS.n212 2.32483
R1459 VSS.n146 VSS.n213 2.32483
R1460 VSS.n553 VSS.n38 2.00687
R1461 VSS.n146 VSS.n176 1.64417
R1462 VSS.n146 VSS.n906 1.64417
R1463 VSS.n146 VSS.n179 1.64417
R1464 VSS.n146 VSS.n180 1.64417
R1465 VSS.n146 VSS.n902 1.64417
R1466 VSS.n35 VSS.n420 1.56144
R1467 VSS.n587 VSS.n13 1.56144
R1468 VSS.n572 VSS.n14 1.56144
R1469 VSS.n549 VSS.n38 1.56144
R1470 VSS.n534 VSS.n1 1.56144
R1471 VSS.n518 VSS.n21 1.56144
R1472 VSS.n557 VSS.n38 1.12565
R1473 VSS.n600 VSS.n35 0.92982
R1474 VSS.n503 VSS.n502 0.909006
R1475 VSS.n504 VSS.n503 0.898984
R1476 VSS.n551 VSS.n38 0.849178
R1477 VSS.n551 VSS.n550 0.728316
R1478 VSS.n552 VSS.n551 0.69965
R1479 VSS.n600 VSS.n419 0.69304
R1480 VSS.n35 VSS.n34 0.613782
R1481 VSS.n443 VSS.n14 0.613782
R1482 VSS.n454 VSS.n38 0.613782
R1483 VSS.n471 VSS.n21 0.613782
R1484 VSS.n10 VSS.n3 0.613782
R1485 VSS.n10 VSS.n5 0.613782
R1486 VSS.n10 VSS.n9 0.613782
R1487 VSS.n10 VSS.n7 0.613782
R1488 VSS.n26 VSS.n176 4666.38
R1489 VSS.n557 VSS.n556 0.603496
R1490 VSS.n146 VSS.n59 0.556705
R1491 VSS.n558 VSS.n557 0.540438
R1492 VSS VSS.n924 0.48296
R1493 VSS.n609 VSS.n608 0.419816
R1494 VSS.n615 VSS.n614 0.419816
R1495 VSS.n624 VSS.n623 0.419816
R1496 VSS.n632 VSS.n631 0.419816
R1497 VSS.n641 VSS.n640 0.419816
R1498 VSS.n649 VSS.n648 0.419816
R1499 VSS.n658 VSS.n657 0.419816
R1500 VSS.n666 VSS.n665 0.419816
R1501 VSS.n675 VSS.n674 0.419816
R1502 VSS.n683 VSS.n682 0.419816
R1503 VSS.n692 VSS.n691 0.419816
R1504 VSS.n700 VSS.n699 0.419816
R1505 VSS.n709 VSS.n708 0.419816
R1506 VSS.n717 VSS.n716 0.419816
R1507 VSS.n726 VSS.n725 0.419816
R1508 VSS.n734 VSS.n733 0.419816
R1509 VSS.n743 VSS.n742 0.419816
R1510 VSS.n751 VSS.n750 0.419816
R1511 VSS.n760 VSS.n759 0.419816
R1512 VSS.n768 VSS.n767 0.419816
R1513 VSS.n777 VSS.n776 0.419816
R1514 VSS.n785 VSS.n784 0.419816
R1515 VSS.n794 VSS.n793 0.419816
R1516 VSS.n802 VSS.n801 0.419816
R1517 VSS.n811 VSS.n810 0.419816
R1518 VSS.n819 VSS.n818 0.419816
R1519 VSS.n828 VSS.n827 0.419816
R1520 VSS.n836 VSS.n835 0.419816
R1521 VSS.n845 VSS.n844 0.419816
R1522 VSS.n853 VSS.n852 0.419816
R1523 VSS.n862 VSS.n861 0.419816
R1524 VSS.n870 VSS.n869 0.419816
R1525 VSS.n879 VSS.n878 0.419816
R1526 VSS.n519 VSS.n518 0.413418
R1527 VSS.n535 VSS.n534 0.413418
R1528 VSS.n550 VSS.n549 0.413418
R1529 VSS.n573 VSS.n572 0.413418
R1530 VSS.n588 VSS.n587 0.413418
R1531 VSS.n420 VSS.n419 0.413418
R1532 VSS.n503 VSS.n10 0.405836
R1533 VSS.n889 VSS.n888 0.385697
R1534 VSS.n884 VSS.n883 0.385697
R1535 VSS.n608 VSS.n607 0.383459
R1536 VSS.n614 VSS.n613 0.383459
R1537 VSS.n623 VSS.n622 0.383459
R1538 VSS.n631 VSS.n630 0.383459
R1539 VSS.n640 VSS.n639 0.383459
R1540 VSS.n648 VSS.n647 0.383459
R1541 VSS.n657 VSS.n656 0.383459
R1542 VSS.n665 VSS.n664 0.383459
R1543 VSS.n674 VSS.n673 0.383459
R1544 VSS.n682 VSS.n681 0.383459
R1545 VSS.n691 VSS.n690 0.383459
R1546 VSS.n699 VSS.n698 0.383459
R1547 VSS.n708 VSS.n707 0.383459
R1548 VSS.n716 VSS.n715 0.383459
R1549 VSS.n725 VSS.n724 0.383459
R1550 VSS.n733 VSS.n732 0.383459
R1551 VSS.n742 VSS.n741 0.383459
R1552 VSS.n750 VSS.n749 0.383459
R1553 VSS.n759 VSS.n758 0.383459
R1554 VSS.n767 VSS.n766 0.383459
R1555 VSS.n776 VSS.n775 0.383459
R1556 VSS.n784 VSS.n783 0.383459
R1557 VSS.n793 VSS.n792 0.383459
R1558 VSS.n801 VSS.n800 0.383459
R1559 VSS.n810 VSS.n809 0.383459
R1560 VSS.n818 VSS.n817 0.383459
R1561 VSS.n827 VSS.n826 0.383459
R1562 VSS.n835 VSS.n834 0.383459
R1563 VSS.n844 VSS.n843 0.383459
R1564 VSS.n852 VSS.n851 0.383459
R1565 VSS.n861 VSS.n860 0.383459
R1566 VSS.n869 VSS.n868 0.383459
R1567 VSS.n878 VSS.n877 0.383459
R1568 VSS.n554 VSS.n553 0.380519
R1569 VSS.n898 VSS.n897 0.379351
R1570 VSS.n604 VSS.n603 0.37817
R1571 VSS.n553 VSS.n552 0.359515
R1572 VSS.n279 VSS.n183 0.351341
R1573 VSS.n277 VSS.n184 0.351341
R1574 VSS.n275 VSS.n185 0.351341
R1575 VSS.n273 VSS.n186 0.351341
R1576 VSS.n271 VSS.n187 0.351341
R1577 VSS.n269 VSS.n188 0.351341
R1578 VSS.n267 VSS.n189 0.351341
R1579 VSS.n265 VSS.n190 0.351341
R1580 VSS.n263 VSS.n191 0.351341
R1581 VSS.n261 VSS.n192 0.351341
R1582 VSS.n259 VSS.n193 0.351341
R1583 VSS.n257 VSS.n194 0.351341
R1584 VSS.n255 VSS.n195 0.351341
R1585 VSS.n253 VSS.n196 0.351341
R1586 VSS.n251 VSS.n197 0.351341
R1587 VSS.n249 VSS.n198 0.351341
R1588 VSS.n247 VSS.n199 0.351341
R1589 VSS.n245 VSS.n200 0.351341
R1590 VSS.n243 VSS.n201 0.351341
R1591 VSS.n241 VSS.n202 0.351341
R1592 VSS.n239 VSS.n203 0.351341
R1593 VSS.n237 VSS.n204 0.351341
R1594 VSS.n235 VSS.n205 0.351341
R1595 VSS.n233 VSS.n206 0.351341
R1596 VSS.n231 VSS.n207 0.351341
R1597 VSS.n229 VSS.n208 0.351341
R1598 VSS.n227 VSS.n209 0.351341
R1599 VSS.n225 VSS.n210 0.351341
R1600 VSS.n223 VSS.n211 0.351341
R1601 VSS.n221 VSS.n212 0.351341
R1602 VSS.n219 VSS.n213 0.351341
R1603 VSS.n416 VSS.n415 0.345929
R1604 VSS.n603 VSS.n602 0.345929
R1605 VSS.n422 VSS.n420 0.340858
R1606 VSS.n587 VSS.n586 0.340858
R1607 VSS.n572 VSS.n571 0.340858
R1608 VSS.n549 VSS.n548 0.340858
R1609 VSS.n534 VSS.n533 0.340858
R1610 VSS.n518 VSS.n517 0.340858
R1611 VSS.n912 VSS.n911 0.318018
R1612 VSS.n486 VSS.n485 0.316299
R1613 VSS.n868 VSS.n183 0.311066
R1614 VSS.n860 VSS.n184 0.311066
R1615 VSS.n851 VSS.n185 0.311066
R1616 VSS.n843 VSS.n186 0.311066
R1617 VSS.n834 VSS.n187 0.311066
R1618 VSS.n826 VSS.n188 0.311066
R1619 VSS.n817 VSS.n189 0.311066
R1620 VSS.n809 VSS.n190 0.311066
R1621 VSS.n800 VSS.n191 0.311066
R1622 VSS.n792 VSS.n192 0.311066
R1623 VSS.n783 VSS.n193 0.311066
R1624 VSS.n775 VSS.n194 0.311066
R1625 VSS.n766 VSS.n195 0.311066
R1626 VSS.n758 VSS.n196 0.311066
R1627 VSS.n749 VSS.n197 0.311066
R1628 VSS.n741 VSS.n198 0.311066
R1629 VSS.n732 VSS.n199 0.311066
R1630 VSS.n724 VSS.n200 0.311066
R1631 VSS.n715 VSS.n201 0.311066
R1632 VSS.n707 VSS.n202 0.311066
R1633 VSS.n698 VSS.n203 0.311066
R1634 VSS.n690 VSS.n204 0.311066
R1635 VSS.n681 VSS.n205 0.311066
R1636 VSS.n673 VSS.n206 0.311066
R1637 VSS.n664 VSS.n207 0.311066
R1638 VSS.n656 VSS.n208 0.311066
R1639 VSS.n647 VSS.n209 0.311066
R1640 VSS.n639 VSS.n210 0.311066
R1641 VSS.n630 VSS.n211 0.311066
R1642 VSS.n622 VSS.n212 0.311066
R1643 VSS.n613 VSS.n213 0.311066
R1644 VSS.n288 VSS.n286 0.284268
R1645 VSS.n296 VSS.n294 0.284268
R1646 VSS.n304 VSS.n302 0.284268
R1647 VSS.n312 VSS.n310 0.284268
R1648 VSS.n320 VSS.n318 0.284268
R1649 VSS.n328 VSS.n326 0.284268
R1650 VSS.n336 VSS.n334 0.284268
R1651 VSS.n344 VSS.n342 0.284268
R1652 VSS.n352 VSS.n350 0.284268
R1653 VSS.n360 VSS.n358 0.284268
R1654 VSS.n368 VSS.n366 0.284268
R1655 VSS.n376 VSS.n374 0.284268
R1656 VSS.n384 VSS.n382 0.284268
R1657 VSS.n392 VSS.n390 0.284268
R1658 VSS.n400 VSS.n398 0.284268
R1659 VSS.n408 VSS.n406 0.284268
R1660 VSS.n897 VSS.n896 0.279928
R1661 VSS.n485 VSS.n484 0.274268
R1662 VSS.n493 VSS.n492 0.274227
R1663 VSS.n505 VSS.n504 0.274227
R1664 VSS.n520 VSS.n519 0.274227
R1665 VSS.n536 VSS.n535 0.274227
R1666 VSS.n559 VSS.n558 0.274227
R1667 VSS.n574 VSS.n573 0.274227
R1668 VSS.n589 VSS.n588 0.274227
R1669 VSS.n919 VSS.n918 0.272997
R1670 VSS.n911 VSS.n910 0.272549
R1671 VSS.n888 VSS.n281 0.271299
R1672 VSS.n146 VSS.n143 0.267794
R1673 VSS.n146 VSS.n141 0.267794
R1674 VSS.n146 VSS.n86 0.267794
R1675 VSS.n146 VSS.n87 0.267794
R1676 VSS.n146 VSS.n88 0.267794
R1677 VSS.n146 VSS.n139 0.267794
R1678 VSS.n146 VSS.n138 0.267794
R1679 VSS.n146 VSS.n90 0.267794
R1680 VSS.n146 VSS.n137 0.267794
R1681 VSS.n146 VSS.n91 0.267794
R1682 VSS.n146 VSS.n93 0.267794
R1683 VSS.n146 VSS.n94 0.267794
R1684 VSS.n146 VSS.n96 0.267794
R1685 VSS.n146 VSS.n135 0.267794
R1686 VSS.n146 VSS.n98 0.267794
R1687 VSS.n146 VSS.n99 0.267794
R1688 VSS.n146 VSS.n100 0.267794
R1689 VSS.n146 VSS.n101 0.267794
R1690 VSS.n146 VSS.n102 0.267794
R1691 VSS.n146 VSS.n103 0.267794
R1692 VSS.n146 VSS.n132 0.267794
R1693 VSS.n146 VSS.n104 0.267794
R1694 VSS.n146 VSS.n105 0.267794
R1695 VSS.n146 VSS.n106 0.267794
R1696 VSS.n146 VSS.n108 0.267794
R1697 VSS.n146 VSS.n110 0.267794
R1698 VSS.n146 VSS.n131 0.267794
R1699 VSS.n146 VSS.n111 0.267794
R1700 VSS.n146 VSS.n112 0.267794
R1701 VSS.n146 VSS.n113 0.267794
R1702 VSS.n146 VSS.n114 0.267794
R1703 VSS.n146 VSS.n115 0.267794
R1704 VSS.n146 VSS.n117 0.267794
R1705 VSS.n146 VSS.n118 0.267794
R1706 VSS.n146 VSS.n129 0.267794
R1707 VSS.n146 VSS.n119 0.267794
R1708 VSS.n146 VSS.n120 0.267794
R1709 VSS.n146 VSS.n121 0.267794
R1710 VSS.n146 VSS.n123 0.267794
R1711 VSS.n146 VSS.n124 0.267794
R1712 VSS.n146 VSS.n127 0.267794
R1713 VSS.n146 VSS.n61 0.267794
R1714 VSS.n146 VSS.n62 0.267794
R1715 VSS.n146 VSS.n63 0.267794
R1716 VSS.n146 VSS.n64 0.267794
R1717 VSS.n146 VSS.n65 0.267794
R1718 VSS.n146 VSS.n66 0.267794
R1719 VSS.n146 VSS.n67 0.267794
R1720 VSS.n146 VSS.n68 0.267794
R1721 VSS.n146 VSS.n69 0.267794
R1722 VSS.n146 VSS.n70 0.267794
R1723 VSS.n146 VSS.n71 0.267794
R1724 VSS.n146 VSS.n72 0.267794
R1725 VSS.n146 VSS.n73 0.267794
R1726 VSS.n146 VSS.n74 0.267794
R1727 VSS.n146 VSS.n75 0.267794
R1728 VSS.n146 VSS.n76 0.267794
R1729 VSS.n146 VSS.n77 0.267794
R1730 VSS.n146 VSS.n78 0.267794
R1731 VSS.n146 VSS.n79 0.267794
R1732 VSS.n146 VSS.n80 0.267794
R1733 VSS.n146 VSS.n81 0.267794
R1734 VSS.n146 VSS.n82 0.267794
R1735 VSS.n146 VSS.n83 0.267794
R1736 VSS.n146 VSS.n84 0.267794
R1737 VSS.n877 VSS.n281 0.265518
R1738 VSS.n147 VSS.n415 0.380118
R1739 VSS.n417 VSS.n416 0.251101
R1740 VSS.n498 VSS.n497 0.245497
R1741 VSS.n871 VSS.n870 0.244247
R1742 VSS.n854 VSS.n853 0.244247
R1743 VSS.n837 VSS.n836 0.244247
R1744 VSS.n820 VSS.n819 0.244247
R1745 VSS.n803 VSS.n802 0.244247
R1746 VSS.n786 VSS.n785 0.244247
R1747 VSS.n769 VSS.n768 0.244247
R1748 VSS.n752 VSS.n751 0.244247
R1749 VSS.n735 VSS.n734 0.244247
R1750 VSS.n718 VSS.n717 0.244247
R1751 VSS.n701 VSS.n700 0.244247
R1752 VSS.n684 VSS.n683 0.244247
R1753 VSS.n667 VSS.n666 0.244247
R1754 VSS.n650 VSS.n649 0.244247
R1755 VSS.n633 VSS.n632 0.244247
R1756 VSS.n616 VSS.n615 0.244247
R1757 VSS.n875 VSS.n286 0.240049
R1758 VSS.n858 VSS.n294 0.240049
R1759 VSS.n841 VSS.n302 0.240049
R1760 VSS.n824 VSS.n310 0.240049
R1761 VSS.n807 VSS.n318 0.240049
R1762 VSS.n790 VSS.n326 0.240049
R1763 VSS.n773 VSS.n334 0.240049
R1764 VSS.n756 VSS.n342 0.240049
R1765 VSS.n739 VSS.n350 0.240049
R1766 VSS.n722 VSS.n358 0.240049
R1767 VSS.n705 VSS.n366 0.240049
R1768 VSS.n688 VSS.n374 0.240049
R1769 VSS.n671 VSS.n382 0.240049
R1770 VSS.n654 VSS.n390 0.240049
R1771 VSS.n637 VSS.n398 0.240049
R1772 VSS.n620 VSS.n406 0.240049
R1773 VSS.n506 VSS.n505 0.237997
R1774 VSS.n521 VSS.n520 0.237997
R1775 VSS.n537 VSS.n536 0.237997
R1776 VSS.n560 VSS.n559 0.237997
R1777 VSS.n575 VSS.n574 0.237997
R1778 VSS.n590 VSS.n589 0.237997
R1779 VSS.n489 VSS.n488 0.234227
R1780 VSS.n915 VSS.n914 0.232997
R1781 VSS.n916 VSS.n915 0.231727
R1782 VSS.n490 VSS.n489 0.230497
R1783 VSS.n871 VSS.n867 0.224227
R1784 VSS.n854 VSS.n850 0.224227
R1785 VSS.n837 VSS.n833 0.224227
R1786 VSS.n820 VSS.n816 0.224227
R1787 VSS.n803 VSS.n799 0.224227
R1788 VSS.n786 VSS.n782 0.224227
R1789 VSS.n769 VSS.n765 0.224227
R1790 VSS.n752 VSS.n748 0.224227
R1791 VSS.n735 VSS.n731 0.224227
R1792 VSS.n718 VSS.n714 0.224227
R1793 VSS.n701 VSS.n697 0.224227
R1794 VSS.n684 VSS.n680 0.224227
R1795 VSS.n667 VSS.n663 0.224227
R1796 VSS.n650 VSS.n646 0.224227
R1797 VSS.n633 VSS.n629 0.224227
R1798 VSS.n616 VSS.n612 0.224227
R1799 VSS.n497 VSS.n496 0.219227
R1800 VSS.n890 VSS.n889 0.21012
R1801 VSS.n886 VSS.n884 0.21012
R1802 VSS.n910 VSS.n909 0.201058
R1803 VSS.n484 VSS.n483 0.200293
R1804 VSS.n920 VSS.n919 0.191727
R1805 VSS.n494 VSS.n493 0.190497
R1806 VSS.n876 VSS.n875 0.186138
R1807 VSS.n859 VSS.n858 0.186138
R1808 VSS.n842 VSS.n841 0.186138
R1809 VSS.n825 VSS.n824 0.186138
R1810 VSS.n808 VSS.n807 0.186138
R1811 VSS.n791 VSS.n790 0.186138
R1812 VSS.n774 VSS.n773 0.186138
R1813 VSS.n757 VSS.n756 0.186138
R1814 VSS.n740 VSS.n739 0.186138
R1815 VSS.n723 VSS.n722 0.186138
R1816 VSS.n706 VSS.n705 0.186138
R1817 VSS.n689 VSS.n688 0.186138
R1818 VSS.n672 VSS.n671 0.186138
R1819 VSS.n655 VSS.n654 0.186138
R1820 VSS.n638 VSS.n637 0.186138
R1821 VSS.n621 VSS.n620 0.186138
R1822 VSS.n502 VSS.n501 0.1833
R1823 VSS.n893 VSS.n892 0.179043
R1824 VSS.n924 VSS.n923 0.167388
R1825 VSS.n217 VSS.n214 0.16705
R1826 VSS.n512 VSS.n511 0.166269
R1827 VSS.n528 VSS.n527 0.166269
R1828 VSS.n543 VSS.n542 0.166269
R1829 VSS.n566 VSS.n565 0.166269
R1830 VSS.n581 VSS.n580 0.166269
R1831 VSS.n596 VSS.n595 0.166269
R1832 VSS.n501 VSS.n500 0.164888
R1833 VSS.n877 VSS.n280 0.16205
R1834 VSS.n868 VSS.n278 0.16205
R1835 VSS.n860 VSS.n276 0.16205
R1836 VSS.n851 VSS.n274 0.16205
R1837 VSS.n843 VSS.n272 0.16205
R1838 VSS.n834 VSS.n270 0.16205
R1839 VSS.n826 VSS.n268 0.16205
R1840 VSS.n817 VSS.n266 0.16205
R1841 VSS.n809 VSS.n264 0.16205
R1842 VSS.n800 VSS.n262 0.16205
R1843 VSS.n792 VSS.n260 0.16205
R1844 VSS.n783 VSS.n258 0.16205
R1845 VSS.n775 VSS.n256 0.16205
R1846 VSS.n766 VSS.n254 0.16205
R1847 VSS.n758 VSS.n252 0.16205
R1848 VSS.n749 VSS.n250 0.16205
R1849 VSS.n741 VSS.n248 0.16205
R1850 VSS.n732 VSS.n246 0.16205
R1851 VSS.n724 VSS.n244 0.16205
R1852 VSS.n715 VSS.n242 0.16205
R1853 VSS.n707 VSS.n240 0.16205
R1854 VSS.n698 VSS.n238 0.16205
R1855 VSS.n690 VSS.n236 0.16205
R1856 VSS.n681 VSS.n234 0.16205
R1857 VSS.n673 VSS.n232 0.16205
R1858 VSS.n664 VSS.n230 0.16205
R1859 VSS.n656 VSS.n228 0.16205
R1860 VSS.n647 VSS.n226 0.16205
R1861 VSS.n639 VSS.n224 0.16205
R1862 VSS.n630 VSS.n222 0.16205
R1863 VSS.n622 VSS.n220 0.16205
R1864 VSS.n613 VSS.n218 0.16205
R1865 VSS.n146 VSS.n144 0.16137
R1866 VSS.n146 VSS.n57 0.16137
R1867 VSS.n146 VSS.n58 0.16137
R1868 VSS.n893 VSS.n882 0.161058
R1869 VSS.n483 VSS.n482 0.161058
R1870 VSS.n909 VSS.n908 0.160293
R1871 VSS.n867 VSS.n292 0.15705
R1872 VSS.n850 VSS.n300 0.15705
R1873 VSS.n833 VSS.n308 0.15705
R1874 VSS.n816 VSS.n316 0.15705
R1875 VSS.n799 VSS.n324 0.15705
R1876 VSS.n782 VSS.n332 0.15705
R1877 VSS.n765 VSS.n340 0.15705
R1878 VSS.n748 VSS.n348 0.15705
R1879 VSS.n731 VSS.n356 0.15705
R1880 VSS.n714 VSS.n364 0.15705
R1881 VSS.n697 VSS.n372 0.15705
R1882 VSS.n680 VSS.n380 0.15705
R1883 VSS.n663 VSS.n388 0.15705
R1884 VSS.n646 VSS.n396 0.15705
R1885 VSS.n629 VSS.n404 0.15705
R1886 VSS.n508 VSS.n473 0.155582
R1887 VSS.n470 VSS.n469 0.155582
R1888 VSS.n517 VSS.n467 0.155582
R1889 VSS.n524 VSS.n464 0.155582
R1890 VSS.n462 VSS.n461 0.155582
R1891 VSS.n533 VSS.n459 0.155582
R1892 VSS.n539 VSS.n456 0.155582
R1893 VSS.n452 VSS.n451 0.155582
R1894 VSS.n548 VSS.n449 0.155582
R1895 VSS.n562 VSS.n445 0.155582
R1896 VSS.n442 VSS.n441 0.155582
R1897 VSS.n571 VSS.n439 0.155582
R1898 VSS.n577 VSS.n436 0.155582
R1899 VSS.n434 VSS.n433 0.155582
R1900 VSS.n586 VSS.n431 0.155582
R1901 VSS.n592 VSS.n428 0.155582
R1902 VSS.n426 VSS.n425 0.155582
R1903 VSS.n422 VSS.n421 0.155582
R1904 VSS.n879 VSS.n876 0.1508
R1905 VSS.n862 VSS.n859 0.1508
R1906 VSS.n845 VSS.n842 0.1508
R1907 VSS.n828 VSS.n825 0.1508
R1908 VSS.n811 VSS.n808 0.1508
R1909 VSS.n794 VSS.n791 0.1508
R1910 VSS.n777 VSS.n774 0.1508
R1911 VSS.n760 VSS.n757 0.1508
R1912 VSS.n743 VSS.n740 0.1508
R1913 VSS.n726 VSS.n723 0.1508
R1914 VSS.n709 VSS.n706 0.1508
R1915 VSS.n692 VSS.n689 0.1508
R1916 VSS.n675 VSS.n672 0.1508
R1917 VSS.n658 VSS.n655 0.1508
R1918 VSS.n641 VSS.n638 0.1508
R1919 VSS.n624 VSS.n621 0.1508
R1920 VSS.n491 VSS.n490 0.149888
R1921 VSS.n917 VSS.n916 0.14955
R1922 VSS.n506 VSS.n480 0.149476
R1923 VSS.n510 VSS.n509 0.149476
R1924 VSS.n514 VSS.n468 0.149476
R1925 VSS.n521 VSS.n466 0.149476
R1926 VSS.n526 VSS.n525 0.149476
R1927 VSS.n530 VSS.n460 0.149476
R1928 VSS.n537 VSS.n458 0.149476
R1929 VSS.n541 VSS.n540 0.149476
R1930 VSS.n545 VSS.n450 0.149476
R1931 VSS.n560 VSS.n448 0.149476
R1932 VSS.n564 VSS.n563 0.149476
R1933 VSS.n568 VSS.n440 0.149476
R1934 VSS.n575 VSS.n438 0.149476
R1935 VSS.n579 VSS.n578 0.149476
R1936 VSS.n583 VSS.n432 0.149476
R1937 VSS.n590 VSS.n430 0.149476
R1938 VSS.n594 VSS.n593 0.149476
R1939 VSS.n598 VSS.n424 0.149476
R1940 VSS.n896 VSS.n895 0.148577
R1941 VSS.n914 VSS.n913 0.147388
R1942 VSS.n488 VSS.n487 0.14705
R1943 VSS.n921 VSS.n920 0.142118
R1944 VSS.n495 VSS.n494 0.142118
R1945 VSS.n147 VSS.n418 0.383913
R1946 VSS.n499 VSS.n498 0.134888
R1947 VSS.n555 VSS.n554 0.134888
R1948 VSS.n508 VSS.n507 0.129618
R1949 VSS.n524 VSS.n523 0.129618
R1950 VSS.n539 VSS.n538 0.129618
R1951 VSS.n562 VSS.n561 0.129618
R1952 VSS.n577 VSS.n576 0.129618
R1953 VSS.n592 VSS.n591 0.129618
R1954 VSS.n418 VSS.n417 0.127569
R1955 VSS.n511 VSS.n472 0.126138
R1956 VSS.n527 VSS.n463 0.126138
R1957 VSS.n542 VSS.n455 0.126138
R1958 VSS.n565 VSS.n444 0.126138
R1959 VSS.n580 VSS.n435 0.126138
R1960 VSS.n595 VSS.n427 0.126138
R1961 VSS.n882 VSS.n880 0.125868
R1962 VSS.n864 VSS.n863 0.125868
R1963 VSS.n847 VSS.n846 0.125868
R1964 VSS.n830 VSS.n829 0.125868
R1965 VSS.n813 VSS.n812 0.125868
R1966 VSS.n796 VSS.n795 0.125868
R1967 VSS.n779 VSS.n778 0.125868
R1968 VSS.n762 VSS.n761 0.125868
R1969 VSS.n745 VSS.n744 0.125868
R1970 VSS.n728 VSS.n727 0.125868
R1971 VSS.n711 VSS.n710 0.125868
R1972 VSS.n694 VSS.n693 0.125868
R1973 VSS.n677 VSS.n676 0.125868
R1974 VSS.n660 VSS.n659 0.125868
R1975 VSS.n643 VSS.n642 0.125868
R1976 VSS.n626 VSS.n625 0.125868
R1977 VSS.n157 VSS.n474 0.156005
R1978 VSS.n160 VSS.n465 0.156005
R1979 VSS.n163 VSS.n457 0.156005
R1980 VSS.n166 VSS.n446 0.156005
R1981 VSS.n169 VSS.n437 0.156005
R1982 VSS.n172 VSS.n429 0.156005
R1983 VSS.n607 VSS.n216 0.124618
R1984 VSS.n923 VSS.n922 0.12455
R1985 VSS.n602 VSS.n216 0.122118
R1986 VSS.n500 VSS.n499 0.12205
R1987 VSS.n517 VSS.n516 0.12205
R1988 VSS.n533 VSS.n532 0.12205
R1989 VSS.n548 VSS.n547 0.12205
R1990 VSS.n556 VSS.n555 0.12205
R1991 VSS.n571 VSS.n570 0.12205
R1992 VSS.n586 VSS.n585 0.12205
R1993 VSS.n423 VSS.n422 0.12205
R1994 VSS.n280 VSS.n279 0.119888
R1995 VSS.n278 VSS.n277 0.119888
R1996 VSS.n276 VSS.n275 0.119888
R1997 VSS.n274 VSS.n273 0.119888
R1998 VSS.n272 VSS.n271 0.119888
R1999 VSS.n270 VSS.n269 0.119888
R2000 VSS.n268 VSS.n267 0.119888
R2001 VSS.n266 VSS.n265 0.119888
R2002 VSS.n264 VSS.n263 0.119888
R2003 VSS.n262 VSS.n261 0.119888
R2004 VSS.n260 VSS.n259 0.119888
R2005 VSS.n258 VSS.n257 0.119888
R2006 VSS.n256 VSS.n255 0.119888
R2007 VSS.n254 VSS.n253 0.119888
R2008 VSS.n252 VSS.n251 0.119888
R2009 VSS.n250 VSS.n249 0.119888
R2010 VSS.n248 VSS.n247 0.119888
R2011 VSS.n246 VSS.n245 0.119888
R2012 VSS.n244 VSS.n243 0.119888
R2013 VSS.n242 VSS.n241 0.119888
R2014 VSS.n240 VSS.n239 0.119888
R2015 VSS.n238 VSS.n237 0.119888
R2016 VSS.n236 VSS.n235 0.119888
R2017 VSS.n234 VSS.n233 0.119888
R2018 VSS.n232 VSS.n231 0.119888
R2019 VSS.n230 VSS.n229 0.119888
R2020 VSS.n228 VSS.n227 0.119888
R2021 VSS.n226 VSS.n225 0.119888
R2022 VSS.n224 VSS.n223 0.119888
R2023 VSS.n222 VSS.n221 0.119888
R2024 VSS.n220 VSS.n219 0.119888
R2025 VSS.n218 VSS.n217 0.119888
R2026 VSS.n607 VSS.n214 0.114888
R2027 VSS.n922 VSS.n921 0.114618
R2028 VSS.n496 VSS.n495 0.114618
R2029 VSS.n863 VSS.n292 0.113638
R2030 VSS.n846 VSS.n300 0.113638
R2031 VSS.n829 VSS.n308 0.113638
R2032 VSS.n812 VSS.n316 0.113638
R2033 VSS.n795 VSS.n324 0.113638
R2034 VSS.n778 VSS.n332 0.113638
R2035 VSS.n761 VSS.n340 0.113638
R2036 VSS.n744 VSS.n348 0.113638
R2037 VSS.n727 VSS.n356 0.113638
R2038 VSS.n710 VSS.n364 0.113638
R2039 VSS.n693 VSS.n372 0.113638
R2040 VSS.n676 VSS.n380 0.113638
R2041 VSS.n659 VSS.n388 0.113638
R2042 VSS.n642 VSS.n396 0.113638
R2043 VSS.n625 VSS.n404 0.113638
R2044 VSS.n487 VSS.n486 0.109888
R2045 VSS.n913 VSS.n912 0.10955
R2046 VSS.n918 VSS.n917 0.107388
R2047 VSS.n492 VSS.n491 0.10705
R2048 VSS.n516 VSS.n515 0.106138
R2049 VSS.n532 VSS.n531 0.106138
R2050 VSS.n547 VSS.n546 0.106138
R2051 VSS.n570 VSS.n569 0.106138
R2052 VSS.n585 VSS.n584 0.106138
R2053 VSS.n599 VSS.n423 0.106138
R2054 VSS.n514 VSS.n513 0.105361
R2055 VSS.n530 VSS.n529 0.105361
R2056 VSS.n545 VSS.n544 0.105361
R2057 VSS.n568 VSS.n567 0.105361
R2058 VSS.n583 VSS.n582 0.105361
R2059 VSS.n598 VSS.n597 0.105361
R2060 VSS.n472 VSS.n470 0.10205
R2061 VSS.n463 VSS.n462 0.10205
R2062 VSS.n455 VSS.n452 0.10205
R2063 VSS.n444 VSS.n442 0.10205
R2064 VSS.n435 VSS.n434 0.10205
R2065 VSS.n427 VSS.n426 0.10205
R2066 VSS.n507 VSS.n474 0.0983676
R2067 VSS.n523 VSS.n465 0.0983676
R2068 VSS.n538 VSS.n457 0.0983676
R2069 VSS.n561 VSS.n446 0.0983676
R2070 VSS.n576 VSS.n437 0.0983676
R2071 VSS.n591 VSS.n429 0.0983676
R2072 VSS.n887 VSS.n886 0.094
R2073 VSS.n890 VSS.n887 0.094
R2074 VSS.n895 VSS.n282 0.08925
R2075 VSS.n880 VSS.n879 0.0883676
R2076 VSS.n864 VSS.n862 0.0883676
R2077 VSS.n847 VSS.n845 0.0883676
R2078 VSS.n830 VSS.n828 0.0883676
R2079 VSS.n813 VSS.n811 0.0883676
R2080 VSS.n796 VSS.n794 0.0883676
R2081 VSS.n779 VSS.n777 0.0883676
R2082 VSS.n762 VSS.n760 0.0883676
R2083 VSS.n745 VSS.n743 0.0883676
R2084 VSS.n728 VSS.n726 0.0883676
R2085 VSS.n711 VSS.n709 0.0883676
R2086 VSS.n694 VSS.n692 0.0883676
R2087 VSS.n677 VSS.n675 0.0883676
R2088 VSS.n660 VSS.n658 0.0883676
R2089 VSS.n643 VSS.n641 0.0883676
R2090 VSS.n626 VSS.n624 0.0883676
R2091 VSS.n610 VSS.n609 0.088
R2092 VSS.n515 VSS.n159 0.176279
R2093 VSS.n162 VSS.n530 0.0435295
R2094 VSS.n546 VSS.n165 0.176279
R2095 VSS.n569 VSS.n168 0.176279
R2096 VSS.n584 VSS.n171 0.176279
R2097 VSS.n174 VSS.n598 0.0435295
R2098 VSS.n886 VSS.n885 0.0851154
R2099 VSS.n892 VSS.n890 0.0851154
R2100 VSS.n605 VSS.n601 0.0805
R2101 VSS.n908 VSS.n907 0.078
R2102 VSS.n482 VSS.n481 0.078
R2103 VSS.n415 VSS.n215 0.0771176
R2104 VSS.n885 VSS.n283 0.0746176
R2105 VSS.n883 VSS.n181 0.0746176
R2106 VSS.n604 VSS.n413 0.07425
R2107 VSS.n602 VSS.n215 0.0696176
R2108 VSS.n885 VSS.n284 0.06925
R2109 VSS.n883 VSS.n182 0.06925
R2110 VSS.n510 VSS.n158 0.103847
R2111 VSS.n526 VSS.n161 0.103847
R2112 VSS.n541 VSS.n164 0.103847
R2113 VSS.n564 VSS.n167 0.103847
R2114 VSS.n579 VSS.n170 0.103847
R2115 VSS.n594 VSS.n173 0.103847
R2116 VSS.n612 VSS.n412 0.06175
R2117 VSS.n888 VSS.n182 0.05925
R2118 VSS.n901 VSS.n899 0.05675
R2119 VSS.n898 VSS.n283 0.0546176
R2120 VSS.n895 VSS.n181 0.0546176
R2121 VSS.n596 VSS.n594 0.0543074
R2122 VSS.n581 VSS.n579 0.0543074
R2123 VSS.n566 VSS.n564 0.0543074
R2124 VSS.n543 VSS.n541 0.0543074
R2125 VSS.n528 VSS.n526 0.0543074
R2126 VSS.n512 VSS.n510 0.0543074
R2127 VSS.n158 VSS.n508 0.0180497
R2128 VSS.n161 VSS.n524 0.0180497
R2129 VSS.n164 VSS.n539 0.0180497
R2130 VSS.n167 VSS.n562 0.0180497
R2131 VSS.n173 VSS.n592 0.0180497
R2132 VSS.n606 VSS.n413 0.04925
R2133 VSS.n289 VSS.n288 0.048
R2134 VSS.n297 VSS.n296 0.048
R2135 VSS.n305 VSS.n304 0.048
R2136 VSS.n313 VSS.n312 0.048
R2137 VSS.n321 VSS.n320 0.048
R2138 VSS.n329 VSS.n328 0.048
R2139 VSS.n337 VSS.n336 0.048
R2140 VSS.n345 VSS.n344 0.048
R2141 VSS.n353 VSS.n352 0.048
R2142 VSS.n361 VSS.n360 0.048
R2143 VSS.n369 VSS.n368 0.048
R2144 VSS.n377 VSS.n376 0.048
R2145 VSS.n385 VSS.n384 0.048
R2146 VSS.n393 VSS.n392 0.048
R2147 VSS.n401 VSS.n400 0.048
R2148 VSS.n409 VSS.n408 0.048
R2149 VSS.n610 VSS.n606 0.04675
R2150 VSS.n870 VSS.n289 0.0405
R2151 VSS.n853 VSS.n297 0.0405
R2152 VSS.n836 VSS.n305 0.0405
R2153 VSS.n819 VSS.n313 0.0405
R2154 VSS.n802 VSS.n321 0.0405
R2155 VSS.n785 VSS.n329 0.0405
R2156 VSS.n768 VSS.n337 0.0405
R2157 VSS.n751 VSS.n345 0.0405
R2158 VSS.n734 VSS.n353 0.0405
R2159 VSS.n717 VSS.n361 0.0405
R2160 VSS.n700 VSS.n369 0.0405
R2161 VSS.n683 VSS.n377 0.0405
R2162 VSS.n666 VSS.n385 0.0405
R2163 VSS.n649 VSS.n393 0.0405
R2164 VSS.n632 VSS.n401 0.0405
R2165 VSS.n615 VSS.n409 0.0405
R2166 VSS.n907 VSS 0.038
R2167 VSS.n899 VSS.n898 0.033
R2168 VSS.n892 VSS.n891 0.033
R2169 VSS.n418 VSS.n414 0.02925
R2170 VSS.n891 VSS.n284 0.02675
R2171 VSS.n30 VSS.n14 0.00596634
R2172 VSS.n150 VSS.n14 0.00760728
R2173 VSS.t391 VSS.n40 212.157
R2174 VSS.n154 VSS.n38 0.00206574
R2175 VSS.n19 VSS.n1 0.00185661
R2176 VSS.n33 VSS.t388 116.468
R2177 VSS.n10 VSS.n4 0.023135
R2178 VSS.n10 VSS.n8 0.00760717
R2179 VSS.n605 VSS.n604 0.02175
R2180 VSS.n146 VSS.n145 0.0166972
R2181 VSS.n146 VSS.n56 0.0166972
R2182 VSS.n597 VSS.n426 0.0166107
R2183 VSS.n582 VSS.n434 0.0166107
R2184 VSS.n567 VSS.n442 0.0166107
R2185 VSS.n544 VSS.n452 0.0166107
R2186 VSS.n529 VSS.n462 0.0166107
R2187 VSS.n513 VSS.n470 0.0166107
R2188 VSS.n601 VSS.n414 0.0155
R2189 VSS.n900 VSS.n60 0.0112403
R2190 VSS.n146 VSS.n95 0.0099255
R2191 VSS.n924 VSS.n60 0.0095322
R2192 VSS.n146 VSS.n85 0.00938635
R2193 VSS.n146 VSS.n89 0.00938635
R2194 VSS.n146 VSS.n92 0.00938635
R2195 VSS.n146 VSS.n125 0.00938635
R2196 VSS.n146 VSS.n142 0.00937856
R2197 VSS.n146 VSS.n140 0.00937856
R2198 VSS.n146 VSS.n136 0.00937856
R2199 VSS.n146 VSS.n107 0.00937856
R2200 VSS.n146 VSS.n109 0.00937856
R2201 VSS.n146 VSS.n130 0.00937856
R2202 VSS.n146 VSS.n116 0.00937856
R2203 VSS.n146 VSS.n122 0.00937856
R2204 VSS.n146 VSS.n126 0.00937856
R2205 VSS.n146 VSS.n97 0.00937856
R2206 VSS.n146 VSS.n134 0.00937856
R2207 VSS.n146 VSS.n133 0.00937856
R2208 VSS.n146 VSS.n128 0.00937856
R2209 VSS.n609 VSS.n412 0.008
R2210 VSS.n901 VSS.n900 0.00675
R2211 VSS.n900 VSS.n282 0.00675
R2212 VSS.n24 VSS.n21 0.0025
R2213 VSS.n24 VSS.n20 0.00119167
R2214 VSS.n50 VSS.n38 0.00201811
R2215 VSS.n45 VSS.n44 0.00179957
R2216 VSS.n45 VSS.n43 0.00179957
R2217 VSS.n45 VSS.n42 0.00104691
R2218 VSS.n45 VSS.n41 0.00179957
R2219 VSS.n13 VSS.n16 0.00179957
R2220 VSS.n50 VSS.n49 0.00179957
R2221 VSS.n50 VSS.n48 0.00179957
R2222 VSS.n50 VSS.n47 0.00104691
R2223 VSS.n50 VSS.n46 0.00179957
R2224 VSS.n55 VSS.n54 0.00179957
R2225 VSS.n55 VSS.n53 0.00179957
R2226 VSS.n55 VSS.n52 0.00104691
R2227 VSS.n55 VSS.n51 0.00179957
R2228 VSS.n24 VSS.n23 0.00179957
R2229 VSS.n24 VSS.n22 0.00179957
R2230 VSS.n25 VSS.t278 402.188
R2231 VSS.n45 VSS.n35 0.00351876
R2232 VSS.n453 VSS.n38 0.00252007
R2233 VSS.n21 VSS.n1 0.0025
R2234 VSS.n55 VSS.n0 0.00107219
R2235 VSS.n55 VSS.n38 0.0025
R2236 VSS.n14 VSS.n13 0.0025
R2237 VSS.n31 VSS.n13 0.00292781
R2238 VSS.n28 VSS.t291 148.827
R2239 VSS.n18 VSS.t338 68.213
R2240 VSS.n10 VSS.n6 0.00541747
R2241 VSS.n50 VSS.n14 0.0042108
R2242 VSS.n2 VSS.n522 454.01
R2243 a_3747_311.n0 a_3747_311.t2 52.0388
R2244 a_3747_311.t1 a_3747_311.n0 35.4491
R2245 a_3747_311.n0 a_3747_311.t3 33.5891
R2246 a_3747_311.t0 a_3747_311.t1 5.61942
R2247 a_3171_311.n0 a_3171_311.t2 51.8377
R2248 a_3171_311.n0 a_3171_311.t3 33.3881
R2249 a_3171_311.t1 a_3171_311.n0 31.8923
R2250 a_3171_311.t0 a_3171_311.t1 5.61777
R2251 a_2595_311.n0 a_2595_311.t2 51.6367
R2252 a_2595_311.n0 a_2595_311.t3 33.187
R2253 a_2595_311.t1 a_2595_311.n0 27.993
R2254 a_2595_311.t0 a_2595_311.t1 5.73018
R2255 a_3747_1047.n0 a_3747_1047.t2 38.0081
R2256 a_3747_1047.n0 a_3747_1047.t3 33.3957
R2257 a_3747_1047.n1 a_3747_1047.t4 33.3957
R2258 a_3747_1047.n2 a_3747_1047.t5 33.3957
R2259 a_3747_1047.n3 a_3747_1047.t6 33.3957
R2260 a_3747_1047.n4 a_3747_1047.t7 33.3957
R2261 a_3747_1047.n5 a_3747_1047.t8 33.3957
R2262 a_3747_1047.n6 a_3747_1047.t9 33.3957
R2263 a_3747_1047.t1 a_3747_1047.n6 23.2419
R2264 a_3747_1047.t0 a_3747_1047.t1 5.61942
R2265 a_3747_1047.n6 a_3747_1047.n5 4.61291
R2266 a_3747_1047.n5 a_3747_1047.n4 4.61291
R2267 a_3747_1047.n4 a_3747_1047.n3 4.61291
R2268 a_3747_1047.n3 a_3747_1047.n2 4.61291
R2269 a_3747_1047.n2 a_3747_1047.n1 4.61291
R2270 a_3747_1047.n1 a_3747_1047.n0 4.61291
R2271 a_3171_1047.n0 a_3171_1047.t2 37.8054
R2272 a_3171_1047.n0 a_3171_1047.t3 33.193
R2273 a_3171_1047.n1 a_3171_1047.t4 33.193
R2274 a_3171_1047.n2 a_3171_1047.t5 33.193
R2275 a_3171_1047.n3 a_3171_1047.t6 33.193
R2276 a_3171_1047.n4 a_3171_1047.t7 33.193
R2277 a_3171_1047.n5 a_3171_1047.t8 33.193
R2278 a_3171_1047.n6 a_3171_1047.t9 33.193
R2279 a_3171_1047.t1 a_3171_1047.n6 23.0313
R2280 a_3171_1047.t0 a_3171_1047.t1 5.61777
R2281 a_3171_1047.n6 a_3171_1047.n5 4.61291
R2282 a_3171_1047.n5 a_3171_1047.n4 4.61291
R2283 a_3171_1047.n4 a_3171_1047.n3 4.61291
R2284 a_3171_1047.n3 a_3171_1047.n2 4.61291
R2285 a_3171_1047.n2 a_3171_1047.n1 4.61291
R2286 a_3171_1047.n1 a_3171_1047.n0 4.61291
R2287 a_2595_1047.n0 a_2595_1047.t2 37.7691
R2288 a_2595_1047.n0 a_2595_1047.t3 33.1567
R2289 a_2595_1047.n1 a_2595_1047.t4 33.1567
R2290 a_2595_1047.n2 a_2595_1047.t5 33.1567
R2291 a_2595_1047.n3 a_2595_1047.t6 33.1567
R2292 a_2595_1047.n4 a_2595_1047.t7 33.1567
R2293 a_2595_1047.n5 a_2595_1047.t8 33.1567
R2294 a_2595_1047.n6 a_2595_1047.t9 33.1567
R2295 a_2595_1047.t1 a_2595_1047.n6 22.7941
R2296 a_2595_1047.t0 a_2595_1047.t1 5.65522
R2297 a_2595_1047.n6 a_2595_1047.n5 4.61291
R2298 a_2595_1047.n5 a_2595_1047.n4 4.61291
R2299 a_2595_1047.n4 a_2595_1047.n3 4.61291
R2300 a_2595_1047.n3 a_2595_1047.n2 4.61291
R2301 a_2595_1047.n2 a_2595_1047.n1 4.61291
R2302 a_2595_1047.n1 a_2595_1047.n0 4.61291
R2303 a_2019_1047.n0 a_2019_1047.t2 37.9701
R2304 a_2019_1047.n0 a_2019_1047.t3 33.3577
R2305 a_2019_1047.n1 a_2019_1047.t4 33.3577
R2306 a_2019_1047.n2 a_2019_1047.t5 33.3577
R2307 a_2019_1047.n3 a_2019_1047.t6 33.3577
R2308 a_2019_1047.n4 a_2019_1047.t7 33.3577
R2309 a_2019_1047.n5 a_2019_1047.t8 33.3577
R2310 a_2019_1047.t1 a_2019_1047.t9 22.5945
R2311 a_2019_1047.t0 a_2019_1047.t1 5.62052
R2312 a_2019_1047.t9 a_2019_1047.n5 4.61291
R2313 a_2019_1047.n5 a_2019_1047.n4 4.61291
R2314 a_2019_1047.n4 a_2019_1047.n3 4.61291
R2315 a_2019_1047.n3 a_2019_1047.n2 4.61291
R2316 a_2019_1047.n2 a_2019_1047.n1 4.61291
R2317 a_2019_1047.n1 a_2019_1047.n0 4.61291
C1105 MUX_OUT VSS 3.24058f
C1106 MUX_SEL4 VSS 1.60778f
C1107 MUX_SEL3 VSS 0.90686f
C1108 MUX_SEL2 VSS 1.81137f
C1109 MUX_SEL1 VSS 0.95076f
C1110 MUX_SEL0 VSS 1.55166f
C1111 DELAY_VBIASN VSS 12.41106f
C1112 DELAY_OUT_LAST VSS 0.39284f
C1113 DELAY_VBIASP VSS 4.14121f
C1114 DELAY_IN VSS 1.91954f
C1115 VDD VSS 46.2831f
C1116 a_26985_519# VSS 0.17928f ; **FLOATING
C1117 a_23945_519# VSS 0.17928f ; **FLOATING
C1118 a_20905_519# VSS 0.17928f ; **FLOATING
C1119 a_17865_519# VSS 0.17593f ; **FLOATING
C1120 a_16851_309# VSS 0.38699f ; **FLOATING
C1121 a_16108_289# VSS 3.70428f ; **FLOATING
C1122 a_15964_289# VSS 0.17613f ; **FLOATING
C1123 a_15765_463# VSS 0.36132f ; **FLOATING
C1124 a_14825_519# VSS 0.17928f ; **FLOATING
C1125 a_11785_519# VSS 0.17928f ; **FLOATING
C1126 a_8745_519# VSS 0.17928f ; **FLOATING
C1127 a_5731_289# VSS 3.39133f ; **FLOATING
C1128 a_2019_311# VSS 1.61601f ; **FLOATING
C1129 a_5705_519# VSS 0.17638f ; **FLOATING
C1130 a_3449_331# VSS 0.18478f ; **FLOATING
C1131 a_2873_331# VSS 0.18321f ; **FLOATING
C1132 a_2297_331# VSS 0.18321f ; **FLOATING
C1133 a_1721_331# VSS 0.17001f ; **FLOATING
C1134 a_1544_289# VSS 0.30014f ; **FLOATING
C1135 a_1256_289# VSS 0.84266f ; **FLOATING
C1136 a_27991_1008# VSS 0.18706f ; **FLOATING
C1137 a_27915_1044# VSS 0.10926f ; **FLOATING
C1138 a_27124_1008# VSS 0.17878f ; **FLOATING
C1139 a_27048_1044# VSS 0.12122f ; **FLOATING
C1140 a_26471_1008# VSS 0.18175f ; **FLOATING
C1141 a_26395_1044# VSS 0.11073f ; **FLOATING
C1142 a_25604_1008# VSS 0.18087f ; **FLOATING
C1143 a_25630_1044# VSS 0.37805f ; **FLOATING
C1144 a_25528_1044# VSS 0.12433f ; **FLOATING
C1145 a_24951_1008# VSS 0.18335f ; **FLOATING
C1146 a_24875_1044# VSS 0.11016f ; **FLOATING
C1147 a_24084_1008# VSS 0.17878f ; **FLOATING
C1148 a_24008_1044# VSS 0.12122f ; **FLOATING
C1149 a_23431_1008# VSS 0.18175f ; **FLOATING
C1150 a_23355_1044# VSS 0.11073f ; **FLOATING
C1151 a_22564_1008# VSS 0.18087f ; **FLOATING
C1152 a_22590_1044# VSS 0.33314f ; **FLOATING
C1153 a_22488_1044# VSS 0.12433f ; **FLOATING
C1154 a_21911_1008# VSS 0.18335f ; **FLOATING
C1155 a_21835_1044# VSS 0.11016f ; **FLOATING
C1156 a_21044_1008# VSS 0.17878f ; **FLOATING
C1157 a_20968_1044# VSS 0.12122f ; **FLOATING
C1158 a_20391_1008# VSS 0.18175f ; **FLOATING
C1159 a_20315_1044# VSS 0.11073f ; **FLOATING
C1160 a_19524_1008# VSS 0.18087f ; **FLOATING
C1161 a_19550_1044# VSS 0.33563f ; **FLOATING
C1162 a_19448_1044# VSS 0.12433f ; **FLOATING
C1163 a_18871_1008# VSS 0.18335f ; **FLOATING
C1164 a_18795_1044# VSS 0.11016f ; **FLOATING
C1165 a_18004_1008# VSS 0.17878f ; **FLOATING
C1166 a_17928_1044# VSS 0.12122f ; **FLOATING
C1167 a_17351_1008# VSS 0.18022f ; **FLOATING
C1168 a_17275_1044# VSS 0.10926f ; **FLOATING
C1169 a_16484_1008# VSS 0.18023f ; **FLOATING
C1170 a_16510_1044# VSS 0.28935f ; **FLOATING
C1171 a_16408_1044# VSS 0.1229f ; **FLOATING
C1172 a_15831_1008# VSS 0.17846f ; **FLOATING
C1173 a_15755_1044# VSS 0.10926f ; **FLOATING
C1174 a_14964_1008# VSS 0.17878f ; **FLOATING
C1175 a_14888_1044# VSS 0.12122f ; **FLOATING
C1176 a_14311_1008# VSS 0.18175f ; **FLOATING
C1177 a_14235_1044# VSS 0.11073f ; **FLOATING
C1178 a_13444_1008# VSS 0.18087f ; **FLOATING
C1179 a_13470_1044# VSS 0.30333f ; **FLOATING
C1180 a_13368_1044# VSS 0.12433f ; **FLOATING
C1181 a_12791_1008# VSS 0.18335f ; **FLOATING
C1182 a_12715_1044# VSS 0.11016f ; **FLOATING
C1183 a_11924_1008# VSS 0.17878f ; **FLOATING
C1184 a_11848_1044# VSS 0.12122f ; **FLOATING
C1185 a_11271_1008# VSS 0.18175f ; **FLOATING
C1186 a_11195_1044# VSS 0.11073f ; **FLOATING
C1187 a_10404_1008# VSS 0.18087f ; **FLOATING
C1188 a_10430_1044# VSS 0.31665f ; **FLOATING
C1189 a_10328_1044# VSS 0.12433f ; **FLOATING
C1190 a_9751_1008# VSS 0.18335f ; **FLOATING
C1191 a_9675_1044# VSS 0.11016f ; **FLOATING
C1192 a_8884_1008# VSS 0.17878f ; **FLOATING
C1193 a_8808_1044# VSS 0.12122f ; **FLOATING
C1194 a_8231_1008# VSS 0.18175f ; **FLOATING
C1195 a_8155_1044# VSS 0.11073f ; **FLOATING
C1196 a_7364_1008# VSS 0.18087f ; **FLOATING
C1197 a_7390_1044# VSS 0.31357f ; **FLOATING
C1198 a_7288_1044# VSS 0.12433f ; **FLOATING
C1199 a_6711_1008# VSS 0.18335f ; **FLOATING
C1200 a_6635_1044# VSS 0.11016f ; **FLOATING
C1201 a_5844_1008# VSS 0.17878f ; **FLOATING
C1202 a_5768_1044# VSS 0.12122f ; **FLOATING
C1203 a_5191_1008# VSS 0.18022f ; **FLOATING
C1204 a_5115_1044# VSS 0.10926f ; **FLOATING
C1205 a_4324_1008# VSS 0.18023f ; **FLOATING
C1206 a_4350_1044# VSS 0.26655f ; **FLOATING
C1207 a_4248_1044# VSS 0.12443f ; **FLOATING
C1208 a_27705_1044# VSS 0.25296f ; **FLOATING
C1209 a_26185_1044# VSS 0.23475f ; **FLOATING
C1210 a_24665_1044# VSS 0.25432f ; **FLOATING
C1211 a_23145_1044# VSS 0.23475f ; **FLOATING
C1212 a_21625_1044# VSS 0.25432f ; **FLOATING
C1213 a_20105_1044# VSS 0.23475f ; **FLOATING
C1214 a_18585_1044# VSS 0.25432f ; **FLOATING
C1215 a_17065_1044# VSS 0.23385f ; **FLOATING
C1216 a_15545_1044# VSS 0.25296f ; **FLOATING
C1217 a_14025_1044# VSS 0.23475f ; **FLOATING
C1218 a_12505_1044# VSS 0.25432f ; **FLOATING
C1219 a_10985_1044# VSS 0.23475f ; **FLOATING
C1220 a_9465_1044# VSS 0.25432f ; **FLOATING
C1221 a_7945_1044# VSS 0.23475f ; **FLOATING
C1222 a_6425_1044# VSS 0.25432f ; **FLOATING
C1223 a_4905_1044# VSS 0.23549f ; **FLOATING
C1224 a_4157_1313# VSS 0.32875f ; **FLOATING
C1225 a_3449_1395# VSS 0.18629f ; **FLOATING
C1226 a_2873_1395# VSS 0.18349f ; **FLOATING
C1227 a_2297_1395# VSS 0.18349f ; **FLOATING
C1228 a_1721_1395# VSS 0.17029f ; **FLOATING
C1229 a_1544_1044# VSS 0.29829f ; **FLOATING
C1230 a_1256_1044# VSS 0.82978f ; **FLOATING
C1231 a_27671_1842# VSS 0.01336f ; **FLOATING
C1232 a_26911_1842# VSS 0.01336f ; **FLOATING
C1233 a_26151_1842# VSS 0.01336f ; **FLOATING
C1234 a_25391_1842# VSS 0.01336f ; **FLOATING
C1235 a_24631_1842# VSS 0.01336f ; **FLOATING
C1236 a_23871_1842# VSS 0.01336f ; **FLOATING
C1237 a_23111_1842# VSS 0.01336f ; **FLOATING
C1238 a_22351_1842# VSS 0.01336f ; **FLOATING
C1239 a_21591_1842# VSS 0.01336f ; **FLOATING
C1240 a_20831_1842# VSS 0.01336f ; **FLOATING
C1241 a_20071_1842# VSS 0.01336f ; **FLOATING
C1242 a_19311_1842# VSS 0.01336f ; **FLOATING
C1243 a_18551_1842# VSS 0.01336f ; **FLOATING
C1244 a_17791_1842# VSS 0.01336f ; **FLOATING
C1245 a_17031_1842# VSS 0.01336f ; **FLOATING
C1246 a_16271_1842# VSS 0.01336f ; **FLOATING
C1247 a_15511_1842# VSS 0.01336f ; **FLOATING
C1248 a_14751_1842# VSS 0.01336f ; **FLOATING
C1249 a_13991_1842# VSS 0.01336f ; **FLOATING
C1250 a_13231_1842# VSS 0.01336f ; **FLOATING
C1251 a_12471_1842# VSS 0.01336f ; **FLOATING
C1252 a_11711_1842# VSS 0.01336f ; **FLOATING
C1253 a_10951_1842# VSS 0.01336f ; **FLOATING
C1254 a_10191_1842# VSS 0.01336f ; **FLOATING
C1255 a_9431_1842# VSS 0.01336f ; **FLOATING
C1256 a_8671_1842# VSS 0.01336f ; **FLOATING
C1257 a_7911_1842# VSS 0.01336f ; **FLOATING
C1258 a_7151_1842# VSS 0.01336f ; **FLOATING
C1259 a_6391_1842# VSS 0.01336f ; **FLOATING
C1260 a_5631_1842# VSS 0.01336f ; **FLOATING
C1261 a_4871_1842# VSS 0.01336f ; **FLOATING
C1262 a_4111_1842# VSS 0.0139f ; **FLOATING
C1263 a_27563_1842# VSS 0.51284f ; **FLOATING
C1264 a_27997_1842# VSS 0.6533f ; **FLOATING
C1265 a_27433_1842# VSS 0.45843f ; **FLOATING
C1266 a_26803_1842# VSS 0.50902f ; **FLOATING
C1267 a_27237_1842# VSS 0.93747f ; **FLOATING
C1268 a_26673_1842# VSS 0.45994f ; **FLOATING
C1269 a_26043_1842# VSS 0.51137f ; **FLOATING
C1270 a_26477_1842# VSS 0.96549f ; **FLOATING
C1271 a_25913_1842# VSS 0.46292f ; **FLOATING
C1272 a_25283_1842# VSS 0.50906f ; **FLOATING
C1273 a_25717_1842# VSS 0.87619f ; **FLOATING
C1274 a_25153_1842# VSS 0.45997f ; **FLOATING
C1275 a_24523_1842# VSS 0.51043f ; **FLOATING
C1276 a_24957_1842# VSS 0.97121f ; **FLOATING
C1277 a_24393_1842# VSS 0.45843f ; **FLOATING
C1278 a_23763_1842# VSS 0.50902f ; **FLOATING
C1279 a_24197_1842# VSS 0.93322f ; **FLOATING
C1280 a_23633_1842# VSS 0.45994f ; **FLOATING
C1281 a_23003_1842# VSS 0.51137f ; **FLOATING
C1282 a_23437_1842# VSS 0.96549f ; **FLOATING
C1283 a_22873_1842# VSS 0.46292f ; **FLOATING
C1284 a_22243_1842# VSS 0.50906f ; **FLOATING
C1285 a_22677_1842# VSS 0.87619f ; **FLOATING
C1286 a_22113_1842# VSS 0.45997f ; **FLOATING
C1287 a_21483_1842# VSS 0.51043f ; **FLOATING
C1288 a_21917_1842# VSS 0.97121f ; **FLOATING
C1289 a_21353_1842# VSS 0.45843f ; **FLOATING
C1290 a_20723_1842# VSS 0.50902f ; **FLOATING
C1291 a_21157_1842# VSS 0.93322f ; **FLOATING
C1292 a_20593_1842# VSS 0.45994f ; **FLOATING
C1293 a_19963_1842# VSS 0.51137f ; **FLOATING
C1294 a_20397_1842# VSS 0.96549f ; **FLOATING
C1295 a_19833_1842# VSS 0.46292f ; **FLOATING
C1296 a_19203_1842# VSS 0.50906f ; **FLOATING
C1297 a_19637_1842# VSS 0.87619f ; **FLOATING
C1298 a_19073_1842# VSS 0.45997f ; **FLOATING
C1299 a_18443_1842# VSS 0.51043f ; **FLOATING
C1300 a_18877_1842# VSS 0.97121f ; **FLOATING
C1301 a_18313_1842# VSS 0.45843f ; **FLOATING
C1302 a_17683_1842# VSS 0.50902f ; **FLOATING
C1303 a_18117_1842# VSS 0.93322f ; **FLOATING
C1304 a_17553_1842# VSS 0.45994f ; **FLOATING
C1305 a_16923_1842# VSS 0.51133f ; **FLOATING
C1306 a_17357_1842# VSS 0.96549f ; **FLOATING
C1307 a_16793_1842# VSS 0.46262f ; **FLOATING
C1308 a_16163_1842# VSS 0.50902f ; **FLOATING
C1309 a_16597_1842# VSS 0.87137f ; **FLOATING
C1310 a_16033_1842# VSS 0.45859f ; **FLOATING
C1311 a_15403_1842# VSS 0.51041f ; **FLOATING
C1312 a_15837_1842# VSS 0.9618f ; **FLOATING
C1313 a_15273_1842# VSS 0.45843f ; **FLOATING
C1314 a_14643_1842# VSS 0.50902f ; **FLOATING
C1315 a_15077_1842# VSS 0.93209f ; **FLOATING
C1316 a_14513_1842# VSS 0.45994f ; **FLOATING
C1317 a_13883_1842# VSS 0.51137f ; **FLOATING
C1318 a_14317_1842# VSS 0.96549f ; **FLOATING
C1319 a_13753_1842# VSS 0.46292f ; **FLOATING
C1320 a_13123_1842# VSS 0.50904f ; **FLOATING
C1321 a_13557_1842# VSS 0.87619f ; **FLOATING
C1322 a_12993_1842# VSS 0.45997f ; **FLOATING
C1323 a_12363_1842# VSS 0.51043f ; **FLOATING
C1324 a_12797_1842# VSS 0.96954f ; **FLOATING
C1325 a_12233_1842# VSS 0.45843f ; **FLOATING
C1326 a_11603_1842# VSS 0.50902f ; **FLOATING
C1327 a_12037_1842# VSS 0.93322f ; **FLOATING
C1328 a_11473_1842# VSS 0.45994f ; **FLOATING
C1329 a_10843_1842# VSS 0.51137f ; **FLOATING
C1330 a_11277_1842# VSS 0.96549f ; **FLOATING
C1331 a_10713_1842# VSS 0.46292f ; **FLOATING
C1332 a_10083_1842# VSS 0.50904f ; **FLOATING
C1333 a_10517_1842# VSS 0.87619f ; **FLOATING
C1334 a_9953_1842# VSS 0.45997f ; **FLOATING
C1335 a_9323_1842# VSS 0.51043f ; **FLOATING
C1336 a_9757_1842# VSS 0.96954f ; **FLOATING
C1337 a_9193_1842# VSS 0.45843f ; **FLOATING
C1338 a_8563_1842# VSS 0.50902f ; **FLOATING
C1339 a_8997_1842# VSS 0.93322f ; **FLOATING
C1340 a_8433_1842# VSS 0.45994f ; **FLOATING
C1341 a_7803_1842# VSS 0.51137f ; **FLOATING
C1342 a_8237_1842# VSS 0.96549f ; **FLOATING
C1343 a_7673_1842# VSS 0.46292f ; **FLOATING
C1344 a_7043_1842# VSS 0.50904f ; **FLOATING
C1345 a_7477_1842# VSS 0.87619f ; **FLOATING
C1346 a_6913_1842# VSS 0.45997f ; **FLOATING
C1347 a_6283_1842# VSS 0.51043f ; **FLOATING
C1348 a_6717_1842# VSS 0.96895f ; **FLOATING
C1349 a_6153_1842# VSS 0.45843f ; **FLOATING
C1350 a_5523_1842# VSS 0.50902f ; **FLOATING
C1351 a_5957_1842# VSS 0.93322f ; **FLOATING
C1352 a_5393_1842# VSS 0.45994f ; **FLOATING
C1353 a_4763_1842# VSS 0.51133f ; **FLOATING
C1354 a_5197_1842# VSS 0.96549f ; **FLOATING
C1355 a_4633_1842# VSS 0.4629f ; **FLOATING
C1356 a_4003_1842# VSS 0.58899f ; **FLOATING
C1357 a_4437_1842# VSS 0.87666f ; **FLOATING
C1358 a_2019_1047.t2 VSS 0.93017f ; **FLOATING
C1359 a_2019_1047.t3 VSS 0.70616f ; **FLOATING
C1360 a_2019_1047.n0 VSS 5.0083f ; **FLOATING
C1361 a_2019_1047.t4 VSS 0.70616f ; **FLOATING
C1362 a_2019_1047.n1 VSS 3.38825f ; **FLOATING
C1363 a_2019_1047.t5 VSS 0.70616f ; **FLOATING
C1364 a_2019_1047.n2 VSS 3.38825f ; **FLOATING
C1365 a_2019_1047.t6 VSS 0.70616f ; **FLOATING
C1366 a_2019_1047.n3 VSS 3.38825f ; **FLOATING
C1367 a_2019_1047.t7 VSS 0.70616f ; **FLOATING
C1368 a_2019_1047.n4 VSS 3.38825f ; **FLOATING
C1369 a_2019_1047.t8 VSS 0.70616f ; **FLOATING
C1370 a_2019_1047.n5 VSS 3.38825f ; **FLOATING
C1371 a_2019_1047.t9 VSS 5.45427f ; **FLOATING
C1372 a_2019_1047.t1 VSS 1.07246f ; **FLOATING
C1373 a_2019_1047.t0 VSS 0.30482f ; **FLOATING
C1374 a_2595_1047.t2 VSS 1.36702f ; **FLOATING
C1375 a_2595_1047.t3 VSS 1.02093f ; **FLOATING
C1376 a_2595_1047.n0 VSS 7.7612f ; **FLOATING
C1377 a_2595_1047.t4 VSS 1.02093f ; **FLOATING
C1378 a_2595_1047.n1 VSS 5.27337f ; **FLOATING
C1379 a_2595_1047.t5 VSS 1.02093f ; **FLOATING
C1380 a_2595_1047.n2 VSS 5.27337f ; **FLOATING
C1381 a_2595_1047.t6 VSS 1.02093f ; **FLOATING
C1382 a_2595_1047.n3 VSS 5.27337f ; **FLOATING
C1383 a_2595_1047.t7 VSS 1.02093f ; **FLOATING
C1384 a_2595_1047.n4 VSS 5.27337f ; **FLOATING
C1385 a_2595_1047.t8 VSS 1.02093f ; **FLOATING
C1386 a_2595_1047.n5 VSS 5.27337f ; **FLOATING
C1387 a_2595_1047.t9 VSS 1.02093f ; **FLOATING
C1388 a_2595_1047.n6 VSS 7.58543f ; **FLOATING
C1389 a_2595_1047.t1 VSS 1.75118f ; **FLOATING
C1390 a_2595_1047.t0 VSS 0.48227f ; **FLOATING
C1391 a_3171_1047.t2 VSS 1.38441f ; **FLOATING
C1392 a_3171_1047.t3 VSS 1.03733f ; **FLOATING
C1393 a_3171_1047.n0 VSS 7.77853f ; **FLOATING
C1394 a_3171_1047.t4 VSS 1.03733f ; **FLOATING
C1395 a_3171_1047.n1 VSS 5.2808f ; **FLOATING
C1396 a_3171_1047.t5 VSS 1.03733f ; **FLOATING
C1397 a_3171_1047.n2 VSS 5.2808f ; **FLOATING
C1398 a_3171_1047.t6 VSS 1.03733f ; **FLOATING
C1399 a_3171_1047.n3 VSS 5.2808f ; **FLOATING
C1400 a_3171_1047.t7 VSS 1.03733f ; **FLOATING
C1401 a_3171_1047.n4 VSS 5.2808f ; **FLOATING
C1402 a_3171_1047.t8 VSS 1.03733f ; **FLOATING
C1403 a_3171_1047.n5 VSS 5.2808f ; **FLOATING
C1404 a_3171_1047.t9 VSS 1.03733f ; **FLOATING
C1405 a_3171_1047.n6 VSS 7.68344f ; **FLOATING
C1406 a_3171_1047.t1 VSS 1.77025f ; **FLOATING
C1407 a_3171_1047.t0 VSS 0.48084f ; **FLOATING
C1408 a_3747_1047.t2 VSS 0.96884f ; **FLOATING
C1409 a_3747_1047.t3 VSS 0.73759f ; **FLOATING
C1410 a_3747_1047.n0 VSS 5.16742f ; **FLOATING
C1411 a_3747_1047.t4 VSS 0.73759f ; **FLOATING
C1412 a_3747_1047.n1 VSS 3.49311f ; **FLOATING
C1413 a_3747_1047.t5 VSS 0.73759f ; **FLOATING
C1414 a_3747_1047.n2 VSS 3.49311f ; **FLOATING
C1415 a_3747_1047.t6 VSS 0.73759f ; **FLOATING
C1416 a_3747_1047.n3 VSS 3.49311f ; **FLOATING
C1417 a_3747_1047.t7 VSS 0.73759f ; **FLOATING
C1418 a_3747_1047.n4 VSS 3.49311f ; **FLOATING
C1419 a_3747_1047.t8 VSS 0.73759f ; **FLOATING
C1420 a_3747_1047.n5 VSS 3.49311f ; **FLOATING
C1421 a_3747_1047.t9 VSS 0.73759f ; **FLOATING
C1422 a_3747_1047.n6 VSS 5.18686f ; **FLOATING
C1423 a_3747_1047.t1 VSS 1.18534f ; **FLOATING
C1424 a_3747_1047.t0 VSS 0.31337f ; **FLOATING
C1425 a_2595_311.t1 VSS 3.27037f ; **FLOATING
C1426 a_2595_311.t2 VSS 5.04145f ; **FLOATING
C1427 a_2595_311.t3 VSS 1.20632f ; **FLOATING
C1428 a_2595_311.n0 VSS 26.8668f ; **FLOATING
C1429 a_2595_311.t0 VSS 0.49572f ; **FLOATING
C1430 a_3171_311.t2 VSS 5.05009f ; **FLOATING
C1431 a_3171_311.t3 VSS 1.21149f ; **FLOATING
C1432 a_3171_311.n0 VSS 29.8499f ; **FLOATING
C1433 a_3171_311.t1 VSS 4.61154f ; **FLOATING
C1434 a_3171_311.t0 VSS 0.4973f ; **FLOATING
C1435 a_3747_311.t2 VSS 3.08793f ; **FLOATING
C1436 a_3747_311.t3 VSS 0.74323f ; **FLOATING
C1437 a_3747_311.n0 VSS 19.8622f ; **FLOATING
C1438 a_3747_311.t1 VSS 3.68403f ; **FLOATING
C1439 a_3747_311.t0 VSS 0.30496f ; **FLOATING
C1440 DELAY_VBIASP.n0 VSS 0.14465f ; **FLOATING
C1441 DELAY_VBIASP.t31 VSS 0.3704f ; **FLOATING
C1442 DELAY_VBIASP.t30 VSS 0.36212f ; **FLOATING
C1443 DELAY_VBIASP.n1 VSS 0.64892f ; **FLOATING
C1444 DELAY_VBIASP.t29 VSS 0.36212f ; **FLOATING
C1445 DELAY_VBIASP.n2 VSS 0.44906f ; **FLOATING
C1446 DELAY_VBIASP.t28 VSS 0.36212f ; **FLOATING
C1447 DELAY_VBIASP.n3 VSS 0.44906f ; **FLOATING
C1448 DELAY_VBIASP.t27 VSS 0.36212f ; **FLOATING
C1449 DELAY_VBIASP.n4 VSS 0.44906f ; **FLOATING
C1450 DELAY_VBIASP.t26 VSS 0.36212f ; **FLOATING
C1451 DELAY_VBIASP.n5 VSS 0.44906f ; **FLOATING
C1452 DELAY_VBIASP.t25 VSS 0.36212f ; **FLOATING
C1453 DELAY_VBIASP.n6 VSS 0.44906f ; **FLOATING
C1454 DELAY_VBIASP.t24 VSS 0.36212f ; **FLOATING
C1455 DELAY_VBIASP.n7 VSS 0.44906f ; **FLOATING
C1456 DELAY_VBIASP.t23 VSS 0.36212f ; **FLOATING
C1457 DELAY_VBIASP.n8 VSS 0.44906f ; **FLOATING
C1458 DELAY_VBIASP.t22 VSS 0.36212f ; **FLOATING
C1459 DELAY_VBIASP.n9 VSS 0.44906f ; **FLOATING
C1460 DELAY_VBIASP.t21 VSS 0.36212f ; **FLOATING
C1461 DELAY_VBIASP.n10 VSS 0.44906f ; **FLOATING
C1462 DELAY_VBIASP.t20 VSS 0.36212f ; **FLOATING
C1463 DELAY_VBIASP.n11 VSS 0.44906f ; **FLOATING
C1464 DELAY_VBIASP.t19 VSS 0.36212f ; **FLOATING
C1465 DELAY_VBIASP.n12 VSS 0.44906f ; **FLOATING
C1466 DELAY_VBIASP.t18 VSS 0.36212f ; **FLOATING
C1467 DELAY_VBIASP.n13 VSS 0.44906f ; **FLOATING
C1468 DELAY_VBIASP.t17 VSS 0.36212f ; **FLOATING
C1469 DELAY_VBIASP.n14 VSS 0.44906f ; **FLOATING
C1470 DELAY_VBIASP.t16 VSS 0.36212f ; **FLOATING
C1471 DELAY_VBIASP.n15 VSS 0.44906f ; **FLOATING
C1472 DELAY_VBIASP.t15 VSS 0.36212f ; **FLOATING
C1473 DELAY_VBIASP.n16 VSS 0.44906f ; **FLOATING
C1474 DELAY_VBIASP.t14 VSS 0.36212f ; **FLOATING
C1475 DELAY_VBIASP.n17 VSS 0.44906f ; **FLOATING
C1476 DELAY_VBIASP.t13 VSS 0.36212f ; **FLOATING
C1477 DELAY_VBIASP.n18 VSS 0.44906f ; **FLOATING
C1478 DELAY_VBIASP.t12 VSS 0.36212f ; **FLOATING
C1479 DELAY_VBIASP.n19 VSS 0.44906f ; **FLOATING
C1480 DELAY_VBIASP.t11 VSS 0.36212f ; **FLOATING
C1481 DELAY_VBIASP.n20 VSS 0.44906f ; **FLOATING
C1482 DELAY_VBIASP.t10 VSS 0.36212f ; **FLOATING
C1483 DELAY_VBIASP.n21 VSS 0.44906f ; **FLOATING
C1484 DELAY_VBIASP.t9 VSS 0.36212f ; **FLOATING
C1485 DELAY_VBIASP.n22 VSS 0.44906f ; **FLOATING
C1486 DELAY_VBIASP.t8 VSS 0.36212f ; **FLOATING
C1487 DELAY_VBIASP.n23 VSS 0.44906f ; **FLOATING
C1488 DELAY_VBIASP.t7 VSS 0.36212f ; **FLOATING
C1489 DELAY_VBIASP.n24 VSS 0.44906f ; **FLOATING
C1490 DELAY_VBIASP.t6 VSS 0.36212f ; **FLOATING
C1491 DELAY_VBIASP.n25 VSS 0.44906f ; **FLOATING
C1492 DELAY_VBIASP.t5 VSS 0.36212f ; **FLOATING
C1493 DELAY_VBIASP.n26 VSS 0.44906f ; **FLOATING
C1494 DELAY_VBIASP.t4 VSS 0.36212f ; **FLOATING
C1495 DELAY_VBIASP.n27 VSS 0.44906f ; **FLOATING
C1496 DELAY_VBIASP.t3 VSS 0.36212f ; **FLOATING
C1497 DELAY_VBIASP.n28 VSS 0.44906f ; **FLOATING
C1498 DELAY_VBIASP.t2 VSS 0.36212f ; **FLOATING
C1499 DELAY_VBIASP.n29 VSS 0.44906f ; **FLOATING
C1500 DELAY_VBIASP.t1 VSS 0.36212f ; **FLOATING
C1501 DELAY_VBIASP.n30 VSS 0.44906f ; **FLOATING
C1502 DELAY_VBIASP.t0 VSS 0.36212f ; **FLOATING
C1503 DELAY_VBIASN.n0 VSS 0.37703f ; **FLOATING
C1504 DELAY_VBIASN.t31 VSS 0.22492f ; **FLOATING
C1505 DELAY_VBIASN.t30 VSS 0.21832f ; **FLOATING
C1506 DELAY_VBIASN.n1 VSS 0.51667f ; **FLOATING
C1507 DELAY_VBIASN.t29 VSS 0.21832f ; **FLOATING
C1508 DELAY_VBIASN.n2 VSS 0.35838f ; **FLOATING
C1509 DELAY_VBIASN.t28 VSS 0.21832f ; **FLOATING
C1510 DELAY_VBIASN.n3 VSS 0.35838f ; **FLOATING
C1511 DELAY_VBIASN.t27 VSS 0.21832f ; **FLOATING
C1512 DELAY_VBIASN.n4 VSS 0.35838f ; **FLOATING
C1513 DELAY_VBIASN.t26 VSS 0.21832f ; **FLOATING
C1514 DELAY_VBIASN.n5 VSS 0.35838f ; **FLOATING
C1515 DELAY_VBIASN.t25 VSS 0.21832f ; **FLOATING
C1516 DELAY_VBIASN.n6 VSS 0.35838f ; **FLOATING
C1517 DELAY_VBIASN.t24 VSS 0.21832f ; **FLOATING
C1518 DELAY_VBIASN.n7 VSS 0.35838f ; **FLOATING
C1519 DELAY_VBIASN.t23 VSS 0.21832f ; **FLOATING
C1520 DELAY_VBIASN.n8 VSS 0.35838f ; **FLOATING
C1521 DELAY_VBIASN.t22 VSS 0.21832f ; **FLOATING
C1522 DELAY_VBIASN.n9 VSS 0.35838f ; **FLOATING
C1523 DELAY_VBIASN.t21 VSS 0.21832f ; **FLOATING
C1524 DELAY_VBIASN.n10 VSS 0.35838f ; **FLOATING
C1525 DELAY_VBIASN.t20 VSS 0.21832f ; **FLOATING
C1526 DELAY_VBIASN.n11 VSS 0.35838f ; **FLOATING
C1527 DELAY_VBIASN.t19 VSS 0.21832f ; **FLOATING
C1528 DELAY_VBIASN.n12 VSS 0.35838f ; **FLOATING
C1529 DELAY_VBIASN.t18 VSS 0.21832f ; **FLOATING
C1530 DELAY_VBIASN.n13 VSS 0.35838f ; **FLOATING
C1531 DELAY_VBIASN.t17 VSS 0.21832f ; **FLOATING
C1532 DELAY_VBIASN.n14 VSS 0.35838f ; **FLOATING
C1533 DELAY_VBIASN.t16 VSS 0.21832f ; **FLOATING
C1534 DELAY_VBIASN.n15 VSS 0.35838f ; **FLOATING
C1535 DELAY_VBIASN.t15 VSS 0.21832f ; **FLOATING
C1536 DELAY_VBIASN.n16 VSS 0.35838f ; **FLOATING
C1537 DELAY_VBIASN.t14 VSS 0.21832f ; **FLOATING
C1538 DELAY_VBIASN.n17 VSS 0.35838f ; **FLOATING
C1539 DELAY_VBIASN.t13 VSS 0.21832f ; **FLOATING
C1540 DELAY_VBIASN.n18 VSS 0.35838f ; **FLOATING
C1541 DELAY_VBIASN.t12 VSS 0.21832f ; **FLOATING
C1542 DELAY_VBIASN.n19 VSS 0.35838f ; **FLOATING
C1543 DELAY_VBIASN.t11 VSS 0.21832f ; **FLOATING
C1544 DELAY_VBIASN.n20 VSS 0.35838f ; **FLOATING
C1545 DELAY_VBIASN.t10 VSS 0.21832f ; **FLOATING
C1546 DELAY_VBIASN.n21 VSS 0.35838f ; **FLOATING
C1547 DELAY_VBIASN.t9 VSS 0.21832f ; **FLOATING
C1548 DELAY_VBIASN.n22 VSS 0.35838f ; **FLOATING
C1549 DELAY_VBIASN.t8 VSS 0.21832f ; **FLOATING
C1550 DELAY_VBIASN.n23 VSS 0.35838f ; **FLOATING
C1551 DELAY_VBIASN.t7 VSS 0.21832f ; **FLOATING
C1552 DELAY_VBIASN.n24 VSS 0.35838f ; **FLOATING
C1553 DELAY_VBIASN.t6 VSS 0.21832f ; **FLOATING
C1554 DELAY_VBIASN.n25 VSS 0.35838f ; **FLOATING
C1555 DELAY_VBIASN.t5 VSS 0.21832f ; **FLOATING
C1556 DELAY_VBIASN.n26 VSS 0.35838f ; **FLOATING
C1557 DELAY_VBIASN.t4 VSS 0.21832f ; **FLOATING
C1558 DELAY_VBIASN.n27 VSS 0.35838f ; **FLOATING
C1559 DELAY_VBIASN.t3 VSS 0.21832f ; **FLOATING
C1560 DELAY_VBIASN.n28 VSS 0.35838f ; **FLOATING
C1561 DELAY_VBIASN.t2 VSS 0.21832f ; **FLOATING
C1562 DELAY_VBIASN.n29 VSS 0.35838f ; **FLOATING
C1563 DELAY_VBIASN.t1 VSS 0.21832f ; **FLOATING
C1564 DELAY_VBIASN.n30 VSS 0.35838f ; **FLOATING
C1565 DELAY_VBIASN.t0 VSS 0.21832f ; **FLOATING
.ends
