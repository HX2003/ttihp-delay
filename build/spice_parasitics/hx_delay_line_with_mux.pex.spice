* NGSPICE file created from hx_delay_line_with_mux.ext - technology: ihp-sg13g2

.subckt hx_delay_line_with_mux VSS VDD DELAY_OUT_LAST DELAY_IN MUX_SEL0 MUX_SEL1 MUX_OUT
+ MUX_SEL4 MUX_SEL2 MUX_SEL3 DELAY_VBIASN DELAY_VBIASP
X0 VDD a_4003_1842# a_4437_1842# VDD sg13_lv_pmos ad=0.2128p pd=1.5u as=0.3808p ps=2.92u w=1.12u l=0.13u
X1 VSS.t235 a_15077_1842# a_15545_1044# VSS.t489 sg13_lv_nmos ad=0.1665p pd=1.19u as=0.2516p ps=2.16u w=0.74u l=0.13u
X2 a_27915_1044# a_27705_1044# VDD VDD sg13_lv_pmos ad=0.2128p pd=1.5u as=0.252p ps=1.57u w=1.12u l=0.13u
X3 VSS.t297 VDD VSS.t295 VSS.t296 sg13_lv_nmos ad=79.8f pd=0.8u as=0 ps=0 w=0.42u l=1u
X4 a_10951_2470# a_10713_1842# a_10843_1842# VDD sg13_lv_pmos ad=0.2128p pd=1.5u as=0.3808p ps=2.92u w=1.12u l=0.2u
X5 VSS.t141 a_3171_1047.t7 a_11924_1008# VSS.t140 sg13_lv_nmos ad=0.2516p pd=2.16u as=0.2516p ps=2.16u w=0.74u l=0.13u
X6 VDD VSS.t572 VDD VDD sg13_lv_pmos ad=0.34p pd=2.68u as=0.30484n ps=1.54979m w=1u l=1u
X7 VSS.t163 a_1256_1044# a_2967_1395# VSS.t547 sg13_lv_nmos ad=0.1331p pd=1.12u as=0.1216p ps=1.02u w=0.64u l=0.13u
X8 VSS.t300 VDD VSS.t299 VSS.t298 sg13_lv_nmos ad=0.1428p pd=1.52u as=0 ps=0 w=0.42u l=1u
X9 a_25153_1842# a_24957_1842# VSS.t213 VSS.t212 sg13_lv_nmos ad=0.2516p pd=2.16u as=0.1406p ps=1.12u w=0.74u l=0.13u
X10 VDD VSS.t586 VDD VDD sg13_lv_pmos ad=0.34p pd=2.68u as=0 ps=0 w=1u l=1u
X11 a_25630_1044# a_2019_1047.t2 a_25528_1044# VSS.t194 sg13_lv_nmos ad=0.2516p pd=2.16u as=0.1406p ps=1.12u w=0.74u l=0.13u
X12 VDD DELAY_VBIASP.t11 a_19311_2470# VDD sg13_lv_pmos ad=0.3808p pd=2.92u as=0.2128p ps=1.5u w=1.12u l=0.6u
X13 a_16108_289# a_2019_311# a_16510_1044# VSS.t99 sg13_lv_nmos ad=0.2516p pd=2.16u as=0.2516p ps=2.16u w=0.74u l=0.13u
X14 VDD DELAY_VBIASP.t24 a_9431_2470# VDD sg13_lv_pmos ad=0.3808p pd=2.92u as=0.2128p ps=1.5u w=1.12u l=0.6u
X15 VSS.t365 VDD VSS.t364 VSS.t363 sg13_lv_nmos ad=0.1428p pd=1.52u as=0 ps=0 w=0.42u l=1u
X16 VDD DELAY_VBIASP.t6 a_23111_2470# VDD sg13_lv_pmos ad=0.3808p pd=2.92u as=0.2128p ps=1.5u w=1.12u l=0.6u
X17 a_7390_1044# a_8231_1008# a_8155_1044# VDD sg13_lv_pmos ad=0.3808p pd=2.92u as=0.2128p ps=1.5u w=1.12u l=0.13u
X18 VSS.t132 a_2595_311.t3 a_8745_519# VSS.t131 sg13_lv_nmos ad=0.2516p pd=2.16u as=0.2516p ps=2.16u w=0.74u l=0.13u
X19 a_17791_1842# a_17553_1842# a_17683_1842# VSS.t419 sg13_lv_nmos ad=0.1406p pd=1.12u as=0.2516p ps=2.16u w=0.74u l=0.2u
X20 VDD a_12037_1842# a_12505_1044# VDD sg13_lv_pmos ad=0.252p pd=1.57u as=0.3808p ps=2.92u w=1.12u l=0.13u
X21 a_16510_1044# a_2019_1047.t5 a_16408_1044# VSS.t540 sg13_lv_nmos ad=0.2516p pd=2.16u as=0.1406p ps=1.12u w=0.74u l=0.13u
X22 a_21591_1842# a_21353_1842# a_21483_1842# VSS.t4 sg13_lv_nmos ad=0.1406p pd=1.12u as=0.2516p ps=2.16u w=0.74u l=0.2u
X23 a_6153_1842# a_5957_1842# VSS.t205 VSS.t204 sg13_lv_nmos ad=0.2516p pd=2.16u as=0.1406p ps=1.12u w=0.74u l=0.13u
X24 VSS.t209 a_16163_1842# a_16597_1842# VSS.t208 sg13_lv_nmos ad=0.1406p pd=1.12u as=0.2516p ps=2.16u w=0.74u l=0.13u
X25 VSS.t20 a_3171_1047.t2 a_27124_1008# VSS.t19 sg13_lv_nmos ad=0.2516p pd=2.16u as=0.2516p ps=2.16u w=0.74u l=0.13u
X26 VDD a_11603_1842# a_12037_1842# VDD sg13_lv_pmos ad=0.2128p pd=1.5u as=0.3808p ps=2.92u w=1.12u l=0.13u
X27 VDD a_3171_311.t3 a_11785_519# VDD sg13_lv_pmos ad=0.3808p pd=2.92u as=0.3808p ps=2.92u w=1.12u l=0.13u
X28 a_24393_1842# a_24197_1842# VDD VDD sg13_lv_pmos ad=0.3808p pd=2.92u as=0.2128p ps=1.5u w=1.12u l=0.13u
X29 a_5731_289# a_2595_311.t3 a_7390_1044# VSS.t130 sg13_lv_nmos ad=0.2516p pd=2.16u as=0.2516p ps=2.16u w=0.74u l=0.13u
X30 a_10430_1044# a_2595_1047.t7 a_11195_1044# VSS.t277 sg13_lv_nmos ad=0.2516p pd=2.16u as=0.1406p ps=1.12u w=0.74u l=0.13u
X31 a_23355_1044# a_23145_1044# VSS.t497 VSS.t554 sg13_lv_nmos ad=0.1406p pd=1.12u as=0.1665p ps=1.19u w=0.74u l=0.13u
X32 VDD DELAY_VBIASP.t17 a_14751_2470# VDD sg13_lv_pmos ad=0.3808p pd=2.92u as=0.2128p ps=1.5u w=1.12u l=0.6u
X33 VSS.t433 DELAY_VBIASN.t23 a_10191_1842# VSS.t432 sg13_lv_nmos ad=0.2516p pd=2.16u as=0.1406p ps=1.12u w=0.74u l=0.6u
X34 VSS.t230 a_3747_1047.t4 a_21911_1008# VSS.t229 sg13_lv_nmos ad=0.2516p pd=2.16u as=0.2516p ps=2.16u w=0.74u l=0.13u
X35 VSS.t41 a_19963_1842# a_20397_1842# VSS.t109 sg13_lv_nmos ad=0.1406p pd=1.12u as=0.2516p ps=2.16u w=0.74u l=0.13u
X36 VDD DELAY_VBIASP.t31 a_4111_2470# VDD sg13_lv_pmos ad=0.3808p pd=2.92u as=0.2128p ps=1.5u w=1.12u l=0.6u
X37 a_10328_1044# a_9757_1842# VDD VDD sg13_lv_pmos ad=0.2128p pd=1.5u as=0.3808p ps=2.92u w=1.12u l=0.13u
X38 a_20968_1044# a_20397_1842# VSS.t39 VSS.t38 sg13_lv_nmos ad=0.1406p pd=1.12u as=0.2516p ps=2.16u w=0.74u l=0.13u
X39 a_22590_1044# a_22564_1008# a_22488_1044# VDD sg13_lv_pmos ad=0.3808p pd=2.92u as=0.2128p ps=1.5u w=1.12u l=0.13u
X40 VDD VSS.t589 VDD VDD sg13_lv_pmos ad=0.19p pd=1.38u as=0 ps=0 w=1u l=1u
X41 a_8808_1044# a_8237_1842# VDD VDD sg13_lv_pmos ad=0.2128p pd=1.5u as=0.3808p ps=2.92u w=1.12u l=0.13u
X42 a_4157_1313# DELAY_IN VDD VDD sg13_lv_pmos ad=0.3808p pd=2.92u as=0.3808p ps=2.92u w=1.12u l=0.13u
X43 a_17031_2470# a_16793_1842# a_16923_1842# VDD sg13_lv_pmos ad=0.2128p pd=1.5u as=0.3808p ps=2.92u w=1.12u l=0.2u
X44 a_11473_1842# a_11277_1842# VSS.t501 VSS.t500 sg13_lv_nmos ad=0.2516p pd=2.16u as=0.1406p ps=1.12u w=0.74u l=0.13u
X45 VSS.t357 VDD VSS.t355 VSS.t356 sg13_lv_nmos ad=79.8f pd=0.8u as=0 ps=0 w=0.42u l=1u
X46 a_19448_1044# a_18877_1842# VSS.t111 VSS.t110 sg13_lv_nmos ad=0.1406p pd=1.12u as=0.2516p ps=2.16u w=0.74u l=0.13u
X47 a_10430_1044# a_3171_1047.t7 a_11848_1044# VSS.t139 sg13_lv_nmos ad=0.2516p pd=2.16u as=0.1406p ps=1.12u w=0.74u l=0.13u
X48 a_20831_2470# a_20593_1842# a_20723_1842# VDD sg13_lv_pmos ad=0.2128p pd=1.5u as=0.3808p ps=2.92u w=1.12u l=0.2u
X49 VSS.t322 VDD VSS.t320 VSS.t321 sg13_lv_nmos ad=79.8f pd=0.8u as=0 ps=0 w=0.42u l=1u
X50 VDD a_27237_1842# a_27705_1044# VDD sg13_lv_pmos ad=0.252p pd=1.57u as=0.3808p ps=2.92u w=1.12u l=0.13u
X51 a_5393_1842# a_5197_1842# VDD VDD sg13_lv_pmos ad=0.3808p pd=2.92u as=0.2128p ps=1.5u w=1.12u l=0.13u
X52 VDD DELAY_VBIASP.t14 a_17031_2470# VDD sg13_lv_pmos ad=0.3808p pd=2.92u as=0.2128p ps=1.5u w=1.12u l=0.6u
X53 VDD a_26803_1842# a_27237_1842# VDD sg13_lv_pmos ad=0.2128p pd=1.5u as=0.3808p ps=2.92u w=1.12u l=0.13u
X54 VDD MUX_SEL1 a_3449_1395# VDD sg13_lv_pmos ad=0.1918p pd=1.5u as=0.1596p ps=1.22u w=0.84u l=0.13u
X55 a_25630_1044# a_2595_1047.t2 a_26395_1044# VSS.t238 sg13_lv_nmos ad=0.2516p pd=2.16u as=0.1406p ps=1.12u w=0.74u l=0.13u
X56 VSS.t427 DELAY_VBIASN.t3 a_25391_1842# VSS.t426 sg13_lv_nmos ad=0.2516p pd=2.16u as=0.1406p ps=1.12u w=0.74u l=0.6u
X57 a_6635_1044# a_6425_1044# VDD VDD sg13_lv_pmos ad=0.2128p pd=1.5u as=0.252p ps=1.57u w=1.12u l=0.13u
X58 a_20315_1044# a_20105_1044# VDD VDD sg13_lv_pmos ad=0.2128p pd=1.5u as=0.252p ps=1.57u w=1.12u l=0.13u
X59 VDD a_2595_1047.t9 a_5191_1008# VDD sg13_lv_pmos ad=0.3808p pd=2.92u as=0.3808p ps=2.92u w=1.12u l=0.13u
X60 a_19311_2470# a_19073_1842# a_19203_1842# VDD sg13_lv_pmos ad=0.2128p pd=1.5u as=0.3808p ps=2.92u w=1.12u l=0.2u
X61 VSS.t56 a_1721_1395# a_2019_1047.t0 VSS.t55 sg13_lv_nmos ad=0.2812p pd=2.24u as=0.1406p ps=1.12u w=0.74u l=0.13u
X62 a_25528_1044# a_24957_1842# VDD VDD sg13_lv_pmos ad=0.2128p pd=1.5u as=0.3808p ps=2.92u w=1.12u l=0.13u
X63 VSS.t125 a_5957_1842# a_6425_1044# VSS.t203 sg13_lv_nmos ad=0.1665p pd=1.19u as=0.2516p ps=2.16u w=0.74u l=0.13u
X64 VSS.t264 a_2019_1047.t6 a_13444_1008# VSS.t263 sg13_lv_nmos ad=0.2516p pd=2.16u as=0.2516p ps=2.16u w=0.74u l=0.13u
X65 a_23111_2470# a_22873_1842# a_23003_1842# VDD sg13_lv_pmos ad=0.2128p pd=1.5u as=0.3808p ps=2.92u w=1.12u l=0.2u
X66 VSS.t295 VDD VSS.t294 VSS.t293 sg13_lv_nmos ad=0.1428p pd=1.52u as=0 ps=0 w=0.42u l=1u
X67 VSS.t92 a_15964_289# a_16851_309# VSS.t91 sg13_lv_nmos ad=0.1371p pd=1.12u as=0.2176p ps=1.96u w=0.64u l=0.13u
X68 a_10713_1842# a_10517_1842# VDD VDD sg13_lv_pmos ad=0.3808p pd=2.92u as=0.2128p ps=1.5u w=1.12u l=0.13u
X69 VDD a_17683_1842# a_18117_1842# VDD sg13_lv_pmos ad=0.2128p pd=1.5u as=0.3808p ps=2.92u w=1.12u l=0.13u
X70 a_16108_289# a_17865_519# a_16510_1044# VDD sg13_lv_pmos ad=0.3808p pd=2.92u as=0.3808p ps=2.92u w=1.12u l=0.13u
X71 a_26673_1842# a_26477_1842# VSS.t190 VSS.t189 sg13_lv_nmos ad=0.2516p pd=2.16u as=0.1406p ps=1.12u w=0.74u l=0.13u
X72 VDD a_7803_1842# a_8237_1842# VDD sg13_lv_pmos ad=0.2128p pd=1.5u as=0.3808p ps=2.92u w=1.12u l=0.13u
X73 a_4248_1044# a_4157_1313# VSS.t161 VSS.t160 sg13_lv_nmos ad=0.1406p pd=1.12u as=0.2516p ps=2.16u w=0.74u l=0.13u
X74 a_16108_289# a_3171_311.t2 a_22590_1044# VSS.t30 sg13_lv_nmos ad=0.2516p pd=2.16u as=0.2516p ps=2.16u w=0.74u l=0.13u
X75 VSS.t443 DELAY_VBIASN.t28 a_6391_1842# VSS.t442 sg13_lv_nmos ad=0.2516p pd=2.16u as=0.1406p ps=1.12u w=0.74u l=0.6u
X76 a_16408_1044# a_15837_1842# VDD VDD sg13_lv_pmos ad=0.2128p pd=1.5u as=0.3808p ps=2.92u w=1.12u l=0.13u
X77 a_19550_1044# a_3747_1047.t4 a_21835_1044# VSS.t228 sg13_lv_nmos ad=0.2516p pd=2.16u as=0.1406p ps=1.12u w=0.74u l=0.13u
X78 VSS.t477 DELAY_VBIASN.t9 a_20831_1842# VSS.t476 sg13_lv_nmos ad=0.2516p pd=2.16u as=0.1406p ps=1.12u w=0.74u l=0.6u
X79 a_3171_311.t1 a_2873_331# VDD VDD sg13_lv_pmos ad=0.2128p pd=1.5u as=0.1918p ps=1.5u w=1.12u l=0.13u
X80 a_3747_311.t1 a_3449_331# VDD VDD sg13_lv_pmos ad=0.2128p pd=1.5u as=0.1918p ps=1.5u w=1.12u l=0.13u
X81 a_7390_1044# a_9751_1008# a_9675_1044# VDD sg13_lv_pmos ad=0.3808p pd=2.92u as=0.2128p ps=1.5u w=1.12u l=0.13u
X82 a_10191_1842# a_9953_1842# a_10083_1842# VSS.t284 sg13_lv_nmos ad=0.1406p pd=1.12u as=0.2516p ps=2.16u w=0.74u l=0.2u
X83 VSS.t497 a_22677_1842# a_23145_1044# VSS.t496 sg13_lv_nmos ad=0.1665p pd=1.19u as=0.2516p ps=2.16u w=0.74u l=0.13u
X84 a_14751_2470# a_14513_1842# a_14643_1842# VDD sg13_lv_pmos ad=0.2128p pd=1.5u as=0.3808p ps=2.92u w=1.12u l=0.2u
X85 a_5731_289# a_8745_519# a_7390_1044# VDD sg13_lv_pmos ad=0.3808p pd=2.92u as=0.3808p ps=2.92u w=1.12u l=0.13u
X86 VDD VDD VDD VDD sg13_lv_pmos ad=0.2128p pd=1.5u as=0 ps=0 w=1.12u l=0.13u
X87 a_4111_2470# DELAY_IN a_4003_1842# VDD sg13_lv_pmos ad=0.2128p pd=1.5u as=0.3808p ps=2.92u w=1.12u l=0.2u
X88 a_7673_1842# a_7477_1842# VSS.t411 VSS.t410 sg13_lv_nmos ad=0.2516p pd=2.16u as=0.1406p ps=1.12u w=0.74u l=0.13u
X89 VDD a_3171_1047.t5 a_18004_1008# VDD sg13_lv_pmos ad=0.3808p pd=2.92u as=0.3808p ps=2.92u w=1.12u l=0.13u
X90 VDD a_13123_1842# a_13557_1842# VDD sg13_lv_pmos ad=0.2128p pd=1.5u as=0.3808p ps=2.92u w=1.12u l=0.13u
X91 VDD a_3747_311.t2 a_26985_519# VDD sg13_lv_pmos ad=0.3808p pd=2.92u as=0.3808p ps=2.92u w=1.12u l=0.13u
X92 a_25913_1842# a_25717_1842# VDD VDD sg13_lv_pmos ad=0.3808p pd=2.92u as=0.2128p ps=1.5u w=1.12u l=0.13u
X93 a_10430_1044# a_3747_1047.t7 a_12715_1044# VSS.t157 sg13_lv_nmos ad=0.2516p pd=2.16u as=0.1406p ps=1.12u w=0.74u l=0.13u
X94 a_14235_1044# a_14025_1044# VDD VDD sg13_lv_pmos ad=0.2128p pd=1.5u as=0.252p ps=1.57u w=1.12u l=0.13u
X95 a_24875_1044# a_24665_1044# VSS.t169 VSS.t168 sg13_lv_nmos ad=0.1406p pd=1.12u as=0.1665p ps=1.19u w=0.74u l=0.13u
X96 VSS.t457 DELAY_VBIASN.t21 a_11711_1842# VSS.t456 sg13_lv_nmos ad=0.2516p pd=2.16u as=0.1406p ps=1.12u w=0.74u l=0.6u
X97 VDD a_3747_1047.t7 a_12791_1008# VDD sg13_lv_pmos ad=0.3808p pd=2.92u as=0.3808p ps=2.92u w=1.12u l=0.13u
X98 VSS.t147 a_2595_1047.t3 a_23431_1008# VSS.t146 sg13_lv_nmos ad=0.2516p pd=2.16u as=0.2516p ps=2.16u w=0.74u l=0.13u
X99 VSS.t219 a_21483_1842# a_21917_1842# VSS.t218 sg13_lv_nmos ad=0.1406p pd=1.12u as=0.2516p ps=2.16u w=0.74u l=0.13u
X100 VSS.t82 a_13557_1842# a_14025_1044# VSS.t215 sg13_lv_nmos ad=0.1665p pd=1.19u as=0.2516p ps=2.16u w=0.74u l=0.13u
X101 a_11848_1044# a_11277_1842# VDD VDD sg13_lv_pmos ad=0.2128p pd=1.5u as=0.3808p ps=2.92u w=1.12u l=0.13u
X102 VDD VSS.t565 VDD VDD sg13_lv_pmos ad=0.19p pd=1.38u as=0 ps=0 w=1u l=1u
X103 a_25391_1842# a_25153_1842# a_25283_1842# VSS.t409 sg13_lv_nmos ad=0.1406p pd=1.12u as=0.2516p ps=2.16u w=0.74u l=0.2u
X104 a_12993_1842# a_12797_1842# VSS.t108 VSS.t107 sg13_lv_nmos ad=0.2516p pd=2.16u as=0.1406p ps=1.12u w=0.74u l=0.13u
X105 DELAY_OUT_LAST a_27997_1842# VDD VDD sg13_lv_pmos ad=0.3808p pd=2.92u as=0.2128p ps=1.5u w=1.12u l=0.13u
X106 VDD VSS.t564 VDD VDD sg13_lv_pmos ad=0.34p pd=2.68u as=0 ps=0 w=1u l=1u
X107 VDD a_19637_1842# a_20105_1044# VDD sg13_lv_pmos ad=0.252p pd=1.57u as=0.3808p ps=2.92u w=1.12u l=0.13u
X108 VSS.t467 DELAY_VBIASN.t18 a_13991_1842# VSS.t466 sg13_lv_nmos ad=0.2516p pd=2.16u as=0.1406p ps=1.12u w=0.74u l=0.6u
X109 VSS.t355 VDD VSS.t354 VSS.t353 sg13_lv_nmos ad=0.1428p pd=1.52u as=0 ps=0 w=0.42u l=1u
X110 a_22590_1044# a_3171_1047.t3 a_24008_1044# VSS.t72 sg13_lv_nmos ad=0.2516p pd=2.16u as=0.1406p ps=1.12u w=0.74u l=0.13u
X111 a_6913_1842# a_6717_1842# VDD VDD sg13_lv_pmos ad=0.3808p pd=2.92u as=0.2128p ps=1.5u w=1.12u l=0.13u
X112 VDD DELAY_VBIASP.t12 a_18551_2470# VDD sg13_lv_pmos ad=0.3808p pd=2.92u as=0.2128p ps=1.5u w=1.12u l=0.6u
X113 VSS.t174 a_23763_1842# a_24197_1842# VSS.t408 sg13_lv_nmos ad=0.1406p pd=1.12u as=0.2516p ps=2.16u w=0.74u l=0.13u
X114 VSS.t320 VDD VSS.t319 VSS.t318 sg13_lv_nmos ad=0.1428p pd=1.52u as=0 ps=0 w=0.42u l=1u
X115 VDD a_1256_1044# a_2873_1395# VDD sg13_lv_pmos ad=0.1918p pd=1.5u as=0.1596p ps=1.22u w=0.84u l=0.13u
X116 a_3171_311.t0 a_2873_331# VSS.t37 VSS.t180 sg13_lv_nmos ad=0.1406p pd=1.12u as=0.1331p ps=1.12u w=0.74u l=0.13u
X117 VDD a_2873_331# a_3171_311.t1 VDD sg13_lv_pmos ad=0.4256p pd=3u as=0.2128p ps=1.5u w=1.12u l=0.13u
X118 a_16510_1044# a_17351_1008# a_17275_1044# VDD sg13_lv_pmos ad=0.3808p pd=2.92u as=0.2128p ps=1.5u w=1.12u l=0.13u
X119 a_25630_1044# a_3747_1047.t2 a_27915_1044# VSS.t154 sg13_lv_nmos ad=0.2516p pd=2.16u as=0.1406p ps=1.12u w=0.74u l=0.13u
X120 VSS.t437 DELAY_VBIASN.t1 a_26911_1842# VSS.t436 sg13_lv_nmos ad=0.2516p pd=2.16u as=0.1406p ps=1.12u w=0.74u l=0.6u
X121 a_3747_311.t0 a_3449_331# VSS.t1 VSS.t0 sg13_lv_nmos ad=0.1406p pd=1.12u as=0.1331p ps=1.12u w=0.74u l=0.13u
X122 VDD a_3449_331# a_3747_311.t1 VDD sg13_lv_pmos ad=0.4256p pd=3u as=0.2128p ps=1.5u w=1.12u l=0.13u
X123 VDD DELAY_VBIASP.t7 a_22351_2470# VDD sg13_lv_pmos ad=0.3808p pd=2.92u as=0.2128p ps=1.5u w=1.12u l=0.6u
X124 VDD a_3747_1047.t2 a_27991_1008# VDD sg13_lv_pmos ad=0.3808p pd=2.92u as=0.3808p ps=2.92u w=1.12u l=0.13u
X125 VDD VSS.t597 VDD VDD sg13_lv_pmos ad=0.19p pd=1.38u as=0 ps=0 w=1u l=1u
X126 VDD a_3747_1047.t9 a_6711_1008# VDD sg13_lv_pmos ad=0.3808p pd=2.92u as=0.3808p ps=2.92u w=1.12u l=0.13u
X127 a_6391_1842# a_6153_1842# a_6283_1842# VSS.t415 sg13_lv_nmos ad=0.1406p pd=1.12u as=0.2516p ps=2.16u w=0.74u l=0.2u
X128 a_15273_1842# a_15077_1842# VSS.t398 VSS.t488 sg13_lv_nmos ad=0.2516p pd=2.16u as=0.1406p ps=1.12u w=0.74u l=0.13u
X129 a_19833_1842# a_19637_1842# VDD VDD sg13_lv_pmos ad=0.3808p pd=2.92u as=0.2128p ps=1.5u w=1.12u l=0.13u
X130 a_16108_289# a_23945_519# a_22590_1044# VDD sg13_lv_pmos ad=0.3808p pd=2.92u as=0.3808p ps=2.92u w=1.12u l=0.13u
X131 a_9193_1842# a_8997_1842# VDD VDD sg13_lv_pmos ad=0.3808p pd=2.92u as=0.2128p ps=1.5u w=1.12u l=0.13u
X132 a_24631_2470# a_24393_1842# a_24523_1842# VDD sg13_lv_pmos ad=0.2128p pd=1.5u as=0.3808p ps=2.92u w=1.12u l=0.2u
X133 VSS.t48 a_15403_1842# a_15837_1842# VSS.t47 sg13_lv_nmos ad=0.1406p pd=1.12u as=0.2516p ps=2.16u w=0.74u l=0.13u
X134 a_8155_1044# a_7945_1044# VSS.t66 VSS.t65 sg13_lv_nmos ad=0.1406p pd=1.12u as=0.1665p ps=1.19u w=0.74u l=0.13u
X135 a_23633_1842# a_23437_1842# VDD VDD sg13_lv_pmos ad=0.3808p pd=2.92u as=0.2128p ps=1.5u w=1.12u l=0.13u
X136 VSS.t198 a_4763_1842# a_5197_1842# VSS.t197 sg13_lv_nmos ad=0.1406p pd=1.12u as=0.2516p ps=2.16u w=0.74u l=0.13u
X137 a_27048_1044# a_26477_1842# VSS.t192 VSS.t191 sg13_lv_nmos ad=0.1406p pd=1.12u as=0.2516p ps=2.16u w=0.74u l=0.13u
X138 VDD a_9323_1842# a_9757_1842# VDD sg13_lv_pmos ad=0.2128p pd=1.5u as=0.3808p ps=2.92u w=1.12u l=0.13u
X139 a_5768_1044# a_5197_1842# VSS.t222 VSS.t221 sg13_lv_nmos ad=0.1406p pd=1.12u as=0.2516p ps=2.16u w=0.74u l=0.13u
X140 a_7390_1044# a_7364_1008# a_7288_1044# VDD sg13_lv_pmos ad=0.3808p pd=2.92u as=0.2128p ps=1.5u w=1.12u l=0.13u
X141 VSS.t453 DELAY_VBIASN.t26 a_7911_1842# VSS.t452 sg13_lv_nmos ad=0.2516p pd=2.16u as=0.1406p ps=1.12u w=0.74u l=0.6u
X142 VDD VSS.t581 VDD VDD sg13_lv_pmos ad=0.19p pd=1.38u as=0 ps=0 w=1u l=1u
X143 a_11711_1842# a_11473_1842# a_11603_1842# VSS.t416 sg13_lv_nmos ad=0.1406p pd=1.12u as=0.2516p ps=2.16u w=0.74u l=0.2u
X144 VSS.t169 a_24197_1842# a_24665_1044# VSS.t175 sg13_lv_nmos ad=0.1665p pd=1.19u as=0.2516p ps=2.16u w=0.74u l=0.13u
X145 a_16510_1044# a_3171_1047.t5 a_17928_1044# VSS.t274 sg13_lv_nmos ad=0.2516p pd=2.16u as=0.1406p ps=1.12u w=0.74u l=0.13u
X146 VSS.t312 VDD VSS.t310 VSS.t311 sg13_lv_nmos ad=79.8f pd=0.8u as=0 ps=0 w=0.42u l=1u
X147 a_5631_2470# a_5393_1842# a_5523_1842# VDD sg13_lv_pmos ad=0.2128p pd=1.5u as=0.3808p ps=2.92u w=1.12u l=0.2u
X148 a_14513_1842# a_14317_1842# VDD VDD sg13_lv_pmos ad=0.3808p pd=2.92u as=0.2128p ps=1.5u w=1.12u l=0.13u
X149 a_4633_1842# a_4437_1842# VDD VDD sg13_lv_pmos ad=0.3808p pd=2.92u as=0.2128p ps=1.5u w=1.12u l=0.13u
X150 VSS.t386 a_10083_1842# a_10517_1842# VSS.t385 sg13_lv_nmos ad=0.1406p pd=1.12u as=0.2516p ps=2.16u w=0.74u l=0.13u
X151 VDD a_2019_1047.t4 a_19524_1008# VDD sg13_lv_pmos ad=0.3808p pd=2.92u as=0.3808p ps=2.92u w=1.12u l=0.13u
X152 VSS.t150 a_3171_1047.t4 a_21044_1008# VSS.t149 sg13_lv_nmos ad=0.2516p pd=2.16u as=0.2516p ps=2.16u w=0.74u l=0.13u
X153 VSS.t182 a_2873_331# a_3171_311.t0 VSS.t181 sg13_lv_nmos ad=0.2812p pd=2.24u as=0.1406p ps=1.12u w=0.74u l=0.13u
X154 VSS.t3 a_3449_331# a_3747_311.t0 VSS.t2 sg13_lv_nmos ad=0.2812p pd=2.24u as=0.1406p ps=1.12u w=0.74u l=0.13u
X155 a_15755_1044# a_15545_1044# VDD VDD sg13_lv_pmos ad=0.2128p pd=1.5u as=0.252p ps=1.57u w=1.12u l=0.13u
X156 VDD a_2595_1047.t6 a_14311_1008# VDD sg13_lv_pmos ad=0.3808p pd=2.92u as=0.3808p ps=2.92u w=1.12u l=0.13u
X157 VSS.t447 DELAY_VBIASN.t4 a_24631_1842# VSS.t446 sg13_lv_nmos ad=0.2516p pd=2.16u as=0.1406p ps=1.12u w=0.74u l=0.6u
X158 a_5115_1044# a_4905_1044# VDD VDD sg13_lv_pmos ad=0.2128p pd=1.5u as=0.252p ps=1.57u w=1.12u l=0.13u
X159 a_18551_2470# a_18313_1842# a_18443_1842# VDD sg13_lv_pmos ad=0.2128p pd=1.5u as=0.3808p ps=2.92u w=1.12u l=0.2u
X160 VDD VSS.t573 VDD VDD sg13_lv_pmos ad=0.19p pd=1.38u as=0 ps=0 w=1u l=1u
X161 a_3171_1047.t0 a_2873_1395# VSS.t163 VSS.t162 sg13_lv_nmos ad=0.1406p pd=1.12u as=0.1331p ps=1.12u w=0.74u l=0.13u
X162 VSS.t27 a_2297_1395# a_2595_1047.t0 VSS.t26 sg13_lv_nmos ad=0.2812p pd=2.24u as=0.1406p ps=1.12u w=0.74u l=0.13u
X163 a_22351_2470# a_22113_1842# a_22243_1842# VDD sg13_lv_pmos ad=0.2128p pd=1.5u as=0.3808p ps=2.92u w=1.12u l=0.2u
X164 VSS.t248 VSS.t245 VSS.t247 VSS.t246 sg13_lv_nmos ad=0.2516p pd=2.16u as=0 ps=0 w=0.74u l=0.13u
X165 a_26911_1842# a_26673_1842# a_26803_1842# VSS.t7 sg13_lv_nmos ad=0.1406p pd=1.12u as=0.2516p ps=2.16u w=0.74u l=0.2u
X166 VSS.t46 a_3171_311.t3 a_11785_519# VSS.t45 sg13_lv_nmos ad=0.2516p pd=2.16u as=0.2516p ps=2.16u w=0.74u l=0.13u
X167 VDD a_1721_1395# a_2019_1047.t1 VDD sg13_lv_pmos ad=0.4256p pd=3u as=0.2128p ps=1.5u w=1.12u l=0.13u
X168 VDD a_16923_1842# a_17357_1842# VDD sg13_lv_pmos ad=0.2128p pd=1.5u as=0.3808p ps=2.92u w=1.12u l=0.13u
X169 a_2391_1395# MUX_SEL0 a_2297_1395# VSS.t492 sg13_lv_nmos ad=0.1216p pd=1.02u as=0.2176p ps=1.96u w=0.64u l=0.13u
X170 VSS.t54 a_1544_1044# a_1815_1395# VSS.t527 sg13_lv_nmos ad=0.1331p pd=1.12u as=0.1216p ps=1.02u w=0.64u l=0.13u
X171 a_13368_1044# a_12797_1842# VSS.t106 VSS.t105 sg13_lv_nmos ad=0.1406p pd=1.12u as=0.2516p ps=2.16u w=0.74u l=0.13u
X172 a_5731_289# a_3171_311.t3 a_10430_1044# VSS.t44 sg13_lv_nmos ad=0.2516p pd=2.16u as=0.2516p ps=2.16u w=0.74u l=0.13u
X173 VDD a_21157_1842# a_21625_1044# VDD sg13_lv_pmos ad=0.252p pd=1.57u as=0.3808p ps=2.92u w=1.12u l=0.13u
X174 VDD DELAY_VBIASP.t22 a_10951_2470# VDD sg13_lv_pmos ad=0.3808p pd=2.92u as=0.2128p ps=1.5u w=1.12u l=0.6u
X175 VSS.t461 DELAY_VBIASN.t16 a_15511_1842# VSS.t460 sg13_lv_nmos ad=0.2516p pd=2.16u as=0.1406p ps=1.12u w=0.74u l=0.6u
X176 VDD a_20723_1842# a_21157_1842# VDD sg13_lv_pmos ad=0.2128p pd=1.5u as=0.3808p ps=2.92u w=1.12u l=0.13u
X177 VSS.t533 a_25283_1842# a_25717_1842# VSS.t532 sg13_lv_nmos ad=0.1406p pd=1.12u as=0.2516p ps=2.16u w=0.74u l=0.13u
X178 a_4350_1044# a_3747_1047.t9 a_6635_1044# VSS.t121 sg13_lv_nmos ad=0.2516p pd=2.16u as=0.1406p ps=1.12u w=0.74u l=0.13u
X179 VSS.t435 DELAY_VBIASN.t29 a_5631_1842# VSS.t434 sg13_lv_nmos ad=0.2516p pd=2.16u as=0.1406p ps=1.12u w=0.74u l=0.6u
X180 VDD a_2019_1047.t9 a_4324_1008# VDD sg13_lv_pmos ad=0.3808p pd=2.92u as=0.3808p ps=2.92u w=1.12u l=0.13u
X181 a_16510_1044# a_18871_1008# a_18795_1044# VDD sg13_lv_pmos ad=0.3808p pd=2.92u as=0.2128p ps=1.5u w=1.12u l=0.13u
X182 a_19550_1044# a_2595_1047.t4 a_20315_1044# VSS.t21 sg13_lv_nmos ad=0.2516p pd=2.16u as=0.1406p ps=1.12u w=0.74u l=0.13u
X183 VDD DELAY_VBIASP.t5 a_23871_2470# VDD sg13_lv_pmos ad=0.3808p pd=2.92u as=0.2128p ps=1.5u w=1.12u l=0.6u
X184 VSS.t66 a_7477_1842# a_7945_1044# VSS.t412 sg13_lv_nmos ad=0.1665p pd=1.19u as=0.2516p ps=2.16u w=0.74u l=0.13u
X185 a_13231_2470# a_12993_1842# a_13123_1842# VDD sg13_lv_pmos ad=0.2128p pd=1.5u as=0.3808p ps=2.92u w=1.12u l=0.2u
X186 VDD VSS.t598 VDD VDD sg13_lv_pmos ad=0.34p pd=2.68u as=0 ps=0 w=1u l=1u
X187 a_12233_1842# a_12037_1842# VDD VDD sg13_lv_pmos ad=0.3808p pd=2.92u as=0.2128p ps=1.5u w=1.12u l=0.13u
X188 a_7911_1842# a_7673_1842# a_7803_1842# VSS.t42 sg13_lv_nmos ad=0.1406p pd=1.12u as=0.2516p ps=2.16u w=0.74u l=0.2u
X189 a_16793_1842# a_16597_1842# VSS.t209 VSS.t388 sg13_lv_nmos ad=0.2516p pd=2.16u as=0.1406p ps=1.12u w=0.74u l=0.13u
X190 VDD a_3747_311.t3 a_14825_519# VDD sg13_lv_pmos ad=0.3808p pd=2.92u as=0.3808p ps=2.92u w=1.12u l=0.13u
X191 VSS.t401 a_27563_1842# a_27997_1842# VSS.t486 sg13_lv_nmos ad=0.1406p pd=1.12u as=0.2516p ps=2.16u w=0.74u l=0.13u
X192 a_9675_1044# a_9465_1044# VSS.t84 VSS.t83 sg13_lv_nmos ad=0.1406p pd=1.12u as=0.1665p ps=1.19u w=0.74u l=0.13u
X193 a_20593_1842# a_20397_1842# VSS.t41 VSS.t40 sg13_lv_nmos ad=0.2516p pd=2.16u as=0.1406p ps=1.12u w=0.74u l=0.13u
X194 VSS.t553 a_2595_1047.t8 a_8231_1008# VSS.t552 sg13_lv_nmos ad=0.2516p pd=2.16u as=0.2516p ps=2.16u w=0.74u l=0.13u
X195 VSS.t396 a_6283_1842# a_6717_1842# VSS.t506 sg13_lv_nmos ad=0.1406p pd=1.12u as=0.2516p ps=2.16u w=0.74u l=0.13u
X196 a_10430_1044# a_10404_1008# a_10328_1044# VDD sg13_lv_pmos ad=0.3808p pd=2.92u as=0.2128p ps=1.5u w=1.12u l=0.13u
X197 VDD DELAY_VBIASP.t2 a_26151_2470# VDD sg13_lv_pmos ad=0.3808p pd=2.92u as=0.2128p ps=1.5u w=1.12u l=0.6u
X198 a_7390_1044# a_8884_1008# a_8808_1044# VDD sg13_lv_pmos ad=0.3808p pd=2.92u as=0.2128p ps=1.5u w=1.12u l=0.13u
X199 VDD DELAY_VBIASP.t30 a_4871_2470# VDD sg13_lv_pmos ad=0.3808p pd=2.92u as=0.2128p ps=1.5u w=1.12u l=0.6u
X200 a_3449_331# MUX_SEL2 VDD VDD sg13_lv_pmos ad=0.1596p pd=1.22u as=0.2856p ps=2.36u w=0.84u l=0.13u
X201 VDD VSS.t575 VDD VDD sg13_lv_pmos ad=0.19p pd=1.38u as=0 ps=0 w=1u l=1u
X202 a_19073_1842# a_18877_1842# VSS.t68 VSS.t112 sg13_lv_nmos ad=0.2516p pd=2.16u as=0.1406p ps=1.12u w=0.74u l=0.13u
X203 VDD a_15077_1842# a_15545_1044# VDD sg13_lv_pmos ad=0.252p pd=1.57u as=0.3808p ps=2.92u w=1.12u l=0.13u
X204 a_19550_1044# a_2019_1047.t4 a_19448_1044# VSS.t268 sg13_lv_nmos ad=0.2516p pd=2.16u as=0.1406p ps=1.12u w=0.74u l=0.13u
X205 VDD VDD VDD VDD sg13_lv_pmos ad=0.3808p pd=2.92u as=0 ps=0 w=1.12u l=0.6u
X206 VSS.t372 VDD VSS.t370 VSS.t371 sg13_lv_nmos ad=79.8f pd=0.8u as=0 ps=0 w=0.42u l=1u
X207 VSS.t103 a_19203_1842# a_19637_1842# VSS.t102 sg13_lv_nmos ad=0.1406p pd=1.12u as=0.2516p ps=2.16u w=0.74u l=0.13u
X208 VDD VSS.t577 VDD VDD sg13_lv_pmos ad=0.19p pd=1.38u as=0 ps=0 w=1u l=1u
X209 VDD VSS.t588 VDD VDD sg13_lv_pmos ad=0.34p pd=2.68u as=0 ps=0 w=1u l=1u
X210 a_27433_1842# a_27237_1842# VDD VDD sg13_lv_pmos ad=0.3808p pd=2.92u as=0.2128p ps=1.5u w=1.12u l=0.13u
X211 VDD a_1256_289# a_2873_331# VDD sg13_lv_pmos ad=0.1918p pd=1.5u as=0.1596p ps=1.22u w=0.84u l=0.13u
X212 a_13470_1044# a_2595_1047.t6 a_14235_1044# VSS.t142 sg13_lv_nmos ad=0.2516p pd=2.16u as=0.1406p ps=1.12u w=0.74u l=0.13u
X213 VSS.t178 a_8563_1842# a_8997_1842# VSS.t558 sg13_lv_nmos ad=0.1406p pd=1.12u as=0.2516p ps=2.16u w=0.74u l=0.13u
X214 VSS.t465 DELAY_VBIASN.t19 a_13231_1842# VSS.t464 sg13_lv_nmos ad=0.2516p pd=2.16u as=0.1406p ps=1.12u w=0.74u l=0.6u
X215 VDD a_3171_1047.t7 a_11924_1008# VDD sg13_lv_pmos ad=0.3808p pd=2.92u as=0.3808p ps=2.92u w=1.12u l=0.13u
X216 VSS.t267 a_2019_1047.t3 a_22564_1008# VSS.t266 sg13_lv_nmos ad=0.2516p pd=2.16u as=0.2516p ps=2.16u w=0.74u l=0.13u
X217 VSS.t119 a_23003_1842# a_23437_1842# VSS.t406 sg13_lv_nmos ad=0.1406p pd=1.12u as=0.2516p ps=2.16u w=0.74u l=0.13u
X218 VSS.t375 VDD VSS.t374 VSS.t373 sg13_lv_nmos ad=0.1428p pd=1.52u as=0 ps=0 w=0.42u l=1u
X219 VDD DELAY_VBIASP.t27 a_7151_2470# VDD sg13_lv_pmos ad=0.3808p pd=2.92u as=0.2128p ps=1.5u w=1.12u l=0.6u
X220 a_25630_1044# a_25604_1008# a_25528_1044# VDD sg13_lv_pmos ad=0.3808p pd=2.92u as=0.2128p ps=1.5u w=1.12u l=0.13u
X221 a_15511_1842# a_15273_1842# a_15403_1842# VSS.t179 sg13_lv_nmos ad=0.1406p pd=1.12u as=0.2516p ps=2.16u w=0.74u l=0.2u
X222 a_18313_1842# a_18117_1842# VDD VDD sg13_lv_pmos ad=0.3808p pd=2.92u as=0.2128p ps=1.5u w=1.12u l=0.13u
X223 a_5731_289# a_11785_519# a_10430_1044# VDD sg13_lv_pmos ad=0.3808p pd=2.92u as=0.3808p ps=2.92u w=1.12u l=0.13u
X224 VSS.t292 VDD VSS.t290 VSS.t291 sg13_lv_nmos ad=79.8f pd=0.8u as=0 ps=0 w=0.42u l=1u
X225 a_9431_2470# a_9193_1842# a_9323_1842# VDD sg13_lv_pmos ad=0.2128p pd=1.5u as=0.3808p ps=2.92u w=1.12u l=0.2u
X226 a_17275_1044# a_17065_1044# VSS.t237 VSS.t236 sg13_lv_nmos ad=0.1406p pd=1.12u as=0.1665p ps=1.19u w=0.74u l=0.13u
X227 VDD VSS.t574 VDD VDD sg13_lv_pmos ad=0.34p pd=2.68u as=0 ps=0 w=1u l=1u
X228 VSS.t14 a_3747_1047.t6 a_15831_1008# VSS.t13 sg13_lv_nmos ad=0.2516p pd=2.16u as=0.2516p ps=2.16u w=0.74u l=0.13u
X229 a_23871_2470# a_23633_1842# a_23763_1842# VDD sg13_lv_pmos ad=0.2128p pd=1.5u as=0.3808p ps=2.92u w=1.12u l=0.2u
X230 VSS.t510 a_13883_1842# a_14317_1842# VSS.t523 sg13_lv_nmos ad=0.1406p pd=1.12u as=0.2516p ps=2.16u w=0.74u l=0.13u
X231 VSS.t539 a_3747_311.t2 a_26985_519# VSS.t538 sg13_lv_nmos ad=0.2516p pd=2.16u as=0.2516p ps=2.16u w=0.74u l=0.13u
X232 a_8433_1842# a_8237_1842# VDD VDD sg13_lv_pmos ad=0.3808p pd=2.92u as=0.2128p ps=1.5u w=1.12u l=0.13u
X233 VDD a_18443_1842# a_18877_1842# VDD sg13_lv_pmos ad=0.2128p pd=1.5u as=0.3808p ps=2.92u w=1.12u l=0.13u
X234 a_22113_1842# a_21917_1842# VDD VDD sg13_lv_pmos ad=0.3808p pd=2.92u as=0.2128p ps=1.5u w=1.12u l=0.13u
X235 a_4350_1044# a_2019_1047.t9 a_4248_1044# VSS.t93 sg13_lv_nmos ad=0.2516p pd=2.16u as=0.1406p ps=1.12u w=0.74u l=0.13u
X236 a_14888_1044# a_14317_1842# VSS.t508 VSS.t507 sg13_lv_nmos ad=0.1406p pd=1.12u as=0.2516p ps=2.16u w=0.74u l=0.13u
X237 a_16108_289# a_3747_311.t2 a_25630_1044# VSS.t537 sg13_lv_nmos ad=0.2516p pd=2.16u as=0.2516p ps=2.16u w=0.74u l=0.13u
X238 VDD DELAY_VBIASP.t20 a_12471_2470# VDD sg13_lv_pmos ad=0.3808p pd=2.92u as=0.2128p ps=1.5u w=1.12u l=0.6u
X239 VSS.t504 a_4003_1842# a_4437_1842# VSS.t526 sg13_lv_nmos ad=0.1406p pd=1.12u as=0.2516p ps=2.16u w=0.74u l=0.13u
X240 a_16510_1044# a_16484_1008# a_16408_1044# VDD sg13_lv_pmos ad=0.3808p pd=2.92u as=0.2128p ps=1.5u w=1.12u l=0.13u
X241 VDD a_22243_1842# a_22677_1842# VDD sg13_lv_pmos ad=0.2128p pd=1.5u as=0.3808p ps=2.92u w=1.12u l=0.13u
X242 VDD a_3171_1047.t2 a_27124_1008# VDD sg13_lv_pmos ad=0.3808p pd=2.92u as=0.3808p ps=2.92u w=1.12u l=0.13u
X243 VDD MUX_SEL3 a_3449_331# VDD sg13_lv_pmos ad=0.1918p pd=1.5u as=0.1596p ps=1.22u w=0.84u l=0.13u
X244 a_2595_311.t1 a_2297_331# VDD VDD sg13_lv_pmos ad=0.2128p pd=1.5u as=0.1918p ps=1.5u w=1.12u l=0.13u
X245 a_10430_1044# a_11271_1008# a_11195_1044# VDD sg13_lv_pmos ad=0.3808p pd=2.92u as=0.2128p ps=1.5u w=1.12u l=0.13u
X246 a_23355_1044# a_23145_1044# VDD VDD sg13_lv_pmos ad=0.2128p pd=1.5u as=0.252p ps=1.57u w=1.12u l=0.13u
X247 VDD a_3747_1047.t4 a_21911_1008# VDD sg13_lv_pmos ad=0.3808p pd=2.92u as=0.3808p ps=2.92u w=1.12u l=0.13u
X248 VSS.t84 a_8997_1842# a_9465_1044# VSS.t176 sg13_lv_nmos ad=0.1665p pd=1.19u as=0.2516p ps=2.16u w=0.74u l=0.13u
X249 a_20968_1044# a_20397_1842# VDD VDD sg13_lv_pmos ad=0.2128p pd=1.5u as=0.3808p ps=2.92u w=1.12u l=0.13u
X250 a_10951_1842# a_10713_1842# a_10843_1842# VSS.t524 sg13_lv_nmos ad=0.1406p pd=1.12u as=0.2516p ps=2.16u w=0.74u l=0.2u
X251 VSS.t542 a_2019_1047.t5 a_16484_1008# VSS.t541 sg13_lv_nmos ad=0.2516p pd=2.16u as=0.2516p ps=2.16u w=0.74u l=0.13u
X252 a_26151_2470# a_25913_1842# a_26043_1842# VDD sg13_lv_pmos ad=0.2128p pd=1.5u as=0.3808p ps=2.92u w=1.12u l=0.2u
X253 a_13753_1842# a_13557_1842# VDD VDD sg13_lv_pmos ad=0.3808p pd=2.92u as=0.2128p ps=1.5u w=1.12u l=0.13u
X254 VDD a_1721_331# a_2019_311# VDD sg13_lv_pmos ad=0.4256p pd=3u as=0.2128p ps=1.5u w=1.12u l=0.13u
X255 a_4871_2470# a_4633_1842# a_4763_1842# VDD sg13_lv_pmos ad=0.2128p pd=1.5u as=0.3808p ps=2.92u w=1.12u l=0.2u
X256 VSS.t153 a_3171_1047.t9 a_5844_1008# VSS.t152 sg13_lv_nmos ad=0.2516p pd=2.16u as=0.2516p ps=2.16u w=0.74u l=0.13u
X257 VSS.t332 VDD VSS.t330 VSS.t331 sg13_lv_nmos ad=79.8f pd=0.8u as=0 ps=0 w=0.42u l=1u
X258 VDD a_2595_311.t2 a_20905_519# VDD sg13_lv_pmos ad=0.3808p pd=2.92u as=0.3808p ps=2.92u w=1.12u l=0.13u
X259 VDD a_2297_331# a_2595_311.t1 VDD sg13_lv_pmos ad=0.4256p pd=3u as=0.2128p ps=1.5u w=1.12u l=0.13u
X260 VSS.t279 a_2595_1047.t7 a_11271_1008# VSS.t278 sg13_lv_nmos ad=0.2516p pd=2.16u as=0.2516p ps=2.16u w=0.74u l=0.13u
X261 VSS.t459 DELAY_VBIASN.t11 a_19311_1842# VSS.t458 sg13_lv_nmos ad=0.2516p pd=2.16u as=0.1406p ps=1.12u w=0.74u l=0.6u
X262 VDD a_24523_1842# a_24957_1842# VDD sg13_lv_pmos ad=0.2128p pd=1.5u as=0.3808p ps=2.92u w=1.12u l=0.13u
X263 VSS.t261 a_3747_1047.t8 a_9751_1008# VSS.t260 sg13_lv_nmos ad=0.2516p pd=2.16u as=0.2516p ps=2.16u w=0.74u l=0.13u
X264 VSS.t455 DELAY_VBIASN.t24 a_9431_1842# VSS.t454 sg13_lv_nmos ad=0.2516p pd=2.16u as=0.1406p ps=1.12u w=0.74u l=0.6u
X265 a_19448_1044# a_18877_1842# VDD VDD sg13_lv_pmos ad=0.2128p pd=1.5u as=0.3808p ps=2.92u w=1.12u l=0.13u
X266 VSS.t431 DELAY_VBIASN.t6 a_23111_1842# VSS.t430 sg13_lv_nmos ad=0.2516p pd=2.16u as=0.1406p ps=1.12u w=0.74u l=0.6u
X267 a_10430_1044# a_11924_1008# a_11848_1044# VDD sg13_lv_pmos ad=0.3808p pd=2.92u as=0.2128p ps=1.5u w=1.12u l=0.13u
X268 VDD DELAY_VBIASP.t0 a_27671_2470# VDD sg13_lv_pmos ad=0.3808p pd=2.92u as=0.2128p ps=1.5u w=1.12u l=0.6u
X269 a_25630_1044# a_26471_1008# a_26395_1044# VDD sg13_lv_pmos ad=0.3808p pd=2.92u as=0.2128p ps=1.5u w=1.12u l=0.13u
X270 a_7151_2470# a_6913_1842# a_7043_1842# VDD sg13_lv_pmos ad=0.2128p pd=1.5u as=0.3808p ps=2.92u w=1.12u l=0.2u
X271 a_16033_1842# a_15837_1842# VDD VDD sg13_lv_pmos ad=0.3808p pd=2.92u as=0.2128p ps=1.5u w=1.12u l=0.13u
X272 VDD a_15964_289# a_16851_309# VDD sg13_lv_pmos ad=0.2086p pd=1.5u as=0.34p ps=2.68u w=1u l=0.13u
X273 VDD VSS.t576 VDD VDD sg13_lv_pmos ad=0.34p pd=2.68u as=0 ps=0 w=1u l=1u
X274 VSS.t115 a_11603_1842# a_12037_1842# VSS.t392 sg13_lv_nmos ad=0.1406p pd=1.12u as=0.2516p ps=2.16u w=0.74u l=0.13u
X275 VSS.t352 VDD VSS.t350 VSS.t351 sg13_lv_nmos ad=79.8f pd=0.8u as=0 ps=0 w=0.42u l=1u
X276 VDD VSS.t590 VDD VDD sg13_lv_pmos ad=0.34p pd=2.68u as=0 ps=0 w=1u l=1u
X277 VDD a_5957_1842# a_6425_1044# VDD sg13_lv_pmos ad=0.252p pd=1.57u as=0.3808p ps=2.92u w=1.12u l=0.13u
X278 a_24393_1842# a_24197_1842# VSS.t174 VSS.t173 sg13_lv_nmos ad=0.2516p pd=2.16u as=0.1406p ps=1.12u w=0.74u l=0.13u
X279 a_3747_1047.t0 a_3449_1395# VSS.t78 VSS.t77 sg13_lv_nmos ad=0.1406p pd=1.12u as=0.1331p ps=1.12u w=0.74u l=0.13u
X280 a_1544_1044# MUX_SEL1 VSS.t513 VSS.t512 sg13_lv_nmos ad=0.2516p pd=2.16u as=0.2516p ps=2.16u w=0.74u l=0.13u
X281 VDD VSS.t578 VDD VDD sg13_lv_pmos ad=0.34p pd=2.68u as=0 ps=0 w=1u l=1u
X282 a_3171_1047.t1 a_2873_1395# VDD VDD sg13_lv_pmos ad=0.2128p pd=1.5u as=0.1918p ps=1.5u w=1.12u l=0.13u
X283 a_13470_1044# a_3747_1047.t6 a_15755_1044# VSS.t12 sg13_lv_nmos ad=0.2516p pd=2.16u as=0.1406p ps=1.12u w=0.74u l=0.13u
X284 VDD a_5523_1842# a_5957_1842# VDD sg13_lv_pmos ad=0.2128p pd=1.5u as=0.3808p ps=2.92u w=1.12u l=0.13u
X285 VDD a_2297_1395# a_2595_1047.t1 VDD sg13_lv_pmos ad=0.4256p pd=3u as=0.2128p ps=1.5u w=1.12u l=0.13u
X286 VSS.t463 DELAY_VBIASN.t17 a_14751_1842# VSS.t462 sg13_lv_nmos ad=0.2516p pd=2.16u as=0.1406p ps=1.12u w=0.74u l=0.6u
X287 a_2967_1395# MUX_SEL1 a_2873_1395# VSS.t514 sg13_lv_nmos ad=0.1216p pd=1.02u as=0.2176p ps=1.96u w=0.64u l=0.13u
X288 a_4350_1044# a_2595_1047.t9 a_5115_1044# VSS.t87 sg13_lv_nmos ad=0.2516p pd=2.16u as=0.1406p ps=1.12u w=0.74u l=0.13u
X289 VDD a_2019_1047.t6 a_13444_1008# VDD sg13_lv_pmos ad=0.3808p pd=2.92u as=0.3808p ps=2.92u w=1.12u l=0.13u
X290 VSS.t240 a_2595_1047.t2 a_26471_1008# VSS.t239 sg13_lv_nmos ad=0.2516p pd=2.16u as=0.2516p ps=2.16u w=0.74u l=0.13u
X291 a_2595_311.t0 a_2297_331# VSS.t60 VSS.t183 sg13_lv_nmos ad=0.1406p pd=1.12u as=0.1331p ps=1.12u w=0.74u l=0.13u
X292 VSS.t439 DELAY_VBIASN.t31 a_4111_1842# VSS.t438 sg13_lv_nmos ad=0.2516p pd=2.16u as=0.1406p ps=1.12u w=0.74u l=0.6u
X293 a_2297_1395# MUX_SEL0 VDD VDD sg13_lv_pmos ad=0.1596p pd=1.22u as=0.2856p ps=2.36u w=0.84u l=0.13u
X294 VSS.t237 a_16597_1842# a_17065_1044# VSS.t387 sg13_lv_nmos ad=0.1665p pd=1.19u as=0.2516p ps=2.16u w=0.74u l=0.13u
X295 VDD DELAY_VBIASP.t25 a_8671_2470# VDD sg13_lv_pmos ad=0.3808p pd=2.92u as=0.2128p ps=1.5u w=1.12u l=0.6u
X296 VDD VSS.t591 VDD VDD sg13_lv_pmos ad=0.19p pd=1.38u as=0 ps=0 w=1u l=1u
X297 VDD a_1544_1044# a_1721_1395# VDD sg13_lv_pmos ad=0.1918p pd=1.5u as=0.1596p ps=1.22u w=0.84u l=0.13u
X298 a_4248_1044# a_4157_1313# VDD VDD sg13_lv_pmos ad=0.2128p pd=1.5u as=0.3808p ps=2.92u w=1.12u l=0.13u
X299 a_12471_2470# a_12233_1842# a_12363_1842# VDD sg13_lv_pmos ad=0.2128p pd=1.5u as=0.3808p ps=2.92u w=1.12u l=0.2u
X300 a_17031_1842# a_16793_1842# a_16923_1842# VSS.t399 sg13_lv_nmos ad=0.1406p pd=1.12u as=0.2516p ps=2.16u w=0.74u l=0.2u
X301 VSS.t172 a_1721_331# a_2019_311# VSS.t171 sg13_lv_nmos ad=0.2812p pd=2.24u as=0.1406p ps=1.12u w=0.74u l=0.13u
X302 a_19550_1044# a_21911_1008# a_21835_1044# VDD sg13_lv_pmos ad=0.3808p pd=2.92u as=0.2128p ps=1.5u w=1.12u l=0.13u
X303 a_16108_289# a_26985_519# a_25630_1044# VDD sg13_lv_pmos ad=0.3808p pd=2.92u as=0.3808p ps=2.92u w=1.12u l=0.13u
X304 VSS.t185 a_2297_331# a_2595_311.t0 VSS.t184 sg13_lv_nmos ad=0.2812p pd=2.24u as=0.1406p ps=1.12u w=0.74u l=0.13u
X305 a_18795_1044# a_18585_1044# VSS.t64 VSS.t516 sg13_lv_nmos ad=0.1406p pd=1.12u as=0.1665p ps=1.19u w=0.74u l=0.13u
X306 a_20831_1842# a_20593_1842# a_20723_1842# VSS.t487 sg13_lv_nmos ad=0.1406p pd=1.12u as=0.2516p ps=2.16u w=0.74u l=0.2u
X307 VSS.t290 VDD VSS.t289 VSS.t288 sg13_lv_nmos ad=0.1428p pd=1.52u as=0 ps=0 w=0.42u l=1u
X308 VDD a_22677_1842# a_23145_1044# VDD sg13_lv_pmos ad=0.252p pd=1.57u as=0.3808p ps=2.92u w=1.12u l=0.13u
X309 VSS.t550 a_2595_1047.t5 a_17351_1008# VSS.t549 sg13_lv_nmos ad=0.2516p pd=2.16u as=0.2516p ps=2.16u w=0.74u l=0.13u
X310 a_5393_1842# a_5197_1842# VSS.t198 VSS.t220 sg13_lv_nmos ad=0.2516p pd=2.16u as=0.1406p ps=1.12u w=0.74u l=0.13u
X311 VSS.t473 DELAY_VBIASN.t14 a_17031_1842# VSS.t472 sg13_lv_nmos ad=0.2516p pd=2.16u as=0.1406p ps=1.12u w=0.74u l=0.6u
X312 a_25630_1044# a_3171_1047.t2 a_27048_1044# VSS.t18 sg13_lv_nmos ad=0.2516p pd=2.16u as=0.1406p ps=1.12u w=0.74u l=0.13u
X313 a_9953_1842# a_9757_1842# VDD VDD sg13_lv_pmos ad=0.3808p pd=2.92u as=0.2128p ps=1.5u w=1.12u l=0.13u
X314 VDD a_10843_1842# a_11277_1842# VDD sg13_lv_pmos ad=0.2128p pd=1.5u as=0.3808p ps=2.92u w=1.12u l=0.13u
X315 VSS.t6 a_26803_1842# a_27237_1842# VSS.t5 sg13_lv_nmos ad=0.1406p pd=1.12u as=0.2516p ps=2.16u w=0.74u l=0.13u
X316 a_4350_1044# a_3171_1047.t9 a_5768_1044# VSS.t151 sg13_lv_nmos ad=0.2516p pd=2.16u as=0.1406p ps=1.12u w=0.74u l=0.13u
X317 a_10430_1044# a_12791_1008# a_12715_1044# VDD sg13_lv_pmos ad=0.3808p pd=2.92u as=0.2128p ps=1.5u w=1.12u l=0.13u
X318 a_19311_1842# a_19073_1842# a_19203_1842# VSS.t391 sg13_lv_nmos ad=0.1406p pd=1.12u as=0.2516p ps=2.16u w=0.74u l=0.2u
X319 a_24875_1044# a_24665_1044# VDD VDD sg13_lv_pmos ad=0.2128p pd=1.5u as=0.252p ps=1.57u w=1.12u l=0.13u
X320 VDD a_2595_1047.t3 a_23431_1008# VDD sg13_lv_pmos ad=0.3808p pd=2.92u as=0.3808p ps=2.92u w=1.12u l=0.13u
X321 VDD a_13557_1842# a_14025_1044# VDD sg13_lv_pmos ad=0.252p pd=1.57u as=0.3808p ps=2.92u w=1.12u l=0.13u
X322 a_23111_1842# a_22873_1842# a_23003_1842# VSS.t49 sg13_lv_nmos ad=0.1406p pd=1.12u as=0.2516p ps=2.16u w=0.74u l=0.2u
X323 a_27671_2470# a_27433_1842# a_27563_1842# VDD sg13_lv_pmos ad=0.2128p pd=1.5u as=0.3808p ps=2.92u w=1.12u l=0.2u
X324 VSS.t62 a_17683_1842# a_18117_1842# VSS.t521 sg13_lv_nmos ad=0.1406p pd=1.12u as=0.2516p ps=2.16u w=0.74u l=0.13u
X325 VSS.t347 VDD VSS.t345 VSS.t346 sg13_lv_nmos ad=79.8f pd=0.8u as=0 ps=0 w=0.42u l=1u
X326 a_10713_1842# a_10517_1842# VSS.t386 VSS.t405 sg13_lv_nmos ad=0.2516p pd=2.16u as=0.1406p ps=1.12u w=0.74u l=0.13u
X327 VSS.t557 a_2019_1047.t8 a_7364_1008# VSS.t556 sg13_lv_nmos ad=0.2516p pd=2.16u as=0.2516p ps=2.16u w=0.74u l=0.13u
X328 VSS.t379 a_7803_1842# a_8237_1842# VSS.t505 sg13_lv_nmos ad=0.1406p pd=1.12u as=0.2516p ps=2.16u w=0.74u l=0.13u
X329 VDD DELAY_VBIASP.t15 a_16271_2470# VDD sg13_lv_pmos ad=0.3808p pd=2.92u as=0.2128p ps=1.5u w=1.12u l=0.6u
X330 VSS.t342 VDD VSS.t340 VSS.t341 sg13_lv_nmos ad=79.8f pd=0.8u as=0 ps=0 w=0.42u l=1u
X331 VSS.t315 VDD VSS.t314 VSS.t313 sg13_lv_nmos ad=0.1428p pd=1.52u as=0 ps=0 w=0.42u l=1u
X332 VDD a_26043_1842# a_26477_1842# VDD sg13_lv_pmos ad=0.2128p pd=1.5u as=0.3808p ps=2.92u w=1.12u l=0.13u
X333 a_3543_331# MUX_SEL2 a_3449_331# VSS.t283 sg13_lv_nmos ad=0.1216p pd=1.02u as=0.2176p ps=1.96u w=0.64u l=0.13u
X334 a_22488_1044# a_21917_1842# VSS.t225 VSS.t224 sg13_lv_nmos ad=0.1406p pd=1.12u as=0.2516p ps=2.16u w=0.74u l=0.13u
X335 VDD VSS.t593 VDD VDD sg13_lv_pmos ad=0.19p pd=1.38u as=0 ps=0 w=1u l=1u
X336 a_22590_1044# a_24084_1008# a_24008_1044# VDD sg13_lv_pmos ad=0.3808p pd=2.92u as=0.2128p ps=1.5u w=1.12u l=0.13u
X337 VDD DELAY_VBIASP.t10 a_20071_2470# VDD sg13_lv_pmos ad=0.3808p pd=2.92u as=0.2128p ps=1.5u w=1.12u l=0.6u
X338 a_14751_1842# a_14513_1842# a_14643_1842# VSS.t76 sg13_lv_nmos ad=0.1406p pd=1.12u as=0.2516p ps=2.16u w=0.74u l=0.2u
X339 VSS.t165 a_2873_1395# a_3171_1047.t0 VSS.t164 sg13_lv_nmos ad=0.2812p pd=2.24u as=0.1406p ps=1.12u w=0.74u l=0.13u
X340 VDD VSS.t567 VDD VDD sg13_lv_pmos ad=0.19p pd=1.38u as=0 ps=0 w=1u l=1u
X341 a_25630_1044# a_27991_1008# a_27915_1044# VDD sg13_lv_pmos ad=0.3808p pd=2.92u as=0.2128p ps=1.5u w=1.12u l=0.13u
X342 VSS.t251 VSS.t249 VSS.t247 VSS.t250 sg13_lv_nmos ad=0.1406p pd=1.12u as=0 ps=0 w=0.74u l=0.13u
X343 a_4111_1842# DELAY_IN a_4003_1842# VSS.t285 sg13_lv_nmos ad=0.1406p pd=1.12u as=0.2516p ps=2.16u w=0.74u l=0.2u
X344 a_8671_2470# a_8433_1842# a_8563_1842# VDD sg13_lv_pmos ad=0.2128p pd=1.5u as=0.3808p ps=2.92u w=1.12u l=0.2u
X345 a_17553_1842# a_17357_1842# VDD VDD sg13_lv_pmos ad=0.3808p pd=2.92u as=0.2128p ps=1.5u w=1.12u l=0.13u
X346 VSS.t25 a_1544_1044# a_2391_1395# VSS.t528 sg13_lv_nmos ad=0.1331p pd=1.12u as=0.1216p ps=1.02u w=0.64u l=0.13u
X347 VSS.t545 a_3747_311.t3 a_14825_519# VSS.t544 sg13_lv_nmos ad=0.2516p pd=2.16u as=0.2516p ps=2.16u w=0.74u l=0.13u
X348 VSS.t37 a_1256_289# a_2967_331# VSS.t36 sg13_lv_nmos ad=0.1331p pd=1.12u as=0.1216p ps=1.02u w=0.64u l=0.13u
X349 a_2019_1047.t0 a_1721_1395# VSS.t54 VSS.t53 sg13_lv_nmos ad=0.1406p pd=1.12u as=0.1331p ps=1.12u w=0.74u l=0.13u
X350 a_15964_289# a_15765_463# a_5731_289# VSS.t522 sg13_lv_nmos ad=0.2183p pd=1.33u as=0.2516p ps=2.16u w=0.74u l=0.13u
X351 a_13470_1044# a_2019_1047.t6 a_13368_1044# VSS.t262 sg13_lv_nmos ad=0.2516p pd=2.16u as=0.1406p ps=1.12u w=0.74u l=0.13u
X352 VSS.t217 a_13123_1842# a_13557_1842# VSS.t417 sg13_lv_nmos ad=0.1406p pd=1.12u as=0.2516p ps=2.16u w=0.74u l=0.13u
X353 VDD VSS.t566 VDD VDD sg13_lv_pmos ad=0.34p pd=2.68u as=0 ps=0 w=1u l=1u
X354 VSS.t74 a_3171_1047.t3 a_24084_1008# VSS.t73 sg13_lv_nmos ad=0.2516p pd=2.16u as=0.2516p ps=2.16u w=0.74u l=0.13u
X355 a_25913_1842# a_25717_1842# VSS.t533 VSS.t560 sg13_lv_nmos ad=0.2516p pd=2.16u as=0.1406p ps=1.12u w=0.74u l=0.13u
X356 a_21353_1842# a_21157_1842# VDD VDD sg13_lv_pmos ad=0.3808p pd=2.92u as=0.2128p ps=1.5u w=1.12u l=0.13u
X357 VSS.t350 VDD VSS.t349 VSS.t348 sg13_lv_nmos ad=0.1428p pd=1.52u as=0 ps=0 w=0.42u l=1u
X358 a_2297_331# MUX_SEL2 VDD VDD sg13_lv_pmos ad=0.1596p pd=1.22u as=0.2856p ps=2.36u w=0.84u l=0.13u
X359 VDD a_7043_1842# a_7477_1842# VDD sg13_lv_pmos ad=0.2128p pd=1.5u as=0.3808p ps=2.92u w=1.12u l=0.13u
X360 a_2873_331# MUX_SEL3 VDD VDD sg13_lv_pmos ad=0.1596p pd=1.22u as=0.2856p ps=2.36u w=0.84u l=0.13u
X361 a_8155_1044# a_7945_1044# VDD VDD sg13_lv_pmos ad=0.2128p pd=1.5u as=0.252p ps=1.57u w=1.12u l=0.13u
X362 VSS.t64 a_18117_1842# a_18585_1044# VSS.t63 sg13_lv_nmos ad=0.1665p pd=1.19u as=0.2516p ps=2.16u w=0.74u l=0.13u
X363 a_27048_1044# a_26477_1842# VDD VDD sg13_lv_pmos ad=0.2128p pd=1.5u as=0.3808p ps=2.92u w=1.12u l=0.13u
X364 a_5768_1044# a_5197_1842# VDD VDD sg13_lv_pmos ad=0.2128p pd=1.5u as=0.3808p ps=2.92u w=1.12u l=0.13u
X365 a_13991_2470# a_13753_1842# a_13883_1842# VDD sg13_lv_pmos ad=0.2128p pd=1.5u as=0.3808p ps=2.92u w=1.12u l=0.2u
X366 VSS.t71 a_3171_1047.t6 a_14964_1008# VSS.t70 sg13_lv_nmos ad=0.2516p pd=2.16u as=0.2516p ps=2.16u w=0.74u l=0.13u
X367 VDD a_2019_311# a_17865_519# VDD sg13_lv_pmos ad=0.3808p pd=2.92u as=0.3808p ps=2.92u w=1.12u l=0.13u
X368 DELAY_OUT_LAST a_27997_1842# VSS.t401 VSS.t400 sg13_lv_nmos ad=0.2516p pd=2.16u as=0.1406p ps=1.12u w=0.74u l=0.13u
X369 a_11195_1044# a_10985_1044# VSS.t167 VSS.t166 sg13_lv_nmos ad=0.1406p pd=1.12u as=0.1665p ps=1.19u w=0.74u l=0.13u
X370 VDD a_24197_1842# a_24665_1044# VDD sg13_lv_pmos ad=0.252p pd=1.57u as=0.3808p ps=2.92u w=1.12u l=0.13u
X371 a_6913_1842# a_6717_1842# VSS.t396 VSS.t395 sg13_lv_nmos ad=0.2516p pd=2.16u as=0.1406p ps=1.12u w=0.74u l=0.13u
X372 VSS.t475 DELAY_VBIASN.t12 a_18551_1842# VSS.t474 sg13_lv_nmos ad=0.2516p pd=2.16u as=0.1406p ps=1.12u w=0.74u l=0.6u
X373 a_16510_1044# a_18004_1008# a_17928_1044# VDD sg13_lv_pmos ad=0.3808p pd=2.92u as=0.2128p ps=1.5u w=1.12u l=0.13u
X374 VDD a_12363_1842# a_12797_1842# VDD sg13_lv_pmos ad=0.2128p pd=1.5u as=0.3808p ps=2.92u w=1.12u l=0.13u
X375 VSS.t1 MUX_SEL3 a_3543_331# VSS.t520 sg13_lv_nmos ad=0.1331p pd=1.12u as=0.1216p ps=1.02u w=0.64u l=0.13u
X376 a_22590_1044# a_2595_1047.t3 a_23355_1044# VSS.t145 sg13_lv_nmos ad=0.2516p pd=2.16u as=0.1406p ps=1.12u w=0.74u l=0.13u
X377 VSS.t423 DELAY_VBIASN.t7 a_22351_1842# VSS.t422 sg13_lv_nmos ad=0.2516p pd=2.16u as=0.1406p ps=1.12u w=0.74u l=0.6u
X378 VDD a_3171_1047.t4 a_21044_1008# VDD sg13_lv_pmos ad=0.3808p pd=2.92u as=0.3808p ps=2.92u w=1.12u l=0.13u
X379 VDD VSS.t569 VDD VDD sg13_lv_pmos ad=0.19p pd=1.38u as=0 ps=0 w=1u l=1u
X380 a_16271_2470# a_16033_1842# a_16163_1842# VDD sg13_lv_pmos ad=0.2128p pd=1.5u as=0.3808p ps=2.92u w=1.12u l=0.2u
X381 VDD VSS.t583 VDD VDD sg13_lv_pmos ad=0.19p pd=1.38u as=0 ps=0 w=1u l=1u
X382 a_19833_1842# a_19637_1842# VSS.t103 VSS.t389 sg13_lv_nmos ad=0.2516p pd=2.16u as=0.1406p ps=1.12u w=0.74u l=0.13u
X383 VDD a_2019_311# a_5705_519# VDD sg13_lv_pmos ad=0.3808p pd=2.92u as=0.3808p ps=2.92u w=1.12u l=0.13u
X384 a_20071_2470# a_19833_1842# a_19963_1842# VDD sg13_lv_pmos ad=0.2128p pd=1.5u as=0.3808p ps=2.92u w=1.12u l=0.2u
X385 a_9193_1842# a_8997_1842# VSS.t178 VSS.t177 sg13_lv_nmos ad=0.2516p pd=2.16u as=0.1406p ps=1.12u w=0.74u l=0.13u
X386 a_24631_1842# a_24393_1842# a_24523_1842# VSS.t104 sg13_lv_nmos ad=0.1406p pd=1.12u as=0.2516p ps=2.16u w=0.74u l=0.2u
X387 VDD VSS.t582 VDD VDD sg13_lv_pmos ad=0.34p pd=2.68u as=0 ps=0 w=1u l=1u
X388 VSS.t273 a_2019_1047.t7 a_10404_1008# VSS.t272 sg13_lv_nmos ad=0.2516p pd=2.16u as=0.2516p ps=2.16u w=0.74u l=0.13u
X389 VDD a_14643_1842# a_15077_1842# VDD sg13_lv_pmos ad=0.2128p pd=1.5u as=0.3808p ps=2.92u w=1.12u l=0.13u
X390 VDD a_1544_289# a_2297_331# VDD sg13_lv_pmos ad=0.1918p pd=1.5u as=0.1596p ps=1.22u w=0.84u l=0.13u
X391 a_23633_1842# a_23437_1842# VSS.t119 VSS.t118 sg13_lv_nmos ad=0.2516p pd=2.16u as=0.1406p ps=1.12u w=0.74u l=0.13u
X392 VSS.t345 VDD VSS.t344 VSS.t343 sg13_lv_nmos ad=0.1428p pd=1.52u as=0 ps=0 w=0.42u l=1u
X393 a_2019_311# a_1721_331# VDD VDD sg13_lv_pmos ad=0.2128p pd=1.5u as=0.1918p ps=1.5u w=1.12u l=0.13u
X394 VSS.t200 a_9323_1842# a_9757_1842# VSS.t494 sg13_lv_nmos ad=0.1406p pd=1.12u as=0.2516p ps=2.16u w=0.74u l=0.13u
X395 a_26395_1044# a_26185_1044# VSS.t242 VSS.t241 sg13_lv_nmos ad=0.1406p pd=1.12u as=0.1665p ps=1.19u w=0.74u l=0.13u
X396 VDD DELAY_VBIASP.t13 a_17791_2470# VDD sg13_lv_pmos ad=0.3808p pd=2.92u as=0.2128p ps=1.5u w=1.12u l=0.6u
X397 VSS.t17 a_3747_1047.t3 a_24951_1008# VSS.t16 sg13_lv_nmos ad=0.2516p pd=2.16u as=0.2516p ps=2.16u w=0.74u l=0.13u
X398 VSS.t310 VDD VSS.t309 VSS.t308 sg13_lv_nmos ad=0.1428p pd=1.52u as=0 ps=0 w=0.42u l=1u
X399 VSS.t340 VDD VSS.t339 VSS.t338 sg13_lv_nmos ad=0.1428p pd=1.52u as=0 ps=0 w=0.42u l=1u
X400 a_3747_1047.t1 a_3449_1395# VDD VDD sg13_lv_pmos ad=0.2128p pd=1.5u as=0.1918p ps=1.5u w=1.12u l=0.13u
X401 a_13368_1044# a_12797_1842# VDD VDD sg13_lv_pmos ad=0.2128p pd=1.5u as=0.3808p ps=2.92u w=1.12u l=0.13u
X402 a_24008_1044# a_23437_1842# VSS.t117 VSS.t116 sg13_lv_nmos ad=0.1406p pd=1.12u as=0.2516p ps=2.16u w=0.74u l=0.13u
X403 VDD DELAY_VBIASP.t8 a_21591_2470# VDD sg13_lv_pmos ad=0.3808p pd=2.92u as=0.2128p ps=1.5u w=1.12u l=0.6u
X404 a_15964_289# MUX_SEL4 a_5731_289# VDD sg13_lv_pmos ad=0.3304p pd=1.71u as=0.3808p ps=2.92u w=1.12u l=0.13u
X405 a_4350_1044# a_6711_1008# a_6635_1044# VDD sg13_lv_pmos ad=0.3808p pd=2.92u as=0.2128p ps=1.5u w=1.12u l=0.13u
X406 a_2873_1395# MUX_SEL1 VDD VDD sg13_lv_pmos ad=0.1596p pd=1.22u as=0.2856p ps=2.36u w=0.84u l=0.13u
X407 a_1256_1044# MUX_SEL0 VSS.t491 VSS.t490 sg13_lv_nmos ad=0.2516p pd=2.16u as=0.2516p ps=2.16u w=0.74u l=0.13u
X408 VSS.t307 VDD VSS.t305 VSS.t306 sg13_lv_nmos ad=79.8f pd=0.8u as=0 ps=0 w=0.42u l=1u
X409 a_19550_1044# a_20391_1008# a_20315_1044# VDD sg13_lv_pmos ad=0.3808p pd=2.92u as=0.2128p ps=1.5u w=1.12u l=0.13u
X410 VDD VDD VDD VDD sg13_lv_pmos ad=0.2128p pd=1.5u as=0 ps=0 w=1.12u l=0.2u
X411 a_5631_1842# a_5393_1842# a_5523_1842# VSS.t227 sg13_lv_nmos ad=0.1406p pd=1.12u as=0.2516p ps=2.16u w=0.74u l=0.2u
X412 a_14513_1842# a_14317_1842# VSS.t510 VSS.t509 sg13_lv_nmos ad=0.2516p pd=2.16u as=0.1406p ps=1.12u w=0.74u l=0.13u
X413 VSS.t135 a_2595_311.t2 a_20905_519# VSS.t134 sg13_lv_nmos ad=0.2516p pd=2.16u as=0.2516p ps=2.16u w=0.74u l=0.13u
X414 VDD a_7477_1842# a_7945_1044# VDD sg13_lv_pmos ad=0.252p pd=1.57u as=0.3808p ps=2.92u w=1.12u l=0.13u
X415 a_13470_1044# a_3171_1047.t6 a_14888_1044# VSS.t69 sg13_lv_nmos ad=0.2516p pd=2.16u as=0.1406p ps=1.12u w=0.74u l=0.13u
X416 a_4633_1842# a_4437_1842# VSS.t504 VSS.t503 sg13_lv_nmos ad=0.2516p pd=2.16u as=0.1406p ps=1.12u w=0.74u l=0.13u
X417 a_1256_289# MUX_SEL2 VSS.t281 VSS.t280 sg13_lv_nmos ad=0.2516p pd=2.16u as=0.2516p ps=2.16u w=0.74u l=0.13u
X418 VSS.t196 a_2019_1047.t2 a_25604_1008# VSS.t195 sg13_lv_nmos ad=0.2516p pd=2.16u as=0.2516p ps=2.16u w=0.74u l=0.13u
X419 a_16108_289# MUX_SEL4 a_15964_289# VSS.t50 sg13_lv_nmos ad=0.2516p pd=2.16u as=0.2183p ps=1.33u w=0.74u l=0.13u
X420 a_22873_1842# a_22677_1842# VDD VDD sg13_lv_pmos ad=0.3808p pd=2.92u as=0.2128p ps=1.5u w=1.12u l=0.13u
X421 a_21835_1044# a_21625_1044# VSS.t244 VSS.t243 sg13_lv_nmos ad=0.1406p pd=1.12u as=0.1665p ps=1.19u w=0.74u l=0.13u
X422 VSS.t23 a_2595_1047.t4 a_20391_1008# VSS.t22 sg13_lv_nmos ad=0.2516p pd=2.16u as=0.2516p ps=2.16u w=0.74u l=0.13u
X423 a_9675_1044# a_9465_1044# VDD VDD sg13_lv_pmos ad=0.2128p pd=1.5u as=0.252p ps=1.57u w=1.12u l=0.13u
X424 VSS.t167 a_10517_1842# a_10985_1044# VSS.t404 sg13_lv_nmos ad=0.1665p pd=1.19u as=0.2516p ps=2.16u w=0.74u l=0.13u
X425 VDD a_2595_1047.t8 a_8231_1008# VDD sg13_lv_pmos ad=0.3808p pd=2.92u as=0.3808p ps=2.92u w=1.12u l=0.13u
X426 a_18551_1842# a_18313_1842# a_18443_1842# VSS.t414 sg13_lv_nmos ad=0.1406p pd=1.12u as=0.2516p ps=2.16u w=0.74u l=0.2u
X427 a_22351_1842# a_22113_1842# a_22243_1842# VSS.t562 sg13_lv_nmos ad=0.1406p pd=1.12u as=0.2516p ps=2.16u w=0.74u l=0.2u
X428 VSS.t233 a_3747_1047.t5 a_18871_1008# VSS.t232 sg13_lv_nmos ad=0.2516p pd=2.16u as=0.2516p ps=2.16u w=0.74u l=0.13u
X429 VSS.t11 a_16923_1842# a_17357_1842# VSS.t484 sg13_lv_nmos ad=0.1406p pd=1.12u as=0.2516p ps=2.16u w=0.74u l=0.13u
X430 VDD a_3171_311.t2 a_23945_519# VDD sg13_lv_pmos ad=0.3808p pd=2.92u as=0.3808p ps=2.92u w=1.12u l=0.13u
X431 a_2019_311# a_1721_331# VSS.t58 VSS.t170 sg13_lv_nmos ad=0.1406p pd=1.12u as=0.1331p ps=1.12u w=0.74u l=0.13u
X432 a_25153_1842# a_24957_1842# VDD VDD sg13_lv_pmos ad=0.3808p pd=2.92u as=0.2128p ps=1.5u w=1.12u l=0.13u
X433 a_17928_1044# a_17357_1842# VSS.t9 VSS.t8 sg13_lv_nmos ad=0.1406p pd=1.12u as=0.2516p ps=2.16u w=0.74u l=0.13u
X434 a_12715_1044# a_12505_1044# VSS.t34 VSS.t33 sg13_lv_nmos ad=0.1406p pd=1.12u as=0.1665p ps=1.19u w=0.74u l=0.13u
X435 VDD MUX_SEL4 a_15765_463# VDD sg13_lv_pmos ad=0.3808p pd=2.92u as=0.3808p ps=2.92u w=1.12u l=0.13u
X436 a_19550_1044# a_3171_1047.t4 a_20968_1044# VSS.t148 sg13_lv_nmos ad=0.2516p pd=2.16u as=0.1406p ps=1.12u w=0.74u l=0.13u
X437 VSS.t429 DELAY_VBIASN.t22 a_10951_1842# VSS.t428 sg13_lv_nmos ad=0.2516p pd=2.16u as=0.1406p ps=1.12u w=0.74u l=0.6u
X438 a_19550_1044# a_19524_1008# a_19448_1044# VDD sg13_lv_pmos ad=0.3808p pd=2.92u as=0.2128p ps=1.5u w=1.12u l=0.13u
X439 a_7288_1044# a_6717_1842# VSS.t394 VSS.t393 sg13_lv_nmos ad=0.1406p pd=1.12u as=0.2516p ps=2.16u w=0.74u l=0.13u
X440 VSS.t86 a_20723_1842# a_21157_1842# VSS.t85 sg13_lv_nmos ad=0.1406p pd=1.12u as=0.2516p ps=2.16u w=0.74u l=0.13u
X441 a_1544_289# MUX_SEL3 VSS.t518 VSS.t517 sg13_lv_nmos ad=0.2516p pd=2.16u as=0.2516p ps=2.16u w=0.74u l=0.13u
X442 a_13470_1044# a_14311_1008# a_14235_1044# VDD sg13_lv_pmos ad=0.3808p pd=2.92u as=0.2128p ps=1.5u w=1.12u l=0.13u
X443 a_22590_1044# a_3747_1047.t3 a_24875_1044# VSS.t15 sg13_lv_nmos ad=0.2516p pd=2.16u as=0.1406p ps=1.12u w=0.74u l=0.13u
X444 VSS.t481 DELAY_VBIASN.t5 a_23871_1842# VSS.t480 sg13_lv_nmos ad=0.2516p pd=2.16u as=0.1406p ps=1.12u w=0.74u l=0.6u
X445 VDD a_2019_1047.t3 a_22564_1008# VDD sg13_lv_pmos ad=0.3808p pd=2.92u as=0.3808p ps=2.92u w=1.12u l=0.13u
X446 VSS.t242 a_25717_1842# a_26185_1044# VSS.t559 sg13_lv_nmos ad=0.1665p pd=1.19u as=0.2516p ps=2.16u w=0.74u l=0.13u
X447 a_13231_1842# a_12993_1842# a_13123_1842# VSS.t511 sg13_lv_nmos ad=0.1406p pd=1.12u as=0.2516p ps=2.16u w=0.74u l=0.2u
X448 VSS.t302 VDD VSS.t300 VSS.t301 sg13_lv_nmos ad=79.8f pd=0.8u as=0 ps=0 w=0.42u l=1u
X449 a_17791_2470# a_17553_1842# a_17683_1842# VDD sg13_lv_pmos ad=0.2128p pd=1.5u as=0.3808p ps=2.92u w=1.12u l=0.2u
X450 VSS.t29 a_4437_1842# a_4905_1044# VSS.t502 sg13_lv_nmos ad=0.1665p pd=1.19u as=0.2516p ps=2.16u w=0.74u l=0.13u
X451 VDD VSS.t570 VDD VDD sg13_lv_pmos ad=0.34p pd=2.68u as=0 ps=0 w=1u l=1u
X452 a_12233_1842# a_12037_1842# VSS.t115 VSS.t114 sg13_lv_nmos ad=0.2516p pd=2.16u as=0.1406p ps=1.12u w=0.74u l=0.13u
X453 VSS.t80 a_3449_1395# a_3747_1047.t0 VSS.t79 sg13_lv_nmos ad=0.2812p pd=2.24u as=0.1406p ps=1.12u w=0.74u l=0.13u
X454 VDD VSS.t584 VDD VDD sg13_lv_pmos ad=0.34p pd=2.68u as=0 ps=0 w=1u l=1u
X455 VDD VSS.t579 VDD VDD sg13_lv_pmos ad=0.19p pd=1.38u as=0 ps=0 w=1u l=1u
X456 VSS.t367 VDD VSS.t365 VSS.t366 sg13_lv_nmos ad=79.8f pd=0.8u as=0 ps=0 w=0.42u l=1u
X457 VSS.t138 a_3171_1047.t8 a_8884_1008# VSS.t137 sg13_lv_nmos ad=0.2516p pd=2.16u as=0.2516p ps=2.16u w=0.74u l=0.13u
X458 a_21591_2470# a_21353_1842# a_21483_1842# VDD sg13_lv_pmos ad=0.2128p pd=1.5u as=0.3808p ps=2.92u w=1.12u l=0.2u
X459 VDD a_2873_1395# a_3171_1047.t1 VDD sg13_lv_pmos ad=0.4256p pd=3u as=0.2128p ps=1.5u w=1.12u l=0.13u
X460 a_6153_1842# a_5957_1842# VDD VDD sg13_lv_pmos ad=0.3808p pd=2.92u as=0.2128p ps=1.5u w=1.12u l=0.13u
X461 VDD a_16163_1842# a_16597_1842# VDD sg13_lv_pmos ad=0.2128p pd=1.5u as=0.3808p ps=2.92u w=1.12u l=0.13u
X462 a_3543_1395# MUX_SEL0 a_3449_1395# VSS.t493 sg13_lv_nmos ad=0.1216p pd=1.02u as=0.2176p ps=1.96u w=0.64u l=0.13u
X463 VDD a_1544_1044# a_2297_1395# VDD sg13_lv_pmos ad=0.1918p pd=1.5u as=0.1596p ps=1.22u w=0.84u l=0.13u
X464 VDD DELAY_VBIASP.t23 a_10191_2470# VDD sg13_lv_pmos ad=0.3808p pd=2.92u as=0.2128p ps=1.5u w=1.12u l=0.6u
X465 a_17275_1044# a_17065_1044# VDD VDD sg13_lv_pmos ad=0.2128p pd=1.5u as=0.252p ps=1.57u w=1.12u l=0.13u
X466 a_2019_1047.t1 a_1721_1395# VDD VDD sg13_lv_pmos ad=0.2128p pd=1.5u as=0.1918p ps=1.5u w=1.12u l=0.13u
X467 a_27915_1044# a_27705_1044# VSS.t127 VSS.t126 sg13_lv_nmos ad=0.1406p pd=1.12u as=0.1665p ps=1.19u w=0.74u l=0.13u
X468 VSS.t445 DELAY_VBIASN.t2 a_26151_1842# VSS.t444 sg13_lv_nmos ad=0.2516p pd=2.16u as=0.1406p ps=1.12u w=0.74u l=0.6u
X469 VDD a_3747_1047.t6 a_15831_1008# VDD sg13_lv_pmos ad=0.3808p pd=2.92u as=0.3808p ps=2.92u w=1.12u l=0.13u
X470 VDD a_19963_1842# a_20397_1842# VDD sg13_lv_pmos ad=0.2128p pd=1.5u as=0.3808p ps=2.92u w=1.12u l=0.13u
X471 VSS.t370 VDD VSS.t369 VSS.t368 sg13_lv_nmos ad=0.1428p pd=1.52u as=0 ps=0 w=0.42u l=1u
X472 VSS.t441 DELAY_VBIASN.t30 a_4871_1842# VSS.t440 sg13_lv_nmos ad=0.2516p pd=2.16u as=0.1406p ps=1.12u w=0.74u l=0.6u
X473 a_14888_1044# a_14317_1842# VDD VDD sg13_lv_pmos ad=0.2128p pd=1.5u as=0.3808p ps=2.92u w=1.12u l=0.13u
X474 a_4350_1044# a_4324_1008# a_4248_1044# VDD sg13_lv_pmos ad=0.3808p pd=2.92u as=0.2128p ps=1.5u w=1.12u l=0.13u
X475 a_1256_289# MUX_SEL2 VDD VDD sg13_lv_pmos ad=0.3808p pd=2.92u as=0.3808p ps=2.92u w=1.12u l=0.13u
X476 VSS.t255 VSS.t252 VSS.t254 VSS.t253 sg13_lv_nmos ad=0.2516p pd=2.16u as=0 ps=0 w=0.74u l=0.6u
X477 a_16108_289# a_15765_463# a_15964_289# VDD sg13_lv_pmos ad=0.3808p pd=2.92u as=0.3304p ps=1.71u w=1.12u l=0.13u
X478 a_11473_1842# a_11277_1842# VDD VDD sg13_lv_pmos ad=0.3808p pd=2.92u as=0.2128p ps=1.5u w=1.12u l=0.13u
X479 VDD a_8997_1842# a_9465_1044# VDD sg13_lv_pmos ad=0.252p pd=1.57u as=0.3808p ps=2.92u w=1.12u l=0.13u
X480 a_27433_1842# a_27237_1842# VSS.t6 VSS.t207 sg13_lv_nmos ad=0.2516p pd=2.16u as=0.1406p ps=1.12u w=0.74u l=0.13u
X481 a_2391_331# MUX_SEL2 a_2297_331# VSS.t282 sg13_lv_nmos ad=0.1216p pd=1.02u as=0.2176p ps=1.96u w=0.64u l=0.13u
X482 a_2967_331# MUX_SEL3 a_2873_331# VSS.t519 sg13_lv_nmos ad=0.1216p pd=1.02u as=0.2176p ps=1.96u w=0.64u l=0.13u
X483 VDD a_2019_1047.t5 a_16484_1008# VDD sg13_lv_pmos ad=0.3808p pd=2.92u as=0.3808p ps=2.92u w=1.12u l=0.13u
X484 a_7390_1044# a_2595_1047.t8 a_8155_1044# VSS.t551 sg13_lv_nmos ad=0.2516p pd=2.16u as=0.1406p ps=1.12u w=0.74u l=0.13u
X485 VSS.t449 DELAY_VBIASN.t27 a_7151_1842# VSS.t448 sg13_lv_nmos ad=0.2516p pd=2.16u as=0.1406p ps=1.12u w=0.74u l=0.6u
X486 VDD a_3171_1047.t9 a_5844_1008# VDD sg13_lv_pmos ad=0.3808p pd=2.92u as=0.3808p ps=2.92u w=1.12u l=0.13u
X487 VDD DELAY_VBIASP.t3 a_25391_2470# VDD sg13_lv_pmos ad=0.3808p pd=2.92u as=0.2128p ps=1.5u w=1.12u l=0.6u
X488 VDD a_2595_1047.t7 a_11271_1008# VDD sg13_lv_pmos ad=0.3808p pd=2.92u as=0.3808p ps=2.92u w=1.12u l=0.13u
X489 VDD VSS.t587 VDD VDD sg13_lv_pmos ad=0.19p pd=1.38u as=0 ps=0 w=1u l=1u
X490 VSS.t34 a_12037_1842# a_12505_1044# VSS.t113 sg13_lv_nmos ad=0.1665p pd=1.19u as=0.2516p ps=2.16u w=0.74u l=0.13u
X491 VDD a_3747_1047.t8 a_9751_1008# VDD sg13_lv_pmos ad=0.3808p pd=2.92u as=0.3808p ps=2.92u w=1.12u l=0.13u
X492 a_9431_1842# a_9193_1842# a_9323_1842# VSS.t561 sg13_lv_nmos ad=0.1406p pd=1.12u as=0.2516p ps=2.16u w=0.74u l=0.2u
X493 a_18313_1842# a_18117_1842# VSS.t62 VSS.t61 sg13_lv_nmos ad=0.2516p pd=2.16u as=0.1406p ps=1.12u w=0.74u l=0.13u
X494 MUX_OUT a_16851_309# VSS.t92 VSS.t186 sg13_lv_nmos ad=0.1406p pd=1.12u as=0.1371p ps=1.12u w=0.74u l=0.13u
X495 VSS.t362 VDD VSS.t360 VSS.t361 sg13_lv_nmos ad=79.8f pd=0.8u as=0 ps=0 w=0.42u l=1u
X496 a_23871_1842# a_23633_1842# a_23763_1842# VSS.t193 sg13_lv_nmos ad=0.1406p pd=1.12u as=0.2516p ps=2.16u w=0.74u l=0.2u
X497 a_8433_1842# a_8237_1842# VSS.t379 VSS.t378 sg13_lv_nmos ad=0.2516p pd=2.16u as=0.1406p ps=1.12u w=0.74u l=0.13u
X498 VSS.t68 a_18443_1842# a_18877_1842# VSS.t67 sg13_lv_nmos ad=0.1406p pd=1.12u as=0.2516p ps=2.16u w=0.74u l=0.13u
X499 VSS.t327 VDD VSS.t325 VSS.t326 sg13_lv_nmos ad=79.8f pd=0.8u as=0 ps=0 w=0.42u l=1u
X500 a_22113_1842# a_21917_1842# VSS.t219 VSS.t226 sg13_lv_nmos ad=0.2516p pd=2.16u as=0.1406p ps=1.12u w=0.74u l=0.13u
X501 a_1544_289# MUX_SEL3 VDD VDD sg13_lv_pmos ad=0.3808p pd=2.92u as=0.3808p ps=2.92u w=1.12u l=0.13u
X502 a_26673_1842# a_26477_1842# VDD VDD sg13_lv_pmos ad=0.3808p pd=2.92u as=0.2128p ps=1.5u w=1.12u l=0.13u
X503 a_10328_1044# a_9757_1842# VSS.t202 VSS.t201 sg13_lv_nmos ad=0.1406p pd=1.12u as=0.2516p ps=2.16u w=0.74u l=0.13u
X504 VSS.t330 VDD VSS.t329 VSS.t328 sg13_lv_nmos ad=0.1428p pd=1.52u as=0 ps=0 w=0.42u l=1u
X505 a_22590_1044# a_2019_1047.t3 a_22488_1044# VSS.t265 sg13_lv_nmos ad=0.2516p pd=2.16u as=0.1406p ps=1.12u w=0.74u l=0.13u
X506 VSS.t421 DELAY_VBIASN.t20 a_12471_1842# VSS.t420 sg13_lv_nmos ad=0.2516p pd=2.16u as=0.1406p ps=1.12u w=0.74u l=0.6u
X507 a_8808_1044# a_8237_1842# VSS.t381 VSS.t380 sg13_lv_nmos ad=0.1406p pd=1.12u as=0.2516p ps=2.16u w=0.74u l=0.13u
X508 VSS.t383 a_22243_1842# a_22677_1842# VSS.t382 sg13_lv_nmos ad=0.1406p pd=1.12u as=0.2516p ps=2.16u w=0.74u l=0.13u
X509 VDD DELAY_VBIASP.t28 a_6391_2470# VDD sg13_lv_pmos ad=0.3808p pd=2.92u as=0.2128p ps=1.5u w=1.12u l=0.6u
X510 a_13470_1044# a_15831_1008# a_15755_1044# VDD sg13_lv_pmos ad=0.3808p pd=2.92u as=0.2128p ps=1.5u w=1.12u l=0.13u
X511 a_1544_1044# MUX_SEL1 VDD VDD sg13_lv_pmos ad=0.3808p pd=2.92u as=0.3808p ps=2.92u w=1.12u l=0.13u
X512 VDD DELAY_VBIASP.t9 a_20831_2470# VDD sg13_lv_pmos ad=0.3808p pd=2.92u as=0.2128p ps=1.5u w=1.12u l=0.6u
X513 VDD a_2595_1047.t2 a_26471_1008# VDD sg13_lv_pmos ad=0.3808p pd=2.92u as=0.3808p ps=2.92u w=1.12u l=0.13u
X514 a_4350_1044# a_5191_1008# a_5115_1044# VDD sg13_lv_pmos ad=0.3808p pd=2.92u as=0.2128p ps=1.5u w=1.12u l=0.13u
X515 VDD a_16597_1842# a_17065_1044# VDD sg13_lv_pmos ad=0.252p pd=1.57u as=0.3808p ps=2.92u w=1.12u l=0.13u
X516 VSS.t127 a_27237_1842# a_27705_1044# VSS.t206 sg13_lv_nmos ad=0.1665p pd=1.19u as=0.2516p ps=2.16u w=0.74u l=0.13u
X517 a_10191_2470# a_9953_1842# a_10083_1842# VDD sg13_lv_pmos ad=0.2128p pd=1.5u as=0.3808p ps=2.92u w=1.12u l=0.2u
X518 a_2595_1047.t0 a_2297_1395# VSS.t25 VSS.t24 sg13_lv_nmos ad=0.1406p pd=1.12u as=0.1331p ps=1.12u w=0.74u l=0.13u
X519 a_26151_1842# a_25913_1842# a_26043_1842# VSS.t407 sg13_lv_nmos ad=0.1406p pd=1.12u as=0.2516p ps=2.16u w=0.74u l=0.2u
X520 VSS.t101 a_2019_311# a_17865_519# VSS.t100 sg13_lv_nmos ad=0.2516p pd=2.16u as=0.2516p ps=2.16u w=0.74u l=0.13u
X521 VSS.t60 a_1544_289# a_2391_331# VSS.t59 sg13_lv_nmos ad=0.1331p pd=1.12u as=0.1216p ps=1.02u w=0.64u l=0.13u
X522 a_4871_1842# a_4633_1842# a_4763_1842# VSS.t534 sg13_lv_nmos ad=0.1406p pd=1.12u as=0.2516p ps=2.16u w=0.74u l=0.2u
X523 a_13753_1842# a_13557_1842# VSS.t217 VSS.t216 sg13_lv_nmos ad=0.2516p pd=2.16u as=0.1406p ps=1.12u w=0.74u l=0.13u
X524 a_1815_1395# a_1256_1044# a_1721_1395# VSS.t546 sg13_lv_nmos ad=0.1216p pd=1.02u as=0.2176p ps=1.96u w=0.64u l=0.13u
X525 a_7673_1842# a_7477_1842# VDD VDD sg13_lv_pmos ad=0.3808p pd=2.92u as=0.2128p ps=1.5u w=1.12u l=0.13u
X526 VDD VSS.t580 VDD VDD sg13_lv_pmos ad=0.34p pd=2.68u as=0 ps=0 w=1u l=1u
X527 a_1721_331# a_1256_289# VDD VDD sg13_lv_pmos ad=0.1596p pd=1.22u as=0.2856p ps=2.36u w=0.84u l=0.13u
X528 VSS.t213 a_24523_1842# a_24957_1842# VSS.t384 sg13_lv_nmos ad=0.1406p pd=1.12u as=0.2516p ps=2.16u w=0.74u l=0.13u
X529 a_6635_1044# a_6425_1044# VSS.t125 VSS.t124 sg13_lv_nmos ad=0.1406p pd=1.12u as=0.1665p ps=1.19u w=0.74u l=0.13u
X530 VSS.t89 a_2595_1047.t9 a_5191_1008# VSS.t88 sg13_lv_nmos ad=0.2516p pd=2.16u as=0.2516p ps=2.16u w=0.74u l=0.13u
X531 a_20315_1044# a_20105_1044# VSS.t129 VSS.t128 sg13_lv_nmos ad=0.1406p pd=1.12u as=0.1665p ps=1.19u w=0.74u l=0.13u
X532 VDD DELAY_VBIASP.t21 a_11711_2470# VDD sg13_lv_pmos ad=0.3808p pd=2.92u as=0.2128p ps=1.5u w=1.12u l=0.6u
X533 a_18795_1044# a_18585_1044# VDD VDD sg13_lv_pmos ad=0.2128p pd=1.5u as=0.252p ps=1.57u w=1.12u l=0.13u
X534 a_25528_1044# a_24957_1842# VSS.t211 VSS.t210 sg13_lv_nmos ad=0.1406p pd=1.12u as=0.2516p ps=2.16u w=0.74u l=0.13u
X535 VSS.t483 DELAY_VBIASN.t0 a_27671_1842# VSS.t482 sg13_lv_nmos ad=0.2516p pd=2.16u as=0.1406p ps=1.12u w=0.74u l=0.6u
X536 a_5731_289# a_3747_311.t3 a_13470_1044# VSS.t543 sg13_lv_nmos ad=0.2516p pd=2.16u as=0.2516p ps=2.16u w=0.74u l=0.13u
X537 a_25630_1044# a_27124_1008# a_27048_1044# VDD sg13_lv_pmos ad=0.3808p pd=2.92u as=0.2128p ps=1.5u w=1.12u l=0.13u
X538 VDD a_2595_1047.t5 a_17351_1008# VDD sg13_lv_pmos ad=0.3808p pd=2.92u as=0.3808p ps=2.92u w=1.12u l=0.13u
X539 VDD a_21483_1842# a_21917_1842# VDD sg13_lv_pmos ad=0.2128p pd=1.5u as=0.3808p ps=2.92u w=1.12u l=0.13u
X540 a_4350_1044# a_5844_1008# a_5768_1044# VDD sg13_lv_pmos ad=0.3808p pd=2.92u as=0.2128p ps=1.5u w=1.12u l=0.13u
X541 VSS.t188 a_16851_309# MUX_OUT VSS.t187 sg13_lv_nmos ad=0.2516p pd=2.16u as=0.1406p ps=1.12u w=0.74u l=0.13u
X542 VSS.t98 a_2019_311# a_5705_519# VSS.t97 sg13_lv_nmos ad=0.2516p pd=2.16u as=0.2516p ps=2.16u w=0.74u l=0.13u
X543 VDD a_1544_289# a_1721_331# VDD sg13_lv_pmos ad=0.1918p pd=1.5u as=0.1596p ps=1.22u w=0.84u l=0.13u
X544 a_7151_1842# a_6913_1842# a_7043_1842# VSS.t413 sg13_lv_nmos ad=0.1406p pd=1.12u as=0.2516p ps=2.16u w=0.74u l=0.2u
X545 a_16033_1842# a_15837_1842# VSS.t48 VSS.t529 sg13_lv_nmos ad=0.2516p pd=2.16u as=0.1406p ps=1.12u w=0.74u l=0.13u
X546 MUX_OUT a_16851_309# VDD VDD sg13_lv_pmos ad=0.2128p pd=1.5u as=0.2086p ps=1.5u w=1.12u l=0.13u
X547 a_25391_2470# a_25153_1842# a_25283_1842# VDD sg13_lv_pmos ad=0.2128p pd=1.5u as=0.3808p ps=2.92u w=1.12u l=0.2u
X548 VDD VSS.t592 VDD VDD sg13_lv_pmos ad=0.34p pd=2.68u as=0 ps=0 w=1u l=1u
X549 a_12993_1842# a_12797_1842# VDD VDD sg13_lv_pmos ad=0.3808p pd=2.92u as=0.2128p ps=1.5u w=1.12u l=0.13u
X550 a_16408_1044# a_15837_1842# VSS.t531 VSS.t530 sg13_lv_nmos ad=0.1406p pd=1.12u as=0.2516p ps=2.16u w=0.74u l=0.13u
X551 VSS.t205 a_5523_1842# a_5957_1842# VSS.t223 sg13_lv_nmos ad=0.1406p pd=1.12u as=0.2516p ps=2.16u w=0.74u l=0.13u
X552 VDD DELAY_VBIASP.t18 a_13991_2470# VDD sg13_lv_pmos ad=0.3808p pd=2.92u as=0.2128p ps=1.5u w=1.12u l=0.6u
X553 a_5731_289# a_2019_311# a_4350_1044# VSS.t96 sg13_lv_nmos ad=0.2516p pd=2.16u as=0.2516p ps=2.16u w=0.74u l=0.13u
X554 a_7390_1044# a_3747_1047.t8 a_9675_1044# VSS.t259 sg13_lv_nmos ad=0.2516p pd=2.16u as=0.1406p ps=1.12u w=0.74u l=0.13u
X555 VDD a_23763_1842# a_24197_1842# VDD sg13_lv_pmos ad=0.2128p pd=1.5u as=0.3808p ps=2.92u w=1.12u l=0.13u
X556 VSS.t425 DELAY_VBIASN.t25 a_8671_1842# VSS.t424 sg13_lv_nmos ad=0.2516p pd=2.16u as=0.1406p ps=1.12u w=0.74u l=0.6u
X557 VDD a_2019_1047.t8 a_7364_1008# VDD sg13_lv_pmos ad=0.3808p pd=2.92u as=0.3808p ps=2.92u w=1.12u l=0.13u
X558 VDD DELAY_VBIASP.t1 a_26911_2470# VDD sg13_lv_pmos ad=0.3808p pd=2.92u as=0.2128p ps=1.5u w=1.12u l=0.6u
X559 VDD VSS.t563 VDD VDD sg13_lv_pmos ad=0.19p pd=1.38u as=0 ps=0 w=1u l=1u
X560 a_12471_1842# a_12233_1842# a_12363_1842# VSS.t214 sg13_lv_nmos ad=0.1406p pd=1.12u as=0.2516p ps=2.16u w=0.74u l=0.2u
X561 a_22488_1044# a_21917_1842# VDD VDD sg13_lv_pmos ad=0.2128p pd=1.5u as=0.3808p ps=2.92u w=1.12u l=0.13u
X562 VDD a_2595_311.t3 a_8745_519# VDD sg13_lv_pmos ad=0.3808p pd=2.92u as=0.3808p ps=2.92u w=1.12u l=0.13u
X563 VSS.t276 a_3171_1047.t5 a_18004_1008# VSS.t275 sg13_lv_nmos ad=0.2516p pd=2.16u as=0.2516p ps=2.16u w=0.74u l=0.13u
X564 a_6391_2470# a_6153_1842# a_6283_1842# VDD sg13_lv_pmos ad=0.2128p pd=1.5u as=0.3808p ps=2.92u w=1.12u l=0.2u
X565 a_15273_1842# a_15077_1842# VDD VDD sg13_lv_pmos ad=0.3808p pd=2.92u as=0.2128p ps=1.5u w=1.12u l=0.13u
X566 a_14235_1044# a_14025_1044# VSS.t82 VSS.t81 sg13_lv_nmos ad=0.1406p pd=1.12u as=0.1665p ps=1.19u w=0.74u l=0.13u
X567 VSS.t159 a_3747_1047.t7 a_12791_1008# VSS.t158 sg13_lv_nmos ad=0.2516p pd=2.16u as=0.2516p ps=2.16u w=0.74u l=0.13u
X568 a_9953_1842# a_9757_1842# VSS.t200 VSS.t199 sg13_lv_nmos ad=0.2516p pd=2.16u as=0.1406p ps=1.12u w=0.74u l=0.13u
X569 VSS.t501 a_10843_1842# a_11277_1842# VSS.t525 sg13_lv_nmos ad=0.1406p pd=1.12u as=0.2516p ps=2.16u w=0.74u l=0.13u
X570 VSS.t360 VDD VSS.t359 VSS.t358 sg13_lv_nmos ad=0.1428p pd=1.52u as=0 ps=0 w=0.42u l=1u
X571 VDD a_15403_1842# a_15837_1842# VDD sg13_lv_pmos ad=0.2128p pd=1.5u as=0.3808p ps=2.92u w=1.12u l=0.13u
X572 VSS.t325 VDD VSS.t324 VSS.t323 sg13_lv_nmos ad=0.1428p pd=1.52u as=0 ps=0 w=0.42u l=1u
X573 a_11848_1044# a_11277_1842# VSS.t499 VSS.t498 sg13_lv_nmos ad=0.1406p pd=1.12u as=0.2516p ps=2.16u w=0.74u l=0.13u
X574 VDD a_4763_1842# a_5197_1842# VDD sg13_lv_pmos ad=0.2128p pd=1.5u as=0.3808p ps=2.92u w=1.12u l=0.13u
X575 VSS.t337 VDD VSS.t335 VSS.t336 sg13_lv_nmos ad=79.8f pd=0.8u as=0 ps=0 w=0.42u l=1u
X576 a_13470_1044# a_13444_1008# a_13368_1044# VDD sg13_lv_pmos ad=0.3808p pd=2.92u as=0.2128p ps=1.5u w=1.12u l=0.13u
X577 VDD a_3449_1395# a_3747_1047.t1 VDD sg13_lv_pmos ad=0.4256p pd=3u as=0.2128p ps=1.5u w=1.12u l=0.13u
X578 VDD a_3171_1047.t3 a_24084_1008# VDD sg13_lv_pmos ad=0.3808p pd=2.92u as=0.3808p ps=2.92u w=1.12u l=0.13u
X579 a_3449_1395# MUX_SEL0 VDD VDD sg13_lv_pmos ad=0.1596p pd=1.22u as=0.2856p ps=2.36u w=0.84u l=0.13u
X580 VDD DELAY_VBIASP.t26 a_7911_2470# VDD sg13_lv_pmos ad=0.3808p pd=2.92u as=0.2128p ps=1.5u w=1.12u l=0.6u
X581 VDD VSS.t595 VDD VDD sg13_lv_pmos ad=0.19p pd=1.38u as=0 ps=0 w=1u l=1u
X582 VDD VSS.t594 VDD VDD sg13_lv_pmos ad=0.34p pd=2.68u as=0 ps=0 w=1u l=1u
X583 VDD a_16851_309# MUX_OUT VDD sg13_lv_pmos ad=0.7336p pd=3.55u as=0.2128p ps=1.5u w=1.12u l=0.13u
X584 VSS.t32 a_3171_311.t2 a_23945_519# VSS.t31 sg13_lv_nmos ad=0.2516p pd=2.16u as=0.2516p ps=2.16u w=0.74u l=0.13u
X585 VDD a_18117_1842# a_18585_1044# VDD sg13_lv_pmos ad=0.252p pd=1.57u as=0.3808p ps=2.92u w=1.12u l=0.13u
X586 VSS.t129 a_19637_1842# a_20105_1044# VSS.t390 sg13_lv_nmos ad=0.1665p pd=1.19u as=0.2516p ps=2.16u w=0.74u l=0.13u
X587 a_11711_2470# a_11473_1842# a_11603_1842# VDD sg13_lv_pmos ad=0.2128p pd=1.5u as=0.3808p ps=2.92u w=1.12u l=0.2u
X588 a_27671_1842# a_27433_1842# a_27563_1842# VSS.t418 sg13_lv_nmos ad=0.1406p pd=1.12u as=0.2516p ps=2.16u w=0.74u l=0.2u
X589 VSS.t52 MUX_SEL4 a_15765_463# VSS.t51 sg13_lv_nmos ad=0.2516p pd=2.16u as=0.2516p ps=2.16u w=0.74u l=0.13u
X590 a_5731_289# a_14825_519# a_13470_1044# VDD sg13_lv_pmos ad=0.3808p pd=2.92u as=0.3808p ps=2.92u w=1.12u l=0.13u
X591 a_16510_1044# a_2595_1047.t5 a_17275_1044# VSS.t548 sg13_lv_nmos ad=0.2516p pd=2.16u as=0.1406p ps=1.12u w=0.74u l=0.13u
X592 VSS.t469 DELAY_VBIASN.t15 a_16271_1842# VSS.t468 sg13_lv_nmos ad=0.2516p pd=2.16u as=0.1406p ps=1.12u w=0.74u l=0.6u
X593 VDD VSS.t568 VDD VDD sg13_lv_pmos ad=0.34p pd=2.68u as=0 ps=0 w=1u l=1u
X594 VDD a_3171_1047.t6 a_14964_1008# VDD sg13_lv_pmos ad=0.3808p pd=2.92u as=0.3808p ps=2.92u w=1.12u l=0.13u
X595 VDD a_10083_1842# a_10517_1842# VDD sg13_lv_pmos ad=0.2128p pd=1.5u as=0.3808p ps=2.92u w=1.12u l=0.13u
X596 VSS.t156 a_3747_1047.t2 a_27991_1008# VSS.t155 sg13_lv_nmos ad=0.2516p pd=2.16u as=0.2516p ps=2.16u w=0.74u l=0.13u
X597 VSS.t190 a_26043_1842# a_26477_1842# VSS.t403 sg13_lv_nmos ad=0.1406p pd=1.12u as=0.2516p ps=2.16u w=0.74u l=0.13u
X598 a_11195_1044# a_10985_1044# VDD VDD sg13_lv_pmos ad=0.2128p pd=1.5u as=0.252p ps=1.57u w=1.12u l=0.13u
X599 VSS.t123 a_3747_1047.t9 a_6711_1008# VSS.t122 sg13_lv_nmos ad=0.2516p pd=2.16u as=0.2516p ps=2.16u w=0.74u l=0.13u
X600 a_16108_289# a_2595_311.t2 a_19550_1044# VSS.t133 sg13_lv_nmos ad=0.2516p pd=2.16u as=0.2516p ps=2.16u w=0.74u l=0.13u
X601 VSS.t479 DELAY_VBIASN.t10 a_20071_1842# VSS.t478 sg13_lv_nmos ad=0.2516p pd=2.16u as=0.1406p ps=1.12u w=0.74u l=0.6u
X602 VDD DELAY_VBIASP.t4 a_24631_2470# VDD sg13_lv_pmos ad=0.3808p pd=2.92u as=0.2128p ps=1.5u w=1.12u l=0.6u
X603 a_22590_1044# a_23431_1008# a_23355_1044# VDD sg13_lv_pmos ad=0.3808p pd=2.92u as=0.2128p ps=1.5u w=1.12u l=0.13u
X604 VSS.t317 VDD VSS.t315 VSS.t316 sg13_lv_nmos ad=79.8f pd=0.8u as=0 ps=0 w=0.42u l=1u
X605 a_8671_1842# a_8433_1842# a_8563_1842# VSS.t90 sg13_lv_nmos ad=0.1406p pd=1.12u as=0.2516p ps=2.16u w=0.74u l=0.2u
X606 a_17553_1842# a_17357_1842# VSS.t11 VSS.t10 sg13_lv_nmos ad=0.2516p pd=2.16u as=0.1406p ps=1.12u w=0.74u l=0.13u
X607 a_5731_289# a_5705_519# a_4350_1044# VDD sg13_lv_pmos ad=0.3808p pd=2.92u as=0.3808p ps=2.92u w=1.12u l=0.13u
X608 VDD VDD VDD VDD sg13_lv_pmos ad=0.3808p pd=2.92u as=0 ps=0 w=1.12u l=0.13u
X609 a_26911_2470# a_26673_1842# a_26803_1842# VDD sg13_lv_pmos ad=0.2128p pd=1.5u as=0.3808p ps=2.92u w=1.12u l=0.2u
X610 a_7390_1044# a_2019_1047.t8 a_7288_1044# VSS.t555 sg13_lv_nmos ad=0.2516p pd=2.16u as=0.1406p ps=1.12u w=0.74u l=0.13u
X611 a_21353_1842# a_21157_1842# VSS.t86 VSS.t535 sg13_lv_nmos ad=0.2516p pd=2.16u as=0.1406p ps=1.12u w=0.74u l=0.13u
X612 VSS.t411 a_7043_1842# a_7477_1842# VSS.t485 sg13_lv_nmos ad=0.1406p pd=1.12u as=0.2516p ps=2.16u w=0.74u l=0.13u
X613 VDD DELAY_VBIASP.t16 a_15511_2470# VDD sg13_lv_pmos ad=0.3808p pd=2.92u as=0.2128p ps=1.5u w=1.12u l=0.6u
X614 VDD a_2019_1047.t7 a_10404_1008# VDD sg13_lv_pmos ad=0.3808p pd=2.92u as=0.3808p ps=2.92u w=1.12u l=0.13u
X615 VDD a_25283_1842# a_25717_1842# VDD sg13_lv_pmos ad=0.2128p pd=1.5u as=0.3808p ps=2.92u w=1.12u l=0.13u
X616 VDD DELAY_VBIASP.t29 a_5631_2470# VDD sg13_lv_pmos ad=0.3808p pd=2.92u as=0.2128p ps=1.5u w=1.12u l=0.6u
X617 a_26395_1044# a_26185_1044# VDD VDD sg13_lv_pmos ad=0.2128p pd=1.5u as=0.252p ps=1.57u w=1.12u l=0.13u
X618 VDD a_3747_1047.t3 a_24951_1008# VDD sg13_lv_pmos ad=0.3808p pd=2.92u as=0.3808p ps=2.92u w=1.12u l=0.13u
X619 VDD VSS.t571 VDD VDD sg13_lv_pmos ad=0.19p pd=1.38u as=0 ps=0 w=1u l=1u
X620 a_13991_1842# a_13753_1842# a_13883_1842# VSS.t402 sg13_lv_nmos ad=0.1406p pd=1.12u as=0.2516p ps=2.16u w=0.74u l=0.2u
X621 a_24008_1044# a_23437_1842# VDD VDD sg13_lv_pmos ad=0.2128p pd=1.5u as=0.3808p ps=2.92u w=1.12u l=0.13u
X622 VDD VSS.t585 VDD VDD sg13_lv_pmos ad=0.19p pd=1.38u as=0 ps=0 w=1u l=1u
X623 VSS.t270 a_2019_1047.t4 a_19524_1008# VSS.t269 sg13_lv_nmos ad=0.2516p pd=2.16u as=0.2516p ps=2.16u w=0.74u l=0.13u
X624 a_7911_2470# a_7673_1842# a_7803_1842# VDD sg13_lv_pmos ad=0.2128p pd=1.5u as=0.3808p ps=2.92u w=1.12u l=0.2u
X625 a_16793_1842# a_16597_1842# VDD VDD sg13_lv_pmos ad=0.3808p pd=2.92u as=0.2128p ps=1.5u w=1.12u l=0.13u
X626 VSS.t78 MUX_SEL1 a_3543_1395# VSS.t515 sg13_lv_nmos ad=0.1331p pd=1.12u as=0.1216p ps=1.02u w=0.64u l=0.13u
X627 a_15755_1044# a_15545_1044# VSS.t235 VSS.t234 sg13_lv_nmos ad=0.1406p pd=1.12u as=0.1665p ps=1.19u w=0.74u l=0.13u
X628 a_2595_1047.t1 a_2297_1395# VDD VDD sg13_lv_pmos ad=0.2128p pd=1.5u as=0.1918p ps=1.5u w=1.12u l=0.13u
X629 VSS.t144 a_2595_1047.t6 a_14311_1008# VSS.t143 sg13_lv_nmos ad=0.2516p pd=2.16u as=0.2516p ps=2.16u w=0.74u l=0.13u
X630 VSS.t108 a_12363_1842# a_12797_1842# VSS.t120 sg13_lv_nmos ad=0.1406p pd=1.12u as=0.2516p ps=2.16u w=0.74u l=0.13u
X631 a_5115_1044# a_4905_1044# VSS.t29 VSS.t28 sg13_lv_nmos ad=0.1406p pd=1.12u as=0.1665p ps=1.19u w=0.74u l=0.13u
X632 a_1256_1044# MUX_SEL0 VDD VDD sg13_lv_pmos ad=0.3808p pd=2.92u as=0.3808p ps=2.92u w=1.12u l=0.13u
X633 VDD a_27563_1842# a_27997_1842# VDD sg13_lv_pmos ad=0.2128p pd=1.5u as=0.3808p ps=2.92u w=1.12u l=0.13u
X634 a_20593_1842# a_20397_1842# VDD VDD sg13_lv_pmos ad=0.3808p pd=2.92u as=0.2128p ps=1.5u w=1.12u l=0.13u
X635 a_1721_1395# a_1256_1044# VDD VDD sg13_lv_pmos ad=0.1596p pd=1.22u as=0.2856p ps=2.36u w=0.84u l=0.13u
X636 VDD a_6283_1842# a_6717_1842# VDD sg13_lv_pmos ad=0.2128p pd=1.5u as=0.3808p ps=2.92u w=1.12u l=0.13u
X637 a_13470_1044# a_14964_1008# a_14888_1044# VDD sg13_lv_pmos ad=0.3808p pd=2.92u as=0.2128p ps=1.5u w=1.12u l=0.13u
X638 VSS.t335 VDD VSS.t334 VSS.t333 sg13_lv_nmos ad=0.1428p pd=1.52u as=0 ps=0 w=0.42u l=1u
X639 VDD a_2019_1047.t2 a_25604_1008# VDD sg13_lv_pmos ad=0.3808p pd=2.92u as=0.3808p ps=2.92u w=1.12u l=0.13u
X640 a_16271_1842# a_16033_1842# a_16163_1842# VSS.t75 sg13_lv_nmos ad=0.1406p pd=1.12u as=0.2516p ps=2.16u w=0.74u l=0.2u
X641 a_21835_1044# a_21625_1044# VDD VDD sg13_lv_pmos ad=0.2128p pd=1.5u as=0.252p ps=1.57u w=1.12u l=0.13u
X642 VDD VSS.t596 VDD VDD sg13_lv_pmos ad=0.34p pd=2.68u as=0 ps=0 w=1u l=1u
X643 VDD a_2595_1047.t4 a_20391_1008# VDD sg13_lv_pmos ad=0.3808p pd=2.92u as=0.3808p ps=2.92u w=1.12u l=0.13u
X644 a_19073_1842# a_18877_1842# VDD VDD sg13_lv_pmos ad=0.3808p pd=2.92u as=0.2128p ps=1.5u w=1.12u l=0.13u
X645 VDD a_10517_1842# a_10985_1044# VDD sg13_lv_pmos ad=0.252p pd=1.57u as=0.3808p ps=2.92u w=1.12u l=0.13u
X646 VSS.t244 a_21157_1842# a_21625_1044# VSS.t536 sg13_lv_nmos ad=0.1665p pd=1.19u as=0.2516p ps=2.16u w=0.74u l=0.13u
X647 a_20071_1842# a_19833_1842# a_19963_1842# VSS.t43 sg13_lv_nmos ad=0.1406p pd=1.12u as=0.2516p ps=2.16u w=0.74u l=0.2u
X648 VSS.t398 a_14643_1842# a_15077_1842# VSS.t397 sg13_lv_nmos ad=0.1406p pd=1.12u as=0.2516p ps=2.16u w=0.74u l=0.13u
X649 a_1815_331# a_1256_289# a_1721_331# VSS.t35 sg13_lv_nmos ad=0.1216p pd=1.02u as=0.2176p ps=1.96u w=0.64u l=0.13u
X650 VDD a_19203_1842# a_19637_1842# VDD sg13_lv_pmos ad=0.2128p pd=1.5u as=0.3808p ps=2.92u w=1.12u l=0.13u
X651 VSS.t95 a_2019_1047.t9 a_4324_1008# VSS.t94 sg13_lv_nmos ad=0.2516p pd=2.16u as=0.2516p ps=2.16u w=0.74u l=0.13u
X652 a_16108_289# a_20905_519# a_19550_1044# VDD sg13_lv_pmos ad=0.3808p pd=2.92u as=0.3808p ps=2.92u w=1.12u l=0.13u
X653 a_16510_1044# a_3747_1047.t5 a_18795_1044# VSS.t231 sg13_lv_nmos ad=0.2516p pd=2.16u as=0.1406p ps=1.12u w=0.74u l=0.13u
X654 VDD a_8563_1842# a_8997_1842# VDD sg13_lv_pmos ad=0.2128p pd=1.5u as=0.3808p ps=2.92u w=1.12u l=0.13u
X655 VDD DELAY_VBIASP.t19 a_13231_2470# VDD sg13_lv_pmos ad=0.3808p pd=2.92u as=0.2128p ps=1.5u w=1.12u l=0.6u
X656 VSS.t471 DELAY_VBIASN.t13 a_17791_1842# VSS.t470 sg13_lv_nmos ad=0.2516p pd=2.16u as=0.1406p ps=1.12u w=0.74u l=0.6u
X657 VSS.t305 VDD VSS.t304 VSS.t303 sg13_lv_nmos ad=0.1428p pd=1.52u as=0 ps=0 w=0.42u l=1u
X658 VDD a_3747_1047.t5 a_18871_1008# VDD sg13_lv_pmos ad=0.3808p pd=2.92u as=0.3808p ps=2.92u w=1.12u l=0.13u
X659 VDD a_23003_1842# a_23437_1842# VDD sg13_lv_pmos ad=0.2128p pd=1.5u as=0.3808p ps=2.92u w=1.12u l=0.13u
X660 a_12715_1044# a_12505_1044# VDD VDD sg13_lv_pmos ad=0.2128p pd=1.5u as=0.252p ps=1.57u w=1.12u l=0.13u
X661 a_19550_1044# a_21044_1008# a_20968_1044# VDD sg13_lv_pmos ad=0.3808p pd=2.92u as=0.2128p ps=1.5u w=1.12u l=0.13u
X662 a_17928_1044# a_17357_1842# VDD VDD sg13_lv_pmos ad=0.2128p pd=1.5u as=0.3808p ps=2.92u w=1.12u l=0.13u
X663 VSS.t451 DELAY_VBIASN.t8 a_21591_1842# VSS.t450 sg13_lv_nmos ad=0.2516p pd=2.16u as=0.1406p ps=1.12u w=0.74u l=0.6u
X664 VSS.t58 a_1544_289# a_1815_331# VSS.t57 sg13_lv_nmos ad=0.1331p pd=1.12u as=0.1216p ps=1.02u w=0.64u l=0.13u
X665 a_7288_1044# a_6717_1842# VDD VDD sg13_lv_pmos ad=0.2128p pd=1.5u as=0.3808p ps=2.92u w=1.12u l=0.13u
X666 a_15511_2470# a_15273_1842# a_15403_1842# VDD sg13_lv_pmos ad=0.2128p pd=1.5u as=0.3808p ps=2.92u w=1.12u l=0.2u
X667 VSS.t254 VSS.t256 VSS.t258 VSS.t257 sg13_lv_nmos ad=0.1406p pd=1.12u as=0 ps=0 w=0.74u l=0.2u
X668 a_22590_1044# a_24951_1008# a_24875_1044# VDD sg13_lv_pmos ad=0.3808p pd=2.92u as=0.2128p ps=1.5u w=1.12u l=0.13u
X669 VSS.t377 VDD VSS.t375 VSS.t376 sg13_lv_nmos ad=79.8f pd=0.8u as=0 ps=0 w=0.42u l=1u
X670 a_10430_1044# a_2019_1047.t7 a_10328_1044# VSS.t271 sg13_lv_nmos ad=0.2516p pd=2.16u as=0.1406p ps=1.12u w=0.74u l=0.13u
X671 VDD a_25717_1842# a_26185_1044# VDD sg13_lv_pmos ad=0.252p pd=1.57u as=0.3808p ps=2.92u w=1.12u l=0.13u
X672 VDD a_13883_1842# a_14317_1842# VDD sg13_lv_pmos ad=0.2128p pd=1.5u as=0.3808p ps=2.92u w=1.12u l=0.13u
X673 VDD a_4437_1842# a_4905_1044# VDD sg13_lv_pmos ad=0.252p pd=1.57u as=0.3808p ps=2.92u w=1.12u l=0.13u
X674 a_4157_1313# DELAY_IN VSS.t287 VSS.t286 sg13_lv_nmos ad=0.2516p pd=2.16u as=0.2553p ps=2.17u w=0.74u l=0.13u
X675 a_7390_1044# a_3171_1047.t8 a_8808_1044# VSS.t136 sg13_lv_nmos ad=0.2516p pd=2.16u as=0.1406p ps=1.12u w=0.74u l=0.13u
X676 a_22873_1842# a_22677_1842# VSS.t383 VSS.t495 sg13_lv_nmos ad=0.2516p pd=2.16u as=0.1406p ps=1.12u w=0.74u l=0.13u
X677 VDD a_3171_1047.t8 a_8884_1008# VDD sg13_lv_pmos ad=0.3808p pd=2.92u as=0.3808p ps=2.92u w=1.12u l=0.13u
C0 a_16510_1044# VDD 0.8795f
C1 a_19550_1044# a_19524_1008# 0.277f
C2 VDD a_19963_1842# 0.4973f
C3 MUX_OUT a_16108_289# 0.24265f
C4 a_11603_1842# VDD 0.49671f
C5 VDD a_20905_519# 0.29292f
C6 MUX_SEL3 MUX_OUT 0.79533f
C7 a_10430_1044# a_10404_1008# 0.277f
C8 a_22873_1842# DELAY_VBIASP 0.11222f
C9 a_22677_1842# DELAY_VBIASN 0.08375f
C10 a_4157_1313# a_4248_1044# 0.11672f
C11 DELAY_VBIASN a_18117_1842# 0.09156f
C12 a_11277_1842# a_11473_1842# 0.76914f
C13 a_1721_331# a_2019_311# 0.18452f
C14 a_15273_1842# DELAY_VBIASP 0.11222f
C15 a_15077_1842# DELAY_VBIASN 0.09156f
C16 a_22677_1842# a_23437_1842# 0.01669f
C17 a_24957_1842# a_25604_1008# 0.02011f
C18 a_10713_1842# VDD 0.49294f
C19 a_9193_1842# DELAY_VBIASN 0.0961f
C20 a_9323_1842# DELAY_VBIASP 0.06627f
C21 a_4763_1842# a_4871_1842# 0.01163f
C22 DELAY_VBIASP a_16597_1842# 0.0414f
C23 a_9757_1842# a_10404_1008# 0.02011f
C24 a_19311_1842# a_19203_1842# 0.01163f
C25 a_15077_1842# a_15837_1842# 0.02912f
C26 a_26673_1842# a_26803_1842# 0.70845f
C27 a_9465_1044# a_8997_1842# 0.2079f
C28 a_13368_1044# a_12797_1842# 0.10864f
C29 VDD a_26043_1842# 0.4973f
C30 a_20105_1044# a_20391_1008# 0.01885f
C31 a_1256_289# a_1544_289# 1.25711f
C32 DELAY_VBIASP a_18877_1842# 0.0414f
C33 a_20391_1008# VDD 0.28336f
C34 a_23355_1044# a_23145_1044# 0.09424f
C35 a_17357_1842# a_16923_1842# 0.6972f
C36 VDD a_7151_2470# 0.01806f
C37 a_20397_1842# a_19833_1842# 0.0114f
C38 a_25630_1044# DELAY_VBIASP 0.01522f
C39 a_16510_1044# a_18585_1044# 0.03208f
C40 a_23355_1044# a_22590_1044# 0.39037f
C41 a_9757_1842# a_9323_1842# 0.6972f
C42 VDD a_7364_1008# 0.28633f
C43 a_21911_1008# a_21917_1842# 0.02354f
C44 a_5523_1842# VDD 0.49671f
C45 a_6283_1842# VDD 0.4973f
C46 a_7945_1044# a_8231_1008# 0.01885f
C47 a_19637_1842# a_19203_1842# 0.69698f
C48 a_27048_1044# a_27124_1008# 0.01176f
C49 a_16510_1044# DELAY_VBIASN 0.02115f
C50 DELAY_VBIASN a_19963_1842# 0.07254f
C51 a_7477_1842# a_7945_1044# 0.19203f
C52 DELAY_VBIASP a_21157_1842# 0.04141f
C53 a_12797_1842# DELAY_VBIASP 0.0414f
C54 a_11603_1842# DELAY_VBIASN 0.07254f
C55 a_19550_1044# a_21157_1842# 0.05231f
C56 a_16271_2470# VDD 0.01806f
C57 a_12797_1842# a_10430_1044# 0.02479f
C58 a_8433_1842# a_8997_1842# 0.0114f
C59 a_7390_1044# a_9675_1044# 0.39036f
C60 a_21625_1044# VDD 0.29722f
C61 a_12505_1044# a_12037_1842# 0.2079f
C62 a_9751_1008# a_7390_1044# 0.26208f
C63 a_7477_1842# a_6717_1842# 0.06198f
C64 a_8237_1842# a_7390_1044# 0.08038f
C65 a_18313_1842# a_18877_1842# 0.0114f
C66 a_8563_1842# a_8671_1842# 0.01163f
C67 a_20831_2470# a_20723_1842# 0.01697f
C68 a_6913_1842# a_7043_1842# 0.70845f
C69 a_12505_1044# VDD 0.29722f
C70 a_22488_1044# VDD 0.17274f
C71 a_10713_1842# DELAY_VBIASN 0.0961f
C72 a_10843_1842# DELAY_VBIASP 0.06627f
C73 a_25604_1008# a_25528_1044# 0.01176f
C74 a_24197_1842# a_23763_1842# 0.6972f
C75 a_15765_463# a_2019_311# 0.05969f
C76 a_2873_1395# VDD 0.46517f
C77 a_4350_1044# a_5768_1044# 0.38994f
C78 MUX_OUT a_2297_331# 0.01179f
C79 MUX_SEL3 a_3449_331# 0.28429f
C80 MUX_SEL4 a_2873_331# 0.04916f
C81 a_10843_1842# a_10430_1044# 0.01012f
C82 a_5197_1842# a_5523_1842# 0.01427f
C83 MUX_SEL1 DELAY_IN 0.01858f
C84 a_25528_1044# a_25630_1044# 0.37183f
C85 a_16484_1008# a_16597_1842# 0.05157f
C86 VDD a_5705_519# 0.29556f
C87 DELAY_VBIASP a_27237_1842# 0.06189f
C88 DELAY_VBIASN a_26043_1842# 0.07254f
C89 a_18871_1008# VDD 0.2822f
C90 a_10191_2470# VDD 0.01806f
C91 a_25717_1842# a_25913_1842# 0.73897f
C92 a_16510_1044# a_18443_1842# 0.01012f
C93 a_26985_519# a_16108_289# 0.2906f
C94 a_25391_2470# VDD 0.01806f
C95 a_20315_1044# a_20391_1008# 0.01194f
C96 VDD a_17553_1842# 0.49417f
C97 MUX_SEL0 DELAY_IN 0.14089f
C98 a_4905_1044# a_5191_1008# 0.01885f
C99 a_24008_1044# a_24084_1008# 0.01176f
C100 a_21917_1842# a_21483_1842# 0.6972f
C101 a_14513_1842# VDD 0.49417f
C102 a_20071_2470# VDD 0.01806f
C103 a_13557_1842# a_13123_1842# 0.69698f
C104 a_5523_1842# DELAY_VBIASN 0.07254f
C105 a_13470_1044# a_14025_1044# 0.03209f
C106 a_6717_1842# DELAY_VBIASP 0.0414f
C107 VDD a_19833_1842# 0.49294f
C108 a_24393_1842# a_24523_1842# 0.70845f
C109 a_4437_1842# DELAY_IN 0.05007f
C110 a_27915_1044# VDD 0.15389f
C111 a_6283_1842# DELAY_VBIASN 0.07254f
C112 a_7477_1842# DELAY_VBIASP 0.0414f
C113 a_8563_1842# VDD 0.49671f
C114 a_16510_1044# a_17351_1008# 0.28268f
C115 a_24523_1842# a_22590_1044# 0.01012f
C116 a_4905_1044# VDD 0.30126f
C117 a_20593_1842# a_21157_1842# 0.0114f
C118 a_5768_1044# a_5844_1008# 0.01176f
C119 a_12233_1842# a_12797_1842# 0.0114f
C120 a_5731_289# a_16108_289# 0.01334f
C121 a_24957_1842# DELAY_VBIASP 0.0414f
C122 a_13991_2470# VDD 0.01806f
C123 a_24875_1044# VDD 0.15406f
C124 a_13470_1044# a_15077_1842# 0.05231f
C125 a_15755_1044# a_15831_1008# 0.01194f
C126 a_13753_1842# VDD 0.49294f
C127 VDD a_8745_519# 0.29292f
C128 a_8237_1842# a_8997_1842# 0.03319f
C129 a_4763_1842# a_4350_1044# 0.01012f
C130 a_14317_1842# a_15077_1842# 0.03319f
C131 a_18871_1008# a_18585_1044# 0.01885f
C132 a_10985_1044# a_11271_1008# 0.01885f
C133 a_11603_1842# a_11473_1842# 0.70845f
C134 VDD a_6635_1044# 0.15406f
C135 a_27915_1044# a_27705_1044# 0.09424f
C136 a_1721_1395# VDD 0.4533f
C137 a_16108_289# a_16851_309# 0.06181f
C138 a_16408_1044# VDD 0.17274f
C139 a_16271_2470# a_16163_1842# 0.01697f
C140 MUX_OUT a_15964_289# 0.01307f
C141 MUX_SEL4 a_16108_289# 0.1283f
C142 a_19448_1044# a_19524_1008# 0.01176f
C143 VDD a_17865_519# 0.29444f
C144 MUX_SEL2 MUX_OUT 0.08497f
C145 MUX_SEL3 MUX_SEL4 0.75489f
C146 a_17357_1842# a_17683_1842# 0.01427f
C147 a_10328_1044# a_10404_1008# 0.01176f
C148 a_22243_1842# DELAY_VBIASP 0.06627f
C149 a_12471_1842# a_12363_1842# 0.01163f
C150 DELAY_VBIASN a_17553_1842# 0.0961f
C151 MUX_OUT VDD 0.35871f
C152 a_11277_1842# a_10843_1842# 0.6972f
C153 a_25913_1842# a_26477_1842# 0.0114f
C154 a_1544_289# a_2019_311# 0.01747f
C155 a_27997_1842# a_27563_1842# 0.69646f
C156 a_14513_1842# DELAY_VBIASN 0.0961f
C157 a_14643_1842# DELAY_VBIASP 0.06627f
C158 a_22677_1842# a_22873_1842# 0.73897f
C159 DELAY_VBIASN a_19833_1842# 0.0961f
C160 a_10083_1842# VDD 0.49727f
C161 a_24957_1842# a_25528_1044# 0.10864f
C162 a_9757_1842# DELAY_VBIASP 0.0414f
C163 a_8563_1842# DELAY_VBIASN 0.07254f
C164 a_7288_1044# a_7364_1008# 0.01176f
C165 a_18004_1008# a_17357_1842# 0.02312f
C166 a_26673_1842# a_27237_1842# 0.0114f
C167 a_15077_1842# a_15273_1842# 0.77122f
C168 a_12791_1008# a_12797_1842# 0.02354f
C169 DELAY_VBIASP a_18313_1842# 0.11222f
C170 a_19448_1044# a_18877_1842# 0.10864f
C171 a_16793_1842# a_16923_1842# 0.70845f
C172 VDD a_6391_2470# 0.01806f
C173 a_14888_1044# VDD 0.17499f
C174 a_13753_1842# DELAY_VBIASN 0.0961f
C175 a_18117_1842# a_18877_1842# 0.02912f
C176 a_16510_1044# a_17065_1044# 0.03209f
C177 a_9193_1842# a_9323_1842# 0.70845f
C178 VDD a_7390_1044# 0.8686f
C179 a_5957_1842# VDD 0.85848f
C180 a_25913_1842# VDD 0.49294f
C181 a_7945_1044# a_8155_1044# 0.09424f
C182 a_20831_1842# a_20723_1842# 0.01163f
C183 a_19073_1842# a_19203_1842# 0.70845f
C184 a_8237_1842# a_7803_1842# 0.6972f
C185 DELAY_VBIASP a_20593_1842# 0.11222f
C186 VDD a_16033_1842# 0.49413f
C187 a_12233_1842# DELAY_VBIASP 0.11222f
C188 a_7043_1842# a_7151_2470# 0.01697f
C189 a_27991_1008# a_25630_1044# 0.26208f
C190 a_12037_1842# a_11924_1008# 0.02055f
C191 a_8155_1044# a_8231_1008# 0.01194f
C192 a_7390_1044# a_8884_1008# 0.28279f
C193 a_6153_1842# a_6717_1842# 0.0114f
C194 a_27124_1008# a_26477_1842# 0.02312f
C195 a_14235_1044# a_14311_1008# 0.01194f
C196 a_6913_1842# a_6717_1842# 0.76914f
C197 a_16408_1044# a_15837_1842# 0.10864f
C198 a_6913_1842# a_7477_1842# 0.0114f
C199 a_11924_1008# VDD 0.28225f
C200 a_2873_1395# MUX_SEL1 0.13092f
C201 a_21911_1008# VDD 0.2822f
C202 a_10985_1044# VDD 0.30409f
C203 a_10083_1842# DELAY_VBIASN 0.07254f
C204 a_11277_1842# DELAY_VBIASP 0.0414f
C205 a_23633_1842# a_23763_1842# 0.70845f
C206 a_24197_1842# VDD 0.85848f
C207 a_4350_1044# a_5191_1008# 0.28268f
C208 MUX_SEL4 a_2297_331# 0.04338f
C209 MUX_SEL3 a_2873_331# 0.12606f
C210 MUX_SEL2 a_3449_331# 0.10741f
C211 a_11277_1842# a_10430_1044# 0.08038f
C212 a_5197_1842# a_5957_1842# 0.03319f
C213 a_16510_1044# a_16597_1842# 0.1088f
C214 a_10430_1044# a_11785_519# 0.02058f
C215 VDD a_3449_331# 0.46596f
C216 DELAY_VBIASP a_26673_1842# 0.11222f
C217 a_18795_1044# VDD 0.15406f
C218 a_2873_1395# MUX_SEL0 0.01504f
C219 a_25717_1842# a_25283_1842# 0.69698f
C220 a_16510_1044# a_18877_1842# 0.02479f
C221 a_9465_1044# a_9675_1044# 0.09424f
C222 a_23763_1842# a_23871_2470# 0.01697f
C223 a_23945_519# a_16108_289# 0.2906f
C224 a_24631_2470# VDD 0.01806f
C225 VDD a_16923_1842# 0.4973f
C226 a_9465_1044# a_9751_1008# 0.01885f
C227 a_4905_1044# a_5115_1044# 0.09424f
C228 VDD a_4350_1044# 0.87635f
C229 a_9953_1842# a_10083_1842# 0.70845f
C230 a_19311_2470# VDD 0.01806f
C231 a_13883_1842# VDD 0.4973f
C232 a_21353_1842# a_21483_1842# 0.70845f
C233 a_26985_519# VDD 0.29292f
C234 DELAY_VBIASN a_7390_1044# 0.02115f
C235 a_6153_1842# DELAY_VBIASP 0.11222f
C236 a_5957_1842# DELAY_VBIASN 0.09156f
C237 a_12993_1842# a_13123_1842# 0.70845f
C238 VDD a_19203_1842# 0.49737f
C239 a_27124_1008# VDD 0.28225f
C240 a_24393_1842# a_24957_1842# 0.0114f
C241 a_25913_1842# DELAY_VBIASN 0.0961f
C242 a_6913_1842# DELAY_VBIASP 0.11222f
C243 a_8997_1842# VDD 0.85848f
C244 a_24665_1044# a_22590_1044# 0.03208f
C245 DELAY_VBIASN a_16033_1842# 0.0961f
C246 a_16510_1044# a_17275_1044# 0.39037f
C247 a_24957_1842# a_22590_1044# 0.02479f
C248 a_4157_1313# VDD 0.48935f
C249 a_12791_1008# a_10430_1044# 0.26208f
C250 a_22243_1842# a_22351_2470# 0.01697f
C251 a_22590_1044# a_22564_1008# 0.277f
C252 a_21917_1842# a_16108_289# 0.0157f
C253 a_5731_289# a_15964_289# 0.2778f
C254 a_24393_1842# DELAY_VBIASP 0.11222f
C255 a_16271_1842# a_16163_1842# 0.01163f
C256 a_8997_1842# a_8884_1008# 0.02055f
C257 a_13231_2470# VDD 0.01806f
C258 a_25630_1044# a_26043_1842# 0.01012f
C259 a_24084_1008# VDD 0.28225f
C260 a_15837_1842# a_16033_1842# 0.76914f
C261 a_13123_1842# VDD 0.49727f
C262 VDD a_21483_1842# 0.4973f
C263 a_8237_1842# a_8433_1842# 0.76914f
C264 a_5197_1842# a_4350_1044# 0.08038f
C265 VDD a_5731_289# 0.6143f
C266 a_14317_1842# a_14513_1842# 0.76914f
C267 a_24197_1842# DELAY_VBIASN 0.09156f
C268 a_18795_1044# a_18585_1044# 0.09424f
C269 a_10985_1044# a_11195_1044# 0.09424f
C270 VDD a_5844_1008# 0.28225f
C271 a_4437_1842# a_4905_1044# 0.19203f
C272 a_22677_1842# a_22564_1008# 0.05157f
C273 a_16033_1842# a_16163_1842# 0.70845f
C274 DELAY_IN DELAY_VBIASP 0.07719f
C275 a_15964_289# a_16851_309# 0.16757f
C276 a_1544_1044# VDD 0.45079f
C277 a_23437_1842# a_24197_1842# 0.03319f
C278 a_15831_1008# VDD 0.2816f
C279 MUX_SEL4 a_15964_289# 0.5544f
C280 a_19448_1044# a_19550_1044# 0.37183f
C281 a_15545_1044# a_15077_1842# 0.2079f
C282 MUX_SEL1 MUX_OUT 0.09357f
C283 MUX_SEL2 MUX_SEL4 0.01978f
C284 VDD a_16851_309# 0.51536f
C285 a_22677_1842# DELAY_VBIASP 0.0414f
C286 a_2873_1395# a_1256_1044# 0.28892f
C287 a_10328_1044# a_10430_1044# 0.37183f
C288 DELAY_VBIASP a_18117_1842# 0.04141f
C289 DELAY_VBIASN a_16923_1842# 0.07254f
C290 MUX_SEL4 VDD 2.63176f
C291 a_17791_2470# a_17683_1842# 0.01697f
C292 DELAY_VBIASN a_4350_1044# 0.02115f
C293 a_10713_1842# a_10843_1842# 0.70845f
C294 a_6717_1842# a_6711_1008# 0.02354f
C295 a_22113_1842# a_21917_1842# 0.76914f
C296 a_1721_1395# MUX_SEL0 0.01315f
C297 VDD a_27563_1842# 0.49811f
C298 a_27433_1842# a_27563_1842# 0.70845f
C299 a_13883_1842# DELAY_VBIASN 0.07254f
C300 a_15077_1842# DELAY_VBIASP 0.04141f
C301 a_22677_1842# a_22243_1842# 0.69698f
C302 DELAY_VBIASN a_19203_1842# 0.07254f
C303 a_1256_289# a_2019_311# 0.02904f
C304 a_13753_1842# a_14317_1842# 0.0114f
C305 a_17928_1044# a_16510_1044# 0.38994f
C306 a_24951_1008# a_24665_1044# 0.01885f
C307 a_10517_1842# VDD 0.86707f
C308 a_9193_1842# DELAY_VBIASP 0.11222f
C309 a_8997_1842# DELAY_VBIASN 0.09156f
C310 a_24957_1842# a_24951_1008# 0.02354f
C311 a_7288_1044# a_7390_1044# 0.37183f
C312 a_9757_1842# a_10328_1044# 0.10864f
C313 a_5197_1842# a_5844_1008# 0.02312f
C314 a_15077_1842# a_14643_1842# 0.6972f
C315 a_4157_1313# DELAY_VBIASN 0.01202f
C316 a_14964_1008# a_15077_1842# 0.02055f
C317 a_7803_1842# VDD 0.4973f
C318 a_18871_1008# a_18877_1842# 0.02354f
C319 a_16793_1842# a_17357_1842# 0.0114f
C320 a_21625_1044# a_21157_1842# 0.2079f
C321 VDD a_5631_2470# 0.01806f
C322 a_20397_1842# a_19637_1842# 0.01669f
C323 a_14311_1008# VDD 0.28336f
C324 a_17031_2470# a_16923_1842# 0.01697f
C325 DELAY_VBIASN a_21483_1842# 0.07254f
C326 a_13123_1842# DELAY_VBIASN 0.07254f
C327 a_9193_1842# a_9757_1842# 0.0114f
C328 a_18117_1842# a_18313_1842# 0.77122f
C329 a_5393_1842# VDD 0.49417f
C330 a_23437_1842# a_24084_1008# 0.02312f
C331 a_4248_1044# VDD 0.17587f
C332 a_9751_1008# a_9675_1044# 0.01194f
C333 a_25283_1842# VDD 0.49737f
C334 a_19073_1842# a_19637_1842# 0.0114f
C335 a_14751_2470# a_14643_1842# 0.01697f
C336 a_7673_1842# a_7803_1842# 0.70845f
C337 DELAY_VBIASP a_19963_1842# 0.06627f
C338 a_11603_1842# DELAY_VBIASP 0.06627f
C339 a_27915_1044# a_25630_1044# 0.39036f
C340 a_19550_1044# a_19963_1842# 0.01012f
C341 a_7390_1044# a_8808_1044# 0.38994f
C342 a_19550_1044# a_20905_519# 0.02165f
C343 a_6717_1842# a_7364_1008# 0.02011f
C344 a_27048_1044# a_26477_1842# 0.10863f
C345 VDD a_17683_1842# 0.49671f
C346 a_4633_1842# a_4763_1842# 0.70845f
C347 a_13470_1044# a_14888_1044# 0.38994f
C348 DELAY_VBIASN a_27563_1842# 0.07259f
C349 a_7477_1842# a_7364_1008# 0.05157f
C350 a_6283_1842# a_6717_1842# 0.6972f
C351 a_15831_1008# a_15837_1842# 0.02354f
C352 a_1256_1044# a_1721_1395# 0.13421f
C353 a_4763_1842# a_4871_2470# 0.01697f
C354 a_14888_1044# a_14317_1842# 0.10863f
C355 a_11848_1044# VDD 0.17499f
C356 a_10517_1842# DELAY_VBIASN 0.08375f
C357 a_21835_1044# VDD 0.15406f
C358 a_9465_1044# VDD 0.29722f
C359 a_10713_1842# DELAY_VBIASP 0.11222f
C360 a_23633_1842# VDD 0.49417f
C361 a_4350_1044# a_5115_1044# 0.39037f
C362 a_25391_1842# a_25283_1842# 0.01163f
C363 MUX_SEL3 a_2297_331# 0.01595f
C364 MUX_SEL4 a_1721_331# 0.05813f
C365 MUX_SEL2 a_2873_331# 0.01422f
C366 MUX_OUT a_1544_289# 0.69943f
C367 a_5197_1842# a_5393_1842# 0.76914f
C368 a_1256_1044# MUX_OUT 0.02466f
C369 VDD a_2873_331# 0.46491f
C370 DELAY_VBIASP a_26043_1842# 0.06627f
C371 a_18004_1008# VDD 0.28225f
C372 a_25153_1842# a_25283_1842# 0.70845f
C373 a_7803_1842# DELAY_VBIASN 0.07254f
C374 a_19550_1044# a_20391_1008# 0.28268f
C375 a_23871_2470# VDD 0.01806f
C376 VDD a_17357_1842# 0.86909f
C377 a_9953_1842# a_10517_1842# 0.0114f
C378 a_23945_519# VDD 0.29292f
C379 a_18551_2470# VDD 0.01806f
C380 a_21353_1842# a_21917_1842# 0.0114f
C381 a_20105_1044# a_19637_1842# 0.19203f
C382 a_5523_1842# DELAY_VBIASP 0.06627f
C383 a_5393_1842# DELAY_VBIASN 0.0961f
C384 a_12993_1842# a_13557_1842# 0.0114f
C385 VDD a_19637_1842# 0.86707f
C386 a_27048_1044# VDD 0.17499f
C387 a_25283_1842# DELAY_VBIASN 0.07254f
C388 a_6283_1842# DELAY_VBIASP 0.06627f
C389 a_8433_1842# VDD 0.49417f
C390 a_23145_1044# a_22590_1044# 0.03209f
C391 a_16510_1044# a_16484_1008# 0.277f
C392 a_3449_1395# VDD 0.46731f
C393 a_4437_1842# a_4350_1044# 0.1088f
C394 a_8563_1842# a_8671_2470# 0.01697f
C395 a_22488_1044# a_22564_1008# 0.01176f
C396 DELAY_VBIASN a_17683_1842# 0.07254f
C397 a_21625_1044# a_19550_1044# 0.03208f
C398 a_5731_289# a_15765_463# 0.23301f
C399 a_9323_1842# a_7390_1044# 0.01012f
C400 a_12471_2470# VDD 0.01806f
C401 a_24008_1044# VDD 0.17499f
C402 a_10191_1842# a_10083_1842# 0.01163f
C403 a_13470_1044# a_13883_1842# 0.01012f
C404 VDD a_21917_1842# 0.87825f
C405 a_13557_1842# VDD 0.86707f
C406 a_22677_1842# a_23145_1044# 0.19203f
C407 a_24523_1842# a_24631_2470# 0.01697f
C408 a_14317_1842# a_13883_1842# 0.6972f
C409 a_23633_1842# DELAY_VBIASN 0.0961f
C410 a_17791_1842# a_17683_1842# 0.01163f
C411 a_12505_1044# a_10430_1044# 0.03208f
C412 a_11603_1842# a_11277_1842# 0.01427f
C413 VDD a_5768_1044# 0.17499f
C414 a_4437_1842# a_4157_1313# 0.01771f
C415 a_1544_1044# MUX_SEL1 0.1672f
C416 a_7803_1842# a_7911_1842# 0.01163f
C417 a_22677_1842# a_22590_1044# 0.1088f
C418 a_16033_1842# a_16597_1842# 0.0114f
C419 a_15964_289# a_16108_289# 0.42202f
C420 a_15755_1044# VDD 0.15389f
C421 a_23437_1842# a_23633_1842# 0.76914f
C422 a_12715_1044# VDD 0.15406f
C423 MUX_SEL4 a_15765_463# 0.65508f
C424 MUX_SEL1 MUX_SEL4 0.03574f
C425 VDD a_16108_289# 1.25759f
C426 MUX_SEL2 MUX_SEL3 3.21891f
C427 DELAY_VBIASN a_17357_1842# 0.09974f
C428 a_21044_1008# a_20397_1842# 0.02312f
C429 DELAY_VBIASP a_17553_1842# 0.11222f
C430 MUX_SEL3 VDD 0.4053f
C431 a_10713_1842# a_11277_1842# 0.0114f
C432 a_1544_1044# MUX_SEL0 0.07603f
C433 a_25717_1842# a_26477_1842# 0.01669f
C434 a_6283_1842# a_6391_1842# 0.01163f
C435 a_27433_1842# a_27997_1842# 0.0114f
C436 a_23763_1842# VDD 0.49671f
C437 a_14513_1842# DELAY_VBIASP 0.11222f
C438 VDD a_27997_1842# 0.76025f
C439 a_13444_1008# a_13557_1842# 0.05157f
C440 a_23003_1842# a_23111_2470# 0.01697f
C441 a_13470_1044# a_5731_289# 0.41365f
C442 DELAY_VBIASP a_19833_1842# 0.11222f
C443 DELAY_VBIASN a_19637_1842# 0.08375f
C444 a_24875_1044# a_24665_1044# 0.09424f
C445 a_17031_1842# a_16923_1842# 0.01163f
C446 a_8563_1842# DELAY_VBIASP 0.06627f
C447 a_8433_1842# DELAY_VBIASN 0.0961f
C448 a_13470_1044# a_15831_1008# 0.26208f
C449 a_5197_1842# a_5768_1044# 0.10863f
C450 a_14513_1842# a_14643_1842# 0.70845f
C451 a_24951_1008# a_22590_1044# 0.26208f
C452 VDD a_9675_1044# 0.15406f
C453 a_9751_1008# VDD 0.2822f
C454 a_8237_1842# VDD 0.86909f
C455 a_4633_1842# VDD 0.49285f
C456 a_13470_1044# MUX_SEL4 0.256f
C457 VDD a_4871_2470# 0.01806f
C458 a_22113_1842# VDD 0.49426f
C459 a_26911_1842# a_26803_1842# 0.01163f
C460 a_14235_1044# VDD 0.15389f
C461 DELAY_VBIASN a_21917_1842# 0.09992f
C462 a_13557_1842# DELAY_VBIASN 0.08375f
C463 a_13753_1842# DELAY_VBIASP 0.11222f
C464 a_4763_1842# VDD 0.4973f
C465 a_23437_1842# a_24008_1044# 0.10863f
C466 a_18551_2470# a_18443_1842# 0.01697f
C467 a_8237_1842# a_8884_1008# 0.02312f
C468 a_25717_1842# VDD 0.86707f
C469 a_7945_1044# a_7390_1044# 0.03209f
C470 a_16510_1044# a_2019_311# 0.03139f
C471 a_18877_1842# a_19203_1842# 0.01427f
C472 a_25630_1044# a_26985_519# 0.02165f
C473 a_7673_1842# a_8237_1842# 0.0114f
C474 a_27124_1008# a_25630_1044# 0.28279f
C475 a_7390_1044# a_8231_1008# 0.28268f
C476 a_5957_1842# a_6717_1842# 0.02912f
C477 a_26471_1008# a_26477_1842# 0.02349f
C478 a_16510_1044# a_18117_1842# 0.05231f
C479 a_17351_1008# a_17357_1842# 0.02349f
C480 a_4633_1842# a_5197_1842# 0.0114f
C481 a_23763_1842# DELAY_VBIASN 0.07254f
C482 a_7477_1842# a_7390_1044# 0.1088f
C483 a_13470_1044# a_14311_1008# 0.28268f
C484 DELAY_VBIASN a_27997_1842# 0.04176f
C485 a_6283_1842# a_6153_1842# 0.70845f
C486 a_14311_1008# a_14317_1842# 0.02349f
C487 a_1256_1044# a_1544_1044# 1.26509f
C488 a_11271_1008# VDD 0.28336f
C489 a_10083_1842# DELAY_VBIASP 0.06627f
C490 a_21044_1008# VDD 0.28225f
C491 a_27671_2470# a_27563_1842# 0.01697f
C492 a_23437_1842# a_23763_1842# 0.01427f
C493 a_23003_1842# VDD 0.4973f
C494 a_4350_1044# a_4324_1008# 0.277f
C495 MUX_SEL2 a_2297_331# 0.10655f
C496 MUX_SEL4 a_1544_289# 0.47529f
C497 a_10517_1842# a_10404_1008# 0.05157f
C498 a_5197_1842# a_4763_1842# 0.6972f
C499 a_6425_1044# a_6711_1008# 0.01885f
C500 a_1256_1044# MUX_SEL4 0.04908f
C501 VDD a_2297_331# 0.46496f
C502 a_15403_1842# VDD 0.4973f
C503 a_1256_289# MUX_OUT 0.1134f
C504 a_15511_1842# a_15403_1842# 0.01163f
C505 a_4633_1842# DELAY_VBIASN 0.0961f
C506 a_25153_1842# a_25717_1842# 0.0114f
C507 VDD a_20397_1842# 0.86909f
C508 a_8237_1842# DELAY_VBIASN 0.09974f
C509 a_26151_2470# a_26043_1842# 0.01697f
C510 a_22113_1842# DELAY_VBIASN 0.0961f
C511 a_23111_2470# VDD 0.01806f
C512 VDD a_16793_1842# 0.49277f
C513 a_4157_1313# a_4324_1008# 0.02463f
C514 a_9757_1842# a_10083_1842# 0.01427f
C515 a_17791_2470# VDD 0.01806f
C516 a_12471_2470# a_12363_1842# 0.01697f
C517 a_12797_1842# a_13123_1842# 0.01427f
C518 a_4763_1842# DELAY_VBIASN 0.07254f
C519 a_12791_1008# a_12505_1044# 0.01885f
C520 a_5957_1842# DELAY_VBIASP 0.04141f
C521 a_27124_1008# a_27237_1842# 0.02055f
C522 a_26471_1008# VDD 0.28336f
C523 a_13991_1842# a_13883_1842# 0.01163f
C524 VDD a_19073_1842# 0.49426f
C525 a_25913_1842# DELAY_VBIASP 0.11222f
C526 a_25717_1842# DELAY_VBIASN 0.08411f
C527 a_25630_1044# a_27563_1842# 0.01024f
C528 a_1544_1044# a_2297_1395# 0.28651f
C529 DELAY_VBIASP a_16033_1842# 0.11222f
C530 a_24197_1842# a_24665_1044# 0.2079f
C531 a_16408_1044# a_16484_1008# 0.01176f
C532 a_3449_1395# MUX_SEL1 0.29404f
C533 a_14888_1044# a_14964_1008# 0.01176f
C534 a_6717_1842# a_4350_1044# 0.02479f
C535 VDD a_26477_1842# 0.86909f
C536 a_24197_1842# a_24957_1842# 0.02912f
C537 a_22488_1044# a_22590_1044# 0.37183f
C538 a_5731_289# a_14825_519# 0.28056f
C539 a_9757_1842# a_7390_1044# 0.02479f
C540 a_12797_1842# MUX_SEL4 0.01829f
C541 a_23431_1008# VDD 0.28336f
C542 a_11711_2470# VDD 0.01806f
C543 a_3449_1395# MUX_SEL0 0.10753f
C544 VDD a_21353_1842# 0.49285f
C545 a_12993_1842# VDD 0.49426f
C546 a_24197_1842# DELAY_VBIASP 0.04141f
C547 a_11195_1044# a_11271_1008# 0.01194f
C548 a_19550_1044# a_21911_1008# 0.26208f
C549 a_10430_1044# a_11924_1008# 0.28279f
C550 a_23003_1842# DELAY_VBIASN 0.07254f
C551 a_10985_1044# a_10430_1044# 0.03209f
C552 a_5705_519# a_2019_311# 0.13872f
C553 a_20968_1044# a_21044_1008# 0.01176f
C554 VDD a_5191_1008# 0.28565f
C555 a_15403_1842# DELAY_VBIASN 0.07254f
C556 a_15765_463# a_16108_289# 0.42004f
C557 a_23437_1842# a_23003_1842# 0.6972f
C558 DELAY_VBIASN a_20397_1842# 0.09974f
C559 MUX_SEL4 a_14825_519# 0.03307f
C560 a_12037_1842# VDD 0.85848f
C561 VDD a_15964_289# 0.31312f
C562 a_5523_1842# a_5631_1842# 0.01163f
C563 DELAY_VBIASP a_16923_1842# 0.06627f
C564 DELAY_VBIASN a_16793_1842# 0.0961f
C565 a_20968_1044# a_20397_1842# 0.10863f
C566 MUX_SEL2 VDD 0.50938f
C567 a_20105_1044# VDD 0.30409f
C568 a_13883_1842# DELAY_VBIASP 0.06627f
C569 a_15837_1842# a_15403_1842# 0.6972f
C570 VDD a_27433_1842# 0.49285f
C571 a_13470_1044# a_13557_1842# 0.1088f
C572 DELAY_VBIASN a_19073_1842# 0.0961f
C573 DELAY_VBIASP a_19203_1842# 0.06627f
C574 a_13557_1842# a_14317_1842# 0.01669f
C575 a_17553_1842# a_18117_1842# 0.0114f
C576 a_19524_1008# a_19637_1842# 0.05157f
C577 a_8997_1842# DELAY_VBIASP 0.04141f
C578 a_10951_1842# a_10843_1842# 0.01163f
C579 a_13470_1044# a_15755_1044# 0.39036f
C580 a_6717_1842# MUX_SEL4 0.0195f
C581 a_5197_1842# a_5191_1008# 0.02349f
C582 a_18551_1842# a_18443_1842# 0.01163f
C583 a_4248_1044# a_4324_1008# 0.01176f
C584 DELAY_VBIASN a_26477_1842# 0.10224f
C585 a_24875_1044# a_22590_1044# 0.39036f
C586 a_14513_1842# a_15077_1842# 0.0114f
C587 VDD a_8884_1008# 0.28225f
C588 a_4003_1842# VDD 0.61559f
C589 a_7673_1842# VDD 0.49294f
C590 a_16597_1842# a_17357_1842# 0.01669f
C591 a_27915_1044# a_27991_1008# 0.01194f
C592 a_13444_1008# VDD 0.28633f
C593 DELAY_VBIASN a_21353_1842# 0.0961f
C594 a_12993_1842# DELAY_VBIASN 0.0961f
C595 a_13123_1842# DELAY_VBIASP 0.06627f
C596 DELAY_VBIASP a_21483_1842# 0.06627f
C597 a_19550_1044# a_21483_1842# 0.01012f
C598 a_8997_1842# a_9757_1842# 0.02912f
C599 a_15831_1008# a_15545_1044# 0.01885f
C600 a_5197_1842# VDD 0.86909f
C601 a_10430_1044# a_5731_289# 0.41176f
C602 a_23437_1842# a_23431_1008# 0.02349f
C603 a_27705_1044# VDD 0.29918f
C604 a_8237_1842# a_8808_1044# 0.10863f
C605 a_25153_1842# VDD 0.49426f
C606 a_9323_1842# a_9431_1842# 0.01163f
C607 a_18877_1842# a_19637_1842# 0.06198f
C608 a_4437_1842# a_4633_1842# 0.73897f
C609 a_26395_1044# a_26471_1008# 0.01194f
C610 a_21591_2470# a_21483_1842# 0.01697f
C611 a_18871_1008# a_16510_1044# 0.26208f
C612 a_12037_1842# DELAY_VBIASN 0.09156f
C613 a_18585_1044# VDD 0.29722f
C614 a_27048_1044# a_25630_1044# 0.38994f
C615 a_17865_519# a_2019_311# 0.13959f
C616 a_20397_1842# a_20723_1842# 0.01427f
C617 a_7390_1044# a_8155_1044# 0.39037f
C618 a_11277_1842# a_11924_1008# 0.02312f
C619 MUX_OUT a_2019_311# 8.45486f
C620 a_5957_1842# a_6153_1842# 0.77122f
C621 DELAY_OUT_LAST a_27997_1842# 0.70955f
C622 DELAY_VBIASP a_27563_1842# 0.06629f
C623 DELAY_VBIASN a_27433_1842# 0.0961f
C624 a_20105_1044# a_20315_1044# 0.09424f
C625 a_13470_1044# a_14235_1044# 0.39037f
C626 VDD DELAY_VBIASN 0.9333f
C627 a_10430_1044# MUX_SEL4 0.24983f
C628 a_20315_1044# VDD 0.15389f
C629 a_20071_2470# a_19963_1842# 0.01697f
C630 a_11195_1044# VDD 0.15389f
C631 a_10517_1842# DELAY_VBIASP 0.0414f
C632 a_20968_1044# VDD 0.17499f
C633 a_15837_1842# a_15964_289# 0.02f
C634 a_23437_1842# VDD 0.86909f
C635 a_19963_1842# a_19833_1842# 0.70845f
C636 MUX_SEL3 a_1544_289# 0.15976f
C637 a_10517_1842# a_10430_1044# 0.1088f
C638 MUX_SEL2 a_1721_331# 0.01315f
C639 a_24875_1044# a_24951_1008# 0.01194f
C640 a_6425_1044# a_6635_1044# 0.09424f
C641 VDD a_1721_331# 0.45259f
C642 a_15837_1842# VDD 0.87963f
C643 a_1256_289# MUX_SEL4 0.65005f
C644 a_25717_1842# a_26185_1044# 0.19203f
C645 a_9757_1842# MUX_SEL4 0.01829f
C646 a_4003_1842# DELAY_VBIASN 0.06486f
C647 a_24957_1842# a_25283_1842# 0.01427f
C648 a_7673_1842# DELAY_VBIASN 0.0961f
C649 a_7803_1842# DELAY_VBIASP 0.06627f
C650 a_9953_1842# VDD 0.49426f
C651 VDD a_16163_1842# 0.4973f
C652 a_23355_1044# a_23431_1008# 0.01194f
C653 a_18877_1842# a_16108_289# 0.0157f
C654 a_4003_1842# a_4111_1842# 0.01163f
C655 a_9757_1842# a_10517_1842# 0.06198f
C656 a_17031_2470# VDD 0.01806f
C657 a_5197_1842# DELAY_VBIASN 0.09974f
C658 a_12797_1842# a_13557_1842# 0.06198f
C659 a_6635_1044# a_6711_1008# 0.01194f
C660 a_21157_1842# a_21917_1842# 0.02912f
C661 a_5393_1842# DELAY_VBIASP 0.11222f
C662 a_25630_1044# a_16108_289# 0.55833f
C663 VDD a_18443_1842# 0.4973f
C664 a_26395_1044# VDD 0.15389f
C665 a_17928_1044# a_18004_1008# 0.01176f
C666 a_25283_1842# DELAY_VBIASP 0.06627f
C667 a_25153_1842# DELAY_VBIASN 0.0961f
C668 a_13470_1044# a_15403_1842# 0.01012f
C669 a_16408_1044# a_16510_1044# 0.37183f
C670 a_17928_1044# a_17357_1842# 0.10863f
C671 a_24197_1842# a_24393_1842# 0.77122f
C672 a_26477_1842# a_26803_1842# 0.01427f
C673 a_5115_1044# a_5191_1008# 0.01194f
C674 a_16510_1044# a_17865_519# 0.02165f
C675 DELAY_VBIASP a_17683_1842# 0.06627f
C676 a_24197_1842# a_22590_1044# 0.05231f
C677 a_5731_289# a_11785_519# 0.28056f
C678 a_17351_1008# VDD 0.28565f
C679 a_23355_1044# VDD 0.15389f
C680 a_10951_2470# VDD 0.01806f
C681 a_12363_1842# VDD 0.4973f
C682 VDD a_20723_1842# 0.49671f
C683 a_23633_1842# DELAY_VBIASP 0.11222f
C684 a_19550_1044# a_21835_1044# 0.39036f
C685 a_13231_1842# a_13123_1842# 0.01163f
C686 a_23437_1842# DELAY_VBIASN 0.09974f
C687 a_10430_1044# a_11848_1044# 0.38994f
C688 a_6425_1044# a_5957_1842# 0.2079f
C689 VDD a_7288_1044# 0.17274f
C690 a_11473_1842# a_12037_1842# 0.0114f
C691 VDD a_5115_1044# 0.15389f
C692 a_3449_331# a_2019_311# 0.01176f
C693 DELAY_IN a_3449_331# 0.01017f
C694 a_15837_1842# DELAY_VBIASN 0.09992f
C695 a_22873_1842# a_23003_1842# 0.70845f
C696 a_26471_1008# a_26185_1044# 0.01885f
C697 a_15765_463# a_15964_289# 0.061f
C698 a_25717_1842# a_25604_1008# 0.05157f
C699 MUX_SEL4 a_11785_519# 0.03255f
C700 a_11473_1842# VDD 0.49417f
C701 a_9953_1842# DELAY_VBIASN 0.0961f
C702 a_25717_1842# a_25630_1044# 0.1088f
C703 VDD a_15765_463# 0.35368f
C704 a_11711_1842# a_11603_1842# 0.01163f
C705 a_4350_1044# a_2019_311# 0.02042f
C706 DELAY_VBIASN a_16163_1842# 0.07254f
C707 DELAY_VBIASP a_17357_1842# 0.0414f
C708 MUX_SEL1 VDD 0.50267f
C709 a_10517_1842# a_11277_1842# 0.01669f
C710 a_1544_289# a_2297_331# 0.27303f
C711 a_15273_1842# a_15403_1842# 0.70845f
C712 VDD a_26803_1842# 0.49671f
C713 a_1256_289# a_2873_331# 0.27926f
C714 DELAY_VBIASP a_19637_1842# 0.0414f
C715 DELAY_VBIASN a_18443_1842# 0.07254f
C716 a_19550_1044# a_19637_1842# 0.1088f
C717 a_8433_1842# DELAY_VBIASP 0.11222f
C718 MUX_SEL0 MUX_SEL2 0.01204f
C719 VDD a_9431_2470# 0.01806f
C720 a_15837_1842# a_16163_1842# 0.01427f
C721 MUX_SEL0 VDD 0.56365f
C722 a_4157_1313# a_2019_311# 0.01018f
C723 a_4157_1313# DELAY_IN 0.50642f
C724 VDD a_8808_1044# 0.17499f
C725 a_24084_1008# a_22590_1044# 0.28279f
C726 a_22564_1008# a_21917_1842# 0.02011f
C727 a_4437_1842# VDD 0.86998f
C728 a_7043_1842# VDD 0.49723f
C729 a_21591_1842# a_21483_1842# 0.01163f
C730 a_16597_1842# a_16793_1842# 0.73897f
C731 a_23871_1842# a_23763_1842# 0.01163f
C732 a_13470_1044# VDD 0.87936f
C733 DELAY_VBIASP a_21917_1842# 0.0414f
C734 a_13557_1842# DELAY_VBIASP 0.0414f
C735 a_6425_1044# a_4350_1044# 0.03208f
C736 a_5731_289# a_2019_311# 1.15781f
C737 a_12363_1842# DELAY_VBIASN 0.07254f
C738 DELAY_VBIASN a_20723_1842# 0.07254f
C739 a_7803_1842# a_7911_2470# 0.01697f
C740 a_24957_1842# a_16108_289# 0.0157f
C741 a_19550_1044# a_21917_1842# 0.02479f
C742 a_14317_1842# VDD 0.86909f
C743 a_15755_1044# a_15545_1044# 0.09424f
C744 a_8997_1842# a_9193_1842# 0.77122f
C745 a_8808_1044# a_8884_1008# 0.01176f
C746 a_21044_1008# a_21157_1842# 0.02055f
C747 a_26185_1044# VDD 0.30409f
C748 a_22243_1842# a_21917_1842# 0.01427f
C749 a_25913_1842# a_26043_1842# 0.70845f
C750 a_24523_1842# VDD 0.4973f
C751 a_8237_1842# a_8231_1008# 0.02349f
C752 a_20071_1842# a_19963_1842# 0.01163f
C753 a_18877_1842# a_19073_1842# 0.76914f
C754 a_4437_1842# a_4003_1842# 0.69698f
C755 a_7477_1842# a_8237_1842# 0.01669f
C756 a_18795_1044# a_16510_1044# 0.39036f
C757 a_17065_1044# VDD 0.30218f
C758 a_11473_1842# DELAY_VBIASN 0.0961f
C759 a_16851_309# a_2019_311# 0.01299f
C760 a_6283_1842# a_6391_2470# 0.01697f
C761 a_26471_1008# a_25630_1044# 0.28268f
C762 a_12715_1044# a_10430_1044# 0.39036f
C763 a_20397_1842# a_21157_1842# 0.03319f
C764 a_4350_1044# a_6711_1008# 0.26208f
C765 a_7390_1044# a_7364_1008# 0.277f
C766 a_19550_1044# a_16108_289# 0.58202f
C767 a_11277_1842# a_11848_1044# 0.10863f
C768 MUX_SEL4 a_2019_311# 0.90276f
C769 a_5957_1842# a_5523_1842# 0.6972f
C770 MUX_SEL4 DELAY_IN 0.0663f
C771 a_22243_1842# a_22351_1842# 0.01163f
C772 a_16510_1044# a_16923_1842# 0.01012f
C773 a_23763_1842# DELAY_VBIASP 0.06627f
C774 DELAY_VBIASP a_27997_1842# 0.04001f
C775 a_4437_1842# a_5197_1842# 0.01669f
C776 a_13470_1044# a_13444_1008# 0.277f
C777 DELAY_VBIASN a_26803_1842# 0.07254f
C778 VDD DELAY_OUT_LAST 0.46312f
C779 a_19524_1008# VDD 0.28633f
C780 a_25630_1044# a_26477_1842# 0.08038f
C781 a_10404_1008# VDD 0.28633f
C782 a_27671_2470# VDD 0.01806f
C783 a_10191_2470# a_10083_1842# 0.01697f
C784 a_22873_1842# VDD 0.49294f
C785 MUX_SEL2 a_1544_289# 0.07405f
C786 VDD a_1544_289# 0.39113f
C787 a_15273_1842# VDD 0.49285f
C788 a_1256_1044# VDD 0.475f
C789 a_1256_289# MUX_SEL3 1.41161f
C790 a_14311_1008# a_14025_1044# 0.01885f
C791 a_4437_1842# DELAY_VBIASN 0.08375f
C792 a_4633_1842# DELAY_VBIASP 0.11222f
C793 a_7043_1842# DELAY_VBIASN 0.07254f
C794 a_8237_1842# DELAY_VBIASP 0.0414f
C795 a_24957_1842# a_25717_1842# 0.06198f
C796 a_9323_1842# VDD 0.4973f
C797 a_22113_1842# DELAY_VBIASP 0.11222f
C798 a_13470_1044# DELAY_VBIASN 0.02115f
C799 VDD a_16597_1842# 0.86876f
C800 a_14317_1842# DELAY_VBIASN 0.09974f
C801 a_21157_1842# a_21353_1842# 0.77122f
C802 a_4763_1842# DELAY_VBIASP 0.06627f
C803 a_12797_1842# a_12993_1842# 0.76914f
C804 a_22113_1842# a_22243_1842# 0.70845f
C805 VDD a_18877_1842# 0.87825f
C806 a_25604_1008# VDD 0.28633f
C807 a_25717_1842# DELAY_VBIASP 0.0414f
C808 a_24523_1842# DELAY_VBIASN 0.07254f
C809 a_25630_1044# VDD 0.89531f
C810 a_21625_1044# a_21911_1008# 0.01885f
C811 a_13470_1044# a_15837_1842# 0.02479f
C812 a_9757_1842# a_9751_1008# 0.02354f
C813 a_26477_1842# a_27237_1842# 0.03319f
C814 a_16510_1044# a_16851_309# 0.02131f
C815 a_12797_1842# a_12037_1842# 0.02912f
C816 a_6283_1842# a_4350_1044# 0.01012f
C817 DELAY_OUT_LAST DELAY_VBIASN 0.04786f
C818 a_2297_1395# VDD 0.46536f
C819 a_17275_1044# VDD 0.15389f
C820 VDD a_21157_1842# 0.85848f
C821 a_12797_1842# VDD 0.87771f
C822 a_18117_1842# a_17683_1842# 0.6972f
C823 a_23003_1842# DELAY_VBIASP 0.06627f
C824 a_22873_1842# DELAY_VBIASN 0.0961f
C825 a_10430_1044# a_11271_1008# 0.28268f
C826 a_19550_1044# a_21044_1008# 0.28279f
C827 VDD a_4324_1008# 0.28597f
C828 a_15403_1842# DELAY_VBIASP 0.06627f
C829 a_15273_1842# DELAY_VBIASN 0.0961f
C830 a_26395_1044# a_26185_1044# 0.09424f
C831 a_22873_1842# a_23437_1842# 0.0114f
C832 DELAY_VBIASP a_20397_1842# 0.0414f
C833 a_18795_1044# a_18871_1008# 0.01194f
C834 a_10843_1842# VDD 0.4973f
C835 a_22590_1044# a_23945_519# 0.02165f
C836 a_25630_1044# a_27705_1044# 0.03208f
C837 a_19550_1044# a_20397_1842# 0.08038f
C838 a_7390_1044# a_8745_519# 0.01756f
C839 a_9323_1842# DELAY_VBIASN 0.07254f
C840 VDD a_14825_519# 0.29292f
C841 DELAY_VBIASP a_16793_1842# 0.11222f
C842 DELAY_VBIASN a_16597_1842# 0.08375f
C843 a_4350_1044# a_5705_519# 0.02005f
C844 a_10517_1842# a_10713_1842# 0.73897f
C845 a_1544_289# a_1721_331# 0.36963f
C846 a_18004_1008# a_18117_1842# 0.02055f
C847 a_27237_1842# a_27433_1842# 0.77122f
C848 a_15273_1842# a_15837_1842# 0.0114f
C849 VDD a_27237_1842# 0.85969f
C850 a_13444_1008# a_12797_1842# 0.02011f
C851 a_1256_289# a_2297_331# 0.04261f
C852 DELAY_VBIASN a_18877_1842# 0.09992f
C853 DELAY_VBIASP a_19073_1842# 0.11222f
C854 a_7945_1044# VDD 0.30409f
C855 a_17357_1842# a_18117_1842# 0.03319f
C856 VDD a_8671_2470# 0.01806f
C857 MUX_SEL0 MUX_SEL1 3.14917f
C858 a_25630_1044# DELAY_VBIASN 0.02756f
C859 a_15837_1842# a_16597_1842# 0.06198f
C860 DELAY_VBIASP a_26477_1842# 0.04144f
C861 a_17351_1008# a_17065_1044# 0.01885f
C862 a_12715_1044# a_12791_1008# 0.01194f
C863 a_3449_1395# DELAY_IN 0.01058f
C864 a_24008_1044# a_22590_1044# 0.38994f
C865 VDD a_8231_1008# 0.28336f
C866 a_6717_1842# VDD 0.87726f
C867 a_17928_1044# VDD 0.17499f
C868 a_14025_1044# a_13557_1842# 0.19203f
C869 a_7477_1842# VDD 0.86707f
C870 a_16597_1842# a_16163_1842# 0.69698f
C871 a_15511_2470# a_15403_1842# 0.01697f
C872 a_13368_1044# VDD 0.17274f
C873 DELAY_VBIASN a_21157_1842# 0.09156f
C874 a_5731_289# a_5705_519# 0.28954f
C875 DELAY_VBIASP a_21353_1842# 0.11222f
C876 a_12993_1842# DELAY_VBIASP 0.11222f
C877 a_12797_1842# DELAY_VBIASN 0.09992f
C878 a_4905_1044# a_4350_1044# 0.03209f
C879 a_8997_1842# a_8563_1842# 0.6972f
C880 a_27705_1044# a_27237_1842# 0.2079f
C881 a_24665_1044# VDD 0.29722f
C882 a_22677_1842# a_21917_1842# 0.06198f
C883 a_22590_1044# a_16108_289# 0.58202f
C884 a_24957_1842# VDD 0.87825f
C885 a_18877_1842# a_18443_1842# 0.6972f
C886 a_13991_2470# a_13883_1842# 0.01697f
C887 a_5523_1842# a_5631_2470# 0.01697f
C888 a_13753_1842# a_13883_1842# 0.70845f
C889 a_7477_1842# a_7673_1842# 0.73897f
C890 a_22564_1008# VDD 0.28633f
C891 a_18004_1008# a_16510_1044# 0.28279f
C892 a_26395_1044# a_25630_1044# 0.39037f
C893 a_16108_289# a_2019_311# 0.33889f
C894 a_12037_1842# DELAY_VBIASP 0.04141f
C895 a_10843_1842# DELAY_VBIASN 0.07254f
C896 a_15545_1044# VDD 0.29918f
C897 a_4350_1044# a_6635_1044# 0.39036f
C898 a_20397_1842# a_20593_1842# 0.76914f
C899 MUX_SEL3 a_2019_311# 0.06209f
C900 a_12037_1842# a_10430_1044# 0.05231f
C901 MUX_SEL4 a_5705_519# 0.03556f
C902 a_11277_1842# a_11271_1008# 0.02349f
C903 a_5393_1842# a_5523_1842# 0.70845f
C904 a_16510_1044# a_17357_1842# 0.08038f
C905 a_20105_1044# a_19550_1044# 0.03209f
C906 DELAY_VBIASP a_27433_1842# 0.11222f
C907 DELAY_VBIASN a_27237_1842# 0.09456f
C908 a_13368_1044# a_13444_1008# 0.01176f
C909 VDD DELAY_VBIASP 13.3418f
C910 a_19550_1044# VDD 0.89766f
C911 a_13470_1044# a_14317_1842# 0.08038f
C912 a_10430_1044# VDD 0.88416f
C913 a_26911_2470# VDD 0.01806f
C914 a_22243_1842# VDD 0.49737f
C915 a_24631_1842# a_24523_1842# 0.01163f
C916 a_1256_1044# MUX_SEL1 1.44243f
C917 a_14643_1842# VDD 0.49671f
C918 a_21591_2470# VDD 0.01806f
C919 a_6717_1842# DELAY_VBIASN 0.09992f
C920 a_14235_1044# a_14025_1044# 0.09424f
C921 a_1256_289# MUX_SEL2 0.33134f
C922 a_14964_1008# VDD 0.28225f
C923 a_1256_289# VDD 0.40292f
C924 a_24957_1842# a_25153_1842# 0.76914f
C925 a_4003_1842# DELAY_VBIASP 0.05992f
C926 a_5731_289# a_8745_519# 0.28635f
C927 a_7477_1842# DELAY_VBIASN 0.08375f
C928 a_7673_1842# DELAY_VBIASP 0.11222f
C929 a_9757_1842# VDD 0.87771f
C930 a_17275_1044# a_17351_1008# 0.01194f
C931 a_1256_1044# MUX_SEL0 0.3314f
C932 a_9323_1842# a_9431_2470# 0.01697f
C933 a_12797_1842# a_12363_1842# 0.6972f
C934 a_5197_1842# DELAY_VBIASP 0.0414f
C935 a_21157_1842# a_20723_1842# 0.6972f
C936 a_22113_1842# a_22677_1842# 0.0114f
C937 a_23003_1842# a_23111_1842# 0.01163f
C938 VDD a_18313_1842# 0.49285f
C939 a_24957_1842# DELAY_VBIASN 0.09992f
C940 a_25153_1842# DELAY_VBIASP 0.11222f
C941 a_21625_1044# a_21835_1044# 0.09424f
C942 a_25528_1044# VDD 0.17274f
C943 MUX_SEL4 a_8745_519# 0.04472f
C944 a_15511_2470# VDD 0.01806f
C945 a_1544_1044# a_1721_1395# 0.38063f
C946 MUX_OUT a_5731_289# 1.04829f
C947 a_5957_1842# a_4350_1044# 0.05231f
C948 a_25283_1842# a_25391_2470# 0.01697f
C949 a_26477_1842# a_26673_1842# 0.76914f
C950 a_10951_2470# a_10843_1842# 0.01697f
C951 a_16510_1044# a_16108_289# 0.56108f
C952 a_12233_1842# a_12037_1842# 0.77122f
C953 a_2297_1395# MUX_SEL1 0.01995f
C954 a_1544_1044# MUX_OUT 0.04258f
C955 a_23003_1842# a_22590_1044# 0.01012f
C956 DELAY_VBIASP DELAY_VBIASN 3.50557f
C957 VDD a_4111_2470# 0.01866f
C958 a_16108_289# a_20905_519# 0.2906f
C959 a_19550_1044# DELAY_VBIASN 0.02115f
C960 a_16484_1008# VDD 0.28597f
C961 a_8997_1842# a_7390_1044# 0.05231f
C962 MUX_OUT a_16851_309# 0.45865f
C963 a_19550_1044# a_20315_1044# 0.39037f
C964 a_10430_1044# DELAY_VBIASN 0.02115f
C965 VDD a_20593_1842# 0.49417f
C966 a_12233_1842# VDD 0.49285f
C967 a_17553_1842# a_17683_1842# 0.70845f
C968 MUX_SEL4 MUX_OUT 0.91933f
C969 a_10430_1044# a_11195_1044# 0.39037f
C970 a_22243_1842# DELAY_VBIASN 0.07254f
C971 a_19550_1044# a_20968_1044# 0.38994f
C972 a_23437_1842# DELAY_VBIASP 0.0414f
C973 a_11277_1842# a_12037_1842# 0.03319f
C974 a_2297_1395# MUX_SEL0 0.10655f
C975 a_2297_331# a_2019_311# 0.04011f
C976 a_7043_1842# a_7151_1842# 0.01163f
C977 a_14643_1842# DELAY_VBIASN 0.07254f
C978 a_15837_1842# DELAY_VBIASP 0.0414f
C979 a_17065_1044# a_16597_1842# 0.19203f
C980 a_11277_1842# VDD 0.86909f
C981 a_4003_1842# a_4111_2470# 0.01697f
C982 a_25630_1044# a_26185_1044# 0.03209f
C983 a_7390_1044# a_5731_289# 0.41331f
C984 a_9953_1842# DELAY_VBIASP 0.11222f
C985 a_9757_1842# DELAY_VBIASN 0.09992f
C986 VDD a_11785_519# 0.29292f
C987 a_6717_1842# a_7288_1044# 0.10864f
C988 DELAY_VBIASP a_16163_1842# 0.06627f
C989 a_10517_1842# a_10083_1842# 0.69698f
C990 a_5957_1842# a_5844_1008# 0.02055f
C991 a_27237_1842# a_26803_1842# 0.6972f
C992 VDD a_26673_1842# 0.49417f
C993 a_4437_1842# a_4324_1008# 0.05157f
C994 a_1256_289# a_1721_331# 0.13421f
C995 DELAY_VBIASP a_18443_1842# 0.06627f
C996 DELAY_VBIASN a_18313_1842# 0.0961f
C997 a_19524_1008# a_18877_1842# 0.02011f
C998 a_23431_1008# a_23145_1044# 0.01885f
C999 a_17357_1842# a_17553_1842# 0.76914f
C1000 VDD a_7911_2470# 0.01806f
C1001 a_27671_1842# a_27563_1842# 0.01163f
C1002 MUX_SEL4 a_7390_1044# 0.34655f
C1003 a_17275_1044# a_17065_1044# 0.09424f
C1004 VDD a_8155_1044# 0.15389f
C1005 a_23431_1008# a_22590_1044# 0.28268f
C1006 a_9757_1842# a_9953_1842# 0.76914f
C1007 a_22488_1044# a_21917_1842# 0.10864f
C1008 a_6153_1842# VDD 0.49285f
C1009 a_24197_1842# a_24084_1008# 0.02055f
C1010 a_19311_2470# a_19203_1842# 0.01697f
C1011 a_13470_1044# a_14825_519# 0.02058f
C1012 a_6913_1842# VDD 0.49426f
C1013 a_22351_2470# VDD 0.01806f
C1014 a_19637_1842# a_19833_1842# 0.73897f
C1015 a_26151_1842# a_26043_1842# 0.01163f
C1016 a_12791_1008# VDD 0.2822f
C1017 a_12363_1842# DELAY_VBIASP 0.06627f
C1018 DELAY_VBIASP a_20723_1842# 0.06627f
C1019 a_12233_1842# DELAY_VBIASN 0.0961f
C1020 DELAY_VBIASN a_20593_1842# 0.0961f
C1021 a_4157_1313# a_4350_1044# 0.04624f
C1022 a_8433_1842# a_8563_1842# 0.70845f
C1023 a_12363_1842# a_10430_1044# 0.01012f
C1024 a_12715_1044# a_12505_1044# 0.09424f
C1025 a_23145_1044# VDD 0.30409f
C1026 a_24393_1842# VDD 0.49285f
C1027 a_7803_1842# a_7390_1044# 0.01012f
C1028 a_7043_1842# a_6717_1842# 0.01427f
C1029 a_18313_1842# a_18443_1842# 0.70845f
C1030 a_16484_1008# a_15837_1842# 0.02011f
C1031 a_1256_1044# a_2297_1395# 0.04619f
C1032 a_4350_1044# a_5731_289# 0.41099f
C1033 a_7477_1842# a_7043_1842# 0.69698f
C1034 a_11473_1842# DELAY_VBIASP 0.11222f
C1035 a_14025_1044# VDD 0.30409f
C1036 a_11277_1842# DELAY_VBIASN 0.09974f
C1037 a_22590_1044# VDD 0.89557f
C1038 a_15964_289# a_2019_311# 0.02413f
C1039 a_25604_1008# a_25630_1044# 0.277f
C1040 a_20397_1842# a_19963_1842# 0.6972f
C1041 a_4350_1044# a_5844_1008# 0.28279f
C1042 MUX_SEL4 a_3449_331# 0.05166f
C1043 a_5393_1842# a_5957_1842# 0.0114f
C1044 a_10985_1044# a_10517_1842# 0.19203f
C1045 VDD a_2019_311# 1.43004f
C1046 VDD DELAY_IN 1.33375f
C1047 a_13368_1044# a_13470_1044# 0.37183f
C1048 DELAY_VBIASN a_26673_1842# 0.0961f
C1049 DELAY_VBIASP a_26803_1842# 0.06627f
C1050 a_19448_1044# VDD 0.17274f
C1051 a_10328_1044# VDD 0.17274f
C1052 a_26911_2470# a_26803_1842# 0.01697f
C1053 a_26151_2470# VDD 0.01806f
C1054 MUX_SEL4 a_4350_1044# 0.31434f
C1055 a_22677_1842# VDD 0.86707f
C1056 VDD a_18117_1842# 0.85848f
C1057 a_13231_2470# a_13123_1842# 0.01697f
C1058 a_20831_2470# VDD 0.01806f
C1059 a_15077_1842# VDD 0.85963f
C1060 a_13557_1842# a_13753_1842# 0.73897f
C1061 a_13470_1044# a_15545_1044# 0.03208f
C1062 a_6153_1842# DELAY_VBIASN 0.0961f
C1063 a_14751_1842# a_14643_1842# 0.01163f
C1064 a_27991_1008# VDD 0.28201f
C1065 a_24957_1842# a_24523_1842# 0.6972f
C1066 a_4003_1842# DELAY_IN 0.54998f
C1067 a_4437_1842# DELAY_VBIASP 0.0414f
C1068 a_6913_1842# DELAY_VBIASN 0.0961f
C1069 a_7043_1842# DELAY_VBIASP 0.06627f
C1070 a_9465_1044# a_7390_1044# 0.03208f
C1071 a_9193_1842# VDD 0.49285f
C1072 a_20391_1008# a_20397_1842# 0.02349f
C1073 a_4157_1313# MUX_SEL4 0.08229f
C1074 a_14317_1842# DELAY_VBIASP 0.0414f
C1075 a_11711_2470# a_11603_1842# 0.01697f
C1076 a_6425_1044# VDD 0.29722f
C1077 a_20593_1842# a_20723_1842# 0.70845f
C1078 a_12233_1842# a_12363_1842# 0.70845f
C1079 a_24523_1842# DELAY_VBIASP 0.06627f
C1080 a_24393_1842# DELAY_VBIASN 0.0961f
C1081 a_25630_1044# a_27237_1842# 0.05253f
C1082 a_24951_1008# VDD 0.2822f
C1083 a_14751_2470# VDD 0.01806f
C1084 MUX_SEL4 a_5731_289# 4.60702f
C1085 a_22590_1044# DELAY_VBIASN 0.02115f
C1086 a_8237_1842# a_8563_1842# 0.01427f
C1087 a_13470_1044# a_14964_1008# 0.28279f
C1088 a_14317_1842# a_14643_1842# 0.01427f
C1089 a_26477_1842# a_26043_1842# 0.6972f
C1090 a_4248_1044# a_4350_1044# 0.37183f
C1091 a_11848_1044# a_11924_1008# 0.01176f
C1092 a_16510_1044# a_15964_289# 0.05416f
C1093 a_14964_1008# a_14317_1842# 0.02312f
C1094 a_21835_1044# a_21911_1008# 0.01194f
C1095 a_11603_1842# a_12037_1842# 0.6972f
C1096 VDD a_6711_1008# 0.2822f
C1097 a_1544_1044# MUX_SEL4 0.03407f
C1098 a_23437_1842# a_22590_1044# 0.08038f
C1099 DELAY_IN DELAY_VBIASN 0.07156f
C1100 a_27991_1008# a_27705_1044# 0.01885f
C1101 DELAY_VBIASP DELAY_OUT_LAST 0.21225f
C1102 a_23633_1842# a_24197_1842# 0.0114f
C1103 a_16108_289# a_17865_519# 0.29564f
C1104 a_18585_1044# a_18117_1842# 0.2079f
R0 DELAY_VBIASN.n1 DELAY_VBIASN.t31 34.3755
R1 DELAY_VBIASN.n1 DELAY_VBIASN.t30 33.0005
R2 DELAY_VBIASN.n2 DELAY_VBIASN.t29 33.0005
R3 DELAY_VBIASN.n3 DELAY_VBIASN.t28 33.0005
R4 DELAY_VBIASN.n4 DELAY_VBIASN.t27 33.0005
R5 DELAY_VBIASN.n5 DELAY_VBIASN.t26 33.0005
R6 DELAY_VBIASN.n6 DELAY_VBIASN.t25 33.0005
R7 DELAY_VBIASN.n7 DELAY_VBIASN.t24 33.0005
R8 DELAY_VBIASN.n8 DELAY_VBIASN.t23 33.0005
R9 DELAY_VBIASN.n9 DELAY_VBIASN.t22 33.0005
R10 DELAY_VBIASN.n10 DELAY_VBIASN.t21 33.0005
R11 DELAY_VBIASN.n11 DELAY_VBIASN.t20 33.0005
R12 DELAY_VBIASN.n12 DELAY_VBIASN.t19 33.0005
R13 DELAY_VBIASN.n13 DELAY_VBIASN.t18 33.0005
R14 DELAY_VBIASN.n14 DELAY_VBIASN.t17 33.0005
R15 DELAY_VBIASN.n15 DELAY_VBIASN.t16 33.0005
R16 DELAY_VBIASN.n16 DELAY_VBIASN.t15 33.0005
R17 DELAY_VBIASN.n17 DELAY_VBIASN.t14 33.0005
R18 DELAY_VBIASN.n18 DELAY_VBIASN.t13 33.0005
R19 DELAY_VBIASN.n19 DELAY_VBIASN.t12 33.0005
R20 DELAY_VBIASN.n20 DELAY_VBIASN.t11 33.0005
R21 DELAY_VBIASN.n21 DELAY_VBIASN.t10 33.0005
R22 DELAY_VBIASN.n22 DELAY_VBIASN.t9 33.0005
R23 DELAY_VBIASN.n23 DELAY_VBIASN.t8 33.0005
R24 DELAY_VBIASN.n24 DELAY_VBIASN.t7 33.0005
R25 DELAY_VBIASN.n25 DELAY_VBIASN.t6 33.0005
R26 DELAY_VBIASN.n26 DELAY_VBIASN.t5 33.0005
R27 DELAY_VBIASN.n27 DELAY_VBIASN.t4 33.0005
R28 DELAY_VBIASN.n28 DELAY_VBIASN.t3 33.0005
R29 DELAY_VBIASN.n29 DELAY_VBIASN.t2 33.0005
R30 DELAY_VBIASN.n30 DELAY_VBIASN.t1 33.0005
R31 DELAY_VBIASN.n0 DELAY_VBIASN.t0 33.0005
R32 DELAY_VBIASN DELAY_VBIASN.n0 1.55517
R33 DELAY_VBIASN.n0 DELAY_VBIASN.n30 1.3755
R34 DELAY_VBIASN.n30 DELAY_VBIASN.n29 1.3755
R35 DELAY_VBIASN.n29 DELAY_VBIASN.n28 1.3755
R36 DELAY_VBIASN.n28 DELAY_VBIASN.n27 1.3755
R37 DELAY_VBIASN.n27 DELAY_VBIASN.n26 1.3755
R38 DELAY_VBIASN.n26 DELAY_VBIASN.n25 1.3755
R39 DELAY_VBIASN.n25 DELAY_VBIASN.n24 1.3755
R40 DELAY_VBIASN.n24 DELAY_VBIASN.n23 1.3755
R41 DELAY_VBIASN.n23 DELAY_VBIASN.n22 1.3755
R42 DELAY_VBIASN.n22 DELAY_VBIASN.n21 1.3755
R43 DELAY_VBIASN.n21 DELAY_VBIASN.n20 1.3755
R44 DELAY_VBIASN.n20 DELAY_VBIASN.n19 1.3755
R45 DELAY_VBIASN.n19 DELAY_VBIASN.n18 1.3755
R46 DELAY_VBIASN.n18 DELAY_VBIASN.n17 1.3755
R47 DELAY_VBIASN.n17 DELAY_VBIASN.n16 1.3755
R48 DELAY_VBIASN.n16 DELAY_VBIASN.n15 1.3755
R49 DELAY_VBIASN.n15 DELAY_VBIASN.n14 1.3755
R50 DELAY_VBIASN.n14 DELAY_VBIASN.n13 1.3755
R51 DELAY_VBIASN.n13 DELAY_VBIASN.n12 1.3755
R52 DELAY_VBIASN.n12 DELAY_VBIASN.n11 1.3755
R53 DELAY_VBIASN.n11 DELAY_VBIASN.n10 1.3755
R54 DELAY_VBIASN.n10 DELAY_VBIASN.n9 1.3755
R55 DELAY_VBIASN.n9 DELAY_VBIASN.n8 1.3755
R56 DELAY_VBIASN.n8 DELAY_VBIASN.n7 1.3755
R57 DELAY_VBIASN.n7 DELAY_VBIASN.n6 1.3755
R58 DELAY_VBIASN.n6 DELAY_VBIASN.n5 1.3755
R59 DELAY_VBIASN.n5 DELAY_VBIASN.n4 1.3755
R60 DELAY_VBIASN.n4 DELAY_VBIASN.n3 1.3755
R61 DELAY_VBIASN.n3 DELAY_VBIASN.n2 1.3755
R62 DELAY_VBIASN.n2 DELAY_VBIASN.n1 1.3755
R63 DELAY_VBIASP.n1 DELAY_VBIASP.t31 34.3685
R64 DELAY_VBIASP.n1 DELAY_VBIASP.t30 33.0005
R65 DELAY_VBIASP.n2 DELAY_VBIASP.t29 33.0005
R66 DELAY_VBIASP.n3 DELAY_VBIASP.t28 33.0005
R67 DELAY_VBIASP.n4 DELAY_VBIASP.t27 33.0005
R68 DELAY_VBIASP.n5 DELAY_VBIASP.t26 33.0005
R69 DELAY_VBIASP.n6 DELAY_VBIASP.t25 33.0005
R70 DELAY_VBIASP.n7 DELAY_VBIASP.t24 33.0005
R71 DELAY_VBIASP.n8 DELAY_VBIASP.t23 33.0005
R72 DELAY_VBIASP.n9 DELAY_VBIASP.t22 33.0005
R73 DELAY_VBIASP.n10 DELAY_VBIASP.t21 33.0005
R74 DELAY_VBIASP.n11 DELAY_VBIASP.t20 33.0005
R75 DELAY_VBIASP.n12 DELAY_VBIASP.t19 33.0005
R76 DELAY_VBIASP.n13 DELAY_VBIASP.t18 33.0005
R77 DELAY_VBIASP.n14 DELAY_VBIASP.t17 33.0005
R78 DELAY_VBIASP.n15 DELAY_VBIASP.t16 33.0005
R79 DELAY_VBIASP.n16 DELAY_VBIASP.t15 33.0005
R80 DELAY_VBIASP.n17 DELAY_VBIASP.t14 33.0005
R81 DELAY_VBIASP.n18 DELAY_VBIASP.t13 33.0005
R82 DELAY_VBIASP.n19 DELAY_VBIASP.t12 33.0005
R83 DELAY_VBIASP.n20 DELAY_VBIASP.t11 33.0005
R84 DELAY_VBIASP.n21 DELAY_VBIASP.t10 33.0005
R85 DELAY_VBIASP.n22 DELAY_VBIASP.t9 33.0005
R86 DELAY_VBIASP.n23 DELAY_VBIASP.t8 33.0005
R87 DELAY_VBIASP.n24 DELAY_VBIASP.t7 33.0005
R88 DELAY_VBIASP.n25 DELAY_VBIASP.t6 33.0005
R89 DELAY_VBIASP.n26 DELAY_VBIASP.t5 33.0005
R90 DELAY_VBIASP.n27 DELAY_VBIASP.t4 33.0005
R91 DELAY_VBIASP.n28 DELAY_VBIASP.t3 33.0005
R92 DELAY_VBIASP.n29 DELAY_VBIASP.t2 33.0005
R93 DELAY_VBIASP.n30 DELAY_VBIASP.t1 33.0005
R94 DELAY_VBIASP.n0 DELAY_VBIASP.t0 33.0005
R95 DELAY_VBIASP DELAY_VBIASP.n0 1.70586
R96 DELAY_VBIASP.n0 DELAY_VBIASP.n30 1.36852
R97 DELAY_VBIASP.n30 DELAY_VBIASP.n29 1.36852
R98 DELAY_VBIASP.n29 DELAY_VBIASP.n28 1.36852
R99 DELAY_VBIASP.n28 DELAY_VBIASP.n27 1.36852
R100 DELAY_VBIASP.n27 DELAY_VBIASP.n26 1.36852
R101 DELAY_VBIASP.n26 DELAY_VBIASP.n25 1.36852
R102 DELAY_VBIASP.n25 DELAY_VBIASP.n24 1.36852
R103 DELAY_VBIASP.n24 DELAY_VBIASP.n23 1.36852
R104 DELAY_VBIASP.n23 DELAY_VBIASP.n22 1.36852
R105 DELAY_VBIASP.n22 DELAY_VBIASP.n21 1.36852
R106 DELAY_VBIASP.n21 DELAY_VBIASP.n20 1.36852
R107 DELAY_VBIASP.n20 DELAY_VBIASP.n19 1.36852
R108 DELAY_VBIASP.n19 DELAY_VBIASP.n18 1.36852
R109 DELAY_VBIASP.n18 DELAY_VBIASP.n17 1.36852
R110 DELAY_VBIASP.n17 DELAY_VBIASP.n16 1.36852
R111 DELAY_VBIASP.n16 DELAY_VBIASP.n15 1.36852
R112 DELAY_VBIASP.n15 DELAY_VBIASP.n14 1.36852
R113 DELAY_VBIASP.n14 DELAY_VBIASP.n13 1.36852
R114 DELAY_VBIASP.n13 DELAY_VBIASP.n12 1.36852
R115 DELAY_VBIASP.n12 DELAY_VBIASP.n11 1.36852
R116 DELAY_VBIASP.n11 DELAY_VBIASP.n10 1.36852
R117 DELAY_VBIASP.n10 DELAY_VBIASP.n9 1.36852
R118 DELAY_VBIASP.n9 DELAY_VBIASP.n8 1.36852
R119 DELAY_VBIASP.n8 DELAY_VBIASP.n7 1.36852
R120 DELAY_VBIASP.n7 DELAY_VBIASP.n6 1.36852
R121 DELAY_VBIASP.n6 DELAY_VBIASP.n5 1.36852
R122 DELAY_VBIASP.n5 DELAY_VBIASP.n4 1.36852
R123 DELAY_VBIASP.n4 DELAY_VBIASP.n3 1.36852
R124 DELAY_VBIASP.n3 DELAY_VBIASP.n2 1.36852
R125 DELAY_VBIASP.n2 DELAY_VBIASP.n1 1.36852
R126 VSS.n6 VSS.n346 7907.02
R127 VSS.t306 VSS.n6 101.74
R128 VSS.n6 VSS.t323 58.3208
R129 VSS.t366 VSS.n6 101.74
R130 VSS.n6 VSS.t51 21.1052
R131 VSS.t181 VSS.n4 25.6732
R132 VSS.t519 VSS.n13 15.2265
R133 VSS.n6 VSS.n16 0.547872
R134 VSS.n6 VSS.t373 49.8619
R135 VSS.n6 VSS.t361 97.2306
R136 VSS.t328 VSS.n6 49.8619
R137 VSS.t313 VSS.n6 49.8619
R138 VSS.t298 VSS.n6 49.8619
R139 VSS.n9 VSS.t520 409.723
R140 VSS.t522 VSS.n6 21.009
R141 VSS.t170 VSS.n11 221.012
R142 VSS.t57 VSS.n397 357.007
R143 VSS.t59 VSS.n10 343.118
R144 VSS.n6 VSS.t517 97.2225
R145 VSS.n6 VSS.t316 97.2306
R146 VSS.n6 VSS.t346 97.2306
R147 VSS.n6 VSS.t376 97.2306
R148 VSS.t0 VSS.n14 332.017
R149 VSS.n6 VSS.t321 101.74
R150 VSS.n6 VSS.t336 101.74
R151 VSS.n398 VSS.t180 299.425
R152 VSS.t538 VSS.n6 116.469
R153 VSS.t30 VSS.n6 110.547
R154 VSS.t133 VSS.n6 110.547
R155 VSS.n6 VSS.t100 116.468
R156 VSS.t44 VSS.n6 110.547
R157 VSS.t130 VSS.n6 110.547
R158 VSS.n6 VSS.t97 116.468
R159 VSS.n398 VSS.t36 287.909
R160 VSS.n6 VSS.t286 114.148
R161 VSS.t283 VSS.n9 105.523
R162 VSS.t2 VSS.n14 106.362
R163 VSS.t186 VSS.n15 332.017
R164 VSS.t131 VSS.n6 116.468
R165 VSS.t45 VSS.n6 116.468
R166 VSS.t184 VSS.n12 107.335
R167 VSS.t285 VSS.n170 252.375
R168 VSS.t561 VSS.n207 252.375
R169 VSS.t414 VSS.n263 252.375
R170 VSS.n317 VSS.t407 252.375
R171 VSS.n174 VSS.t534 252.375
R172 VSS.t415 VSS.n184 252.375
R173 VSS.t42 VSS.n195 252.375
R174 VSS.n737 VSS.t524 252.375
R175 VSS.t214 VSS.n226 252.375
R176 VSS.n698 VSS.t402 252.375
R177 VSS.t179 VSS.n244 252.375
R178 VSS.n660 VSS.t399 252.375
R179 VSS.t43 VSS.n274 252.375
R180 VSS.n606 VSS.t4 252.375
R181 VSS.t49 VSS.n296 252.375
R182 VSS.n568 VSS.t104 252.375
R183 VSS.t418 VSS.n327 252.375
R184 VSS.t227 VSS.n181 252.117
R185 VSS.t90 VSS.n202 252.117
R186 VSS.t562 VSS.n292 252.117
R187 VSS.n303 VSS.t193 252.117
R188 VSS.n783 VSS.t413 252.115
R189 VSS.t284 VSS.n58 252.115
R190 VSS.t416 VSS.n61 252.115
R191 VSS.n709 VSS.t511 252.115
R192 VSS.t76 VSS.n69 252.115
R193 VSS.n670 VSS.t75 252.115
R194 VSS.t419 VSS.n75 252.115
R195 VSS.t391 VSS.n80 252.115
R196 VSS.n616 VSS.t487 252.115
R197 VSS.n559 VSS.t409 252.115
R198 VSS.t7 VSS.n95 252.115
R199 VSS.t438 VSS.n172 250.837
R200 VSS.t440 VSS.n176 250.837
R201 VSS.t434 VSS.n183 250.837
R202 VSS.t442 VSS.n186 250.837
R203 VSS.t448 VSS.n193 250.837
R204 VSS.t452 VSS.n197 250.837
R205 VSS.t424 VSS.n205 250.837
R206 VSS.t454 VSS.n210 250.837
R207 VSS.t432 VSS.n216 250.837
R208 VSS.t428 VSS.n219 250.837
R209 VSS.t456 VSS.n225 250.837
R210 VSS.t420 VSS.n229 250.837
R211 VSS.t464 VSS.n235 250.837
R212 VSS.t466 VSS.n237 250.837
R213 VSS.t462 VSS.n243 250.837
R214 VSS.t460 VSS.n247 250.837
R215 VSS.t468 VSS.n254 250.837
R216 VSS.t472 VSS.n256 250.837
R217 VSS.t470 VSS.n262 250.837
R218 VSS.t474 VSS.n266 250.837
R219 VSS.t458 VSS.n272 250.837
R220 VSS.t478 VSS.n277 250.837
R221 VSS.t476 VSS.n284 250.837
R222 VSS.t450 VSS.n287 250.837
R223 VSS.t422 VSS.n295 250.837
R224 VSS.t430 VSS.n298 250.837
R225 VSS.t480 VSS.n305 250.837
R226 VSS.t446 VSS.n308 250.837
R227 VSS.t426 VSS.n315 250.837
R228 VSS.t444 VSS.n319 250.837
R229 VSS.t436 VSS.n326 250.837
R230 VSS.t482 VSS.n330 250.837
R231 VSS.n6 VSS.t296 117.531
R232 VSS.n6 VSS.t311 117.528
R233 VSS.n6 VSS.t326 117.531
R234 VSS.n6 VSS.t371 117.529
R235 VSS.n803 VSS.t220 234.114
R236 VSS.n784 VSS.t395 234.114
R237 VSS.n765 VSS.t378 234.114
R238 VSS.n748 VSS.t199 234.114
R239 VSS.n728 VSS.t500 234.114
R240 VSS.n710 VSS.t107 234.114
R241 VSS.n690 VSS.t509 234.114
R242 VSS.n671 VSS.t529 234.114
R243 VSS.n651 VSS.t10 234.114
R244 VSS.n634 VSS.t112 234.114
R245 VSS.n617 VSS.t40 234.114
R246 VSS.n598 VSS.t226 234.114
R247 VSS.n579 VSS.t118 234.114
R248 VSS.n560 VSS.t212 234.114
R249 VSS.n542 VSS.t189 234.114
R250 VSS.n525 VSS.t400 234.114
R251 VSS.t170 VSS.n397 230.327
R252 VSS.t280 VSS.n6 117.216
R253 VSS.t393 VSS.n192 225.361
R254 VSS.t380 VSS.n204 225.361
R255 VSS.t530 VSS.n253 225.361
R256 VSS.t38 VSS.n283 225.361
R257 VSS.t224 VSS.n294 225.361
R258 VSS.t210 VSS.n314 225.361
R259 VSS.t191 VSS.n325 225.361
R260 VSS.n819 VSS.t160 225.359
R261 VSS.n802 VSS.t221 225.359
R262 VSS.n747 VSS.t201 225.359
R263 VSS.t498 VSS.n62 225.359
R264 VSS.t105 VSS.n65 225.359
R265 VSS.n689 VSS.t507 225.359
R266 VSS.t8 VSS.n76 225.359
R267 VSS.t110 VSS.n81 225.359
R268 VSS.t116 VSS.n89 225.359
R269 VSS.n6 VSS.t544 116.469
R270 VSS.t151 VSS.n51 211.982
R271 VSS.t540 VSS.n72 211.982
R272 VSS.t274 VSS.n77 211.982
R273 VSS.t18 VSS.n96 211.982
R274 VSS.n721 VSS.t139 211.982
R275 VSS.n702 VSS.t262 211.982
R276 VSS.n682 VSS.t69 211.982
R277 VSS.n591 VSS.t265 211.982
R278 VSS.n572 VSS.t72 211.982
R279 VSS.n173 VSS.t93 211.982
R280 VSS.n194 VSS.t555 211.982
R281 VSS.n206 VSS.t136 211.982
R282 VSS.n217 VSS.t271 211.982
R283 VSS.n273 VSS.t268 211.982
R284 VSS.n285 VSS.t148 211.982
R285 VSS.n316 VSS.t194 211.982
R286 VSS.n10 VSS.t282 107.931
R287 VSS.t183 VSS.n12 398.622
R288 VSS.t176 VSS.n209 195.26
R289 VSS.t113 VSS.n228 195.26
R290 VSS.t489 VSS.n246 195.26
R291 VSS.t63 VSS.n265 195.26
R292 VSS.t390 VSS.n276 195.26
R293 VSS.t175 VSS.n307 195.26
R294 VSS.t206 VSS.n329 195.26
R295 VSS.t502 VSS.n49 195.26
R296 VSS.n792 VSS.t203 195.26
R297 VSS.n773 VSS.t412 195.26
R298 VSS.n736 VSS.t404 195.26
R299 VSS.t215 VSS.n67 195.26
R300 VSS.n659 VSS.t387 195.26
R301 VSS.t536 VSS.n85 195.26
R302 VSS.n587 VSS.t496 195.26
R303 VSS.t559 VSS.n93 195.26
R304 VSS.t187 VSS.n15 106.362
R305 VSS.n6 VSS.n14 6.82737
R306 VSS.n809 VSS.t28 187.292
R307 VSS.n790 VSS.t124 187.292
R308 VSS.n771 VSS.t65 187.292
R309 VSS.n754 VSS.t83 187.292
R310 VSS.n734 VSS.t166 187.292
R311 VSS.n716 VSS.t33 187.292
R312 VSS.n696 VSS.t81 187.292
R313 VSS.n677 VSS.t234 187.292
R314 VSS.n657 VSS.t236 187.292
R315 VSS.n640 VSS.t516 187.292
R316 VSS.n623 VSS.t128 187.292
R317 VSS.n604 VSS.t243 187.292
R318 VSS.n585 VSS.t554 187.292
R319 VSS.n566 VSS.t168 187.292
R320 VSS.n548 VSS.t241 187.292
R321 VSS.n531 VSS.t126 187.292
R322 VSS.n6 VSS.t96 110.547
R323 VSS.n6 VSS.t99 110.547
R324 VSS.n6 VSS.t543 110.546
R325 VSS.t537 VSS.n6 110.546
R326 VSS.t88 VSS.n180 173.913
R327 VSS.t122 VSS.n190 173.913
R328 VSS.t552 VSS.n201 173.913
R329 VSS.n214 VSS.t260 173.913
R330 VSS.n223 VSS.t278 173.913
R331 VSS.t158 VSS.n233 173.913
R332 VSS.n241 VSS.t143 173.913
R333 VSS.t13 VSS.n251 173.913
R334 VSS.n260 VSS.t549 173.913
R335 VSS.n270 VSS.t232 173.913
R336 VSS.t22 VSS.n281 173.913
R337 VSS.t229 VSS.n291 173.913
R338 VSS.t146 VSS.n302 173.913
R339 VSS.t16 VSS.n312 173.913
R340 VSS.n323 VSS.t239 173.913
R341 VSS.t155 VSS.n334 173.913
R342 VSS.n346 VSS.n337 173.913
R343 VSS.t94 VSS.t503 163.881
R344 VSS.t152 VSS.t204 163.881
R345 VSS.t556 VSS.t410 163.881
R346 VSS.t137 VSS.t177 163.881
R347 VSS.t272 VSS.t405 163.881
R348 VSS.t140 VSS.t114 163.881
R349 VSS.t263 VSS.t216 163.881
R350 VSS.t70 VSS.t488 163.881
R351 VSS.t541 VSS.t388 163.881
R352 VSS.t275 VSS.t61 163.881
R353 VSS.t269 VSS.t389 163.881
R354 VSS.t149 VSS.t535 163.881
R355 VSS.t266 VSS.t495 163.881
R356 VSS.t73 VSS.t173 163.881
R357 VSS.t195 VSS.t560 163.881
R358 VSS.t19 VSS.t207 163.881
R359 VSS.n6 VSS.t288 105.688
R360 VSS.n6 VSS.t303 105.688
R361 VSS.n6 VSS.t318 105.688
R362 VSS.n6 VSS.t333 105.688
R363 VSS.n6 VSS.t348 105.688
R364 VSS.n6 VSS.t363 105.689
R365 VSS.t514 VSS.n42 157.062
R366 VSS.t493 VSS.n44 156.429
R367 VSS.t526 VSS.n173 155.126
R368 VSS.t485 VSS.n194 155.126
R369 VSS.t558 VSS.n206 155.126
R370 VSS.t385 VSS.n217 155.126
R371 VSS.t102 VSS.n273 155.126
R372 VSS.t85 VSS.n285 155.126
R373 VSS.t532 VSS.n316 155.126
R374 VSS.t223 VSS.n51 155.125
R375 VSS.n721 VSS.t392 155.125
R376 VSS.n702 VSS.t417 155.125
R377 VSS.n682 VSS.t397 155.125
R378 VSS.t208 VSS.n72 155.125
R379 VSS.t521 VSS.n77 155.125
R380 VSS.n591 VSS.t382 155.125
R381 VSS.n572 VSS.t408 155.125
R382 VSS.t5 VSS.n96 155.125
R383 VSS.n832 VSS.t79 153.846
R384 VSS.n809 VSS.t87 153.846
R385 VSS.n790 VSS.t121 153.846
R386 VSS.n771 VSS.t551 153.846
R387 VSS.n754 VSS.t259 153.846
R388 VSS.n734 VSS.t277 153.846
R389 VSS.n716 VSS.t157 153.846
R390 VSS.n696 VSS.t142 153.846
R391 VSS.n677 VSS.t12 153.846
R392 VSS.n657 VSS.t548 153.846
R393 VSS.n640 VSS.t231 153.846
R394 VSS.n623 VSS.t21 153.846
R395 VSS.n604 VSS.t228 153.846
R396 VSS.n585 VSS.t145 153.846
R397 VSS.n566 VSS.t15 153.846
R398 VSS.n548 VSS.t238 153.846
R399 VSS.n531 VSS.t154 153.846
R400 VSS.t164 VSS.n44 153.327
R401 VSS.t515 VSS.n45 153.236
R402 VSS.t36 VSS.n13 165.508
R403 VSS.t197 VSS.n179 147.157
R404 VSS.t506 VSS.n189 147.157
R405 VSS.t505 VSS.n200 147.157
R406 VSS.t494 VSS.n213 147.157
R407 VSS.t525 VSS.n222 147.157
R408 VSS.t120 VSS.n232 147.157
R409 VSS.t523 VSS.n240 147.157
R410 VSS.t47 VSS.n250 147.157
R411 VSS.t484 VSS.n259 147.157
R412 VSS.t67 VSS.n269 147.157
R413 VSS.t109 VSS.n280 147.157
R414 VSS.t218 VSS.n290 147.157
R415 VSS.t406 VSS.n301 147.157
R416 VSS.t384 VSS.n311 147.157
R417 VSS.t403 VSS.n322 147.157
R418 VSS.t486 VSS.n333 147.157
R419 VSS.n518 VSS.t257 145.093
R420 VSS.t253 VSS.n518 138.404
R421 VSS.t331 VSS.n6 97.2306
R422 VSS.t301 VSS.n6 97.2306
R423 VSS.n845 VSS.t546 134.661
R424 VSS.n524 VSS.t253 131.974
R425 VSS.n3 VSS.t0 130.939
R426 VSS.n16 VSS.t186 131.005
R427 VSS.n842 VSS.t24 126.945
R428 VSS.n843 VSS.t55 123.212
R429 VSS.n45 VSS.t493 120.691
R430 VSS.n5 VSS.t59 119.422
R431 VSS.t512 VSS.n845 117.858
R432 VSS.t257 VSS.n337 117.058
R433 VSS.t527 VSS.n38 115.745
R434 VSS.t528 VSS.n40 108.276
R435 VSS.n811 VSS.t526 107.023
R436 VSS.n803 VSS.t197 107.023
R437 VSS.n793 VSS.t223 107.023
R438 VSS.n784 VSS.t506 107.023
R439 VSS.n774 VSS.t485 107.023
R440 VSS.n765 VSS.t505 107.023
R441 VSS.n756 VSS.t558 107.023
R442 VSS.n748 VSS.t494 107.023
R443 VSS.n738 VSS.t385 107.023
R444 VSS.n728 VSS.t525 107.023
R445 VSS.t392 VSS.n718 107.023
R446 VSS.n710 VSS.t120 107.023
R447 VSS.t417 VSS.n699 107.023
R448 VSS.n690 VSS.t523 107.023
R449 VSS.t397 VSS.n679 107.023
R450 VSS.n671 VSS.t47 107.023
R451 VSS.n661 VSS.t208 107.023
R452 VSS.n651 VSS.t484 107.023
R453 VSS.n642 VSS.t521 107.023
R454 VSS.n634 VSS.t67 107.023
R455 VSS.n625 VSS.t102 107.023
R456 VSS.n617 VSS.t109 107.023
R457 VSS.n607 VSS.t85 107.023
R458 VSS.n598 VSS.t218 107.023
R459 VSS.t382 VSS.n588 107.023
R460 VSS.n579 VSS.t406 107.023
R461 VSS.t408 VSS.n569 107.023
R462 VSS.n560 VSS.t384 107.023
R463 VSS.n550 VSS.t532 107.023
R464 VSS.n542 VSS.t403 107.023
R465 VSS.n533 VSS.t5 107.023
R466 VSS.n525 VSS.t486 107.023
R467 VSS.n832 VSS.t246 100.335
R468 VSS.t87 VSS.n179 100.335
R469 VSS.t121 VSS.n189 100.335
R470 VSS.t551 VSS.n200 100.335
R471 VSS.t259 VSS.n213 100.335
R472 VSS.t277 VSS.n222 100.335
R473 VSS.t157 VSS.n232 100.335
R474 VSS.t142 VSS.n240 100.335
R475 VSS.t12 VSS.n250 100.335
R476 VSS.t548 VSS.n259 100.335
R477 VSS.t231 VSS.n269 100.335
R478 VSS.t21 VSS.n280 100.335
R479 VSS.t228 VSS.n290 100.335
R480 VSS.t145 VSS.n301 100.335
R481 VSS.t15 VSS.n311 100.335
R482 VSS.t238 VSS.n322 100.335
R483 VSS.t154 VSS.n333 100.335
R484 VSS.n841 VSS.t162 97.0758
R485 VSS.n2 VSS.t57 96.5008
R486 VSS.t26 VSS.n42 93.5889
R487 VSS.n841 VSS.t547 93.3421
R488 VSS.n524 VSS.t155 88.4945
R489 VSS.t260 VSS.n58 88.2366
R490 VSS.t278 VSS.n61 88.2366
R491 VSS.t143 VSS.n69 88.2366
R492 VSS.t549 VSS.n75 88.2366
R493 VSS.t232 VSS.n80 88.2366
R494 VSS.t239 VSS.n95 88.2366
R495 VSS.n783 VSS.t122 88.2366
R496 VSS.n709 VSS.t158 88.2366
R497 VSS.n670 VSS.t13 88.2366
R498 VSS.n616 VSS.t22 88.2366
R499 VSS.n559 VSS.t16 88.2366
R500 VSS.n181 VSS.t88 88.2359
R501 VSS.n202 VSS.t552 88.2359
R502 VSS.n292 VSS.t229 88.2359
R503 VSS.n303 VSS.t146 88.2359
R504 VSS.n846 VSS.t490 88.133
R505 VSS.n346 VSS.n17 88.4708
R506 VSS.t246 VSS.t77 86.957
R507 VSS.t79 VSS.t250 86.957
R508 VSS.t35 VSS.n2 69.4495
R509 VSS.t490 VSS.n8 82.7875
R510 VSS.n40 VSS.t492 82.1411
R511 VSS.t492 VSS.n39 75.0671
R512 VSS.t77 VSS.n168 74.8587
R513 VSS.t53 VSS.n38 74.6738
R514 VSS.t171 VSS.n11 59.6836
R515 VSS.n811 VSS.t94 70.2346
R516 VSS.n793 VSS.t152 70.2346
R517 VSS.n774 VSS.t556 70.2346
R518 VSS.n756 VSS.t137 70.2346
R519 VSS.n738 VSS.t272 70.2346
R520 VSS.n718 VSS.t140 70.2346
R521 VSS.n699 VSS.t263 70.2346
R522 VSS.n679 VSS.t70 70.2346
R523 VSS.n661 VSS.t541 70.2346
R524 VSS.n642 VSS.t275 70.2346
R525 VSS.n625 VSS.t269 70.2346
R526 VSS.n607 VSS.t149 70.2346
R527 VSS.n588 VSS.t266 70.2346
R528 VSS.n569 VSS.t73 70.2346
R529 VSS.n550 VSS.t195 70.2346
R530 VSS.n533 VSS.t19 70.2346
R531 VSS.t338 VSS.n6 58.3217
R532 VSS.t353 VSS.n6 58.3217
R533 VSS.n843 VSS.t53 67.2065
R534 VSS.n810 VSS.t502 66.8901
R535 VSS.t28 VSS.n176 66.8901
R536 VSS.t203 VSS.n791 66.8901
R537 VSS.t124 VSS.n186 66.8901
R538 VSS.t412 VSS.n772 66.8901
R539 VSS.t65 VSS.n197 66.8901
R540 VSS.n755 VSS.t176 66.8901
R541 VSS.t83 VSS.n210 66.8901
R542 VSS.t404 VSS.n735 66.8901
R543 VSS.t166 VSS.n219 66.8901
R544 VSS.n717 VSS.t113 66.8901
R545 VSS.t33 VSS.n229 66.8901
R546 VSS.n697 VSS.t215 66.8901
R547 VSS.t81 VSS.n237 66.8901
R548 VSS.n678 VSS.t489 66.8901
R549 VSS.t234 VSS.n247 66.8901
R550 VSS.t387 VSS.n658 66.8901
R551 VSS.t236 VSS.n256 66.8901
R552 VSS.n641 VSS.t63 66.8901
R553 VSS.t516 VSS.n266 66.8901
R554 VSS.n624 VSS.t390 66.8901
R555 VSS.t128 VSS.n277 66.8901
R556 VSS.n605 VSS.t536 66.8901
R557 VSS.t243 VSS.n287 66.8901
R558 VSS.t496 VSS.n586 66.8901
R559 VSS.t554 VSS.n298 66.8901
R560 VSS.n567 VSS.t175 66.8901
R561 VSS.t168 VSS.n308 66.8901
R562 VSS.n549 VSS.t559 66.8901
R563 VSS.t241 VSS.n319 66.8901
R564 VSS.n532 VSS.t206 66.8901
R565 VSS.t126 VSS.n330 66.8901
R566 VSS.n842 VSS.t26 63.4728
R567 VSS.t547 VSS.n43 62.2523
R568 VSS.t183 VSS.n5 61.8407
R569 VSS.t162 VSS.n840 58.5186
R570 VSS.t50 VSS.n6 49.7663
R571 VSS.n6 VSS.t343 49.8619
R572 VSS.n6 VSS.t358 49.8619
R573 VSS.n846 VSS.t512 54.532
R574 VSS.t520 VSS.n3 50.3244
R575 VSS.t91 VSS.n16 44.8755
R576 VSS.t93 VSS.n172 50.1677
R577 VSS.n183 VSS.t151 50.1677
R578 VSS.t555 VSS.n193 50.1677
R579 VSS.t136 VSS.n205 50.1677
R580 VSS.t271 VSS.n216 50.1677
R581 VSS.t139 VSS.n225 50.1677
R582 VSS.t262 VSS.n235 50.1677
R583 VSS.t69 VSS.n243 50.1677
R584 VSS.n254 VSS.t540 50.1677
R585 VSS.n262 VSS.t274 50.1677
R586 VSS.t268 VSS.n272 50.1677
R587 VSS.t148 VSS.n284 50.1677
R588 VSS.t265 VSS.n295 50.1677
R589 VSS.t72 VSS.n305 50.1677
R590 VSS.t194 VSS.n315 50.1677
R591 VSS.n326 VSS.t18 50.1677
R592 VSS.n41 VSS.t528 47.3176
R593 VSS.n844 VSS.t527 39.8503
R594 VSS.t160 VSS.n818 36.7898
R595 VSS.t221 VSS.n801 36.7898
R596 VSS.n782 VSS.t393 36.7898
R597 VSS.n764 VSS.t380 36.7898
R598 VSS.t201 VSS.n746 36.7898
R599 VSS.n727 VSS.t498 36.7898
R600 VSS.n708 VSS.t105 36.7898
R601 VSS.t507 VSS.n688 36.7898
R602 VSS.n669 VSS.t530 36.7898
R603 VSS.n650 VSS.t8 36.7898
R604 VSS.n633 VSS.t110 36.7898
R605 VSS.n615 VSS.t38 36.7898
R606 VSS.n597 VSS.t224 36.7898
R607 VSS.n578 VSS.t116 36.7898
R608 VSS.n558 VSS.t210 36.7898
R609 VSS.n541 VSS.t191 36.7898
R610 VSS.t546 VSS.n844 36.1166
R611 VSS.t55 VSS.n39 33.9948
R612 VSS.t24 VSS.n41 28.6493
R613 VSS.t503 VSS.n174 28.2938
R614 VSS.t204 VSS.n184 28.2938
R615 VSS.t410 VSS.n195 28.2938
R616 VSS.t405 VSS.n737 28.2938
R617 VSS.t114 VSS.n226 28.2938
R618 VSS.t216 VSS.n698 28.2938
R619 VSS.t488 VSS.n244 28.2938
R620 VSS.t388 VSS.n660 28.2938
R621 VSS.t389 VSS.n274 28.2938
R622 VSS.t535 VSS.n606 28.2938
R623 VSS.t495 VSS.n296 28.2938
R624 VSS.t173 VSS.n568 28.2938
R625 VSS.t207 VSS.n327 28.2938
R626 VSS.t177 VSS.n207 28.2928
R627 VSS.t61 VSS.n263 28.2928
R628 VSS.t560 VSS.n317 28.2928
R629 VSS.n168 VSS.t515 28.0352
R630 VSS.t180 VSS.n4 154.007
R631 VSS.t250 VSS.n170 21.6039
R632 VSS.t220 VSS.n180 20.0674
R633 VSS.t395 VSS.n190 20.0674
R634 VSS.t378 VSS.n201 20.0674
R635 VSS.t199 VSS.n214 20.0674
R636 VSS.t500 VSS.n223 20.0674
R637 VSS.t107 VSS.n233 20.0674
R638 VSS.t509 VSS.n241 20.0674
R639 VSS.t529 VSS.n251 20.0674
R640 VSS.t10 VSS.n260 20.0674
R641 VSS.t112 VSS.n270 20.0674
R642 VSS.t40 VSS.n281 20.0674
R643 VSS.t226 VSS.n291 20.0674
R644 VSS.t118 VSS.n302 20.0674
R645 VSS.t212 VSS.n312 20.0674
R646 VSS.t189 VSS.n323 20.0674
R647 VSS.t400 VSS.n334 20.0674
R648 VSS.t534 VSS.n49 18.0025
R649 VSS.n62 VSS.t416 18.0025
R650 VSS.t511 VSS.n65 18.0025
R651 VSS.t402 VSS.n67 18.0025
R652 VSS.n76 VSS.t419 18.0025
R653 VSS.n81 VSS.t391 18.0025
R654 VSS.t4 VSS.n85 18.0025
R655 VSS.t193 VSS.n89 18.0025
R656 VSS.t407 VSS.n93 18.0025
R657 VSS.n819 VSS.t285 18.0025
R658 VSS.n802 VSS.t227 18.0025
R659 VSS.n792 VSS.t415 18.0025
R660 VSS.n773 VSS.t42 18.0025
R661 VSS.n747 VSS.t284 18.0025
R662 VSS.t524 VSS.n736 18.0025
R663 VSS.n689 VSS.t76 18.0025
R664 VSS.t399 VSS.n659 18.0025
R665 VSS.n587 VSS.t49 18.0025
R666 VSS.t413 VSS.n192 18.0017
R667 VSS.n204 VSS.t90 18.0017
R668 VSS.n209 VSS.t561 18.0017
R669 VSS.n228 VSS.t214 18.0017
R670 VSS.n246 VSS.t179 18.0017
R671 VSS.t75 VSS.n253 18.0017
R672 VSS.n265 VSS.t414 18.0017
R673 VSS.n276 VSS.t43 18.0017
R674 VSS.t487 VSS.n283 18.0017
R675 VSS.n294 VSS.t562 18.0017
R676 VSS.t104 VSS.n307 18.0017
R677 VSS.t409 VSS.n314 18.0017
R678 VSS.n325 VSS.t7 18.0017
R679 VSS.n329 VSS.t418 18.0017
R680 VSS.n840 VSS.t164 17.4483
R681 VSS.n861 VSS.t163 17.3368
R682 VSS.n857 VSS.t25 17.3368
R683 VSS.n853 VSS.t54 17.3368
R684 VSS.n405 VSS.t58 17.3368
R685 VSS.n409 VSS.t60 17.3368
R686 VSS.n413 VSS.t37 17.3368
R687 VSS.n417 VSS.t1 17.3368
R688 VSS.n837 VSS.t78 17.3368
R689 VSS.n466 VSS.t92 17.2607
R690 VSS.n396 VSS.t290 17.2313
R691 VSS.n424 VSS.t295 17.2313
R692 VSS.n428 VSS.t300 17.2313
R693 VSS.n388 VSS.t305 17.2313
R694 VSS.n439 VSS.t310 17.2313
R695 VSS.n443 VSS.t315 17.2313
R696 VSS.n380 VSS.t320 17.2313
R697 VSS.n454 VSS.t325 17.2313
R698 VSS.n458 VSS.t330 17.2313
R699 VSS.n372 VSS.t335 17.2313
R700 VSS.n477 VSS.t340 17.2313
R701 VSS.n481 VSS.t345 17.2313
R702 VSS.n364 VSS.t350 17.2313
R703 VSS.n492 VSS.t355 17.2313
R704 VSS.n496 VSS.t360 17.2313
R705 VSS.n356 VSS.t365 17.2313
R706 VSS.n507 VSS.t370 17.2313
R707 VSS.n511 VSS.t375 17.2313
R708 VSS.n848 VSS.n847 17.0005
R709 VSS.n847 VSS.n38 17.0005
R710 VSS.n847 VSS.n843 17.0005
R711 VSS.n847 VSS.n40 17.0005
R712 VSS.n847 VSS.n842 17.0005
R713 VSS.n847 VSS.n841 17.0005
R714 VSS.n847 VSS.n839 17.0005
R715 VSS.n847 VSS.n171 17.0005
R716 VSS.n847 VSS.n178 17.0005
R717 VSS.n847 VSS.n188 17.0005
R718 VSS.n847 VSS.n199 17.0005
R719 VSS.n847 VSS.n212 17.0005
R720 VSS.n847 VSS.n221 17.0005
R721 VSS.n847 VSS.n231 17.0005
R722 VSS.n847 VSS.n239 17.0005
R723 VSS.n847 VSS.n249 17.0005
R724 VSS.n847 VSS.n258 17.0005
R725 VSS.n847 VSS.n268 17.0005
R726 VSS.n847 VSS.n279 17.0005
R727 VSS.n847 VSS.n289 17.0005
R728 VSS.n847 VSS.n300 17.0005
R729 VSS.n847 VSS.n310 17.0005
R730 VSS.n847 VSS.n321 17.0005
R731 VSS.n847 VSS.n332 17.0005
R732 VSS.n847 VSS.n335 17.0005
R733 VSS.n847 VSS.n523 17.0005
R734 VSS.n847 VSS.n336 17.0005
R735 VSS.n847 VSS.n517 17.0005
R736 VSS.n847 VSS.n338 17.0005
R737 VSS.n847 VSS.n167 17.0005
R738 VSS.n847 VSS.n47 17.0005
R739 VSS.n15 VSS.n6 6.82739
R740 VSS.n6 VSS.n25 5.65652
R741 VSS.n6 VSS.n19 5.65652
R742 VSS.n6 VSS.n9 9.73657
R743 VSS.n6 VSS.n398 17.0005
R744 VSS.n6 VSS.n12 9.32125
R745 VSS.n6 VSS.n10 7.24297
R746 VSS.n6 VSS.n11 2.67074
R747 VSS.n6 VSS.n397 17.0005
R748 VSS.n400 VSS.n6 17.0005
R749 VSS.n399 VSS.t289 17.0005
R750 VSS.n395 VSS.t292 17.0005
R751 VSS.n422 VSS.t294 17.0005
R752 VSS.n392 VSS.t297 17.0005
R753 VSS.n391 VSS.t299 17.0005
R754 VSS.n390 VSS.t302 17.0005
R755 VSS.n389 VSS.t304 17.0005
R756 VSS.n387 VSS.t307 17.0005
R757 VSS.n437 VSS.t309 17.0005
R758 VSS.n384 VSS.t312 17.0005
R759 VSS.n383 VSS.t314 17.0005
R760 VSS.n382 VSS.t317 17.0005
R761 VSS.n381 VSS.t319 17.0005
R762 VSS.n379 VSS.t322 17.0005
R763 VSS.n452 VSS.t324 17.0005
R764 VSS.n376 VSS.t327 17.0005
R765 VSS.n375 VSS.t329 17.0005
R766 VSS.n374 VSS.t332 17.0005
R767 VSS.n373 VSS.t334 17.0005
R768 VSS.n371 VSS.t337 17.0005
R769 VSS.n475 VSS.t339 17.0005
R770 VSS.n368 VSS.t342 17.0005
R771 VSS.n367 VSS.t344 17.0005
R772 VSS.n366 VSS.t347 17.0005
R773 VSS.n365 VSS.t349 17.0005
R774 VSS.n363 VSS.t352 17.0005
R775 VSS.n490 VSS.t354 17.0005
R776 VSS.n360 VSS.t357 17.0005
R777 VSS.n359 VSS.t359 17.0005
R778 VSS.n358 VSS.t362 17.0005
R779 VSS.n357 VSS.t364 17.0005
R780 VSS.n355 VSS.t367 17.0005
R781 VSS.n505 VSS.t369 17.0005
R782 VSS.n352 VSS.t372 17.0005
R783 VSS.n351 VSS.t374 17.0005
R784 VSS.n348 VSS.t377 17.0005
R785 VSS.n6 VSS.n13 0.592458
R786 VSS.n395 VSS.t597 15.3099
R787 VSS.n392 VSS.t595 15.3099
R788 VSS.n390 VSS.t593 15.3099
R789 VSS.n387 VSS.t591 15.3099
R790 VSS.n384 VSS.t589 15.3099
R791 VSS.n382 VSS.t587 15.3099
R792 VSS.n379 VSS.t585 15.3099
R793 VSS.n376 VSS.t583 15.3099
R794 VSS.n374 VSS.t581 15.3099
R795 VSS.n371 VSS.t579 15.3099
R796 VSS.n368 VSS.t577 15.3099
R797 VSS.n366 VSS.t575 15.3099
R798 VSS.n363 VSS.t573 15.3099
R799 VSS.n360 VSS.t571 15.3099
R800 VSS.n358 VSS.t569 15.3099
R801 VSS.n355 VSS.t567 15.3099
R802 VSS.n352 VSS.t565 15.3099
R803 VSS.n348 VSS.t563 15.3099
R804 VSS.n399 VSS.t598 15.2696
R805 VSS.n422 VSS.t596 15.2696
R806 VSS.n391 VSS.t594 15.2696
R807 VSS.n389 VSS.t592 15.2696
R808 VSS.n437 VSS.t590 15.2696
R809 VSS.n383 VSS.t588 15.2696
R810 VSS.n381 VSS.t586 15.2696
R811 VSS.n452 VSS.t584 15.2696
R812 VSS.n375 VSS.t582 15.2696
R813 VSS.n373 VSS.t580 15.2696
R814 VSS.n475 VSS.t578 15.2696
R815 VSS.n367 VSS.t576 15.2696
R816 VSS.n365 VSS.t574 15.2696
R817 VSS.n490 VSS.t572 15.2696
R818 VSS.n359 VSS.t570 15.2696
R819 VSS.n357 VSS.t568 15.2696
R820 VSS.n505 VSS.t566 15.2696
R821 VSS.n351 VSS.t564 15.2696
R822 VSS.n519 VSS.t252 15.1276
R823 VSS.n341 VSS.t256 15.0005
R824 VSS.n825 VSS.t249 15.0005
R825 VSS.n834 VSS.t245 15.0005
R826 VSS.n43 VSS.t514 13.7147
R827 VSS.n102 VSS.t401 8.85039
R828 VSS.n104 VSS.t6 8.85039
R829 VSS.n106 VSS.t190 8.85039
R830 VSS.n108 VSS.t533 8.85039
R831 VSS.n110 VSS.t213 8.85039
R832 VSS.n112 VSS.t174 8.85039
R833 VSS.n114 VSS.t119 8.85039
R834 VSS.n116 VSS.t383 8.85039
R835 VSS.n118 VSS.t219 8.85039
R836 VSS.n120 VSS.t86 8.85039
R837 VSS.n122 VSS.t41 8.85039
R838 VSS.n124 VSS.t103 8.85039
R839 VSS.n126 VSS.t68 8.85039
R840 VSS.n128 VSS.t62 8.85039
R841 VSS.n130 VSS.t11 8.85039
R842 VSS.n132 VSS.t209 8.85039
R843 VSS.n134 VSS.t48 8.85039
R844 VSS.n136 VSS.t398 8.85039
R845 VSS.n138 VSS.t510 8.85039
R846 VSS.n140 VSS.t217 8.85039
R847 VSS.n142 VSS.t108 8.85039
R848 VSS.n144 VSS.t115 8.85039
R849 VSS.n146 VSS.t501 8.85039
R850 VSS.n148 VSS.t386 8.85039
R851 VSS.n150 VSS.t200 8.85039
R852 VSS.n152 VSS.t178 8.85039
R853 VSS.n154 VSS.t379 8.85039
R854 VSS.n156 VSS.t411 8.85039
R855 VSS.n158 VSS.t396 8.85039
R856 VSS.n160 VSS.t205 8.85039
R857 VSS.n162 VSS.t198 8.85039
R858 VSS.n164 VSS.t504 8.85039
R859 VSS.n863 VSS.t165 8.80385
R860 VSS.n859 VSS.t27 8.80385
R861 VSS.n855 VSS.t56 8.80385
R862 VSS.n829 VSS.t80 8.80385
R863 VSS.n407 VSS.t172 8.80285
R864 VSS.n411 VSS.t185 8.80285
R865 VSS.n415 VSS.t182 8.80285
R866 VSS.n0 VSS.t3 8.80285
R867 VSS.n526 VSS.t156 8.77423
R868 VSS.n331 VSS.t127 8.77423
R869 VSS.n534 VSS.t20 8.77423
R870 VSS.n539 VSS.t192 8.77423
R871 VSS.n543 VSS.t240 8.77423
R872 VSS.n320 VSS.t242 8.77423
R873 VSS.n551 VSS.t196 8.77423
R874 VSS.n556 VSS.t211 8.77423
R875 VSS.n561 VSS.t17 8.77423
R876 VSS.n309 VSS.t169 8.77423
R877 VSS.n570 VSS.t74 8.77423
R878 VSS.n576 VSS.t117 8.77423
R879 VSS.n580 VSS.t147 8.77423
R880 VSS.n299 VSS.t497 8.77423
R881 VSS.n589 VSS.t267 8.77423
R882 VSS.n595 VSS.t225 8.77423
R883 VSS.n599 VSS.t230 8.77423
R884 VSS.n288 VSS.t244 8.77423
R885 VSS.n608 VSS.t150 8.77423
R886 VSS.n613 VSS.t39 8.77423
R887 VSS.n618 VSS.t23 8.77423
R888 VSS.n278 VSS.t129 8.77423
R889 VSS.n626 VSS.t270 8.77423
R890 VSS.n631 VSS.t111 8.77423
R891 VSS.n635 VSS.t233 8.77423
R892 VSS.n267 VSS.t64 8.77423
R893 VSS.n643 VSS.t276 8.77423
R894 VSS.n648 VSS.t9 8.77423
R895 VSS.n652 VSS.t550 8.77423
R896 VSS.n257 VSS.t237 8.77423
R897 VSS.n662 VSS.t542 8.77423
R898 VSS.n667 VSS.t531 8.77423
R899 VSS.n672 VSS.t14 8.77423
R900 VSS.n248 VSS.t235 8.77423
R901 VSS.n680 VSS.t71 8.77423
R902 VSS.n686 VSS.t508 8.77423
R903 VSS.n691 VSS.t144 8.77423
R904 VSS.n238 VSS.t82 8.77423
R905 VSS.n700 VSS.t264 8.77423
R906 VSS.n706 VSS.t106 8.77423
R907 VSS.n711 VSS.t159 8.77423
R908 VSS.n230 VSS.t34 8.77423
R909 VSS.n719 VSS.t141 8.77423
R910 VSS.n725 VSS.t499 8.77423
R911 VSS.n729 VSS.t279 8.77423
R912 VSS.n220 VSS.t167 8.77423
R913 VSS.n739 VSS.t273 8.77423
R914 VSS.n744 VSS.t202 8.77423
R915 VSS.n749 VSS.t261 8.77423
R916 VSS.n211 VSS.t84 8.77423
R917 VSS.n757 VSS.t138 8.77423
R918 VSS.n762 VSS.t381 8.77423
R919 VSS.n766 VSS.t553 8.77423
R920 VSS.n198 VSS.t66 8.77423
R921 VSS.n775 VSS.t557 8.77423
R922 VSS.n780 VSS.t394 8.77423
R923 VSS.n785 VSS.t123 8.77423
R924 VSS.n187 VSS.t125 8.77423
R925 VSS.n794 VSS.t153 8.77423
R926 VSS.n799 VSS.t222 8.77423
R927 VSS.n804 VSS.t89 8.77423
R928 VSS.n177 VSS.t29 8.77423
R929 VSS.n812 VSS.t95 8.77423
R930 VSS.n820 VSS.t161 8.77423
R931 VSS.n7 VSS.t98 8.82841
R932 VSS.n432 VSS.t132 8.77323
R933 VSS.n447 VSS.t46 8.77323
R934 VSS.n462 VSS.t545 8.77323
R935 VSS.n464 VSS.t52 8.77323
R936 VSS.n470 VSS.t101 8.77323
R937 VSS.n485 VSS.t135 8.77323
R938 VSS.n500 VSS.t32 8.77323
R939 VSS.n345 VSS.t539 8.77323
R940 VSS.n1 VSS.t287 8.79211
R941 VSS.n468 VSS.t188 8.76678
R942 VSS.n851 VSS.t513 8.75731
R943 VSS.n849 VSS.t491 8.75731
R944 VSS.n401 VSS.t281 8.75631
R945 VSS.n403 VSS.t518 8.75631
R946 VSS.n510 VSS.n35 0.0435295
R947 VSS.n34 VSS.n6 5.65652
R948 VSS.n33 VSS.n502 0.0633111
R949 VSS.n32 VSS.n6 4.22409
R950 VSS.n31 VSS.n6 5.65652
R951 VSS.n30 VSS.n487 0.0633111
R952 VSS.n29 VSS.n6 4.22409
R953 VSS.n28 VSS.n6 5.65652
R954 VSS.n27 VSS.n472 0.0633111
R955 VSS.n26 VSS.n6 4.22409
R956 VSS.n451 VSS.n25 0.0180497
R957 VSS.n24 VSS.n449 0.0633111
R958 VSS.n23 VSS.n6 4.22409
R959 VSS.n22 VSS.n6 5.65652
R960 VSS.n21 VSS.n434 0.0633111
R961 VSS.n427 VSS.n20 0.0435295
R962 VSS.n421 VSS.n19 0.0180497
R963 VSS.n18 VSS.n419 0.0633111
R964 VSS.n847 VSS.n832 8.5005
R965 VSS.n847 VSS.n818 8.5005
R966 VSS.n847 VSS.n172 8.5005
R967 VSS.n847 VSS.n811 8.5005
R968 VSS.n847 VSS.n810 8.5005
R969 VSS.n847 VSS.n176 8.5005
R970 VSS.n847 VSS.n809 8.5005
R971 VSS.n847 VSS.n179 8.5005
R972 VSS.n847 VSS.n803 8.5005
R973 VSS.n847 VSS.n180 8.5005
R974 VSS.n847 VSS.n801 8.5005
R975 VSS.n847 VSS.n183 8.5005
R976 VSS.n847 VSS.n793 8.5005
R977 VSS.n847 VSS.n791 8.5005
R978 VSS.n847 VSS.n186 8.5005
R979 VSS.n847 VSS.n790 8.5005
R980 VSS.n847 VSS.n189 8.5005
R981 VSS.n847 VSS.n784 8.5005
R982 VSS.n847 VSS.n190 8.5005
R983 VSS.n847 VSS.n782 8.5005
R984 VSS.n847 VSS.n193 8.5005
R985 VSS.n847 VSS.n774 8.5005
R986 VSS.n847 VSS.n772 8.5005
R987 VSS.n847 VSS.n197 8.5005
R988 VSS.n847 VSS.n771 8.5005
R989 VSS.n847 VSS.n200 8.5005
R990 VSS.n847 VSS.n765 8.5005
R991 VSS.n847 VSS.n201 8.5005
R992 VSS.n847 VSS.n764 8.5005
R993 VSS.n847 VSS.n205 8.5005
R994 VSS.n847 VSS.n756 8.5005
R995 VSS.n847 VSS.n755 8.5005
R996 VSS.n847 VSS.n210 8.5005
R997 VSS.n847 VSS.n754 8.5005
R998 VSS.n847 VSS.n213 8.5005
R999 VSS.n847 VSS.n748 8.5005
R1000 VSS.n847 VSS.n214 8.5005
R1001 VSS.n847 VSS.n746 8.5005
R1002 VSS.n847 VSS.n216 8.5005
R1003 VSS.n847 VSS.n738 8.5005
R1004 VSS.n847 VSS.n735 8.5005
R1005 VSS.n847 VSS.n219 8.5005
R1006 VSS.n847 VSS.n734 8.5005
R1007 VSS.n847 VSS.n222 8.5005
R1008 VSS.n847 VSS.n728 8.5005
R1009 VSS.n847 VSS.n223 8.5005
R1010 VSS.n847 VSS.n727 8.5005
R1011 VSS.n847 VSS.n225 8.5005
R1012 VSS.n847 VSS.n718 8.5005
R1013 VSS.n847 VSS.n717 8.5005
R1014 VSS.n847 VSS.n229 8.5005
R1015 VSS.n847 VSS.n716 8.5005
R1016 VSS.n847 VSS.n232 8.5005
R1017 VSS.n847 VSS.n710 8.5005
R1018 VSS.n847 VSS.n233 8.5005
R1019 VSS.n847 VSS.n708 8.5005
R1020 VSS.n847 VSS.n235 8.5005
R1021 VSS.n847 VSS.n699 8.5005
R1022 VSS.n847 VSS.n697 8.5005
R1023 VSS.n847 VSS.n237 8.5005
R1024 VSS.n847 VSS.n696 8.5005
R1025 VSS.n847 VSS.n240 8.5005
R1026 VSS.n847 VSS.n690 8.5005
R1027 VSS.n847 VSS.n241 8.5005
R1028 VSS.n847 VSS.n688 8.5005
R1029 VSS.n847 VSS.n243 8.5005
R1030 VSS.n847 VSS.n679 8.5005
R1031 VSS.n847 VSS.n678 8.5005
R1032 VSS.n847 VSS.n247 8.5005
R1033 VSS.n847 VSS.n677 8.5005
R1034 VSS.n847 VSS.n250 8.5005
R1035 VSS.n847 VSS.n671 8.5005
R1036 VSS.n847 VSS.n251 8.5005
R1037 VSS.n847 VSS.n669 8.5005
R1038 VSS.n847 VSS.n254 8.5005
R1039 VSS.n847 VSS.n661 8.5005
R1040 VSS.n847 VSS.n658 8.5005
R1041 VSS.n847 VSS.n256 8.5005
R1042 VSS.n847 VSS.n657 8.5005
R1043 VSS.n847 VSS.n259 8.5005
R1044 VSS.n847 VSS.n651 8.5005
R1045 VSS.n847 VSS.n260 8.5005
R1046 VSS.n847 VSS.n650 8.5005
R1047 VSS.n847 VSS.n262 8.5005
R1048 VSS.n847 VSS.n642 8.5005
R1049 VSS.n847 VSS.n641 8.5005
R1050 VSS.n847 VSS.n266 8.5005
R1051 VSS.n847 VSS.n640 8.5005
R1052 VSS.n847 VSS.n269 8.5005
R1053 VSS.n847 VSS.n634 8.5005
R1054 VSS.n847 VSS.n270 8.5005
R1055 VSS.n847 VSS.n633 8.5005
R1056 VSS.n847 VSS.n272 8.5005
R1057 VSS.n847 VSS.n625 8.5005
R1058 VSS.n847 VSS.n624 8.5005
R1059 VSS.n847 VSS.n277 8.5005
R1060 VSS.n847 VSS.n623 8.5005
R1061 VSS.n847 VSS.n280 8.5005
R1062 VSS.n847 VSS.n617 8.5005
R1063 VSS.n847 VSS.n281 8.5005
R1064 VSS.n847 VSS.n615 8.5005
R1065 VSS.n847 VSS.n284 8.5005
R1066 VSS.n847 VSS.n607 8.5005
R1067 VSS.n847 VSS.n605 8.5005
R1068 VSS.n847 VSS.n287 8.5005
R1069 VSS.n847 VSS.n604 8.5005
R1070 VSS.n847 VSS.n290 8.5005
R1071 VSS.n847 VSS.n598 8.5005
R1072 VSS.n847 VSS.n291 8.5005
R1073 VSS.n847 VSS.n597 8.5005
R1074 VSS.n847 VSS.n295 8.5005
R1075 VSS.n847 VSS.n588 8.5005
R1076 VSS.n847 VSS.n586 8.5005
R1077 VSS.n847 VSS.n298 8.5005
R1078 VSS.n847 VSS.n585 8.5005
R1079 VSS.n847 VSS.n301 8.5005
R1080 VSS.n847 VSS.n579 8.5005
R1081 VSS.n847 VSS.n302 8.5005
R1082 VSS.n847 VSS.n578 8.5005
R1083 VSS.n847 VSS.n305 8.5005
R1084 VSS.n847 VSS.n569 8.5005
R1085 VSS.n847 VSS.n567 8.5005
R1086 VSS.n847 VSS.n308 8.5005
R1087 VSS.n847 VSS.n566 8.5005
R1088 VSS.n847 VSS.n311 8.5005
R1089 VSS.n847 VSS.n560 8.5005
R1090 VSS.n847 VSS.n312 8.5005
R1091 VSS.n847 VSS.n558 8.5005
R1092 VSS.n847 VSS.n315 8.5005
R1093 VSS.n847 VSS.n550 8.5005
R1094 VSS.n847 VSS.n549 8.5005
R1095 VSS.n847 VSS.n319 8.5005
R1096 VSS.n847 VSS.n548 8.5005
R1097 VSS.n847 VSS.n322 8.5005
R1098 VSS.n847 VSS.n542 8.5005
R1099 VSS.n847 VSS.n323 8.5005
R1100 VSS.n847 VSS.n541 8.5005
R1101 VSS.n847 VSS.n326 8.5005
R1102 VSS.n847 VSS.n533 8.5005
R1103 VSS.n847 VSS.n532 8.5005
R1104 VSS.n847 VSS.n330 8.5005
R1105 VSS.n847 VSS.n531 8.5005
R1106 VSS.n847 VSS.n333 8.5005
R1107 VSS.n847 VSS.n525 8.5005
R1108 VSS.n847 VSS.n334 8.5005
R1109 VSS.n847 VSS.n337 8.5005
R1110 VSS.n509 VSS.n6 8.49319
R1111 VSS.n494 VSS.n6 8.49319
R1112 VSS.n479 VSS.n6 8.49319
R1113 VSS.n456 VSS.n6 8.49319
R1114 VSS.n441 VSS.n6 8.49319
R1115 VSS.n426 VSS.n6 8.49319
R1116 VSS.n862 VSS.n847 8.47732
R1117 VSS.n847 VSS.n169 8.47732
R1118 VSS.n847 VSS.n817 8.47732
R1119 VSS.n847 VSS.n800 8.47732
R1120 VSS.n847 VSS.n781 8.47732
R1121 VSS.n847 VSS.n763 8.47732
R1122 VSS.n847 VSS.n745 8.47732
R1123 VSS.n847 VSS.n726 8.47732
R1124 VSS.n847 VSS.n707 8.47732
R1125 VSS.n847 VSS.n687 8.47732
R1126 VSS.n847 VSS.n668 8.47732
R1127 VSS.n847 VSS.n649 8.47732
R1128 VSS.n847 VSS.n632 8.47732
R1129 VSS.n847 VSS.n614 8.47732
R1130 VSS.n847 VSS.n596 8.47732
R1131 VSS.n847 VSS.n577 8.47732
R1132 VSS.n847 VSS.n557 8.47732
R1133 VSS.n847 VSS.n540 8.47732
R1134 VSS.n847 VSS.n46 8.47732
R1135 VSS.n847 VSS.n101 8.47732
R1136 VSS.n847 VSS.n100 8.47732
R1137 VSS.n6 VSS.n35 4.22409
R1138 VSS.n503 VSS.n6 8.47732
R1139 VSS.n6 VSS.n33 4.21421
R1140 VSS.n496 VSS.n32 0.176279
R1141 VSS.n488 VSS.n6 8.47732
R1142 VSS.n6 VSS.n30 4.21421
R1143 VSS.n481 VSS.n29 0.176279
R1144 VSS.n473 VSS.n6 8.47732
R1145 VSS.n6 VSS.n27 4.21421
R1146 VSS.n458 VSS.n26 0.176279
R1147 VSS.n450 VSS.n6 8.47732
R1148 VSS.n6 VSS.n24 4.21421
R1149 VSS.n443 VSS.n23 0.176279
R1150 VSS.n435 VSS.n6 8.47732
R1151 VSS.n6 VSS.n21 4.21421
R1152 VSS.n20 VSS.n6 4.22409
R1153 VSS.n420 VSS.n6 8.47732
R1154 VSS.n6 VSS.n18 4.21421
R1155 VSS.n414 VSS.n6 8.47732
R1156 VSS.n340 VSS.t258 8.46888
R1157 VSS.n515 VSS.t254 8.46888
R1158 VSS.n521 VSS.t255 8.46631
R1159 VSS.n528 VSS.t483 8.46631
R1160 VSS.n537 VSS.t437 8.46631
R1161 VSS.n545 VSS.t445 8.46631
R1162 VSS.n554 VSS.t427 8.46631
R1163 VSS.n563 VSS.t447 8.46631
R1164 VSS.n574 VSS.t481 8.46631
R1165 VSS.n582 VSS.t431 8.46631
R1166 VSS.n593 VSS.t423 8.46631
R1167 VSS.n601 VSS.t451 8.46631
R1168 VSS.n611 VSS.t477 8.46631
R1169 VSS.n620 VSS.t479 8.46631
R1170 VSS.n629 VSS.t459 8.46631
R1171 VSS.n637 VSS.t475 8.46631
R1172 VSS.n646 VSS.t471 8.46631
R1173 VSS.n654 VSS.t473 8.46631
R1174 VSS.n665 VSS.t469 8.46631
R1175 VSS.n674 VSS.t461 8.46631
R1176 VSS.n684 VSS.t463 8.46631
R1177 VSS.n693 VSS.t467 8.46631
R1178 VSS.n704 VSS.t465 8.46631
R1179 VSS.n713 VSS.t421 8.46631
R1180 VSS.n723 VSS.t457 8.46631
R1181 VSS.n731 VSS.t429 8.46631
R1182 VSS.n742 VSS.t433 8.46631
R1183 VSS.n751 VSS.t455 8.46631
R1184 VSS.n760 VSS.t425 8.46631
R1185 VSS.n768 VSS.t453 8.46631
R1186 VSS.n778 VSS.t449 8.46631
R1187 VSS.n787 VSS.t443 8.46631
R1188 VSS.n797 VSS.t435 8.46631
R1189 VSS.n806 VSS.t441 8.46631
R1190 VSS.n815 VSS.t439 8.46631
R1191 VSS.n827 VSS.t251 8.46519
R1192 VSS.n822 VSS.t247 8.46519
R1193 VSS.n835 VSS.t248 8.46519
R1194 VSS.n865 VSS.n36 6.99673
R1195 VSS.n847 VSS.n344 5.63777
R1196 VSS.n854 VSS.n847 5.62581
R1197 VSS.n858 VSS.n847 5.62581
R1198 VSS.n864 VSS.n847 5.62581
R1199 VSS.n847 VSS.n813 5.62581
R1200 VSS.n847 VSS.n182 5.62581
R1201 VSS.n847 VSS.n795 5.62581
R1202 VSS.n847 VSS.n191 5.62581
R1203 VSS.n847 VSS.n776 5.62581
R1204 VSS.n847 VSS.n203 5.62581
R1205 VSS.n847 VSS.n758 5.62581
R1206 VSS.n847 VSS.n215 5.62581
R1207 VSS.n847 VSS.n740 5.62581
R1208 VSS.n847 VSS.n224 5.62581
R1209 VSS.n847 VSS.n720 5.62581
R1210 VSS.n847 VSS.n234 5.62581
R1211 VSS.n847 VSS.n701 5.62581
R1212 VSS.n847 VSS.n242 5.62581
R1213 VSS.n847 VSS.n681 5.62581
R1214 VSS.n847 VSS.n252 5.62581
R1215 VSS.n847 VSS.n663 5.62581
R1216 VSS.n847 VSS.n261 5.62581
R1217 VSS.n847 VSS.n644 5.62581
R1218 VSS.n847 VSS.n271 5.62581
R1219 VSS.n847 VSS.n627 5.62581
R1220 VSS.n847 VSS.n282 5.62581
R1221 VSS.n847 VSS.n609 5.62581
R1222 VSS.n847 VSS.n293 5.62581
R1223 VSS.n847 VSS.n590 5.62581
R1224 VSS.n847 VSS.n304 5.62581
R1225 VSS.n847 VSS.n571 5.62581
R1226 VSS.n847 VSS.n313 5.62581
R1227 VSS.n847 VSS.n552 5.62581
R1228 VSS.n847 VSS.n324 5.62581
R1229 VSS.n847 VSS.n535 5.62581
R1230 VSS.n847 VSS.n165 5.62581
R1231 VSS.n847 VSS.n163 5.62581
R1232 VSS.n847 VSS.n161 5.62581
R1233 VSS.n847 VSS.n159 5.62581
R1234 VSS.n847 VSS.n157 5.62581
R1235 VSS.n847 VSS.n155 5.62581
R1236 VSS.n847 VSS.n153 5.62581
R1237 VSS.n847 VSS.n151 5.62581
R1238 VSS.n847 VSS.n149 5.62581
R1239 VSS.n847 VSS.n147 5.62581
R1240 VSS.n847 VSS.n145 5.62581
R1241 VSS.n847 VSS.n143 5.62581
R1242 VSS.n847 VSS.n141 5.62581
R1243 VSS.n847 VSS.n139 5.62581
R1244 VSS.n847 VSS.n137 5.62581
R1245 VSS.n847 VSS.n135 5.62581
R1246 VSS.n847 VSS.n133 5.62581
R1247 VSS.n847 VSS.n131 5.62581
R1248 VSS.n847 VSS.n129 5.62581
R1249 VSS.n847 VSS.n127 5.62581
R1250 VSS.n847 VSS.n125 5.62581
R1251 VSS.n847 VSS.n123 5.62581
R1252 VSS.n847 VSS.n121 5.62581
R1253 VSS.n847 VSS.n119 5.62581
R1254 VSS.n847 VSS.n117 5.62581
R1255 VSS.n847 VSS.n115 5.62581
R1256 VSS.n847 VSS.n113 5.62581
R1257 VSS.n847 VSS.n111 5.62581
R1258 VSS.n847 VSS.n109 5.62581
R1259 VSS.n847 VSS.n107 5.62581
R1260 VSS.n847 VSS.n105 5.62581
R1261 VSS.n847 VSS.n103 5.62581
R1262 VSS.n847 VSS.n98 5.62581
R1263 VSS.n6 VSS.n350 5.62581
R1264 VSS.n6 VSS.n354 5.62581
R1265 VSS.n497 VSS.n6 5.62581
R1266 VSS.n6 VSS.n362 5.62581
R1267 VSS.n482 VSS.n6 5.62581
R1268 VSS.n6 VSS.n370 5.62581
R1269 VSS.n467 VSS.n6 5.62581
R1270 VSS.n459 VSS.n6 5.62581
R1271 VSS.n6 VSS.n378 5.62581
R1272 VSS.n444 VSS.n6 5.62581
R1273 VSS.n6 VSS.n386 5.62581
R1274 VSS.n429 VSS.n6 5.62581
R1275 VSS.n6 VSS.n394 5.62581
R1276 VSS.n418 VSS.n6 5.62581
R1277 VSS.n410 VSS.n6 5.62581
R1278 VSS.n406 VSS.n6 5.62581
R1279 VSS.n400 VSS.n36 4.28471
R1280 VSS.n6 VSS.n508 4.21914
R1281 VSS.n6 VSS.n493 4.21914
R1282 VSS.n6 VSS.n478 4.21914
R1283 VSS.n6 VSS.n455 4.21914
R1284 VSS.n6 VSS.n440 4.21914
R1285 VSS.n6 VSS.n425 4.21914
R1286 VSS.n847 VSS.n99 4.20662
R1287 VSS.n850 VSS.n847 4.19244
R1288 VSS.n847 VSS.n831 4.19244
R1289 VSS.n402 VSS.n6 4.19244
R1290 VSS VSS.n36 3.80469
R1291 VSS.n818 VSS.t438 3.34498
R1292 VSS.n810 VSS.t440 3.34498
R1293 VSS.n801 VSS.t434 3.34498
R1294 VSS.n791 VSS.t442 3.34498
R1295 VSS.n782 VSS.t448 3.34498
R1296 VSS.n772 VSS.t452 3.34498
R1297 VSS.n764 VSS.t424 3.34498
R1298 VSS.n755 VSS.t454 3.34498
R1299 VSS.n746 VSS.t432 3.34498
R1300 VSS.n735 VSS.t428 3.34498
R1301 VSS.n727 VSS.t456 3.34498
R1302 VSS.n717 VSS.t420 3.34498
R1303 VSS.n708 VSS.t464 3.34498
R1304 VSS.n697 VSS.t466 3.34498
R1305 VSS.n688 VSS.t462 3.34498
R1306 VSS.n678 VSS.t460 3.34498
R1307 VSS.n669 VSS.t468 3.34498
R1308 VSS.n658 VSS.t472 3.34498
R1309 VSS.n650 VSS.t470 3.34498
R1310 VSS.n641 VSS.t474 3.34498
R1311 VSS.n633 VSS.t458 3.34498
R1312 VSS.n624 VSS.t478 3.34498
R1313 VSS.n615 VSS.t476 3.34498
R1314 VSS.n605 VSS.t450 3.34498
R1315 VSS.n597 VSS.t422 3.34498
R1316 VSS.n586 VSS.t430 3.34498
R1317 VSS.n578 VSS.t480 3.34498
R1318 VSS.n567 VSS.t446 3.34498
R1319 VSS.n558 VSS.t426 3.34498
R1320 VSS.n549 VSS.t444 3.34498
R1321 VSS.n541 VSS.t436 3.34498
R1322 VSS.n532 VSS.t482 3.34498
R1323 VSS.n856 VSS.n847 3.3265
R1324 VSS.n860 VSS.n847 3.3265
R1325 VSS.n847 VSS.n808 3.3265
R1326 VSS.n847 VSS.n789 3.3265
R1327 VSS.n847 VSS.n770 3.3265
R1328 VSS.n847 VSS.n753 3.3265
R1329 VSS.n847 VSS.n733 3.3265
R1330 VSS.n847 VSS.n715 3.3265
R1331 VSS.n847 VSS.n695 3.3265
R1332 VSS.n847 VSS.n676 3.3265
R1333 VSS.n847 VSS.n656 3.3265
R1334 VSS.n847 VSS.n639 3.3265
R1335 VSS.n847 VSS.n622 3.3265
R1336 VSS.n847 VSS.n603 3.3265
R1337 VSS.n847 VSS.n584 3.3265
R1338 VSS.n847 VSS.n565 3.3265
R1339 VSS.n847 VSS.n547 3.3265
R1340 VSS.n847 VSS.n530 3.3265
R1341 VSS.n501 VSS.n6 3.3265
R1342 VSS.n486 VSS.n6 3.3265
R1343 VSS.n471 VSS.n6 3.3265
R1344 VSS.n448 VSS.n6 3.3265
R1345 VSS.n433 VSS.n6 3.3265
R1346 VSS.n419 VSS.n7 0.440892
R1347 VSS.n416 VSS.n6 3.3265
R1348 VSS.n412 VSS.n6 3.3265
R1349 VSS.n408 VSS.n6 3.3265
R1350 VSS.n838 VSS 3.16675
R1351 VSS.n513 VSS.n512 3.01826
R1352 VSS.n847 VSS.n37 2.83376
R1353 VSS.n852 VSS.n847 2.74446
R1354 VSS.n847 VSS.n175 2.74446
R1355 VSS.n847 VSS.n185 2.74446
R1356 VSS.n847 VSS.n196 2.74446
R1357 VSS.n847 VSS.n208 2.74446
R1358 VSS.n847 VSS.n218 2.74446
R1359 VSS.n847 VSS.n227 2.74446
R1360 VSS.n847 VSS.n236 2.74446
R1361 VSS.n847 VSS.n245 2.74446
R1362 VSS.n847 VSS.n255 2.74446
R1363 VSS.n847 VSS.n264 2.74446
R1364 VSS.n847 VSS.n275 2.74446
R1365 VSS.n847 VSS.n286 2.74446
R1366 VSS.n847 VSS.n297 2.74446
R1367 VSS.n847 VSS.n306 2.74446
R1368 VSS.n847 VSS.n318 2.74446
R1369 VSS.n847 VSS.n328 2.74446
R1370 VSS.n847 VSS.n166 2.74446
R1371 VSS.n404 VSS.n6 2.74446
R1372 VSS.n847 VSS.n48 2.32483
R1373 VSS.n847 VSS.n50 2.32483
R1374 VSS.n847 VSS.n52 2.32483
R1375 VSS.n847 VSS.n53 2.32483
R1376 VSS.n847 VSS.n54 2.32483
R1377 VSS.n847 VSS.n55 2.32483
R1378 VSS.n847 VSS.n56 2.32483
R1379 VSS.n847 VSS.n57 2.32483
R1380 VSS.n847 VSS.n59 2.32483
R1381 VSS.n847 VSS.n60 2.32483
R1382 VSS.n847 VSS.n63 2.32483
R1383 VSS.n847 VSS.n64 2.32483
R1384 VSS.n847 VSS.n66 2.32483
R1385 VSS.n847 VSS.n68 2.32483
R1386 VSS.n847 VSS.n70 2.32483
R1387 VSS.n847 VSS.n71 2.32483
R1388 VSS.n847 VSS.n73 2.32483
R1389 VSS.n847 VSS.n74 2.32483
R1390 VSS.n847 VSS.n78 2.32483
R1391 VSS.n847 VSS.n79 2.32483
R1392 VSS.n847 VSS.n82 2.32483
R1393 VSS.n847 VSS.n83 2.32483
R1394 VSS.n847 VSS.n84 2.32483
R1395 VSS.n847 VSS.n86 2.32483
R1396 VSS.n847 VSS.n87 2.32483
R1397 VSS.n847 VSS.n88 2.32483
R1398 VSS.n847 VSS.n90 2.32483
R1399 VSS.n847 VSS.n91 2.32483
R1400 VSS.n847 VSS.n92 2.32483
R1401 VSS.n847 VSS.n94 2.32483
R1402 VSS.n847 VSS.n97 2.32483
R1403 VSS.n465 VSS.n6 2.00687
R1404 VSS.n847 VSS.n8 1.64417
R1405 VSS.n847 VSS.n844 1.64417
R1406 VSS.n847 VSS.n41 1.64417
R1407 VSS.n847 VSS.n43 1.64417
R1408 VSS.n847 VSS.n840 1.64417
R1409 VSS.n6 VSS.n347 1.56144
R1410 VSS.n499 VSS.n6 1.56144
R1411 VSS.n484 VSS.n6 1.56144
R1412 VSS.n461 VSS.n6 1.56144
R1413 VSS.n446 VSS.n6 1.56144
R1414 VSS.n431 VSS.n6 1.56144
R1415 VSS.n469 VSS.n6 1.12565
R1416 VSS.n512 VSS.n6 0.92982
R1417 VSS.n6 VSS.n1 0.761893
R1418 VSS.n7 VSS.n6 0.665344
R1419 VSS.n463 VSS.n6 0.849178
R1420 VSS.n463 VSS.n462 0.728316
R1421 VSS.n464 VSS.n463 0.69965
R1422 VSS.n512 VSS.n345 0.69304
R1423 VSS.n6 VSS.n3 0.613782
R1424 VSS.n6 VSS.n4 0.577899
R1425 VSS.n6 VSS.n5 0.613782
R1426 VSS.n6 VSS.n8 4666.38
R1427 VSS.n469 VSS.n468 0.603496
R1428 VSS.n847 VSS.n17 0.00104694
R1429 VSS.n847 VSS.n45 0.556705
R1430 VSS.n470 VSS.n469 0.540438
R1431 VSS VSS.n865 0.48296
R1432 VSS.n522 VSS.n521 0.419816
R1433 VSS.n529 VSS.n528 0.419816
R1434 VSS.n538 VSS.n537 0.419816
R1435 VSS.n546 VSS.n545 0.419816
R1436 VSS.n555 VSS.n554 0.419816
R1437 VSS.n564 VSS.n563 0.419816
R1438 VSS.n575 VSS.n574 0.419816
R1439 VSS.n583 VSS.n582 0.419816
R1440 VSS.n594 VSS.n593 0.419816
R1441 VSS.n602 VSS.n601 0.419816
R1442 VSS.n612 VSS.n611 0.419816
R1443 VSS.n621 VSS.n620 0.419816
R1444 VSS.n630 VSS.n629 0.419816
R1445 VSS.n638 VSS.n637 0.419816
R1446 VSS.n647 VSS.n646 0.419816
R1447 VSS.n655 VSS.n654 0.419816
R1448 VSS.n666 VSS.n665 0.419816
R1449 VSS.n675 VSS.n674 0.419816
R1450 VSS.n685 VSS.n684 0.419816
R1451 VSS.n694 VSS.n693 0.419816
R1452 VSS.n705 VSS.n704 0.419816
R1453 VSS.n714 VSS.n713 0.419816
R1454 VSS.n724 VSS.n723 0.419816
R1455 VSS.n732 VSS.n731 0.419816
R1456 VSS.n743 VSS.n742 0.419816
R1457 VSS.n752 VSS.n751 0.419816
R1458 VSS.n761 VSS.n760 0.419816
R1459 VSS.n769 VSS.n768 0.419816
R1460 VSS.n779 VSS.n778 0.419816
R1461 VSS.n788 VSS.n787 0.419816
R1462 VSS.n798 VSS.n797 0.419816
R1463 VSS.n807 VSS.n806 0.419816
R1464 VSS.n816 VSS.n815 0.419816
R1465 VSS.n432 VSS.n431 0.413418
R1466 VSS.n447 VSS.n446 0.413418
R1467 VSS.n462 VSS.n461 0.413418
R1468 VSS.n485 VSS.n484 0.413418
R1469 VSS.n500 VSS.n499 0.413418
R1470 VSS.n347 VSS.n345 0.413418
R1471 VSS.n827 VSS.n826 0.385697
R1472 VSS.n822 VSS.n821 0.385697
R1473 VSS.n521 VSS.n520 0.383459
R1474 VSS.n528 VSS.n527 0.383459
R1475 VSS.n537 VSS.n536 0.383459
R1476 VSS.n545 VSS.n544 0.383459
R1477 VSS.n554 VSS.n553 0.383459
R1478 VSS.n563 VSS.n562 0.383459
R1479 VSS.n574 VSS.n573 0.383459
R1480 VSS.n582 VSS.n581 0.383459
R1481 VSS.n593 VSS.n592 0.383459
R1482 VSS.n601 VSS.n600 0.383459
R1483 VSS.n611 VSS.n610 0.383459
R1484 VSS.n620 VSS.n619 0.383459
R1485 VSS.n629 VSS.n628 0.383459
R1486 VSS.n637 VSS.n636 0.383459
R1487 VSS.n646 VSS.n645 0.383459
R1488 VSS.n654 VSS.n653 0.383459
R1489 VSS.n665 VSS.n664 0.383459
R1490 VSS.n674 VSS.n673 0.383459
R1491 VSS.n684 VSS.n683 0.383459
R1492 VSS.n693 VSS.n692 0.383459
R1493 VSS.n704 VSS.n703 0.383459
R1494 VSS.n713 VSS.n712 0.383459
R1495 VSS.n723 VSS.n722 0.383459
R1496 VSS.n731 VSS.n730 0.383459
R1497 VSS.n742 VSS.n741 0.383459
R1498 VSS.n751 VSS.n750 0.383459
R1499 VSS.n760 VSS.n759 0.383459
R1500 VSS.n768 VSS.n767 0.383459
R1501 VSS.n778 VSS.n777 0.383459
R1502 VSS.n787 VSS.n786 0.383459
R1503 VSS.n797 VSS.n796 0.383459
R1504 VSS.n806 VSS.n805 0.383459
R1505 VSS.n815 VSS.n814 0.383459
R1506 VSS.n466 VSS.n465 0.380519
R1507 VSS.n836 VSS.n835 0.379351
R1508 VSS.n516 VSS.n515 0.37817
R1509 VSS.n465 VSS.n464 0.359515
R1510 VSS.n164 VSS.n48 0.351341
R1511 VSS.n162 VSS.n50 0.351341
R1512 VSS.n160 VSS.n52 0.351341
R1513 VSS.n158 VSS.n53 0.351341
R1514 VSS.n156 VSS.n54 0.351341
R1515 VSS.n154 VSS.n55 0.351341
R1516 VSS.n152 VSS.n56 0.351341
R1517 VSS.n150 VSS.n57 0.351341
R1518 VSS.n148 VSS.n59 0.351341
R1519 VSS.n146 VSS.n60 0.351341
R1520 VSS.n144 VSS.n63 0.351341
R1521 VSS.n142 VSS.n64 0.351341
R1522 VSS.n140 VSS.n66 0.351341
R1523 VSS.n138 VSS.n68 0.351341
R1524 VSS.n136 VSS.n70 0.351341
R1525 VSS.n134 VSS.n71 0.351341
R1526 VSS.n132 VSS.n73 0.351341
R1527 VSS.n130 VSS.n74 0.351341
R1528 VSS.n128 VSS.n78 0.351341
R1529 VSS.n126 VSS.n79 0.351341
R1530 VSS.n124 VSS.n82 0.351341
R1531 VSS.n122 VSS.n83 0.351341
R1532 VSS.n120 VSS.n84 0.351341
R1533 VSS.n118 VSS.n86 0.351341
R1534 VSS.n116 VSS.n87 0.351341
R1535 VSS.n114 VSS.n88 0.351341
R1536 VSS.n112 VSS.n90 0.351341
R1537 VSS.n110 VSS.n91 0.351341
R1538 VSS.n108 VSS.n92 0.351341
R1539 VSS.n106 VSS.n94 0.351341
R1540 VSS.n104 VSS.n97 0.351341
R1541 VSS.n340 VSS.n339 0.345929
R1542 VSS.n515 VSS.n514 0.345929
R1543 VSS.n349 VSS.n347 0.340858
R1544 VSS.n499 VSS.n498 0.340858
R1545 VSS.n484 VSS.n483 0.340858
R1546 VSS.n461 VSS.n460 0.340858
R1547 VSS.n446 VSS.n445 0.340858
R1548 VSS.n431 VSS.n430 0.340858
R1549 VSS.n853 VSS.n852 0.318018
R1550 VSS.n405 VSS.n404 0.316299
R1551 VSS.n805 VSS.n48 0.311066
R1552 VSS.n796 VSS.n50 0.311066
R1553 VSS.n786 VSS.n52 0.311066
R1554 VSS.n777 VSS.n53 0.311066
R1555 VSS.n767 VSS.n54 0.311066
R1556 VSS.n759 VSS.n55 0.311066
R1557 VSS.n750 VSS.n56 0.311066
R1558 VSS.n741 VSS.n57 0.311066
R1559 VSS.n730 VSS.n59 0.311066
R1560 VSS.n722 VSS.n60 0.311066
R1561 VSS.n712 VSS.n63 0.311066
R1562 VSS.n703 VSS.n64 0.311066
R1563 VSS.n692 VSS.n66 0.311066
R1564 VSS.n683 VSS.n68 0.311066
R1565 VSS.n673 VSS.n70 0.311066
R1566 VSS.n664 VSS.n71 0.311066
R1567 VSS.n653 VSS.n73 0.311066
R1568 VSS.n645 VSS.n74 0.311066
R1569 VSS.n636 VSS.n78 0.311066
R1570 VSS.n628 VSS.n79 0.311066
R1571 VSS.n619 VSS.n82 0.311066
R1572 VSS.n610 VSS.n83 0.311066
R1573 VSS.n600 VSS.n84 0.311066
R1574 VSS.n592 VSS.n86 0.311066
R1575 VSS.n581 VSS.n87 0.311066
R1576 VSS.n573 VSS.n88 0.311066
R1577 VSS.n562 VSS.n90 0.311066
R1578 VSS.n553 VSS.n91 0.311066
R1579 VSS.n544 VSS.n92 0.311066
R1580 VSS.n536 VSS.n94 0.311066
R1581 VSS.n527 VSS.n97 0.311066
R1582 VSS.n177 VSS.n175 0.284268
R1583 VSS.n187 VSS.n185 0.284268
R1584 VSS.n198 VSS.n196 0.284268
R1585 VSS.n211 VSS.n208 0.284268
R1586 VSS.n220 VSS.n218 0.284268
R1587 VSS.n230 VSS.n227 0.284268
R1588 VSS.n238 VSS.n236 0.284268
R1589 VSS.n248 VSS.n245 0.284268
R1590 VSS.n257 VSS.n255 0.284268
R1591 VSS.n267 VSS.n264 0.284268
R1592 VSS.n278 VSS.n275 0.284268
R1593 VSS.n288 VSS.n286 0.284268
R1594 VSS.n299 VSS.n297 0.284268
R1595 VSS.n309 VSS.n306 0.284268
R1596 VSS.n320 VSS.n318 0.284268
R1597 VSS.n331 VSS.n328 0.284268
R1598 VSS.n835 VSS.n834 0.279928
R1599 VSS.n404 VSS.n403 0.274268
R1600 VSS.n412 VSS.n411 0.274227
R1601 VSS.n433 VSS.n432 0.274227
R1602 VSS.n448 VSS.n447 0.274227
R1603 VSS.n471 VSS.n470 0.274227
R1604 VSS.n486 VSS.n485 0.274227
R1605 VSS.n501 VSS.n500 0.274227
R1606 VSS.n860 VSS.n859 0.272997
R1607 VSS.n852 VSS.n851 0.272549
R1608 VSS.n826 VSS.n166 0.271299
R1609 VSS.n847 VSS.n168 0.267794
R1610 VSS.n847 VSS.n819 0.267794
R1611 VSS.n847 VSS.n173 0.267794
R1612 VSS.n847 VSS.n181 0.267794
R1613 VSS.n847 VSS.n802 0.267794
R1614 VSS.n847 VSS.n792 0.267794
R1615 VSS.n847 VSS.n783 0.267794
R1616 VSS.n847 VSS.n192 0.267794
R1617 VSS.n847 VSS.n194 0.267794
R1618 VSS.n847 VSS.n773 0.267794
R1619 VSS.n847 VSS.n202 0.267794
R1620 VSS.n847 VSS.n204 0.267794
R1621 VSS.n847 VSS.n206 0.267794
R1622 VSS.n847 VSS.n209 0.267794
R1623 VSS.n847 VSS.n747 0.267794
R1624 VSS.n847 VSS.n217 0.267794
R1625 VSS.n847 VSS.n736 0.267794
R1626 VSS.n847 VSS.n721 0.267794
R1627 VSS.n847 VSS.n228 0.267794
R1628 VSS.n847 VSS.n709 0.267794
R1629 VSS.n847 VSS.n702 0.267794
R1630 VSS.n847 VSS.n689 0.267794
R1631 VSS.n847 VSS.n682 0.267794
R1632 VSS.n847 VSS.n246 0.267794
R1633 VSS.n847 VSS.n670 0.267794
R1634 VSS.n847 VSS.n253 0.267794
R1635 VSS.n847 VSS.n659 0.267794
R1636 VSS.n847 VSS.n265 0.267794
R1637 VSS.n847 VSS.n273 0.267794
R1638 VSS.n847 VSS.n276 0.267794
R1639 VSS.n847 VSS.n616 0.267794
R1640 VSS.n847 VSS.n283 0.267794
R1641 VSS.n847 VSS.n285 0.267794
R1642 VSS.n847 VSS.n292 0.267794
R1643 VSS.n847 VSS.n294 0.267794
R1644 VSS.n847 VSS.n591 0.267794
R1645 VSS.n847 VSS.n587 0.267794
R1646 VSS.n847 VSS.n303 0.267794
R1647 VSS.n847 VSS.n572 0.267794
R1648 VSS.n847 VSS.n307 0.267794
R1649 VSS.n847 VSS.n559 0.267794
R1650 VSS.n847 VSS.n314 0.267794
R1651 VSS.n847 VSS.n316 0.267794
R1652 VSS.n847 VSS.n325 0.267794
R1653 VSS.n847 VSS.n329 0.267794
R1654 VSS.n847 VSS.n518 0.267794
R1655 VSS.n847 VSS.n49 0.267794
R1656 VSS.n847 VSS.n51 0.267794
R1657 VSS.n847 VSS.n58 0.267794
R1658 VSS.n847 VSS.n61 0.267794
R1659 VSS.n847 VSS.n62 0.267794
R1660 VSS.n847 VSS.n65 0.267794
R1661 VSS.n847 VSS.n67 0.267794
R1662 VSS.n847 VSS.n69 0.267794
R1663 VSS.n847 VSS.n72 0.267794
R1664 VSS.n847 VSS.n75 0.267794
R1665 VSS.n847 VSS.n76 0.267794
R1666 VSS.n847 VSS.n77 0.267794
R1667 VSS.n847 VSS.n80 0.267794
R1668 VSS.n847 VSS.n81 0.267794
R1669 VSS.n847 VSS.n85 0.267794
R1670 VSS.n847 VSS.n89 0.267794
R1671 VSS.n847 VSS.n93 0.267794
R1672 VSS.n847 VSS.n95 0.267794
R1673 VSS.n847 VSS.n96 0.267794
R1674 VSS.n814 VSS.n166 0.265518
R1675 VSS.n343 VSS.n99 0.259448
R1676 VSS.n341 VSS.n340 0.251101
R1677 VSS.n417 VSS.n416 0.245497
R1678 VSS.n808 VSS.n807 0.244247
R1679 VSS.n789 VSS.n788 0.244247
R1680 VSS.n770 VSS.n769 0.244247
R1681 VSS.n753 VSS.n752 0.244247
R1682 VSS.n733 VSS.n732 0.244247
R1683 VSS.n715 VSS.n714 0.244247
R1684 VSS.n695 VSS.n694 0.244247
R1685 VSS.n676 VSS.n675 0.244247
R1686 VSS.n656 VSS.n655 0.244247
R1687 VSS.n639 VSS.n638 0.244247
R1688 VSS.n622 VSS.n621 0.244247
R1689 VSS.n603 VSS.n602 0.244247
R1690 VSS.n584 VSS.n583 0.244247
R1691 VSS.n565 VSS.n564 0.244247
R1692 VSS.n547 VSS.n546 0.244247
R1693 VSS.n530 VSS.n529 0.244247
R1694 VSS.n812 VSS.n175 0.240049
R1695 VSS.n794 VSS.n185 0.240049
R1696 VSS.n775 VSS.n196 0.240049
R1697 VSS.n757 VSS.n208 0.240049
R1698 VSS.n739 VSS.n218 0.240049
R1699 VSS.n719 VSS.n227 0.240049
R1700 VSS.n700 VSS.n236 0.240049
R1701 VSS.n680 VSS.n245 0.240049
R1702 VSS.n662 VSS.n255 0.240049
R1703 VSS.n643 VSS.n264 0.240049
R1704 VSS.n626 VSS.n275 0.240049
R1705 VSS.n608 VSS.n286 0.240049
R1706 VSS.n589 VSS.n297 0.240049
R1707 VSS.n570 VSS.n306 0.240049
R1708 VSS.n551 VSS.n318 0.240049
R1709 VSS.n534 VSS.n328 0.240049
R1710 VSS.n434 VSS.n433 0.237997
R1711 VSS.n449 VSS.n448 0.237997
R1712 VSS.n472 VSS.n471 0.237997
R1713 VSS.n487 VSS.n486 0.237997
R1714 VSS.n502 VSS.n501 0.237997
R1715 VSS.n408 VSS.n407 0.234227
R1716 VSS.n856 VSS.n855 0.232997
R1717 VSS.n857 VSS.n856 0.231727
R1718 VSS.n409 VSS.n408 0.230497
R1719 VSS.n808 VSS.n804 0.224227
R1720 VSS.n789 VSS.n785 0.224227
R1721 VSS.n770 VSS.n766 0.224227
R1722 VSS.n753 VSS.n749 0.224227
R1723 VSS.n733 VSS.n729 0.224227
R1724 VSS.n715 VSS.n711 0.224227
R1725 VSS.n695 VSS.n691 0.224227
R1726 VSS.n676 VSS.n672 0.224227
R1727 VSS.n656 VSS.n652 0.224227
R1728 VSS.n639 VSS.n635 0.224227
R1729 VSS.n622 VSS.n618 0.224227
R1730 VSS.n603 VSS.n599 0.224227
R1731 VSS.n584 VSS.n580 0.224227
R1732 VSS.n565 VSS.n561 0.224227
R1733 VSS.n547 VSS.n543 0.224227
R1734 VSS.n530 VSS.n526 0.224227
R1735 VSS.n416 VSS.n415 0.219227
R1736 VSS.n828 VSS.n827 0.21012
R1737 VSS.n824 VSS.n822 0.21012
R1738 VSS.n344 VSS.n343 0.206787
R1739 VSS.n851 VSS.n850 0.201058
R1740 VSS.n403 VSS.n402 0.200293
R1741 VSS.n861 VSS.n860 0.191727
R1742 VSS.n413 VSS.n412 0.190497
R1743 VSS.n813 VSS.n812 0.186138
R1744 VSS.n795 VSS.n794 0.186138
R1745 VSS.n776 VSS.n775 0.186138
R1746 VSS.n758 VSS.n757 0.186138
R1747 VSS.n740 VSS.n739 0.186138
R1748 VSS.n720 VSS.n719 0.186138
R1749 VSS.n701 VSS.n700 0.186138
R1750 VSS.n681 VSS.n680 0.186138
R1751 VSS.n663 VSS.n662 0.186138
R1752 VSS.n644 VSS.n643 0.186138
R1753 VSS.n627 VSS.n626 0.186138
R1754 VSS.n609 VSS.n608 0.186138
R1755 VSS.n590 VSS.n589 0.186138
R1756 VSS.n571 VSS.n570 0.186138
R1757 VSS.n552 VSS.n551 0.186138
R1758 VSS.n535 VSS.n534 0.186138
R1759 VSS.n831 VSS.n830 0.179043
R1760 VSS.n339 VSS.n99 0.177116
R1761 VSS.n865 VSS.n864 0.167388
R1762 VSS.n102 VSS.n98 0.16705
R1763 VSS.n425 VSS.n424 0.166269
R1764 VSS.n440 VSS.n439 0.166269
R1765 VSS.n455 VSS.n454 0.166269
R1766 VSS.n478 VSS.n477 0.166269
R1767 VSS.n493 VSS.n492 0.166269
R1768 VSS.n508 VSS.n507 0.166269
R1769 VSS.n1 VSS.n0 0.318488
R1770 VSS.n814 VSS.n165 0.16205
R1771 VSS.n805 VSS.n163 0.16205
R1772 VSS.n796 VSS.n161 0.16205
R1773 VSS.n786 VSS.n159 0.16205
R1774 VSS.n777 VSS.n157 0.16205
R1775 VSS.n767 VSS.n155 0.16205
R1776 VSS.n759 VSS.n153 0.16205
R1777 VSS.n750 VSS.n151 0.16205
R1778 VSS.n741 VSS.n149 0.16205
R1779 VSS.n730 VSS.n147 0.16205
R1780 VSS.n722 VSS.n145 0.16205
R1781 VSS.n712 VSS.n143 0.16205
R1782 VSS.n703 VSS.n141 0.16205
R1783 VSS.n692 VSS.n139 0.16205
R1784 VSS.n683 VSS.n137 0.16205
R1785 VSS.n673 VSS.n135 0.16205
R1786 VSS.n664 VSS.n133 0.16205
R1787 VSS.n653 VSS.n131 0.16205
R1788 VSS.n645 VSS.n129 0.16205
R1789 VSS.n636 VSS.n127 0.16205
R1790 VSS.n628 VSS.n125 0.16205
R1791 VSS.n619 VSS.n123 0.16205
R1792 VSS.n610 VSS.n121 0.16205
R1793 VSS.n600 VSS.n119 0.16205
R1794 VSS.n592 VSS.n117 0.16205
R1795 VSS.n581 VSS.n115 0.16205
R1796 VSS.n573 VSS.n113 0.16205
R1797 VSS.n562 VSS.n111 0.16205
R1798 VSS.n553 VSS.n109 0.16205
R1799 VSS.n544 VSS.n107 0.16205
R1800 VSS.n536 VSS.n105 0.16205
R1801 VSS.n527 VSS.n103 0.16205
R1802 VSS.n847 VSS.n845 0.16137
R1803 VSS.n847 VSS.n42 0.16137
R1804 VSS.n847 VSS.n44 0.16137
R1805 VSS.n831 VSS.n820 0.161058
R1806 VSS.n402 VSS.n401 0.161058
R1807 VSS.n850 VSS.n849 0.160293
R1808 VSS.n804 VSS.n182 0.15705
R1809 VSS.n785 VSS.n191 0.15705
R1810 VSS.n766 VSS.n203 0.15705
R1811 VSS.n749 VSS.n215 0.15705
R1812 VSS.n729 VSS.n224 0.15705
R1813 VSS.n711 VSS.n234 0.15705
R1814 VSS.n691 VSS.n242 0.15705
R1815 VSS.n672 VSS.n252 0.15705
R1816 VSS.n652 VSS.n261 0.15705
R1817 VSS.n635 VSS.n271 0.15705
R1818 VSS.n618 VSS.n282 0.15705
R1819 VSS.n599 VSS.n293 0.15705
R1820 VSS.n580 VSS.n304 0.15705
R1821 VSS.n561 VSS.n313 0.15705
R1822 VSS.n543 VSS.n324 0.15705
R1823 VSS.n421 VSS.n395 0.155582
R1824 VSS.n393 VSS.n392 0.155582
R1825 VSS.n430 VSS.n390 0.155582
R1826 VSS.n436 VSS.n387 0.155582
R1827 VSS.n385 VSS.n384 0.155582
R1828 VSS.n445 VSS.n382 0.155582
R1829 VSS.n451 VSS.n379 0.155582
R1830 VSS.n377 VSS.n376 0.155582
R1831 VSS.n460 VSS.n374 0.155582
R1832 VSS.n474 VSS.n371 0.155582
R1833 VSS.n369 VSS.n368 0.155582
R1834 VSS.n483 VSS.n366 0.155582
R1835 VSS.n489 VSS.n363 0.155582
R1836 VSS.n361 VSS.n360 0.155582
R1837 VSS.n498 VSS.n358 0.155582
R1838 VSS.n504 VSS.n355 0.155582
R1839 VSS.n353 VSS.n352 0.155582
R1840 VSS.n349 VSS.n348 0.155582
R1841 VSS.n816 VSS.n813 0.1508
R1842 VSS.n798 VSS.n795 0.1508
R1843 VSS.n779 VSS.n776 0.1508
R1844 VSS.n761 VSS.n758 0.1508
R1845 VSS.n743 VSS.n740 0.1508
R1846 VSS.n724 VSS.n720 0.1508
R1847 VSS.n705 VSS.n701 0.1508
R1848 VSS.n685 VSS.n681 0.1508
R1849 VSS.n666 VSS.n663 0.1508
R1850 VSS.n647 VSS.n644 0.1508
R1851 VSS.n630 VSS.n627 0.1508
R1852 VSS.n612 VSS.n609 0.1508
R1853 VSS.n594 VSS.n590 0.1508
R1854 VSS.n575 VSS.n571 0.1508
R1855 VSS.n555 VSS.n552 0.1508
R1856 VSS.n538 VSS.n535 0.1508
R1857 VSS.n410 VSS.n409 0.149888
R1858 VSS.n858 VSS.n857 0.14955
R1859 VSS.n419 VSS.n399 0.149476
R1860 VSS.n423 VSS.n422 0.149476
R1861 VSS.n427 VSS.n391 0.149476
R1862 VSS.n434 VSS.n389 0.149476
R1863 VSS.n438 VSS.n437 0.149476
R1864 VSS.n442 VSS.n383 0.149476
R1865 VSS.n449 VSS.n381 0.149476
R1866 VSS.n453 VSS.n452 0.149476
R1867 VSS.n457 VSS.n375 0.149476
R1868 VSS.n472 VSS.n373 0.149476
R1869 VSS.n476 VSS.n475 0.149476
R1870 VSS.n480 VSS.n367 0.149476
R1871 VSS.n487 VSS.n365 0.149476
R1872 VSS.n491 VSS.n490 0.149476
R1873 VSS.n495 VSS.n359 0.149476
R1874 VSS.n502 VSS.n357 0.149476
R1875 VSS.n506 VSS.n505 0.149476
R1876 VSS.n510 VSS.n351 0.149476
R1877 VSS.n834 VSS.n833 0.148577
R1878 VSS.n855 VSS.n854 0.147388
R1879 VSS.n407 VSS.n406 0.14705
R1880 VSS.n862 VSS.n861 0.142118
R1881 VSS.n414 VSS.n413 0.142118
R1882 VSS.n344 VSS.n342 0.141022
R1883 VSS.n418 VSS.n417 0.134888
R1884 VSS.n467 VSS.n466 0.134888
R1885 VSS.n421 VSS.n420 0.129618
R1886 VSS.n436 VSS.n435 0.129618
R1887 VSS.n451 VSS.n450 0.129618
R1888 VSS.n474 VSS.n473 0.129618
R1889 VSS.n489 VSS.n488 0.129618
R1890 VSS.n504 VSS.n503 0.129618
R1891 VSS.n342 VSS.n341 0.127569
R1892 VSS.n424 VSS.n394 0.126138
R1893 VSS.n439 VSS.n386 0.126138
R1894 VSS.n454 VSS.n378 0.126138
R1895 VSS.n477 VSS.n370 0.126138
R1896 VSS.n492 VSS.n362 0.126138
R1897 VSS.n507 VSS.n354 0.126138
R1898 VSS.n820 VSS.n817 0.125868
R1899 VSS.n800 VSS.n799 0.125868
R1900 VSS.n781 VSS.n780 0.125868
R1901 VSS.n763 VSS.n762 0.125868
R1902 VSS.n745 VSS.n744 0.125868
R1903 VSS.n726 VSS.n725 0.125868
R1904 VSS.n707 VSS.n706 0.125868
R1905 VSS.n687 VSS.n686 0.125868
R1906 VSS.n668 VSS.n667 0.125868
R1907 VSS.n649 VSS.n648 0.125868
R1908 VSS.n632 VSS.n631 0.125868
R1909 VSS.n614 VSS.n613 0.125868
R1910 VSS.n596 VSS.n595 0.125868
R1911 VSS.n577 VSS.n576 0.125868
R1912 VSS.n557 VSS.n556 0.125868
R1913 VSS.n540 VSS.n539 0.125868
R1914 VSS.n18 VSS.n396 0.156005
R1915 VSS.n21 VSS.n388 0.156005
R1916 VSS.n24 VSS.n380 0.156005
R1917 VSS.n27 VSS.n372 0.156005
R1918 VSS.n30 VSS.n364 0.156005
R1919 VSS.n33 VSS.n356 0.156005
R1920 VSS.n520 VSS.n101 0.124618
R1921 VSS.n864 VSS.n863 0.12455
R1922 VSS.n514 VSS.n101 0.122118
R1923 VSS.n0 VSS.n418 0.12205
R1924 VSS.n430 VSS.n429 0.12205
R1925 VSS.n445 VSS.n444 0.12205
R1926 VSS.n460 VSS.n459 0.12205
R1927 VSS.n468 VSS.n467 0.12205
R1928 VSS.n483 VSS.n482 0.12205
R1929 VSS.n498 VSS.n497 0.12205
R1930 VSS.n350 VSS.n349 0.12205
R1931 VSS.n165 VSS.n164 0.119888
R1932 VSS.n163 VSS.n162 0.119888
R1933 VSS.n161 VSS.n160 0.119888
R1934 VSS.n159 VSS.n158 0.119888
R1935 VSS.n157 VSS.n156 0.119888
R1936 VSS.n155 VSS.n154 0.119888
R1937 VSS.n153 VSS.n152 0.119888
R1938 VSS.n151 VSS.n150 0.119888
R1939 VSS.n149 VSS.n148 0.119888
R1940 VSS.n147 VSS.n146 0.119888
R1941 VSS.n145 VSS.n144 0.119888
R1942 VSS.n143 VSS.n142 0.119888
R1943 VSS.n141 VSS.n140 0.119888
R1944 VSS.n139 VSS.n138 0.119888
R1945 VSS.n137 VSS.n136 0.119888
R1946 VSS.n135 VSS.n134 0.119888
R1947 VSS.n133 VSS.n132 0.119888
R1948 VSS.n131 VSS.n130 0.119888
R1949 VSS.n129 VSS.n128 0.119888
R1950 VSS.n127 VSS.n126 0.119888
R1951 VSS.n125 VSS.n124 0.119888
R1952 VSS.n123 VSS.n122 0.119888
R1953 VSS.n121 VSS.n120 0.119888
R1954 VSS.n119 VSS.n118 0.119888
R1955 VSS.n117 VSS.n116 0.119888
R1956 VSS.n115 VSS.n114 0.119888
R1957 VSS.n113 VSS.n112 0.119888
R1958 VSS.n111 VSS.n110 0.119888
R1959 VSS.n109 VSS.n108 0.119888
R1960 VSS.n107 VSS.n106 0.119888
R1961 VSS.n105 VSS.n104 0.119888
R1962 VSS.n103 VSS.n102 0.119888
R1963 VSS.n520 VSS.n98 0.114888
R1964 VSS.n863 VSS.n862 0.114618
R1965 VSS.n415 VSS.n414 0.114618
R1966 VSS.n799 VSS.n182 0.113638
R1967 VSS.n780 VSS.n191 0.113638
R1968 VSS.n762 VSS.n203 0.113638
R1969 VSS.n744 VSS.n215 0.113638
R1970 VSS.n725 VSS.n224 0.113638
R1971 VSS.n706 VSS.n234 0.113638
R1972 VSS.n686 VSS.n242 0.113638
R1973 VSS.n667 VSS.n252 0.113638
R1974 VSS.n648 VSS.n261 0.113638
R1975 VSS.n631 VSS.n271 0.113638
R1976 VSS.n613 VSS.n282 0.113638
R1977 VSS.n595 VSS.n293 0.113638
R1978 VSS.n576 VSS.n304 0.113638
R1979 VSS.n556 VSS.n313 0.113638
R1980 VSS.n539 VSS.n324 0.113638
R1981 VSS.n406 VSS.n405 0.109888
R1982 VSS.n854 VSS.n853 0.10955
R1983 VSS.n859 VSS.n858 0.107388
R1984 VSS.n411 VSS.n410 0.10705
R1985 VSS.n429 VSS.n428 0.106138
R1986 VSS.n444 VSS.n443 0.106138
R1987 VSS.n459 VSS.n458 0.106138
R1988 VSS.n482 VSS.n481 0.106138
R1989 VSS.n497 VSS.n496 0.106138
R1990 VSS.n511 VSS.n350 0.106138
R1991 VSS.n427 VSS.n426 0.105361
R1992 VSS.n442 VSS.n441 0.105361
R1993 VSS.n457 VSS.n456 0.105361
R1994 VSS.n480 VSS.n479 0.105361
R1995 VSS.n495 VSS.n494 0.105361
R1996 VSS.n510 VSS.n509 0.105361
R1997 VSS.n394 VSS.n393 0.10205
R1998 VSS.n386 VSS.n385 0.10205
R1999 VSS.n378 VSS.n377 0.10205
R2000 VSS.n370 VSS.n369 0.10205
R2001 VSS.n362 VSS.n361 0.10205
R2002 VSS.n354 VSS.n353 0.10205
R2003 VSS.n420 VSS.n396 0.0983676
R2004 VSS.n435 VSS.n388 0.0983676
R2005 VSS.n450 VSS.n380 0.0983676
R2006 VSS.n473 VSS.n372 0.0983676
R2007 VSS.n488 VSS.n364 0.0983676
R2008 VSS.n503 VSS.n356 0.0983676
R2009 VSS.n825 VSS.n824 0.094
R2010 VSS.n828 VSS.n825 0.094
R2011 VSS.n833 VSS.n167 0.08925
R2012 VSS.n817 VSS.n816 0.0883676
R2013 VSS.n800 VSS.n798 0.0883676
R2014 VSS.n781 VSS.n779 0.0883676
R2015 VSS.n763 VSS.n761 0.0883676
R2016 VSS.n745 VSS.n743 0.0883676
R2017 VSS.n726 VSS.n724 0.0883676
R2018 VSS.n707 VSS.n705 0.0883676
R2019 VSS.n687 VSS.n685 0.0883676
R2020 VSS.n668 VSS.n666 0.0883676
R2021 VSS.n649 VSS.n647 0.0883676
R2022 VSS.n632 VSS.n630 0.0883676
R2023 VSS.n614 VSS.n612 0.0883676
R2024 VSS.n596 VSS.n594 0.0883676
R2025 VSS.n577 VSS.n575 0.0883676
R2026 VSS.n557 VSS.n555 0.0883676
R2027 VSS.n540 VSS.n538 0.0883676
R2028 VSS.n523 VSS.n522 0.088
R2029 VSS.n428 VSS.n20 0.176279
R2030 VSS.n23 VSS.n442 0.0435295
R2031 VSS.n26 VSS.n457 0.0435295
R2032 VSS.n29 VSS.n480 0.0435295
R2033 VSS.n32 VSS.n495 0.0435295
R2034 VSS.n511 VSS.n35 0.176279
R2035 VSS.n824 VSS.n823 0.0851154
R2036 VSS.n830 VSS.n828 0.0851154
R2037 VSS.n517 VSS.n513 0.0805
R2038 VSS.n849 VSS.n848 0.078
R2039 VSS.n401 VSS.n400 0.078
R2040 VSS.n339 VSS.n100 0.0771176
R2041 VSS.n823 VSS.n169 0.0746176
R2042 VSS.n821 VSS.n46 0.0746176
R2043 VSS.n516 VSS.n336 0.07425
R2044 VSS.n514 VSS.n100 0.0696176
R2045 VSS.n823 VSS.n171 0.06925
R2046 VSS.n821 VSS.n47 0.06925
R2047 VSS.n423 VSS.n19 0.103847
R2048 VSS.n438 VSS.n22 0.103847
R2049 VSS.n453 VSS.n25 0.103847
R2050 VSS.n476 VSS.n28 0.103847
R2051 VSS.n491 VSS.n31 0.103847
R2052 VSS.n506 VSS.n34 0.103847
R2053 VSS.n526 VSS.n335 0.06175
R2054 VSS.n826 VSS.n47 0.05925
R2055 VSS.n839 VSS.n837 0.05675
R2056 VSS.n836 VSS.n169 0.0546176
R2057 VSS.n833 VSS.n46 0.0546176
R2058 VSS.n508 VSS.n506 0.0543074
R2059 VSS.n493 VSS.n491 0.0543074
R2060 VSS.n478 VSS.n476 0.0543074
R2061 VSS.n455 VSS.n453 0.0543074
R2062 VSS.n440 VSS.n438 0.0543074
R2063 VSS.n425 VSS.n423 0.0543074
R2064 VSS.n22 VSS.n436 0.0180497
R2065 VSS.n28 VSS.n474 0.0180497
R2066 VSS.n31 VSS.n489 0.0180497
R2067 VSS.n34 VSS.n504 0.0180497
R2068 VSS.n519 VSS.n336 0.04925
R2069 VSS.n178 VSS.n177 0.048
R2070 VSS.n188 VSS.n187 0.048
R2071 VSS.n199 VSS.n198 0.048
R2072 VSS.n212 VSS.n211 0.048
R2073 VSS.n221 VSS.n220 0.048
R2074 VSS.n231 VSS.n230 0.048
R2075 VSS.n239 VSS.n238 0.048
R2076 VSS.n249 VSS.n248 0.048
R2077 VSS.n258 VSS.n257 0.048
R2078 VSS.n268 VSS.n267 0.048
R2079 VSS.n279 VSS.n278 0.048
R2080 VSS.n289 VSS.n288 0.048
R2081 VSS.n300 VSS.n299 0.048
R2082 VSS.n310 VSS.n309 0.048
R2083 VSS.n321 VSS.n320 0.048
R2084 VSS.n332 VSS.n331 0.048
R2085 VSS.n523 VSS.n519 0.04675
R2086 VSS.n807 VSS.n178 0.0405
R2087 VSS.n788 VSS.n188 0.0405
R2088 VSS.n769 VSS.n199 0.0405
R2089 VSS.n752 VSS.n212 0.0405
R2090 VSS.n732 VSS.n221 0.0405
R2091 VSS.n714 VSS.n231 0.0405
R2092 VSS.n694 VSS.n239 0.0405
R2093 VSS.n675 VSS.n249 0.0405
R2094 VSS.n655 VSS.n258 0.0405
R2095 VSS.n638 VSS.n268 0.0405
R2096 VSS.n621 VSS.n279 0.0405
R2097 VSS.n602 VSS.n289 0.0405
R2098 VSS.n583 VSS.n300 0.0405
R2099 VSS.n564 VSS.n310 0.0405
R2100 VSS.n546 VSS.n321 0.0405
R2101 VSS.n529 VSS.n332 0.0405
R2102 VSS.n848 VSS 0.038
R2103 VSS.n837 VSS.n836 0.033
R2104 VSS.n830 VSS.n829 0.033
R2105 VSS.n342 VSS.n338 0.02925
R2106 VSS.n829 VSS.n171 0.02675
R2107 VSS.t31 VSS.n6 116.468
R2108 VSS.t134 VSS.n6 116.468
R2109 VSS.n517 VSS.n516 0.02175
R2110 VSS.n847 VSS.n846 0.0166972
R2111 VSS.n847 VSS.n39 0.0166972
R2112 VSS.n509 VSS.n353 0.0166107
R2113 VSS.n494 VSS.n361 0.0166107
R2114 VSS.n479 VSS.n369 0.0166107
R2115 VSS.n456 VSS.n377 0.0166107
R2116 VSS.n441 VSS.n385 0.0166107
R2117 VSS.n426 VSS.n393 0.0166107
R2118 VSS.n513 VSS.n338 0.0155
R2119 VSS.n838 VSS.n37 0.0112403
R2120 VSS.n865 VSS.n37 0.0095322
R2121 VSS.n847 VSS.n170 0.00938635
R2122 VSS.n847 VSS.n207 0.00938635
R2123 VSS.n847 VSS.n263 0.00938635
R2124 VSS.n847 VSS.n317 0.00938635
R2125 VSS.n847 VSS.n174 0.00937856
R2126 VSS.n847 VSS.n195 0.00937856
R2127 VSS.n847 VSS.n737 0.00937856
R2128 VSS.n847 VSS.n226 0.00937856
R2129 VSS.n847 VSS.n698 0.00937856
R2130 VSS.n847 VSS.n244 0.00937856
R2131 VSS.n847 VSS.n606 0.00937856
R2132 VSS.n847 VSS.n568 0.00937856
R2133 VSS.n847 VSS.n327 0.00937856
R2134 VSS.n847 VSS.n524 0.00937856
R2135 VSS.n847 VSS.n184 0.00937856
R2136 VSS.n847 VSS.n660 0.00937856
R2137 VSS.n847 VSS.n274 0.00937856
R2138 VSS.n847 VSS.n296 0.00937856
R2139 VSS.n522 VSS.n335 0.008
R2140 VSS.n839 VSS.n838 0.00675
R2141 VSS.n838 VSS.n167 0.00675
R2142 VSS.n6 VSS.t368 58.3224
R2143 VSS.n6 VSS.t356 117.529
R2144 VSS.n6 VSS.t351 101.74
R2145 VSS.n6 VSS.t341 117.529
R2146 VSS.n6 VSS.t308 58.3228
R2147 VSS.n6 VSS.t291 101.74
R2148 VSS.n17 VSS.n343 8.48044
R2149 VSS.n6 VSS.t293 58.3205
R2150 VSS.n6 VSS.n2 1.45033
R2151 a_3747_311.n0 a_3747_311.t2 52.0388
R2152 a_3747_311.t0 a_3747_311.n0 35.4491
R2153 a_3747_311.n0 a_3747_311.t3 33.5891
R2154 a_3747_311.t1 a_3747_311.t0 5.61942
R2155 a_3171_311.n0 a_3171_311.t2 51.8377
R2156 a_3171_311.n0 a_3171_311.t3 33.3881
R2157 a_3171_311.t0 a_3171_311.n0 31.8923
R2158 a_3171_311.t1 a_3171_311.t0 5.61777
R2159 a_2595_311.n0 a_2595_311.t2 51.6367
R2160 a_2595_311.n0 a_2595_311.t3 33.187
R2161 a_2595_311.t0 a_2595_311.n0 27.993
R2162 a_2595_311.t1 a_2595_311.t0 5.73018
R2163 a_3747_1047.n0 a_3747_1047.t2 38.0081
R2164 a_3747_1047.n0 a_3747_1047.t3 33.3957
R2165 a_3747_1047.n1 a_3747_1047.t4 33.3957
R2166 a_3747_1047.n2 a_3747_1047.t5 33.3957
R2167 a_3747_1047.n3 a_3747_1047.t6 33.3957
R2168 a_3747_1047.n4 a_3747_1047.t7 33.3957
R2169 a_3747_1047.n5 a_3747_1047.t8 33.3957
R2170 a_3747_1047.n6 a_3747_1047.t9 33.3957
R2171 a_3747_1047.t0 a_3747_1047.n6 23.2419
R2172 a_3747_1047.t1 a_3747_1047.t0 5.61942
R2173 a_3747_1047.n6 a_3747_1047.n5 4.61291
R2174 a_3747_1047.n5 a_3747_1047.n4 4.61291
R2175 a_3747_1047.n4 a_3747_1047.n3 4.61291
R2176 a_3747_1047.n3 a_3747_1047.n2 4.61291
R2177 a_3747_1047.n2 a_3747_1047.n1 4.61291
R2178 a_3747_1047.n1 a_3747_1047.n0 4.61291
R2179 a_3171_1047.n0 a_3171_1047.t2 37.8054
R2180 a_3171_1047.n0 a_3171_1047.t3 33.193
R2181 a_3171_1047.n1 a_3171_1047.t4 33.193
R2182 a_3171_1047.n2 a_3171_1047.t5 33.193
R2183 a_3171_1047.n3 a_3171_1047.t6 33.193
R2184 a_3171_1047.n4 a_3171_1047.t7 33.193
R2185 a_3171_1047.n5 a_3171_1047.t8 33.193
R2186 a_3171_1047.n6 a_3171_1047.t9 33.193
R2187 a_3171_1047.t0 a_3171_1047.n6 23.0313
R2188 a_3171_1047.t1 a_3171_1047.t0 5.61777
R2189 a_3171_1047.n6 a_3171_1047.n5 4.61291
R2190 a_3171_1047.n5 a_3171_1047.n4 4.61291
R2191 a_3171_1047.n4 a_3171_1047.n3 4.61291
R2192 a_3171_1047.n3 a_3171_1047.n2 4.61291
R2193 a_3171_1047.n2 a_3171_1047.n1 4.61291
R2194 a_3171_1047.n1 a_3171_1047.n0 4.61291
R2195 a_2595_1047.n0 a_2595_1047.t2 37.7691
R2196 a_2595_1047.n0 a_2595_1047.t3 33.1567
R2197 a_2595_1047.n1 a_2595_1047.t4 33.1567
R2198 a_2595_1047.n2 a_2595_1047.t5 33.1567
R2199 a_2595_1047.n3 a_2595_1047.t6 33.1567
R2200 a_2595_1047.n4 a_2595_1047.t7 33.1567
R2201 a_2595_1047.n5 a_2595_1047.t8 33.1567
R2202 a_2595_1047.n6 a_2595_1047.t9 33.1567
R2203 a_2595_1047.t0 a_2595_1047.n6 22.7941
R2204 a_2595_1047.t1 a_2595_1047.t0 5.65522
R2205 a_2595_1047.n6 a_2595_1047.n5 4.61291
R2206 a_2595_1047.n5 a_2595_1047.n4 4.61291
R2207 a_2595_1047.n4 a_2595_1047.n3 4.61291
R2208 a_2595_1047.n3 a_2595_1047.n2 4.61291
R2209 a_2595_1047.n2 a_2595_1047.n1 4.61291
R2210 a_2595_1047.n1 a_2595_1047.n0 4.61291
R2211 a_2019_1047.n0 a_2019_1047.t2 37.9701
R2212 a_2019_1047.n0 a_2019_1047.t3 33.3577
R2213 a_2019_1047.n1 a_2019_1047.t4 33.3577
R2214 a_2019_1047.n2 a_2019_1047.t5 33.3577
R2215 a_2019_1047.n3 a_2019_1047.t6 33.3577
R2216 a_2019_1047.n4 a_2019_1047.t7 33.3577
R2217 a_2019_1047.n5 a_2019_1047.t8 33.3577
R2218 a_2019_1047.t0 a_2019_1047.t9 22.5945
R2219 a_2019_1047.t1 a_2019_1047.t0 5.62052
R2220 a_2019_1047.t9 a_2019_1047.n5 4.61291
R2221 a_2019_1047.n5 a_2019_1047.n4 4.61291
R2222 a_2019_1047.n4 a_2019_1047.n3 4.61291
R2223 a_2019_1047.n3 a_2019_1047.n2 4.61291
R2224 a_2019_1047.n2 a_2019_1047.n1 4.61291
R2225 a_2019_1047.n1 a_2019_1047.n0 4.61291
C1105 MUX_OUT VSS 3.24058f
C1106 MUX_SEL4 VSS 1.60778f
C1107 MUX_SEL3 VSS 0.90686f
C1108 MUX_SEL2 VSS 1.81137f
C1109 MUX_SEL1 VSS 0.95076f
C1110 MUX_SEL0 VSS 1.55166f
C1111 DELAY_VBIASN VSS 12.41106f
C1112 DELAY_OUT_LAST VSS 0.39284f
C1113 DELAY_VBIASP VSS 4.13999f
C1114 DELAY_IN VSS 1.91954f
C1115 VDD VSS 46.2831f
C1116 a_26985_519# VSS 0.17928f ; **FLOATING
C1117 a_23945_519# VSS 0.17928f ; **FLOATING
C1118 a_20905_519# VSS 0.17928f ; **FLOATING
C1119 a_17865_519# VSS 0.17593f ; **FLOATING
C1120 a_16851_309# VSS 0.38699f ; **FLOATING
C1121 a_16108_289# VSS 3.85084f ; **FLOATING
C1122 a_15964_289# VSS 0.17613f ; **FLOATING
C1123 a_15765_463# VSS 0.36132f ; **FLOATING
C1124 a_14825_519# VSS 0.17928f ; **FLOATING
C1125 a_11785_519# VSS 0.17928f ; **FLOATING
C1126 a_8745_519# VSS 0.17928f ; **FLOATING
C1127 a_5731_289# VSS 3.39133f ; **FLOATING
C1128 a_2019_311# VSS 1.61601f ; **FLOATING
C1129 a_5705_519# VSS 0.17638f ; **FLOATING
C1130 a_3449_331# VSS 0.18478f ; **FLOATING
C1131 a_2873_331# VSS 0.18321f ; **FLOATING
C1132 a_2297_331# VSS 0.18321f ; **FLOATING
C1133 a_1721_331# VSS 0.17001f ; **FLOATING
C1134 a_1544_289# VSS 0.30014f ; **FLOATING
C1135 a_1256_289# VSS 0.84266f ; **FLOATING
C1136 a_27991_1008# VSS 0.18706f ; **FLOATING
C1137 a_27915_1044# VSS 0.10926f ; **FLOATING
C1138 a_27124_1008# VSS 0.17878f ; **FLOATING
C1139 a_27048_1044# VSS 0.12122f ; **FLOATING
C1140 a_26471_1008# VSS 0.18175f ; **FLOATING
C1141 a_26395_1044# VSS 0.11073f ; **FLOATING
C1142 a_25604_1008# VSS 0.18087f ; **FLOATING
C1143 a_25630_1044# VSS 0.34158f ; **FLOATING
C1144 a_25528_1044# VSS 0.12433f ; **FLOATING
C1145 a_24951_1008# VSS 0.18335f ; **FLOATING
C1146 a_24875_1044# VSS 0.11016f ; **FLOATING
C1147 a_24084_1008# VSS 0.17878f ; **FLOATING
C1148 a_24008_1044# VSS 0.12122f ; **FLOATING
C1149 a_23431_1008# VSS 0.18175f ; **FLOATING
C1150 a_23355_1044# VSS 0.11073f ; **FLOATING
C1151 a_22564_1008# VSS 0.18087f ; **FLOATING
C1152 a_22590_1044# VSS 0.33314f ; **FLOATING
C1153 a_22488_1044# VSS 0.12433f ; **FLOATING
C1154 a_21911_1008# VSS 0.18335f ; **FLOATING
C1155 a_21835_1044# VSS 0.11016f ; **FLOATING
C1156 a_21044_1008# VSS 0.17878f ; **FLOATING
C1157 a_20968_1044# VSS 0.12122f ; **FLOATING
C1158 a_20391_1008# VSS 0.18175f ; **FLOATING
C1159 a_20315_1044# VSS 0.11073f ; **FLOATING
C1160 a_19524_1008# VSS 0.18087f ; **FLOATING
C1161 a_19550_1044# VSS 0.33563f ; **FLOATING
C1162 a_19448_1044# VSS 0.12433f ; **FLOATING
C1163 a_18871_1008# VSS 0.18335f ; **FLOATING
C1164 a_18795_1044# VSS 0.11016f ; **FLOATING
C1165 a_18004_1008# VSS 0.17878f ; **FLOATING
C1166 a_17928_1044# VSS 0.12122f ; **FLOATING
C1167 a_17351_1008# VSS 0.18022f ; **FLOATING
C1168 a_17275_1044# VSS 0.10926f ; **FLOATING
C1169 a_16484_1008# VSS 0.18023f ; **FLOATING
C1170 a_16510_1044# VSS 0.28935f ; **FLOATING
C1171 a_16408_1044# VSS 0.1229f ; **FLOATING
C1172 a_15831_1008# VSS 0.17846f ; **FLOATING
C1173 a_15755_1044# VSS 0.10926f ; **FLOATING
C1174 a_14964_1008# VSS 0.17878f ; **FLOATING
C1175 a_14888_1044# VSS 0.12122f ; **FLOATING
C1176 a_14311_1008# VSS 0.18175f ; **FLOATING
C1177 a_14235_1044# VSS 0.11073f ; **FLOATING
C1178 a_13444_1008# VSS 0.18087f ; **FLOATING
C1179 a_13470_1044# VSS 0.30333f ; **FLOATING
C1180 a_13368_1044# VSS 0.12433f ; **FLOATING
C1181 a_12791_1008# VSS 0.18335f ; **FLOATING
C1182 a_12715_1044# VSS 0.11016f ; **FLOATING
C1183 a_11924_1008# VSS 0.17878f ; **FLOATING
C1184 a_11848_1044# VSS 0.12122f ; **FLOATING
C1185 a_11271_1008# VSS 0.18175f ; **FLOATING
C1186 a_11195_1044# VSS 0.11073f ; **FLOATING
C1187 a_10404_1008# VSS 0.18087f ; **FLOATING
C1188 a_10430_1044# VSS 0.31665f ; **FLOATING
C1189 a_10328_1044# VSS 0.12433f ; **FLOATING
C1190 a_9751_1008# VSS 0.18335f ; **FLOATING
C1191 a_9675_1044# VSS 0.11016f ; **FLOATING
C1192 a_8884_1008# VSS 0.17878f ; **FLOATING
C1193 a_8808_1044# VSS 0.12122f ; **FLOATING
C1194 a_8231_1008# VSS 0.18175f ; **FLOATING
C1195 a_8155_1044# VSS 0.11073f ; **FLOATING
C1196 a_7364_1008# VSS 0.18087f ; **FLOATING
C1197 a_7390_1044# VSS 0.31357f ; **FLOATING
C1198 a_7288_1044# VSS 0.12433f ; **FLOATING
C1199 a_6711_1008# VSS 0.18335f ; **FLOATING
C1200 a_6635_1044# VSS 0.11016f ; **FLOATING
C1201 a_5844_1008# VSS 0.17878f ; **FLOATING
C1202 a_5768_1044# VSS 0.12122f ; **FLOATING
C1203 a_5191_1008# VSS 0.18022f ; **FLOATING
C1204 a_5115_1044# VSS 0.10926f ; **FLOATING
C1205 a_4324_1008# VSS 0.18023f ; **FLOATING
C1206 a_4350_1044# VSS 0.26655f ; **FLOATING
C1207 a_4248_1044# VSS 0.12443f ; **FLOATING
C1208 a_27705_1044# VSS 0.25296f ; **FLOATING
C1209 a_26185_1044# VSS 0.23475f ; **FLOATING
C1210 a_24665_1044# VSS 0.25432f ; **FLOATING
C1211 a_23145_1044# VSS 0.23475f ; **FLOATING
C1212 a_21625_1044# VSS 0.25432f ; **FLOATING
C1213 a_20105_1044# VSS 0.23475f ; **FLOATING
C1214 a_18585_1044# VSS 0.25432f ; **FLOATING
C1215 a_17065_1044# VSS 0.23385f ; **FLOATING
C1216 a_15545_1044# VSS 0.25296f ; **FLOATING
C1217 a_14025_1044# VSS 0.23475f ; **FLOATING
C1218 a_12505_1044# VSS 0.25432f ; **FLOATING
C1219 a_10985_1044# VSS 0.23475f ; **FLOATING
C1220 a_9465_1044# VSS 0.25432f ; **FLOATING
C1221 a_7945_1044# VSS 0.23475f ; **FLOATING
C1222 a_6425_1044# VSS 0.25432f ; **FLOATING
C1223 a_4905_1044# VSS 0.23549f ; **FLOATING
C1224 a_4157_1313# VSS 0.32875f ; **FLOATING
C1225 a_3449_1395# VSS 0.18629f ; **FLOATING
C1226 a_2873_1395# VSS 0.18349f ; **FLOATING
C1227 a_2297_1395# VSS 0.18349f ; **FLOATING
C1228 a_1721_1395# VSS 0.17029f ; **FLOATING
C1229 a_1544_1044# VSS 0.29829f ; **FLOATING
C1230 a_1256_1044# VSS 0.82978f ; **FLOATING
C1231 a_27671_1842# VSS 0.01336f ; **FLOATING
C1232 a_26911_1842# VSS 0.01336f ; **FLOATING
C1233 a_26151_1842# VSS 0.01336f ; **FLOATING
C1234 a_25391_1842# VSS 0.01336f ; **FLOATING
C1235 a_24631_1842# VSS 0.01336f ; **FLOATING
C1236 a_23871_1842# VSS 0.01336f ; **FLOATING
C1237 a_23111_1842# VSS 0.01336f ; **FLOATING
C1238 a_22351_1842# VSS 0.01336f ; **FLOATING
C1239 a_21591_1842# VSS 0.01336f ; **FLOATING
C1240 a_20831_1842# VSS 0.01336f ; **FLOATING
C1241 a_20071_1842# VSS 0.01336f ; **FLOATING
C1242 a_19311_1842# VSS 0.01336f ; **FLOATING
C1243 a_18551_1842# VSS 0.01336f ; **FLOATING
C1244 a_17791_1842# VSS 0.01336f ; **FLOATING
C1245 a_17031_1842# VSS 0.01336f ; **FLOATING
C1246 a_16271_1842# VSS 0.01336f ; **FLOATING
C1247 a_15511_1842# VSS 0.01336f ; **FLOATING
C1248 a_14751_1842# VSS 0.01336f ; **FLOATING
C1249 a_13991_1842# VSS 0.01336f ; **FLOATING
C1250 a_13231_1842# VSS 0.01336f ; **FLOATING
C1251 a_12471_1842# VSS 0.01336f ; **FLOATING
C1252 a_11711_1842# VSS 0.01336f ; **FLOATING
C1253 a_10951_1842# VSS 0.01336f ; **FLOATING
C1254 a_10191_1842# VSS 0.01336f ; **FLOATING
C1255 a_9431_1842# VSS 0.01336f ; **FLOATING
C1256 a_8671_1842# VSS 0.01336f ; **FLOATING
C1257 a_7911_1842# VSS 0.01336f ; **FLOATING
C1258 a_7151_1842# VSS 0.01336f ; **FLOATING
C1259 a_6391_1842# VSS 0.01336f ; **FLOATING
C1260 a_5631_1842# VSS 0.01336f ; **FLOATING
C1261 a_4871_1842# VSS 0.01336f ; **FLOATING
C1262 a_4111_1842# VSS 0.0139f ; **FLOATING
C1263 a_27563_1842# VSS 0.51284f ; **FLOATING
C1264 a_27997_1842# VSS 0.6533f ; **FLOATING
C1265 a_27433_1842# VSS 0.45843f ; **FLOATING
C1266 a_26803_1842# VSS 0.50902f ; **FLOATING
C1267 a_27237_1842# VSS 0.93747f ; **FLOATING
C1268 a_26673_1842# VSS 0.45994f ; **FLOATING
C1269 a_26043_1842# VSS 0.51137f ; **FLOATING
C1270 a_26477_1842# VSS 0.96549f ; **FLOATING
C1271 a_25913_1842# VSS 0.46292f ; **FLOATING
C1272 a_25283_1842# VSS 0.50906f ; **FLOATING
C1273 a_25717_1842# VSS 0.87619f ; **FLOATING
C1274 a_25153_1842# VSS 0.45997f ; **FLOATING
C1275 a_24523_1842# VSS 0.51043f ; **FLOATING
C1276 a_24957_1842# VSS 0.97121f ; **FLOATING
C1277 a_24393_1842# VSS 0.45843f ; **FLOATING
C1278 a_23763_1842# VSS 0.50902f ; **FLOATING
C1279 a_24197_1842# VSS 0.93322f ; **FLOATING
C1280 a_23633_1842# VSS 0.45994f ; **FLOATING
C1281 a_23003_1842# VSS 0.51137f ; **FLOATING
C1282 a_23437_1842# VSS 0.96549f ; **FLOATING
C1283 a_22873_1842# VSS 0.46292f ; **FLOATING
C1284 a_22243_1842# VSS 0.50906f ; **FLOATING
C1285 a_22677_1842# VSS 0.87619f ; **FLOATING
C1286 a_22113_1842# VSS 0.45997f ; **FLOATING
C1287 a_21483_1842# VSS 0.51043f ; **FLOATING
C1288 a_21917_1842# VSS 0.97121f ; **FLOATING
C1289 a_21353_1842# VSS 0.45843f ; **FLOATING
C1290 a_20723_1842# VSS 0.50902f ; **FLOATING
C1291 a_21157_1842# VSS 0.93322f ; **FLOATING
C1292 a_20593_1842# VSS 0.45994f ; **FLOATING
C1293 a_19963_1842# VSS 0.51137f ; **FLOATING
C1294 a_20397_1842# VSS 0.96549f ; **FLOATING
C1295 a_19833_1842# VSS 0.46292f ; **FLOATING
C1296 a_19203_1842# VSS 0.50906f ; **FLOATING
C1297 a_19637_1842# VSS 0.87619f ; **FLOATING
C1298 a_19073_1842# VSS 0.45997f ; **FLOATING
C1299 a_18443_1842# VSS 0.51043f ; **FLOATING
C1300 a_18877_1842# VSS 0.97121f ; **FLOATING
C1301 a_18313_1842# VSS 0.45843f ; **FLOATING
C1302 a_17683_1842# VSS 0.50902f ; **FLOATING
C1303 a_18117_1842# VSS 0.93322f ; **FLOATING
C1304 a_17553_1842# VSS 0.45994f ; **FLOATING
C1305 a_16923_1842# VSS 0.51133f ; **FLOATING
C1306 a_17357_1842# VSS 0.96549f ; **FLOATING
C1307 a_16793_1842# VSS 0.46262f ; **FLOATING
C1308 a_16163_1842# VSS 0.50902f ; **FLOATING
C1309 a_16597_1842# VSS 0.87137f ; **FLOATING
C1310 a_16033_1842# VSS 0.45859f ; **FLOATING
C1311 a_15403_1842# VSS 0.51041f ; **FLOATING
C1312 a_15837_1842# VSS 0.9618f ; **FLOATING
C1313 a_15273_1842# VSS 0.45843f ; **FLOATING
C1314 a_14643_1842# VSS 0.50902f ; **FLOATING
C1315 a_15077_1842# VSS 0.93209f ; **FLOATING
C1316 a_14513_1842# VSS 0.45994f ; **FLOATING
C1317 a_13883_1842# VSS 0.51137f ; **FLOATING
C1318 a_14317_1842# VSS 0.96549f ; **FLOATING
C1319 a_13753_1842# VSS 0.46292f ; **FLOATING
C1320 a_13123_1842# VSS 0.50904f ; **FLOATING
C1321 a_13557_1842# VSS 0.87619f ; **FLOATING
C1322 a_12993_1842# VSS 0.45997f ; **FLOATING
C1323 a_12363_1842# VSS 0.51043f ; **FLOATING
C1324 a_12797_1842# VSS 0.96954f ; **FLOATING
C1325 a_12233_1842# VSS 0.45843f ; **FLOATING
C1326 a_11603_1842# VSS 0.50902f ; **FLOATING
C1327 a_12037_1842# VSS 0.93322f ; **FLOATING
C1328 a_11473_1842# VSS 0.45994f ; **FLOATING
C1329 a_10843_1842# VSS 0.51137f ; **FLOATING
C1330 a_11277_1842# VSS 0.96549f ; **FLOATING
C1331 a_10713_1842# VSS 0.46292f ; **FLOATING
C1332 a_10083_1842# VSS 0.50904f ; **FLOATING
C1333 a_10517_1842# VSS 0.87619f ; **FLOATING
C1334 a_9953_1842# VSS 0.45997f ; **FLOATING
C1335 a_9323_1842# VSS 0.51043f ; **FLOATING
C1336 a_9757_1842# VSS 0.96954f ; **FLOATING
C1337 a_9193_1842# VSS 0.45843f ; **FLOATING
C1338 a_8563_1842# VSS 0.50902f ; **FLOATING
C1339 a_8997_1842# VSS 0.93322f ; **FLOATING
C1340 a_8433_1842# VSS 0.45994f ; **FLOATING
C1341 a_7803_1842# VSS 0.51137f ; **FLOATING
C1342 a_8237_1842# VSS 0.96549f ; **FLOATING
C1343 a_7673_1842# VSS 0.46292f ; **FLOATING
C1344 a_7043_1842# VSS 0.50904f ; **FLOATING
C1345 a_7477_1842# VSS 0.87619f ; **FLOATING
C1346 a_6913_1842# VSS 0.45997f ; **FLOATING
C1347 a_6283_1842# VSS 0.51043f ; **FLOATING
C1348 a_6717_1842# VSS 0.96895f ; **FLOATING
C1349 a_6153_1842# VSS 0.45843f ; **FLOATING
C1350 a_5523_1842# VSS 0.50902f ; **FLOATING
C1351 a_5957_1842# VSS 0.93322f ; **FLOATING
C1352 a_5393_1842# VSS 0.45994f ; **FLOATING
C1353 a_4763_1842# VSS 0.51133f ; **FLOATING
C1354 a_5197_1842# VSS 0.96549f ; **FLOATING
C1355 a_4633_1842# VSS 0.4629f ; **FLOATING
C1356 a_4003_1842# VSS 0.58899f ; **FLOATING
C1357 a_4437_1842# VSS 0.87666f ; **FLOATING
C1358 a_2019_1047.t2 VSS 0.93017f ; **FLOATING
C1359 a_2019_1047.t3 VSS 0.70616f ; **FLOATING
C1360 a_2019_1047.n0 VSS 5.0083f ; **FLOATING
C1361 a_2019_1047.t4 VSS 0.70616f ; **FLOATING
C1362 a_2019_1047.n1 VSS 3.38825f ; **FLOATING
C1363 a_2019_1047.t5 VSS 0.70616f ; **FLOATING
C1364 a_2019_1047.n2 VSS 3.38825f ; **FLOATING
C1365 a_2019_1047.t6 VSS 0.70616f ; **FLOATING
C1366 a_2019_1047.n3 VSS 3.38825f ; **FLOATING
C1367 a_2019_1047.t7 VSS 0.70616f ; **FLOATING
C1368 a_2019_1047.n4 VSS 3.38825f ; **FLOATING
C1369 a_2019_1047.t8 VSS 0.70616f ; **FLOATING
C1370 a_2019_1047.n5 VSS 3.38825f ; **FLOATING
C1371 a_2019_1047.t9 VSS 5.45427f ; **FLOATING
C1372 a_2019_1047.t0 VSS 1.07246f ; **FLOATING
C1373 a_2019_1047.t1 VSS 0.30482f ; **FLOATING
C1374 a_2595_1047.t2 VSS 1.36702f ; **FLOATING
C1375 a_2595_1047.t3 VSS 1.02093f ; **FLOATING
C1376 a_2595_1047.n0 VSS 7.7612f ; **FLOATING
C1377 a_2595_1047.t4 VSS 1.02093f ; **FLOATING
C1378 a_2595_1047.n1 VSS 5.27337f ; **FLOATING
C1379 a_2595_1047.t5 VSS 1.02093f ; **FLOATING
C1380 a_2595_1047.n2 VSS 5.27337f ; **FLOATING
C1381 a_2595_1047.t6 VSS 1.02093f ; **FLOATING
C1382 a_2595_1047.n3 VSS 5.27337f ; **FLOATING
C1383 a_2595_1047.t7 VSS 1.02093f ; **FLOATING
C1384 a_2595_1047.n4 VSS 5.27337f ; **FLOATING
C1385 a_2595_1047.t8 VSS 1.02093f ; **FLOATING
C1386 a_2595_1047.n5 VSS 5.27337f ; **FLOATING
C1387 a_2595_1047.t9 VSS 1.02093f ; **FLOATING
C1388 a_2595_1047.n6 VSS 7.58543f ; **FLOATING
C1389 a_2595_1047.t0 VSS 1.75118f ; **FLOATING
C1390 a_2595_1047.t1 VSS 0.48227f ; **FLOATING
C1391 a_3171_1047.t2 VSS 1.38442f ; **FLOATING
C1392 a_3171_1047.t3 VSS 1.03733f ; **FLOATING
C1393 a_3171_1047.n0 VSS 7.77855f ; **FLOATING
C1394 a_3171_1047.t4 VSS 1.03733f ; **FLOATING
C1395 a_3171_1047.n1 VSS 5.28082f ; **FLOATING
C1396 a_3171_1047.t5 VSS 1.03733f ; **FLOATING
C1397 a_3171_1047.n2 VSS 5.28082f ; **FLOATING
C1398 a_3171_1047.t6 VSS 1.03733f ; **FLOATING
C1399 a_3171_1047.n3 VSS 5.28082f ; **FLOATING
C1400 a_3171_1047.t7 VSS 1.03733f ; **FLOATING
C1401 a_3171_1047.n4 VSS 5.28082f ; **FLOATING
C1402 a_3171_1047.t8 VSS 1.03733f ; **FLOATING
C1403 a_3171_1047.n5 VSS 5.28082f ; **FLOATING
C1404 a_3171_1047.t9 VSS 1.03733f ; **FLOATING
C1405 a_3171_1047.n6 VSS 7.68346f ; **FLOATING
C1406 a_3171_1047.t0 VSS 1.77026f ; **FLOATING
C1407 a_3171_1047.t1 VSS 0.48084f ; **FLOATING
C1408 a_3747_1047.t2 VSS 0.96886f ; **FLOATING
C1409 a_3747_1047.t3 VSS 0.73761f ; **FLOATING
C1410 a_3747_1047.n0 VSS 5.16753f ; **FLOATING
C1411 a_3747_1047.t4 VSS 0.73761f ; **FLOATING
C1412 a_3747_1047.n1 VSS 3.49318f ; **FLOATING
C1413 a_3747_1047.t5 VSS 0.73761f ; **FLOATING
C1414 a_3747_1047.n2 VSS 3.49318f ; **FLOATING
C1415 a_3747_1047.t6 VSS 0.73761f ; **FLOATING
C1416 a_3747_1047.n3 VSS 3.49318f ; **FLOATING
C1417 a_3747_1047.t7 VSS 0.73761f ; **FLOATING
C1418 a_3747_1047.n4 VSS 3.49318f ; **FLOATING
C1419 a_3747_1047.t8 VSS 0.73761f ; **FLOATING
C1420 a_3747_1047.n5 VSS 3.49318f ; **FLOATING
C1421 a_3747_1047.t9 VSS 0.73761f ; **FLOATING
C1422 a_3747_1047.n6 VSS 5.18696f ; **FLOATING
C1423 a_3747_1047.t0 VSS 1.18537f ; **FLOATING
C1424 a_3747_1047.t1 VSS 0.31338f ; **FLOATING
C1425 a_2595_311.t0 VSS 3.27037f ; **FLOATING
C1426 a_2595_311.t2 VSS 5.04145f ; **FLOATING
C1427 a_2595_311.t3 VSS 1.20632f ; **FLOATING
C1428 a_2595_311.n0 VSS 26.8668f ; **FLOATING
C1429 a_2595_311.t1 VSS 0.49572f ; **FLOATING
C1430 a_3171_311.t2 VSS 5.05009f ; **FLOATING
C1431 a_3171_311.t3 VSS 1.21149f ; **FLOATING
C1432 a_3171_311.n0 VSS 29.8499f ; **FLOATING
C1433 a_3171_311.t0 VSS 4.61154f ; **FLOATING
C1434 a_3171_311.t1 VSS 0.4973f ; **FLOATING
C1435 a_3747_311.t2 VSS 3.09203f ; **FLOATING
C1436 a_3747_311.t3 VSS 0.74422f ; **FLOATING
C1437 a_3747_311.n0 VSS 19.8885f ; **FLOATING
C1438 a_3747_311.t0 VSS 3.68893f ; **FLOATING
C1439 a_3747_311.t1 VSS 0.30537f ; **FLOATING
C1440 DELAY_VBIASP.n0 VSS 0.14465f ; **FLOATING
C1441 DELAY_VBIASP.t31 VSS 0.37042f ; **FLOATING
C1442 DELAY_VBIASP.t30 VSS 0.36213f ; **FLOATING
C1443 DELAY_VBIASP.n1 VSS 0.64895f ; **FLOATING
C1444 DELAY_VBIASP.t29 VSS 0.36213f ; **FLOATING
C1445 DELAY_VBIASP.n2 VSS 0.44908f ; **FLOATING
C1446 DELAY_VBIASP.t28 VSS 0.36213f ; **FLOATING
C1447 DELAY_VBIASP.n3 VSS 0.44908f ; **FLOATING
C1448 DELAY_VBIASP.t27 VSS 0.36213f ; **FLOATING
C1449 DELAY_VBIASP.n4 VSS 0.44908f ; **FLOATING
C1450 DELAY_VBIASP.t26 VSS 0.36213f ; **FLOATING
C1451 DELAY_VBIASP.n5 VSS 0.44908f ; **FLOATING
C1452 DELAY_VBIASP.t25 VSS 0.36213f ; **FLOATING
C1453 DELAY_VBIASP.n6 VSS 0.44908f ; **FLOATING
C1454 DELAY_VBIASP.t24 VSS 0.36213f ; **FLOATING
C1455 DELAY_VBIASP.n7 VSS 0.44908f ; **FLOATING
C1456 DELAY_VBIASP.t23 VSS 0.36213f ; **FLOATING
C1457 DELAY_VBIASP.n8 VSS 0.44908f ; **FLOATING
C1458 DELAY_VBIASP.t22 VSS 0.36213f ; **FLOATING
C1459 DELAY_VBIASP.n9 VSS 0.44908f ; **FLOATING
C1460 DELAY_VBIASP.t21 VSS 0.36213f ; **FLOATING
C1461 DELAY_VBIASP.n10 VSS 0.44908f ; **FLOATING
C1462 DELAY_VBIASP.t20 VSS 0.36213f ; **FLOATING
C1463 DELAY_VBIASP.n11 VSS 0.44908f ; **FLOATING
C1464 DELAY_VBIASP.t19 VSS 0.36213f ; **FLOATING
C1465 DELAY_VBIASP.n12 VSS 0.44908f ; **FLOATING
C1466 DELAY_VBIASP.t18 VSS 0.36213f ; **FLOATING
C1467 DELAY_VBIASP.n13 VSS 0.44908f ; **FLOATING
C1468 DELAY_VBIASP.t17 VSS 0.36213f ; **FLOATING
C1469 DELAY_VBIASP.n14 VSS 0.44908f ; **FLOATING
C1470 DELAY_VBIASP.t16 VSS 0.36213f ; **FLOATING
C1471 DELAY_VBIASP.n15 VSS 0.44908f ; **FLOATING
C1472 DELAY_VBIASP.t15 VSS 0.36213f ; **FLOATING
C1473 DELAY_VBIASP.n16 VSS 0.44908f ; **FLOATING
C1474 DELAY_VBIASP.t14 VSS 0.36213f ; **FLOATING
C1475 DELAY_VBIASP.n17 VSS 0.44908f ; **FLOATING
C1476 DELAY_VBIASP.t13 VSS 0.36213f ; **FLOATING
C1477 DELAY_VBIASP.n18 VSS 0.44908f ; **FLOATING
C1478 DELAY_VBIASP.t12 VSS 0.36213f ; **FLOATING
C1479 DELAY_VBIASP.n19 VSS 0.44908f ; **FLOATING
C1480 DELAY_VBIASP.t11 VSS 0.36213f ; **FLOATING
C1481 DELAY_VBIASP.n20 VSS 0.44908f ; **FLOATING
C1482 DELAY_VBIASP.t10 VSS 0.36213f ; **FLOATING
C1483 DELAY_VBIASP.n21 VSS 0.44908f ; **FLOATING
C1484 DELAY_VBIASP.t9 VSS 0.36213f ; **FLOATING
C1485 DELAY_VBIASP.n22 VSS 0.44908f ; **FLOATING
C1486 DELAY_VBIASP.t8 VSS 0.36213f ; **FLOATING
C1487 DELAY_VBIASP.n23 VSS 0.44908f ; **FLOATING
C1488 DELAY_VBIASP.t7 VSS 0.36213f ; **FLOATING
C1489 DELAY_VBIASP.n24 VSS 0.44908f ; **FLOATING
C1490 DELAY_VBIASP.t6 VSS 0.36213f ; **FLOATING
C1491 DELAY_VBIASP.n25 VSS 0.44908f ; **FLOATING
C1492 DELAY_VBIASP.t5 VSS 0.36213f ; **FLOATING
C1493 DELAY_VBIASP.n26 VSS 0.44908f ; **FLOATING
C1494 DELAY_VBIASP.t4 VSS 0.36213f ; **FLOATING
C1495 DELAY_VBIASP.n27 VSS 0.44908f ; **FLOATING
C1496 DELAY_VBIASP.t3 VSS 0.36213f ; **FLOATING
C1497 DELAY_VBIASP.n28 VSS 0.44908f ; **FLOATING
C1498 DELAY_VBIASP.t2 VSS 0.36213f ; **FLOATING
C1499 DELAY_VBIASP.n29 VSS 0.44908f ; **FLOATING
C1500 DELAY_VBIASP.t1 VSS 0.36213f ; **FLOATING
C1501 DELAY_VBIASP.n30 VSS 0.44908f ; **FLOATING
C1502 DELAY_VBIASP.t0 VSS 0.36213f ; **FLOATING
C1503 DELAY_VBIASN.n0 VSS 0.37703f ; **FLOATING
C1504 DELAY_VBIASN.t31 VSS 0.22492f ; **FLOATING
C1505 DELAY_VBIASN.t30 VSS 0.21832f ; **FLOATING
C1506 DELAY_VBIASN.n1 VSS 0.51667f ; **FLOATING
C1507 DELAY_VBIASN.t29 VSS 0.21832f ; **FLOATING
C1508 DELAY_VBIASN.n2 VSS 0.35838f ; **FLOATING
C1509 DELAY_VBIASN.t28 VSS 0.21832f ; **FLOATING
C1510 DELAY_VBIASN.n3 VSS 0.35838f ; **FLOATING
C1511 DELAY_VBIASN.t27 VSS 0.21832f ; **FLOATING
C1512 DELAY_VBIASN.n4 VSS 0.35838f ; **FLOATING
C1513 DELAY_VBIASN.t26 VSS 0.21832f ; **FLOATING
C1514 DELAY_VBIASN.n5 VSS 0.35838f ; **FLOATING
C1515 DELAY_VBIASN.t25 VSS 0.21832f ; **FLOATING
C1516 DELAY_VBIASN.n6 VSS 0.35838f ; **FLOATING
C1517 DELAY_VBIASN.t24 VSS 0.21832f ; **FLOATING
C1518 DELAY_VBIASN.n7 VSS 0.35838f ; **FLOATING
C1519 DELAY_VBIASN.t23 VSS 0.21832f ; **FLOATING
C1520 DELAY_VBIASN.n8 VSS 0.35838f ; **FLOATING
C1521 DELAY_VBIASN.t22 VSS 0.21832f ; **FLOATING
C1522 DELAY_VBIASN.n9 VSS 0.35838f ; **FLOATING
C1523 DELAY_VBIASN.t21 VSS 0.21832f ; **FLOATING
C1524 DELAY_VBIASN.n10 VSS 0.35838f ; **FLOATING
C1525 DELAY_VBIASN.t20 VSS 0.21832f ; **FLOATING
C1526 DELAY_VBIASN.n11 VSS 0.35838f ; **FLOATING
C1527 DELAY_VBIASN.t19 VSS 0.21832f ; **FLOATING
C1528 DELAY_VBIASN.n12 VSS 0.35838f ; **FLOATING
C1529 DELAY_VBIASN.t18 VSS 0.21832f ; **FLOATING
C1530 DELAY_VBIASN.n13 VSS 0.35838f ; **FLOATING
C1531 DELAY_VBIASN.t17 VSS 0.21832f ; **FLOATING
C1532 DELAY_VBIASN.n14 VSS 0.35838f ; **FLOATING
C1533 DELAY_VBIASN.t16 VSS 0.21832f ; **FLOATING
C1534 DELAY_VBIASN.n15 VSS 0.35838f ; **FLOATING
C1535 DELAY_VBIASN.t15 VSS 0.21832f ; **FLOATING
C1536 DELAY_VBIASN.n16 VSS 0.35838f ; **FLOATING
C1537 DELAY_VBIASN.t14 VSS 0.21832f ; **FLOATING
C1538 DELAY_VBIASN.n17 VSS 0.35838f ; **FLOATING
C1539 DELAY_VBIASN.t13 VSS 0.21832f ; **FLOATING
C1540 DELAY_VBIASN.n18 VSS 0.35838f ; **FLOATING
C1541 DELAY_VBIASN.t12 VSS 0.21832f ; **FLOATING
C1542 DELAY_VBIASN.n19 VSS 0.35838f ; **FLOATING
C1543 DELAY_VBIASN.t11 VSS 0.21832f ; **FLOATING
C1544 DELAY_VBIASN.n20 VSS 0.35838f ; **FLOATING
C1545 DELAY_VBIASN.t10 VSS 0.21832f ; **FLOATING
C1546 DELAY_VBIASN.n21 VSS 0.35838f ; **FLOATING
C1547 DELAY_VBIASN.t9 VSS 0.21832f ; **FLOATING
C1548 DELAY_VBIASN.n22 VSS 0.35838f ; **FLOATING
C1549 DELAY_VBIASN.t8 VSS 0.21832f ; **FLOATING
C1550 DELAY_VBIASN.n23 VSS 0.35838f ; **FLOATING
C1551 DELAY_VBIASN.t7 VSS 0.21832f ; **FLOATING
C1552 DELAY_VBIASN.n24 VSS 0.35838f ; **FLOATING
C1553 DELAY_VBIASN.t6 VSS 0.21832f ; **FLOATING
C1554 DELAY_VBIASN.n25 VSS 0.35838f ; **FLOATING
C1555 DELAY_VBIASN.t5 VSS 0.21832f ; **FLOATING
C1556 DELAY_VBIASN.n26 VSS 0.35838f ; **FLOATING
C1557 DELAY_VBIASN.t4 VSS 0.21832f ; **FLOATING
C1558 DELAY_VBIASN.n27 VSS 0.35838f ; **FLOATING
C1559 DELAY_VBIASN.t3 VSS 0.21832f ; **FLOATING
C1560 DELAY_VBIASN.n28 VSS 0.35838f ; **FLOATING
C1561 DELAY_VBIASN.t2 VSS 0.21832f ; **FLOATING
C1562 DELAY_VBIASN.n29 VSS 0.35838f ; **FLOATING
C1563 DELAY_VBIASN.t1 VSS 0.21832f ; **FLOATING
C1564 DELAY_VBIASN.n30 VSS 0.35838f ; **FLOATING
C1565 DELAY_VBIASN.t0 VSS 0.21832f ; **FLOATING
.ends
