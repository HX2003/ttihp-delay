* NGSPICE file created from hx_delay_line_with_mux.ext - technology: ihp-sg13g2

.subckt hx_delay_line_with_mux VSS VDD DELAY_OUT_LAST DELAY_IN MUX_SEL0 MUX_SEL1 MUX_OUT
+ MUX_SEL4 MUX_SEL2 MUX_SEL3 DELAY_VBIASN DELAY_VBIASP
X0 VDD a_4003_1842# a_4437_1842# VDD sg13_lv_pmos ad=0.2128p pd=1.5u as=0.3808p ps=2.92u w=1.12u l=0.13u
X1 VSS.t66 a_15077_1842# a_15545_1044# VSS.t420 sg13_lv_nmos ad=0.1665p pd=1.19u as=0.2516p ps=2.16u w=0.74u l=0.13u
X2 a_27915_1044# a_27705_1044# VDD VDD sg13_lv_pmos ad=0.2128p pd=1.5u as=0.252p ps=1.57u w=1.12u l=0.13u
X3 VSS.t225 VDD VSS.t223 VSS.t224 sg13_lv_nmos ad=79.8f pd=0.8u as=0 ps=0 w=0.42u l=1u
X4 a_10951_2470# a_10713_1842# a_10843_1842# VDD sg13_lv_pmos ad=0.2128p pd=1.5u as=0.3808p ps=2.92u w=1.12u l=0.2u
X5 VSS.t327 a_3171_1047.t7 a_11924_1008# VSS.t326 sg13_lv_nmos ad=0.2516p pd=2.16u as=0.2516p ps=2.16u w=0.74u l=0.13u
X6 VDD VSS.t572 VDD VDD sg13_lv_pmos ad=0.34p pd=2.68u as=0.30484n ps=1.54979m w=1u l=1u
X7 VSS.t190 a_1256_1044# a_2967_1395# VSS.t189 sg13_lv_nmos ad=0.1331p pd=1.12u as=0.1216p ps=1.02u w=0.64u l=0.13u
X8 VSS.t228 VDD VSS.t227 VSS.t226 sg13_lv_nmos ad=0.1428p pd=1.52u as=0 ps=0 w=0.42u l=1u
X9 a_25153_1842# a_24957_1842# VSS.t406 VSS.t499 sg13_lv_nmos ad=0.2516p pd=2.16u as=0.1406p ps=1.12u w=0.74u l=0.13u
X10 VDD VSS.t586 VDD VDD sg13_lv_pmos ad=0.34p pd=2.68u as=0 ps=0 w=1u l=1u
X11 a_25630_1044# a_2019_1047.t2 a_25528_1044# VSS.t200 sg13_lv_nmos ad=0.2516p pd=2.16u as=0.1406p ps=1.12u w=0.74u l=0.13u
X12 VDD DELAY_VBIASP.t11 a_19311_2470# VDD sg13_lv_pmos ad=0.3808p pd=2.92u as=0.2128p ps=1.5u w=1.12u l=0.6u
X13 a_16108_289# a_2019_311# a_16510_1044# VSS.t391 sg13_lv_nmos ad=0.2516p pd=2.16u as=0.2516p ps=2.16u w=0.74u l=0.13u
X14 VDD DELAY_VBIASP.t24 a_9431_2470# VDD sg13_lv_pmos ad=0.3808p pd=2.92u as=0.2128p ps=1.5u w=1.12u l=0.6u
X15 VSS.t293 VDD VSS.t292 VSS.t291 sg13_lv_nmos ad=0.1428p pd=1.52u as=0 ps=0 w=0.42u l=1u
X16 VDD DELAY_VBIASP.t6 a_23111_2470# VDD sg13_lv_pmos ad=0.3808p pd=2.92u as=0.2128p ps=1.5u w=1.12u l=0.6u
X17 a_7390_1044# a_8231_1008# a_8155_1044# VDD sg13_lv_pmos ad=0.3808p pd=2.92u as=0.2128p ps=1.5u w=1.12u l=0.13u
X18 VSS.t196 a_2595_311.t3 a_8745_519# VSS.t195 sg13_lv_nmos ad=0.2516p pd=2.16u as=0.2516p ps=2.16u w=0.74u l=0.13u
X19 a_17791_1842# a_17553_1842# a_17683_1842# VSS.t548 sg13_lv_nmos ad=0.1406p pd=1.12u as=0.2516p ps=2.16u w=0.74u l=0.2u
X20 VDD a_12037_1842# a_12505_1044# VDD sg13_lv_pmos ad=0.252p pd=1.57u as=0.3808p ps=2.92u w=1.12u l=0.13u
X21 a_16510_1044# a_2019_1047.t5 a_16408_1044# VSS.t331 sg13_lv_nmos ad=0.2516p pd=2.16u as=0.1406p ps=1.12u w=0.74u l=0.13u
X22 a_21591_1842# a_21353_1842# a_21483_1842# VSS.t418 sg13_lv_nmos ad=0.1406p pd=1.12u as=0.2516p ps=2.16u w=0.74u l=0.2u
X23 a_6153_1842# a_5957_1842# VSS.t415 VSS.t414 sg13_lv_nmos ad=0.2516p pd=2.16u as=0.1406p ps=1.12u w=0.74u l=0.13u
X24 VSS.t383 a_16163_1842# a_16597_1842# VSS.t559 sg13_lv_nmos ad=0.1406p pd=1.12u as=0.2516p ps=2.16u w=0.74u l=0.13u
X25 VSS.t59 a_3171_1047.t2 a_27124_1008# VSS.t58 sg13_lv_nmos ad=0.2516p pd=2.16u as=0.2516p ps=2.16u w=0.74u l=0.13u
X26 VDD a_11603_1842# a_12037_1842# VDD sg13_lv_pmos ad=0.2128p pd=1.5u as=0.3808p ps=2.92u w=1.12u l=0.13u
X27 VDD a_3171_311.t3 a_11785_519# VDD sg13_lv_pmos ad=0.3808p pd=2.92u as=0.3808p ps=2.92u w=1.12u l=0.13u
X28 a_24393_1842# a_24197_1842# VDD VDD sg13_lv_pmos ad=0.3808p pd=2.92u as=0.2128p ps=1.5u w=1.12u l=0.13u
X29 a_5731_289# a_2595_311.t3 a_7390_1044# VSS.t194 sg13_lv_nmos ad=0.2516p pd=2.16u as=0.2516p ps=2.16u w=0.74u l=0.13u
X30 a_10430_1044# a_2595_1047.t7 a_11195_1044# VSS.t14 sg13_lv_nmos ad=0.2516p pd=2.16u as=0.1406p ps=1.12u w=0.74u l=0.13u
X31 a_23355_1044# a_23145_1044# VSS.t212 VSS.t211 sg13_lv_nmos ad=0.1406p pd=1.12u as=0.1665p ps=1.19u w=0.74u l=0.13u
X32 VDD DELAY_VBIASP.t17 a_14751_2470# VDD sg13_lv_pmos ad=0.3808p pd=2.92u as=0.2128p ps=1.5u w=1.12u l=0.6u
X33 VSS.t462 DELAY_VBIASN.t23 a_10191_1842# VSS.t461 sg13_lv_nmos ad=0.2516p pd=2.16u as=0.1406p ps=1.12u w=0.74u l=0.6u
X34 VSS.t78 a_3747_1047.t4 a_21911_1008# VSS.t77 sg13_lv_nmos ad=0.2516p pd=2.16u as=0.2516p ps=2.16u w=0.74u l=0.13u
X35 VSS.t30 a_19963_1842# a_20397_1842# VSS.t29 sg13_lv_nmos ad=0.1406p pd=1.12u as=0.2516p ps=2.16u w=0.74u l=0.13u
X36 VDD DELAY_VBIASP.t31 a_4111_2470# VDD sg13_lv_pmos ad=0.3808p pd=2.92u as=0.2128p ps=1.5u w=1.12u l=0.6u
X37 a_10328_1044# a_9757_1842# VDD VDD sg13_lv_pmos ad=0.2128p pd=1.5u as=0.3808p ps=2.92u w=1.12u l=0.13u
X38 a_20968_1044# a_20397_1842# VSS.t557 VSS.t556 sg13_lv_nmos ad=0.1406p pd=1.12u as=0.2516p ps=2.16u w=0.74u l=0.13u
X39 a_22590_1044# a_22564_1008# a_22488_1044# VDD sg13_lv_pmos ad=0.3808p pd=2.92u as=0.2128p ps=1.5u w=1.12u l=0.13u
X40 VDD VSS.t589 VDD VDD sg13_lv_pmos ad=0.19p pd=1.38u as=0 ps=0 w=1u l=1u
X41 a_8808_1044# a_8237_1842# VDD VDD sg13_lv_pmos ad=0.2128p pd=1.5u as=0.3808p ps=2.92u w=1.12u l=0.13u
X42 a_4157_1313# DELAY_IN VDD VDD sg13_lv_pmos ad=0.3808p pd=2.92u as=0.3808p ps=2.92u w=1.12u l=0.13u
X43 a_17031_2470# a_16793_1842# a_16923_1842# VDD sg13_lv_pmos ad=0.2128p pd=1.5u as=0.3808p ps=2.92u w=1.12u l=0.2u
X44 a_11473_1842# a_11277_1842# VSS.t136 VSS.t135 sg13_lv_nmos ad=0.2516p pd=2.16u as=0.1406p ps=1.12u w=0.74u l=0.13u
X45 VSS.t285 VDD VSS.t283 VSS.t284 sg13_lv_nmos ad=79.8f pd=0.8u as=0 ps=0 w=0.42u l=1u
X46 a_19448_1044# a_18877_1842# VSS.t340 VSS.t339 sg13_lv_nmos ad=0.1406p pd=1.12u as=0.2516p ps=2.16u w=0.74u l=0.13u
X47 a_10430_1044# a_3171_1047.t7 a_11848_1044# VSS.t325 sg13_lv_nmos ad=0.2516p pd=2.16u as=0.1406p ps=1.12u w=0.74u l=0.13u
X48 a_20831_2470# a_20593_1842# a_20723_1842# VDD sg13_lv_pmos ad=0.2128p pd=1.5u as=0.3808p ps=2.92u w=1.12u l=0.2u
X49 VSS.t250 VDD VSS.t248 VSS.t249 sg13_lv_nmos ad=79.8f pd=0.8u as=0 ps=0 w=0.42u l=1u
X50 VDD a_27237_1842# a_27705_1044# VDD sg13_lv_pmos ad=0.252p pd=1.57u as=0.3808p ps=2.92u w=1.12u l=0.13u
X51 a_5393_1842# a_5197_1842# VDD VDD sg13_lv_pmos ad=0.3808p pd=2.92u as=0.2128p ps=1.5u w=1.12u l=0.13u
X52 VDD DELAY_VBIASP.t14 a_17031_2470# VDD sg13_lv_pmos ad=0.3808p pd=2.92u as=0.2128p ps=1.5u w=1.12u l=0.6u
X53 VDD a_26803_1842# a_27237_1842# VDD sg13_lv_pmos ad=0.2128p pd=1.5u as=0.3808p ps=2.92u w=1.12u l=0.13u
X54 VDD MUX_SEL1 a_3449_1395# VDD sg13_lv_pmos ad=0.1918p pd=1.5u as=0.1596p ps=1.22u w=0.84u l=0.13u
X55 a_25630_1044# a_2595_1047.t2 a_26395_1044# VSS.t101 sg13_lv_nmos ad=0.2516p pd=2.16u as=0.1406p ps=1.12u w=0.74u l=0.13u
X56 VSS.t488 DELAY_VBIASN.t3 a_25391_1842# VSS.t487 sg13_lv_nmos ad=0.2516p pd=2.16u as=0.1406p ps=1.12u w=0.74u l=0.6u
X57 a_6635_1044# a_6425_1044# VDD VDD sg13_lv_pmos ad=0.2128p pd=1.5u as=0.252p ps=1.57u w=1.12u l=0.13u
X58 a_20315_1044# a_20105_1044# VDD VDD sg13_lv_pmos ad=0.2128p pd=1.5u as=0.252p ps=1.57u w=1.12u l=0.13u
X59 VDD a_2595_1047.t9 a_5191_1008# VDD sg13_lv_pmos ad=0.3808p pd=2.92u as=0.3808p ps=2.92u w=1.12u l=0.13u
X60 a_19311_2470# a_19073_1842# a_19203_1842# VDD sg13_lv_pmos ad=0.2128p pd=1.5u as=0.3808p ps=2.92u w=1.12u l=0.2u
X61 VSS.t527 a_1721_1395# a_2019_1047.t1 VSS.t526 sg13_lv_nmos ad=0.2812p pd=2.24u as=0.1406p ps=1.12u w=0.74u l=0.13u
X62 a_25528_1044# a_24957_1842# VDD VDD sg13_lv_pmos ad=0.2128p pd=1.5u as=0.3808p ps=2.92u w=1.12u l=0.13u
X63 VSS.t192 a_5957_1842# a_6425_1044# VSS.t413 sg13_lv_nmos ad=0.1665p pd=1.19u as=0.2516p ps=2.16u w=0.74u l=0.13u
X64 VSS.t539 a_2019_1047.t6 a_13444_1008# VSS.t538 sg13_lv_nmos ad=0.2516p pd=2.16u as=0.2516p ps=2.16u w=0.74u l=0.13u
X65 a_23111_2470# a_22873_1842# a_23003_1842# VDD sg13_lv_pmos ad=0.2128p pd=1.5u as=0.3808p ps=2.92u w=1.12u l=0.2u
X66 VSS.t223 VDD VSS.t222 VSS.t221 sg13_lv_nmos ad=0.1428p pd=1.52u as=0 ps=0 w=0.42u l=1u
X67 VSS.t518 a_15964_289# a_16851_309# VSS.t521 sg13_lv_nmos ad=0.1371p pd=1.12u as=0.2176p ps=1.96u w=0.64u l=0.13u
X68 a_10713_1842# a_10517_1842# VDD VDD sg13_lv_pmos ad=0.3808p pd=2.92u as=0.2128p ps=1.5u w=1.12u l=0.13u
X69 VDD a_17683_1842# a_18117_1842# VDD sg13_lv_pmos ad=0.2128p pd=1.5u as=0.3808p ps=2.92u w=1.12u l=0.13u
X70 a_16108_289# a_17865_519# a_16510_1044# VDD sg13_lv_pmos ad=0.3808p pd=2.92u as=0.3808p ps=2.92u w=1.12u l=0.13u
X71 a_26673_1842# a_26477_1842# VSS.t368 VSS.t562 sg13_lv_nmos ad=0.2516p pd=2.16u as=0.1406p ps=1.12u w=0.74u l=0.13u
X72 VDD a_7803_1842# a_8237_1842# VDD sg13_lv_pmos ad=0.2128p pd=1.5u as=0.3808p ps=2.92u w=1.12u l=0.13u
X73 a_4248_1044# a_4157_1313# VSS.t64 VSS.t63 sg13_lv_nmos ad=0.1406p pd=1.12u as=0.2516p ps=2.16u w=0.74u l=0.13u
X74 a_16108_289# a_3171_311.t2 a_22590_1044# VSS.t213 sg13_lv_nmos ad=0.2516p pd=2.16u as=0.2516p ps=2.16u w=0.74u l=0.13u
X75 VSS.t456 DELAY_VBIASN.t28 a_6391_1842# VSS.t455 sg13_lv_nmos ad=0.2516p pd=2.16u as=0.1406p ps=1.12u w=0.74u l=0.6u
X76 a_16408_1044# a_15837_1842# VDD VDD sg13_lv_pmos ad=0.2128p pd=1.5u as=0.3808p ps=2.92u w=1.12u l=0.13u
X77 a_19550_1044# a_3747_1047.t4 a_21835_1044# VSS.t76 sg13_lv_nmos ad=0.2516p pd=2.16u as=0.1406p ps=1.12u w=0.74u l=0.13u
X78 VSS.t482 DELAY_VBIASN.t9 a_20831_1842# VSS.t481 sg13_lv_nmos ad=0.2516p pd=2.16u as=0.1406p ps=1.12u w=0.74u l=0.6u
X79 a_3171_311.t0 a_2873_331# VDD VDD sg13_lv_pmos ad=0.2128p pd=1.5u as=0.1918p ps=1.5u w=1.12u l=0.13u
X80 a_3747_311.t0 a_3449_331# VDD VDD sg13_lv_pmos ad=0.2128p pd=1.5u as=0.1918p ps=1.5u w=1.12u l=0.13u
X81 a_7390_1044# a_9751_1008# a_9675_1044# VDD sg13_lv_pmos ad=0.3808p pd=2.92u as=0.2128p ps=1.5u w=1.12u l=0.13u
X82 a_10191_1842# a_9953_1842# a_10083_1842# VSS.t347 sg13_lv_nmos ad=0.1406p pd=1.12u as=0.2516p ps=2.16u w=0.74u l=0.2u
X83 VSS.t212 a_22677_1842# a_23145_1044# VSS.t549 sg13_lv_nmos ad=0.1665p pd=1.19u as=0.2516p ps=2.16u w=0.74u l=0.13u
X84 a_14751_2470# a_14513_1842# a_14643_1842# VDD sg13_lv_pmos ad=0.2128p pd=1.5u as=0.3808p ps=2.92u w=1.12u l=0.2u
X85 a_5731_289# a_8745_519# a_7390_1044# VDD sg13_lv_pmos ad=0.3808p pd=2.92u as=0.3808p ps=2.92u w=1.12u l=0.13u
X86 VDD VDD VDD VDD sg13_lv_pmos ad=0.2128p pd=1.5u as=0 ps=0 w=1.12u l=0.13u
X87 a_4111_2470# DELAY_IN a_4003_1842# VDD sg13_lv_pmos ad=0.2128p pd=1.5u as=0.3808p ps=2.92u w=1.12u l=0.2u
X88 a_7673_1842# a_7477_1842# VSS.t8 VSS.t7 sg13_lv_nmos ad=0.2516p pd=2.16u as=0.1406p ps=1.12u w=0.74u l=0.13u
X89 VDD a_3171_1047.t5 a_18004_1008# VDD sg13_lv_pmos ad=0.3808p pd=2.92u as=0.3808p ps=2.92u w=1.12u l=0.13u
X90 VDD a_13123_1842# a_13557_1842# VDD sg13_lv_pmos ad=0.2128p pd=1.5u as=0.3808p ps=2.92u w=1.12u l=0.13u
X91 VDD a_3747_311.t2 a_26985_519# VDD sg13_lv_pmos ad=0.3808p pd=2.92u as=0.3808p ps=2.92u w=1.12u l=0.13u
X92 a_25913_1842# a_25717_1842# VDD VDD sg13_lv_pmos ad=0.3808p pd=2.92u as=0.2128p ps=1.5u w=1.12u l=0.13u
X93 a_10430_1044# a_3747_1047.t7 a_12715_1044# VSS.t37 sg13_lv_nmos ad=0.2516p pd=2.16u as=0.1406p ps=1.12u w=0.74u l=0.13u
X94 a_14235_1044# a_14025_1044# VDD VDD sg13_lv_pmos ad=0.2128p pd=1.5u as=0.252p ps=1.57u w=1.12u l=0.13u
X95 a_24875_1044# a_24665_1044# VSS.t505 VSS.t536 sg13_lv_nmos ad=0.1406p pd=1.12u as=0.1665p ps=1.19u w=0.74u l=0.13u
X96 VSS.t468 DELAY_VBIASN.t21 a_11711_1842# VSS.t467 sg13_lv_nmos ad=0.2516p pd=2.16u as=0.1406p ps=1.12u w=0.74u l=0.6u
X97 VDD a_3747_1047.t7 a_12791_1008# VDD sg13_lv_pmos ad=0.3808p pd=2.92u as=0.3808p ps=2.92u w=1.12u l=0.13u
X98 VSS.t83 a_2595_1047.t3 a_23431_1008# VSS.t82 sg13_lv_nmos ad=0.2516p pd=2.16u as=0.2516p ps=2.16u w=0.74u l=0.13u
X99 VSS.t49 a_21483_1842# a_21917_1842# VSS.t338 sg13_lv_nmos ad=0.1406p pd=1.12u as=0.2516p ps=2.16u w=0.74u l=0.13u
X100 VSS.t24 a_13557_1842# a_14025_1044# VSS.t416 sg13_lv_nmos ad=0.1665p pd=1.19u as=0.2516p ps=2.16u w=0.74u l=0.13u
X101 a_11848_1044# a_11277_1842# VDD VDD sg13_lv_pmos ad=0.2128p pd=1.5u as=0.3808p ps=2.92u w=1.12u l=0.13u
X102 VDD VSS.t565 VDD VDD sg13_lv_pmos ad=0.19p pd=1.38u as=0 ps=0 w=1u l=1u
X103 a_25391_1842# a_25153_1842# a_25283_1842# VSS.t379 sg13_lv_nmos ad=0.1406p pd=1.12u as=0.2516p ps=2.16u w=0.74u l=0.2u
X104 a_12993_1842# a_12797_1842# VSS.t169 VSS.t168 sg13_lv_nmos ad=0.2516p pd=2.16u as=0.1406p ps=1.12u w=0.74u l=0.13u
X105 DELAY_OUT_LAST a_27997_1842# VDD VDD sg13_lv_pmos ad=0.3808p pd=2.92u as=0.2128p ps=1.5u w=1.12u l=0.13u
X106 VDD VSS.t564 VDD VDD sg13_lv_pmos ad=0.34p pd=2.68u as=0 ps=0 w=1u l=1u
X107 VDD a_19637_1842# a_20105_1044# VDD sg13_lv_pmos ad=0.252p pd=1.57u as=0.3808p ps=2.92u w=1.12u l=0.13u
X108 VSS.t470 DELAY_VBIASN.t18 a_13991_1842# VSS.t469 sg13_lv_nmos ad=0.2516p pd=2.16u as=0.1406p ps=1.12u w=0.74u l=0.6u
X109 VSS.t283 VDD VSS.t282 VSS.t281 sg13_lv_nmos ad=0.1428p pd=1.52u as=0 ps=0 w=0.42u l=1u
X110 a_22590_1044# a_3171_1047.t3 a_24008_1044# VSS.t161 sg13_lv_nmos ad=0.2516p pd=2.16u as=0.1406p ps=1.12u w=0.74u l=0.13u
X111 a_6913_1842# a_6717_1842# VDD VDD sg13_lv_pmos ad=0.3808p pd=2.92u as=0.2128p ps=1.5u w=1.12u l=0.13u
X112 VDD DELAY_VBIASP.t12 a_18551_2470# VDD sg13_lv_pmos ad=0.3808p pd=2.92u as=0.2128p ps=1.5u w=1.12u l=0.6u
X113 VSS.t381 a_23763_1842# a_24197_1842# VSS.t380 sg13_lv_nmos ad=0.1406p pd=1.12u as=0.2516p ps=2.16u w=0.74u l=0.13u
X114 VSS.t248 VDD VSS.t247 VSS.t246 sg13_lv_nmos ad=0.1428p pd=1.52u as=0 ps=0 w=0.42u l=1u
X115 VDD a_1256_1044# a_2873_1395# VDD sg13_lv_pmos ad=0.1918p pd=1.5u as=0.1596p ps=1.22u w=0.84u l=0.13u
X116 a_3171_311.t1 a_2873_331# VSS.t90 VSS.t147 sg13_lv_nmos ad=0.1406p pd=1.12u as=0.1331p ps=1.12u w=0.74u l=0.13u
X117 VDD a_2873_331# a_3171_311.t0 VDD sg13_lv_pmos ad=0.4256p pd=3u as=0.2128p ps=1.5u w=1.12u l=0.13u
X118 a_16510_1044# a_17351_1008# a_17275_1044# VDD sg13_lv_pmos ad=0.3808p pd=2.92u as=0.2128p ps=1.5u w=1.12u l=0.13u
X119 a_25630_1044# a_3747_1047.t2 a_27915_1044# VSS.t0 sg13_lv_nmos ad=0.2516p pd=2.16u as=0.1406p ps=1.12u w=0.74u l=0.13u
X120 VSS.t440 DELAY_VBIASN.t1 a_26911_1842# VSS.t439 sg13_lv_nmos ad=0.2516p pd=2.16u as=0.1406p ps=1.12u w=0.74u l=0.6u
X121 a_3747_311.t1 a_3449_331# VSS.t144 VSS.t143 sg13_lv_nmos ad=0.1406p pd=1.12u as=0.1331p ps=1.12u w=0.74u l=0.13u
X122 VDD a_3449_331# a_3747_311.t0 VDD sg13_lv_pmos ad=0.4256p pd=3u as=0.2128p ps=1.5u w=1.12u l=0.13u
X123 VDD DELAY_VBIASP.t7 a_22351_2470# VDD sg13_lv_pmos ad=0.3808p pd=2.92u as=0.2128p ps=1.5u w=1.12u l=0.6u
X124 VDD a_3747_1047.t2 a_27991_1008# VDD sg13_lv_pmos ad=0.3808p pd=2.92u as=0.3808p ps=2.92u w=1.12u l=0.13u
X125 VDD VSS.t597 VDD VDD sg13_lv_pmos ad=0.19p pd=1.38u as=0 ps=0 w=1u l=1u
X126 VDD a_3747_1047.t9 a_6711_1008# VDD sg13_lv_pmos ad=0.3808p pd=2.92u as=0.3808p ps=2.92u w=1.12u l=0.13u
X127 a_6391_1842# a_6153_1842# a_6283_1842# VSS.t506 sg13_lv_nmos ad=0.1406p pd=1.12u as=0.2516p ps=2.16u w=0.74u l=0.2u
X128 a_15273_1842# a_15077_1842# VSS.t400 VSS.t421 sg13_lv_nmos ad=0.2516p pd=2.16u as=0.1406p ps=1.12u w=0.74u l=0.13u
X129 a_19833_1842# a_19637_1842# VDD VDD sg13_lv_pmos ad=0.3808p pd=2.92u as=0.2128p ps=1.5u w=1.12u l=0.13u
X130 a_16108_289# a_23945_519# a_22590_1044# VDD sg13_lv_pmos ad=0.3808p pd=2.92u as=0.3808p ps=2.92u w=1.12u l=0.13u
X131 a_9193_1842# a_8997_1842# VDD VDD sg13_lv_pmos ad=0.3808p pd=2.92u as=0.2128p ps=1.5u w=1.12u l=0.13u
X132 a_24631_2470# a_24393_1842# a_24523_1842# VDD sg13_lv_pmos ad=0.2128p pd=1.5u as=0.3808p ps=2.92u w=1.12u l=0.2u
X133 VSS.t370 a_15403_1842# a_15837_1842# VSS.t493 sg13_lv_nmos ad=0.1406p pd=1.12u as=0.2516p ps=2.16u w=0.74u l=0.13u
X134 a_8155_1044# a_7945_1044# VSS.t10 VSS.t528 sg13_lv_nmos ad=0.1406p pd=1.12u as=0.1665p ps=1.19u w=0.74u l=0.13u
X135 a_23633_1842# a_23437_1842# VDD VDD sg13_lv_pmos ad=0.3808p pd=2.92u as=0.2128p ps=1.5u w=1.12u l=0.13u
X136 VSS.t139 a_4763_1842# a_5197_1842# VSS.t138 sg13_lv_nmos ad=0.1406p pd=1.12u as=0.2516p ps=2.16u w=0.74u l=0.13u
X137 a_27048_1044# a_26477_1842# VSS.t561 VSS.t560 sg13_lv_nmos ad=0.1406p pd=1.12u as=0.2516p ps=2.16u w=0.74u l=0.13u
X138 VDD a_9323_1842# a_9757_1842# VDD sg13_lv_pmos ad=0.2128p pd=1.5u as=0.3808p ps=2.92u w=1.12u l=0.13u
X139 a_5768_1044# a_5197_1842# VSS.t178 VSS.t177 sg13_lv_nmos ad=0.1406p pd=1.12u as=0.2516p ps=2.16u w=0.74u l=0.13u
X140 a_7390_1044# a_7364_1008# a_7288_1044# VDD sg13_lv_pmos ad=0.3808p pd=2.92u as=0.2128p ps=1.5u w=1.12u l=0.13u
X141 VSS.t464 DELAY_VBIASN.t26 a_7911_1842# VSS.t463 sg13_lv_nmos ad=0.2516p pd=2.16u as=0.1406p ps=1.12u w=0.74u l=0.6u
X142 VDD VSS.t581 VDD VDD sg13_lv_pmos ad=0.19p pd=1.38u as=0 ps=0 w=1u l=1u
X143 a_11711_1842# a_11473_1842# a_11603_1842# VSS.t337 sg13_lv_nmos ad=0.1406p pd=1.12u as=0.2516p ps=2.16u w=0.74u l=0.2u
X144 VSS.t505 a_24197_1842# a_24665_1044# VSS.t504 sg13_lv_nmos ad=0.1665p pd=1.19u as=0.2516p ps=2.16u w=0.74u l=0.13u
X145 a_16510_1044# a_3171_1047.t5 a_17928_1044# VSS.t104 sg13_lv_nmos ad=0.2516p pd=2.16u as=0.1406p ps=1.12u w=0.74u l=0.13u
X146 VSS.t240 VDD VSS.t238 VSS.t239 sg13_lv_nmos ad=79.8f pd=0.8u as=0 ps=0 w=0.42u l=1u
X147 a_5631_2470# a_5393_1842# a_5523_1842# VDD sg13_lv_pmos ad=0.2128p pd=1.5u as=0.3808p ps=2.92u w=1.12u l=0.2u
X148 a_14513_1842# a_14317_1842# VDD VDD sg13_lv_pmos ad=0.3808p pd=2.92u as=0.2128p ps=1.5u w=1.12u l=0.13u
X149 a_4633_1842# a_4437_1842# VDD VDD sg13_lv_pmos ad=0.3808p pd=2.92u as=0.2128p ps=1.5u w=1.12u l=0.13u
X150 VSS.t96 a_10083_1842# a_10517_1842# VSS.t95 sg13_lv_nmos ad=0.1406p pd=1.12u as=0.2516p ps=2.16u w=0.74u l=0.13u
X151 VDD a_2019_1047.t4 a_19524_1008# VDD sg13_lv_pmos ad=0.3808p pd=2.92u as=0.3808p ps=2.92u w=1.12u l=0.13u
X152 VSS.t324 a_3171_1047.t4 a_21044_1008# VSS.t323 sg13_lv_nmos ad=0.2516p pd=2.16u as=0.2516p ps=2.16u w=0.74u l=0.13u
X153 VSS.t149 a_2873_331# a_3171_311.t1 VSS.t148 sg13_lv_nmos ad=0.2812p pd=2.24u as=0.1406p ps=1.12u w=0.74u l=0.13u
X154 VSS.t146 a_3449_331# a_3747_311.t1 VSS.t145 sg13_lv_nmos ad=0.2812p pd=2.24u as=0.1406p ps=1.12u w=0.74u l=0.13u
X155 a_15755_1044# a_15545_1044# VDD VDD sg13_lv_pmos ad=0.2128p pd=1.5u as=0.252p ps=1.57u w=1.12u l=0.13u
X156 VDD a_2595_1047.t6 a_14311_1008# VDD sg13_lv_pmos ad=0.3808p pd=2.92u as=0.3808p ps=2.92u w=1.12u l=0.13u
X157 VSS.t490 DELAY_VBIASN.t4 a_24631_1842# VSS.t489 sg13_lv_nmos ad=0.2516p pd=2.16u as=0.1406p ps=1.12u w=0.74u l=0.6u
X158 a_5115_1044# a_4905_1044# VDD VDD sg13_lv_pmos ad=0.2128p pd=1.5u as=0.252p ps=1.57u w=1.12u l=0.13u
X159 a_18551_2470# a_18313_1842# a_18443_1842# VDD sg13_lv_pmos ad=0.2128p pd=1.5u as=0.3808p ps=2.92u w=1.12u l=0.2u
X160 VDD VSS.t573 VDD VDD sg13_lv_pmos ad=0.19p pd=1.38u as=0 ps=0 w=1u l=1u
X161 a_3171_1047.t1 a_2873_1395# VSS.t190 VSS.t206 sg13_lv_nmos ad=0.1406p pd=1.12u as=0.1331p ps=1.12u w=0.74u l=0.13u
X162 VSS.t122 a_2297_1395# a_2595_1047.t1 VSS.t121 sg13_lv_nmos ad=0.2812p pd=2.24u as=0.1406p ps=1.12u w=0.74u l=0.13u
X163 a_22351_2470# a_22113_1842# a_22243_1842# VDD sg13_lv_pmos ad=0.2128p pd=1.5u as=0.3808p ps=2.92u w=1.12u l=0.2u
X164 VSS.t355 VSS.t352 VSS.t354 VSS.t353 sg13_lv_nmos ad=0.2516p pd=2.16u as=0 ps=0 w=0.74u l=0.13u
X165 a_26911_1842# a_26673_1842# a_26803_1842# VSS.t150 sg13_lv_nmos ad=0.1406p pd=1.12u as=0.2516p ps=2.16u w=0.74u l=0.2u
X166 VSS.t13 a_3171_311.t3 a_11785_519# VSS.t12 sg13_lv_nmos ad=0.2516p pd=2.16u as=0.2516p ps=2.16u w=0.74u l=0.13u
X167 VDD a_1721_1395# a_2019_1047.t0 VDD sg13_lv_pmos ad=0.4256p pd=3u as=0.2128p ps=1.5u w=1.12u l=0.13u
X168 VDD a_16923_1842# a_17357_1842# VDD sg13_lv_pmos ad=0.2128p pd=1.5u as=0.3808p ps=2.92u w=1.12u l=0.13u
X169 a_2391_1395# MUX_SEL0 a_2297_1395# VSS.t496 sg13_lv_nmos ad=0.1216p pd=1.02u as=0.2176p ps=1.96u w=0.64u l=0.13u
X170 VSS.t525 a_1544_1044# a_1815_1395# VSS.t535 sg13_lv_nmos ad=0.1331p pd=1.12u as=0.1216p ps=1.02u w=0.64u l=0.13u
X171 a_13368_1044# a_12797_1842# VSS.t171 VSS.t170 sg13_lv_nmos ad=0.1406p pd=1.12u as=0.2516p ps=2.16u w=0.74u l=0.13u
X172 a_5731_289# a_3171_311.t3 a_10430_1044# VSS.t11 sg13_lv_nmos ad=0.2516p pd=2.16u as=0.2516p ps=2.16u w=0.74u l=0.13u
X173 VDD a_21157_1842# a_21625_1044# VDD sg13_lv_pmos ad=0.252p pd=1.57u as=0.3808p ps=2.92u w=1.12u l=0.13u
X174 VDD DELAY_VBIASP.t22 a_10951_2470# VDD sg13_lv_pmos ad=0.3808p pd=2.92u as=0.2128p ps=1.5u w=1.12u l=0.6u
X175 VSS.t472 DELAY_VBIASN.t16 a_15511_1842# VSS.t471 sg13_lv_nmos ad=0.2516p pd=2.16u as=0.1406p ps=1.12u w=0.74u l=0.6u
X176 VDD a_20723_1842# a_21157_1842# VDD sg13_lv_pmos ad=0.2128p pd=1.5u as=0.3808p ps=2.92u w=1.12u l=0.13u
X177 VSS.t181 a_25283_1842# a_25717_1842# VSS.t426 sg13_lv_nmos ad=0.1406p pd=1.12u as=0.2516p ps=2.16u w=0.74u l=0.13u
X178 a_4350_1044# a_3747_1047.t9 a_6635_1044# VSS.t319 sg13_lv_nmos ad=0.2516p pd=2.16u as=0.1406p ps=1.12u w=0.74u l=0.13u
X179 VSS.t430 DELAY_VBIASN.t29 a_5631_1842# VSS.t429 sg13_lv_nmos ad=0.2516p pd=2.16u as=0.1406p ps=1.12u w=0.74u l=0.6u
X180 VDD a_2019_1047.t9 a_4324_1008# VDD sg13_lv_pmos ad=0.3808p pd=2.92u as=0.3808p ps=2.92u w=1.12u l=0.13u
X181 a_16510_1044# a_18871_1008# a_18795_1044# VDD sg13_lv_pmos ad=0.3808p pd=2.92u as=0.2128p ps=1.5u w=1.12u l=0.13u
X182 a_19550_1044# a_2595_1047.t4 a_20315_1044# VSS.t60 sg13_lv_nmos ad=0.2516p pd=2.16u as=0.1406p ps=1.12u w=0.74u l=0.13u
X183 VDD DELAY_VBIASP.t5 a_23871_2470# VDD sg13_lv_pmos ad=0.3808p pd=2.92u as=0.2128p ps=1.5u w=1.12u l=0.6u
X184 VSS.t10 a_7477_1842# a_7945_1044# VSS.t9 sg13_lv_nmos ad=0.1665p pd=1.19u as=0.2516p ps=2.16u w=0.74u l=0.13u
X185 a_13231_2470# a_12993_1842# a_13123_1842# VDD sg13_lv_pmos ad=0.2128p pd=1.5u as=0.3808p ps=2.92u w=1.12u l=0.2u
X186 VDD VSS.t598 VDD VDD sg13_lv_pmos ad=0.34p pd=2.68u as=0 ps=0 w=1u l=1u
X187 a_12233_1842# a_12037_1842# VDD VDD sg13_lv_pmos ad=0.3808p pd=2.92u as=0.2128p ps=1.5u w=1.12u l=0.13u
X188 a_7911_1842# a_7673_1842# a_7803_1842# VSS.t131 sg13_lv_nmos ad=0.1406p pd=1.12u as=0.2516p ps=2.16u w=0.74u l=0.2u
X189 a_16793_1842# a_16597_1842# VSS.t383 VSS.t382 sg13_lv_nmos ad=0.2516p pd=2.16u as=0.1406p ps=1.12u w=0.74u l=0.13u
X190 VDD a_3747_311.t3 a_14825_519# VDD sg13_lv_pmos ad=0.3808p pd=2.92u as=0.3808p ps=2.92u w=1.12u l=0.13u
X191 VSS.t530 a_27563_1842# a_27997_1842# VSS.t529 sg13_lv_nmos ad=0.1406p pd=1.12u as=0.2516p ps=2.16u w=0.74u l=0.13u
X192 a_9675_1044# a_9465_1044# VSS.t56 VSS.t55 sg13_lv_nmos ad=0.1406p pd=1.12u as=0.1665p ps=1.19u w=0.74u l=0.13u
X193 a_20593_1842# a_20397_1842# VSS.t30 VSS.t558 sg13_lv_nmos ad=0.2516p pd=2.16u as=0.1406p ps=1.12u w=0.74u l=0.13u
X194 VSS.t118 a_2595_1047.t8 a_8231_1008# VSS.t117 sg13_lv_nmos ad=0.2516p pd=2.16u as=0.2516p ps=2.16u w=0.74u l=0.13u
X195 VSS.t80 a_6283_1842# a_6717_1842# VSS.t79 sg13_lv_nmos ad=0.1406p pd=1.12u as=0.2516p ps=2.16u w=0.74u l=0.13u
X196 a_10430_1044# a_10404_1008# a_10328_1044# VDD sg13_lv_pmos ad=0.3808p pd=2.92u as=0.2128p ps=1.5u w=1.12u l=0.13u
X197 VDD DELAY_VBIASP.t2 a_26151_2470# VDD sg13_lv_pmos ad=0.3808p pd=2.92u as=0.2128p ps=1.5u w=1.12u l=0.6u
X198 a_7390_1044# a_8884_1008# a_8808_1044# VDD sg13_lv_pmos ad=0.3808p pd=2.92u as=0.2128p ps=1.5u w=1.12u l=0.13u
X199 VDD DELAY_VBIASP.t30 a_4871_2470# VDD sg13_lv_pmos ad=0.3808p pd=2.92u as=0.2128p ps=1.5u w=1.12u l=0.6u
X200 a_3449_331# MUX_SEL2 VDD VDD sg13_lv_pmos ad=0.1596p pd=1.22u as=0.2856p ps=2.36u w=0.84u l=0.13u
X201 VDD VSS.t575 VDD VDD sg13_lv_pmos ad=0.19p pd=1.38u as=0 ps=0 w=1u l=1u
X202 a_19073_1842# a_18877_1842# VSS.t342 VSS.t341 sg13_lv_nmos ad=0.2516p pd=2.16u as=0.1406p ps=1.12u w=0.74u l=0.13u
X203 VDD a_15077_1842# a_15545_1044# VDD sg13_lv_pmos ad=0.252p pd=1.57u as=0.3808p ps=2.92u w=1.12u l=0.13u
X204 a_19550_1044# a_2019_1047.t4 a_19448_1044# VSS.t313 sg13_lv_nmos ad=0.2516p pd=2.16u as=0.1406p ps=1.12u w=0.74u l=0.13u
X205 VDD VDD VDD VDD sg13_lv_pmos ad=0.3808p pd=2.92u as=0 ps=0 w=1.12u l=0.6u
X206 VSS.t300 VDD VSS.t298 VSS.t299 sg13_lv_nmos ad=79.8f pd=0.8u as=0 ps=0 w=0.42u l=1u
X207 VSS.t378 a_19203_1842# a_19637_1842# VSS.t377 sg13_lv_nmos ad=0.1406p pd=1.12u as=0.2516p ps=2.16u w=0.74u l=0.13u
X208 VDD VSS.t577 VDD VDD sg13_lv_pmos ad=0.19p pd=1.38u as=0 ps=0 w=1u l=1u
X209 VDD VSS.t588 VDD VDD sg13_lv_pmos ad=0.34p pd=2.68u as=0 ps=0 w=1u l=1u
X210 a_27433_1842# a_27237_1842# VDD VDD sg13_lv_pmos ad=0.3808p pd=2.92u as=0.2128p ps=1.5u w=1.12u l=0.13u
X211 VDD a_1256_289# a_2873_331# VDD sg13_lv_pmos ad=0.1918p pd=1.5u as=0.1596p ps=1.22u w=0.84u l=0.13u
X212 a_13470_1044# a_2595_1047.t6 a_14235_1044# VSS.t531 sg13_lv_nmos ad=0.2516p pd=2.16u as=0.1406p ps=1.12u w=0.74u l=0.13u
X213 VSS.t36 a_8563_1842# a_8997_1842# VSS.t35 sg13_lv_nmos ad=0.1406p pd=1.12u as=0.2516p ps=2.16u w=0.74u l=0.13u
X214 VSS.t432 DELAY_VBIASN.t19 a_13231_1842# VSS.t431 sg13_lv_nmos ad=0.2516p pd=2.16u as=0.1406p ps=1.12u w=0.74u l=0.6u
X215 VDD a_3171_1047.t7 a_11924_1008# VDD sg13_lv_pmos ad=0.3808p pd=2.92u as=0.3808p ps=2.92u w=1.12u l=0.13u
X216 VSS.t542 a_2019_1047.t3 a_22564_1008# VSS.t541 sg13_lv_nmos ad=0.2516p pd=2.16u as=0.2516p ps=2.16u w=0.74u l=0.13u
X217 VSS.t175 a_23003_1842# a_23437_1842# VSS.t412 sg13_lv_nmos ad=0.1406p pd=1.12u as=0.2516p ps=2.16u w=0.74u l=0.13u
X218 VSS.t303 VDD VSS.t302 VSS.t301 sg13_lv_nmos ad=0.1428p pd=1.52u as=0 ps=0 w=0.42u l=1u
X219 VDD DELAY_VBIASP.t27 a_7151_2470# VDD sg13_lv_pmos ad=0.3808p pd=2.92u as=0.2128p ps=1.5u w=1.12u l=0.6u
X220 a_25630_1044# a_25604_1008# a_25528_1044# VDD sg13_lv_pmos ad=0.3808p pd=2.92u as=0.2128p ps=1.5u w=1.12u l=0.13u
X221 a_15511_1842# a_15273_1842# a_15403_1842# VSS.t394 sg13_lv_nmos ad=0.1406p pd=1.12u as=0.2516p ps=2.16u w=0.74u l=0.2u
X222 a_18313_1842# a_18117_1842# VDD VDD sg13_lv_pmos ad=0.3808p pd=2.92u as=0.2128p ps=1.5u w=1.12u l=0.13u
X223 a_5731_289# a_11785_519# a_10430_1044# VDD sg13_lv_pmos ad=0.3808p pd=2.92u as=0.3808p ps=2.92u w=1.12u l=0.13u
X224 VSS.t220 VDD VSS.t218 VSS.t219 sg13_lv_nmos ad=79.8f pd=0.8u as=0 ps=0 w=0.42u l=1u
X225 a_9431_2470# a_9193_1842# a_9323_1842# VDD sg13_lv_pmos ad=0.2128p pd=1.5u as=0.3808p ps=2.92u w=1.12u l=0.2u
X226 a_17275_1044# a_17065_1044# VSS.t98 VSS.t97 sg13_lv_nmos ad=0.1406p pd=1.12u as=0.1665p ps=1.19u w=0.74u l=0.13u
X227 VDD VSS.t574 VDD VDD sg13_lv_pmos ad=0.34p pd=2.68u as=0 ps=0 w=1u l=1u
X228 VSS.t75 a_3747_1047.t6 a_15831_1008# VSS.t74 sg13_lv_nmos ad=0.2516p pd=2.16u as=0.2516p ps=2.16u w=0.74u l=0.13u
X229 a_23871_2470# a_23633_1842# a_23763_1842# VDD sg13_lv_pmos ad=0.2128p pd=1.5u as=0.3808p ps=2.92u w=1.12u l=0.2u
X230 VSS.t404 a_13883_1842# a_14317_1842# VSS.t422 sg13_lv_nmos ad=0.1406p pd=1.12u as=0.2516p ps=2.16u w=0.74u l=0.13u
X231 VSS.t312 a_3747_311.t2 a_26985_519# VSS.t311 sg13_lv_nmos ad=0.2516p pd=2.16u as=0.2516p ps=2.16u w=0.74u l=0.13u
X232 a_8433_1842# a_8237_1842# VDD VDD sg13_lv_pmos ad=0.3808p pd=2.92u as=0.2128p ps=1.5u w=1.12u l=0.13u
X233 VDD a_18443_1842# a_18877_1842# VDD sg13_lv_pmos ad=0.2128p pd=1.5u as=0.3808p ps=2.92u w=1.12u l=0.13u
X234 a_22113_1842# a_21917_1842# VDD VDD sg13_lv_pmos ad=0.3808p pd=2.92u as=0.2128p ps=1.5u w=1.12u l=0.13u
X235 a_4350_1044# a_2019_1047.t9 a_4248_1044# VSS.t316 sg13_lv_nmos ad=0.2516p pd=2.16u as=0.1406p ps=1.12u w=0.74u l=0.13u
X236 a_14888_1044# a_14317_1842# VSS.t402 VSS.t401 sg13_lv_nmos ad=0.1406p pd=1.12u as=0.2516p ps=2.16u w=0.74u l=0.13u
X237 a_16108_289# a_3747_311.t2 a_25630_1044# VSS.t310 sg13_lv_nmos ad=0.2516p pd=2.16u as=0.2516p ps=2.16u w=0.74u l=0.13u
X238 VDD DELAY_VBIASP.t20 a_12471_2470# VDD sg13_lv_pmos ad=0.3808p pd=2.92u as=0.2128p ps=1.5u w=1.12u l=0.6u
X239 VSS.t346 a_4003_1842# a_4437_1842# VSS.t427 sg13_lv_nmos ad=0.1406p pd=1.12u as=0.2516p ps=2.16u w=0.74u l=0.13u
X240 a_16510_1044# a_16484_1008# a_16408_1044# VDD sg13_lv_pmos ad=0.3808p pd=2.92u as=0.2128p ps=1.5u w=1.12u l=0.13u
X241 VDD a_22243_1842# a_22677_1842# VDD sg13_lv_pmos ad=0.2128p pd=1.5u as=0.3808p ps=2.92u w=1.12u l=0.13u
X242 VDD a_3171_1047.t2 a_27124_1008# VDD sg13_lv_pmos ad=0.3808p pd=2.92u as=0.3808p ps=2.92u w=1.12u l=0.13u
X243 VDD MUX_SEL3 a_3449_331# VDD sg13_lv_pmos ad=0.1918p pd=1.5u as=0.1596p ps=1.22u w=0.84u l=0.13u
X244 a_2595_311.t0 a_2297_331# VDD VDD sg13_lv_pmos ad=0.2128p pd=1.5u as=0.1918p ps=1.5u w=1.12u l=0.13u
X245 a_10430_1044# a_11271_1008# a_11195_1044# VDD sg13_lv_pmos ad=0.3808p pd=2.92u as=0.2128p ps=1.5u w=1.12u l=0.13u
X246 a_23355_1044# a_23145_1044# VDD VDD sg13_lv_pmos ad=0.2128p pd=1.5u as=0.252p ps=1.57u w=1.12u l=0.13u
X247 VDD a_3747_1047.t4 a_21911_1008# VDD sg13_lv_pmos ad=0.3808p pd=2.92u as=0.3808p ps=2.92u w=1.12u l=0.13u
X248 VSS.t56 a_8997_1842# a_9465_1044# VSS.t424 sg13_lv_nmos ad=0.1665p pd=1.19u as=0.2516p ps=2.16u w=0.74u l=0.13u
X249 a_20968_1044# a_20397_1842# VDD VDD sg13_lv_pmos ad=0.2128p pd=1.5u as=0.3808p ps=2.92u w=1.12u l=0.13u
X250 a_10951_1842# a_10713_1842# a_10843_1842# VSS.t343 sg13_lv_nmos ad=0.1406p pd=1.12u as=0.2516p ps=2.16u w=0.74u l=0.2u
X251 VSS.t333 a_2019_1047.t5 a_16484_1008# VSS.t332 sg13_lv_nmos ad=0.2516p pd=2.16u as=0.2516p ps=2.16u w=0.74u l=0.13u
X252 a_26151_2470# a_25913_1842# a_26043_1842# VDD sg13_lv_pmos ad=0.2128p pd=1.5u as=0.3808p ps=2.92u w=1.12u l=0.2u
X253 a_13753_1842# a_13557_1842# VDD VDD sg13_lv_pmos ad=0.3808p pd=2.92u as=0.2128p ps=1.5u w=1.12u l=0.13u
X254 VDD a_1721_331# a_2019_311# VDD sg13_lv_pmos ad=0.4256p pd=3u as=0.2128p ps=1.5u w=1.12u l=0.13u
X255 a_4871_2470# a_4633_1842# a_4763_1842# VDD sg13_lv_pmos ad=0.2128p pd=1.5u as=0.3808p ps=2.92u w=1.12u l=0.2u
X256 VSS.t112 a_3171_1047.t9 a_5844_1008# VSS.t111 sg13_lv_nmos ad=0.2516p pd=2.16u as=0.2516p ps=2.16u w=0.74u l=0.13u
X257 VSS.t260 VDD VSS.t258 VSS.t259 sg13_lv_nmos ad=79.8f pd=0.8u as=0 ps=0 w=0.42u l=1u
X258 VDD a_2595_311.t2 a_20905_519# VDD sg13_lv_pmos ad=0.3808p pd=2.92u as=0.3808p ps=2.92u w=1.12u l=0.13u
X259 VDD a_2297_331# a_2595_311.t0 VDD sg13_lv_pmos ad=0.4256p pd=3u as=0.2128p ps=1.5u w=1.12u l=0.13u
X260 VSS.t16 a_2595_1047.t7 a_11271_1008# VSS.t15 sg13_lv_nmos ad=0.2516p pd=2.16u as=0.2516p ps=2.16u w=0.74u l=0.13u
X261 VSS.t484 DELAY_VBIASN.t11 a_19311_1842# VSS.t483 sg13_lv_nmos ad=0.2516p pd=2.16u as=0.1406p ps=1.12u w=0.74u l=0.6u
X262 VDD a_24523_1842# a_24957_1842# VDD sg13_lv_pmos ad=0.2128p pd=1.5u as=0.3808p ps=2.92u w=1.12u l=0.13u
X263 VSS.t330 a_3747_1047.t8 a_9751_1008# VSS.t329 sg13_lv_nmos ad=0.2516p pd=2.16u as=0.2516p ps=2.16u w=0.74u l=0.13u
X264 VSS.t466 DELAY_VBIASN.t24 a_9431_1842# VSS.t465 sg13_lv_nmos ad=0.2516p pd=2.16u as=0.1406p ps=1.12u w=0.74u l=0.6u
X265 a_19448_1044# a_18877_1842# VDD VDD sg13_lv_pmos ad=0.2128p pd=1.5u as=0.3808p ps=2.92u w=1.12u l=0.13u
X266 VSS.t436 DELAY_VBIASN.t6 a_23111_1842# VSS.t435 sg13_lv_nmos ad=0.2516p pd=2.16u as=0.1406p ps=1.12u w=0.74u l=0.6u
X267 a_10430_1044# a_11924_1008# a_11848_1044# VDD sg13_lv_pmos ad=0.3808p pd=2.92u as=0.2128p ps=1.5u w=1.12u l=0.13u
X268 VDD DELAY_VBIASP.t0 a_27671_2470# VDD sg13_lv_pmos ad=0.3808p pd=2.92u as=0.2128p ps=1.5u w=1.12u l=0.6u
X269 a_25630_1044# a_26471_1008# a_26395_1044# VDD sg13_lv_pmos ad=0.3808p pd=2.92u as=0.2128p ps=1.5u w=1.12u l=0.13u
X270 a_7151_2470# a_6913_1842# a_7043_1842# VDD sg13_lv_pmos ad=0.2128p pd=1.5u as=0.3808p ps=2.92u w=1.12u l=0.2u
X271 a_16033_1842# a_15837_1842# VDD VDD sg13_lv_pmos ad=0.3808p pd=2.92u as=0.2128p ps=1.5u w=1.12u l=0.13u
X272 VDD a_15964_289# a_16851_309# VDD sg13_lv_pmos ad=0.2086p pd=1.5u as=0.34p ps=2.68u w=1u l=0.13u
X273 VDD VSS.t576 VDD VDD sg13_lv_pmos ad=0.34p pd=2.68u as=0 ps=0 w=1u l=1u
X274 VSS.t6 a_11603_1842# a_12037_1842# VSS.t5 sg13_lv_nmos ad=0.1406p pd=1.12u as=0.2516p ps=2.16u w=0.74u l=0.13u
X275 VSS.t280 VDD VSS.t278 VSS.t279 sg13_lv_nmos ad=79.8f pd=0.8u as=0 ps=0 w=0.42u l=1u
X276 VDD VSS.t590 VDD VDD sg13_lv_pmos ad=0.34p pd=2.68u as=0 ps=0 w=1u l=1u
X277 VDD a_5957_1842# a_6425_1044# VDD sg13_lv_pmos ad=0.252p pd=1.57u as=0.3808p ps=2.92u w=1.12u l=0.13u
X278 a_24393_1842# a_24197_1842# VSS.t381 VSS.t503 sg13_lv_nmos ad=0.2516p pd=2.16u as=0.1406p ps=1.12u w=0.74u l=0.13u
X279 a_3747_1047.t1 a_3449_1395# VSS.t165 VSS.t164 sg13_lv_nmos ad=0.1406p pd=1.12u as=0.1331p ps=1.12u w=0.74u l=0.13u
X280 a_1544_1044# MUX_SEL1 VSS.t513 VSS.t512 sg13_lv_nmos ad=0.2516p pd=2.16u as=0.2516p ps=2.16u w=0.74u l=0.13u
X281 VDD VSS.t578 VDD VDD sg13_lv_pmos ad=0.34p pd=2.68u as=0 ps=0 w=1u l=1u
X282 a_3171_1047.t0 a_2873_1395# VDD VDD sg13_lv_pmos ad=0.2128p pd=1.5u as=0.1918p ps=1.5u w=1.12u l=0.13u
X283 a_13470_1044# a_3747_1047.t6 a_15755_1044# VSS.t73 sg13_lv_nmos ad=0.2516p pd=2.16u as=0.1406p ps=1.12u w=0.74u l=0.13u
X284 VDD a_5523_1842# a_5957_1842# VDD sg13_lv_pmos ad=0.2128p pd=1.5u as=0.3808p ps=2.92u w=1.12u l=0.13u
X285 VDD a_2297_1395# a_2595_1047.t0 VDD sg13_lv_pmos ad=0.4256p pd=3u as=0.2128p ps=1.5u w=1.12u l=0.13u
X286 VSS.t474 DELAY_VBIASN.t17 a_14751_1842# VSS.t473 sg13_lv_nmos ad=0.2516p pd=2.16u as=0.1406p ps=1.12u w=0.74u l=0.6u
X287 a_2967_1395# MUX_SEL1 a_2873_1395# VSS.t514 sg13_lv_nmos ad=0.1216p pd=1.02u as=0.2176p ps=1.96u w=0.64u l=0.13u
X288 a_4350_1044# a_2595_1047.t9 a_5115_1044# VSS.t70 sg13_lv_nmos ad=0.2516p pd=2.16u as=0.1406p ps=1.12u w=0.74u l=0.13u
X289 VDD a_2019_1047.t6 a_13444_1008# VDD sg13_lv_pmos ad=0.3808p pd=2.92u as=0.3808p ps=2.92u w=1.12u l=0.13u
X290 VSS.t103 a_2595_1047.t2 a_26471_1008# VSS.t102 sg13_lv_nmos ad=0.2516p pd=2.16u as=0.2516p ps=2.16u w=0.74u l=0.13u
X291 a_2595_311.t1 a_2297_331# VSS.t28 VSS.t128 sg13_lv_nmos ad=0.1406p pd=1.12u as=0.1331p ps=1.12u w=0.74u l=0.13u
X292 VSS.t438 DELAY_VBIASN.t31 a_4111_1842# VSS.t437 sg13_lv_nmos ad=0.2516p pd=2.16u as=0.1406p ps=1.12u w=0.74u l=0.6u
X293 a_2297_1395# MUX_SEL0 VDD VDD sg13_lv_pmos ad=0.1596p pd=1.22u as=0.2856p ps=2.36u w=0.84u l=0.13u
X294 VSS.t98 a_16597_1842# a_17065_1044# VSS.t384 sg13_lv_nmos ad=0.1665p pd=1.19u as=0.2516p ps=2.16u w=0.74u l=0.13u
X295 VDD DELAY_VBIASP.t25 a_8671_2470# VDD sg13_lv_pmos ad=0.3808p pd=2.92u as=0.2128p ps=1.5u w=1.12u l=0.6u
X296 VDD VSS.t591 VDD VDD sg13_lv_pmos ad=0.19p pd=1.38u as=0 ps=0 w=1u l=1u
X297 VDD a_1544_1044# a_1721_1395# VDD sg13_lv_pmos ad=0.1918p pd=1.5u as=0.1596p ps=1.22u w=0.84u l=0.13u
X298 a_4248_1044# a_4157_1313# VDD VDD sg13_lv_pmos ad=0.2128p pd=1.5u as=0.3808p ps=2.92u w=1.12u l=0.13u
X299 a_12471_2470# a_12233_1842# a_12363_1842# VDD sg13_lv_pmos ad=0.2128p pd=1.5u as=0.3808p ps=2.92u w=1.12u l=0.2u
X300 a_17031_1842# a_16793_1842# a_16923_1842# VSS.t33 sg13_lv_nmos ad=0.1406p pd=1.12u as=0.2516p ps=2.16u w=0.74u l=0.2u
X301 VSS.t54 a_1721_331# a_2019_311# VSS.t53 sg13_lv_nmos ad=0.2812p pd=2.24u as=0.1406p ps=1.12u w=0.74u l=0.13u
X302 a_19550_1044# a_21911_1008# a_21835_1044# VDD sg13_lv_pmos ad=0.3808p pd=2.92u as=0.2128p ps=1.5u w=1.12u l=0.13u
X303 a_16108_289# a_26985_519# a_25630_1044# VDD sg13_lv_pmos ad=0.3808p pd=2.92u as=0.3808p ps=2.92u w=1.12u l=0.13u
X304 VSS.t130 a_2297_331# a_2595_311.t1 VSS.t129 sg13_lv_nmos ad=0.2812p pd=2.24u as=0.1406p ps=1.12u w=0.74u l=0.13u
X305 a_18795_1044# a_18585_1044# VSS.t43 VSS.t193 sg13_lv_nmos ad=0.1406p pd=1.12u as=0.1665p ps=1.19u w=0.74u l=0.13u
X306 a_20831_1842# a_20593_1842# a_20723_1842# VSS.t92 sg13_lv_nmos ad=0.1406p pd=1.12u as=0.2516p ps=2.16u w=0.74u l=0.2u
X307 VSS.t218 VDD VSS.t217 VSS.t216 sg13_lv_nmos ad=0.1428p pd=1.52u as=0 ps=0 w=0.42u l=1u
X308 VDD a_22677_1842# a_23145_1044# VDD sg13_lv_pmos ad=0.252p pd=1.57u as=0.3808p ps=2.92u w=1.12u l=0.13u
X309 VSS.t115 a_2595_1047.t5 a_17351_1008# VSS.t114 sg13_lv_nmos ad=0.2516p pd=2.16u as=0.2516p ps=2.16u w=0.74u l=0.13u
X310 a_5393_1842# a_5197_1842# VSS.t139 VSS.t176 sg13_lv_nmos ad=0.2516p pd=2.16u as=0.1406p ps=1.12u w=0.74u l=0.13u
X311 VSS.t442 DELAY_VBIASN.t14 a_17031_1842# VSS.t441 sg13_lv_nmos ad=0.2516p pd=2.16u as=0.1406p ps=1.12u w=0.74u l=0.6u
X312 a_25630_1044# a_3171_1047.t2 a_27048_1044# VSS.t57 sg13_lv_nmos ad=0.2516p pd=2.16u as=0.1406p ps=1.12u w=0.74u l=0.13u
X313 a_9953_1842# a_9757_1842# VDD VDD sg13_lv_pmos ad=0.3808p pd=2.92u as=0.2128p ps=1.5u w=1.12u l=0.13u
X314 VDD a_10843_1842# a_11277_1842# VDD sg13_lv_pmos ad=0.2128p pd=1.5u as=0.3808p ps=2.92u w=1.12u l=0.13u
X315 VSS.t336 a_26803_1842# a_27237_1842# VSS.t398 sg13_lv_nmos ad=0.1406p pd=1.12u as=0.2516p ps=2.16u w=0.74u l=0.13u
X316 a_4350_1044# a_3171_1047.t9 a_5768_1044# VSS.t110 sg13_lv_nmos ad=0.2516p pd=2.16u as=0.1406p ps=1.12u w=0.74u l=0.13u
X317 a_10430_1044# a_12791_1008# a_12715_1044# VDD sg13_lv_pmos ad=0.3808p pd=2.92u as=0.2128p ps=1.5u w=1.12u l=0.13u
X318 a_19311_1842# a_19073_1842# a_19203_1842# VSS.t551 sg13_lv_nmos ad=0.1406p pd=1.12u as=0.2516p ps=2.16u w=0.74u l=0.2u
X319 a_24875_1044# a_24665_1044# VDD VDD sg13_lv_pmos ad=0.2128p pd=1.5u as=0.252p ps=1.57u w=1.12u l=0.13u
X320 VDD a_2595_1047.t3 a_23431_1008# VDD sg13_lv_pmos ad=0.3808p pd=2.92u as=0.3808p ps=2.92u w=1.12u l=0.13u
X321 VDD a_13557_1842# a_14025_1044# VDD sg13_lv_pmos ad=0.252p pd=1.57u as=0.3808p ps=2.92u w=1.12u l=0.13u
X322 a_23111_1842# a_22873_1842# a_23003_1842# VSS.t366 sg13_lv_nmos ad=0.1406p pd=1.12u as=0.2516p ps=2.16u w=0.74u l=0.2u
X323 a_27671_2470# a_27433_1842# a_27563_1842# VDD sg13_lv_pmos ad=0.2128p pd=1.5u as=0.3808p ps=2.92u w=1.12u l=0.2u
X324 VSS.t41 a_17683_1842# a_18117_1842# VSS.t91 sg13_lv_nmos ad=0.1406p pd=1.12u as=0.2516p ps=2.16u w=0.74u l=0.13u
X325 VSS.t275 VDD VSS.t273 VSS.t274 sg13_lv_nmos ad=79.8f pd=0.8u as=0 ps=0 w=0.42u l=1u
X326 a_10713_1842# a_10517_1842# VSS.t96 VSS.t141 sg13_lv_nmos ad=0.2516p pd=2.16u as=0.1406p ps=1.12u w=0.74u l=0.13u
X327 VSS.t199 a_2019_1047.t8 a_7364_1008# VSS.t198 sg13_lv_nmos ad=0.2516p pd=2.16u as=0.2516p ps=2.16u w=0.74u l=0.13u
X328 VSS.t4 a_7803_1842# a_8237_1842# VSS.t3 sg13_lv_nmos ad=0.1406p pd=1.12u as=0.2516p ps=2.16u w=0.74u l=0.13u
X329 VDD DELAY_VBIASP.t15 a_16271_2470# VDD sg13_lv_pmos ad=0.3808p pd=2.92u as=0.2128p ps=1.5u w=1.12u l=0.6u
X330 VSS.t270 VDD VSS.t268 VSS.t269 sg13_lv_nmos ad=79.8f pd=0.8u as=0 ps=0 w=0.42u l=1u
X331 VSS.t243 VDD VSS.t242 VSS.t241 sg13_lv_nmos ad=0.1428p pd=1.52u as=0 ps=0 w=0.42u l=1u
X332 VDD a_26043_1842# a_26477_1842# VDD sg13_lv_pmos ad=0.2128p pd=1.5u as=0.3808p ps=2.92u w=1.12u l=0.13u
X333 a_3543_331# MUX_SEL2 a_3449_331# VSS.t309 sg13_lv_nmos ad=0.1216p pd=1.02u as=0.2176p ps=1.96u w=0.64u l=0.13u
X334 a_22488_1044# a_21917_1842# VSS.t51 VSS.t50 sg13_lv_nmos ad=0.1406p pd=1.12u as=0.2516p ps=2.16u w=0.74u l=0.13u
X335 VDD VSS.t593 VDD VDD sg13_lv_pmos ad=0.19p pd=1.38u as=0 ps=0 w=1u l=1u
X336 a_22590_1044# a_24084_1008# a_24008_1044# VDD sg13_lv_pmos ad=0.3808p pd=2.92u as=0.2128p ps=1.5u w=1.12u l=0.13u
X337 VDD DELAY_VBIASP.t10 a_20071_2470# VDD sg13_lv_pmos ad=0.3808p pd=2.92u as=0.2128p ps=1.5u w=1.12u l=0.6u
X338 a_14751_1842# a_14513_1842# a_14643_1842# VSS.t373 sg13_lv_nmos ad=0.1406p pd=1.12u as=0.2516p ps=2.16u w=0.74u l=0.2u
X339 VSS.t208 a_2873_1395# a_3171_1047.t1 VSS.t207 sg13_lv_nmos ad=0.2812p pd=2.24u as=0.1406p ps=1.12u w=0.74u l=0.13u
X340 VDD VSS.t567 VDD VDD sg13_lv_pmos ad=0.19p pd=1.38u as=0 ps=0 w=1u l=1u
X341 a_25630_1044# a_27991_1008# a_27915_1044# VDD sg13_lv_pmos ad=0.3808p pd=2.92u as=0.2128p ps=1.5u w=1.12u l=0.13u
X342 VSS.t358 VSS.t356 VSS.t354 VSS.t357 sg13_lv_nmos ad=0.1406p pd=1.12u as=0 ps=0 w=0.74u l=0.13u
X343 a_4111_1842# DELAY_IN a_4003_1842# VSS.t348 sg13_lv_nmos ad=0.1406p pd=1.12u as=0.2516p ps=2.16u w=0.74u l=0.2u
X344 a_8671_2470# a_8433_1842# a_8563_1842# VDD sg13_lv_pmos ad=0.2128p pd=1.5u as=0.3808p ps=2.92u w=1.12u l=0.2u
X345 a_17553_1842# a_17357_1842# VDD VDD sg13_lv_pmos ad=0.3808p pd=2.92u as=0.2128p ps=1.5u w=1.12u l=0.13u
X346 VSS.t120 a_1544_1044# a_2391_1395# VSS.t534 sg13_lv_nmos ad=0.1331p pd=1.12u as=0.1216p ps=1.02u w=0.64u l=0.13u
X347 VSS.t511 a_3747_311.t3 a_14825_519# VSS.t510 sg13_lv_nmos ad=0.2516p pd=2.16u as=0.2516p ps=2.16u w=0.74u l=0.13u
X348 VSS.t90 a_1256_289# a_2967_331# VSS.t89 sg13_lv_nmos ad=0.1331p pd=1.12u as=0.1216p ps=1.02u w=0.64u l=0.13u
X349 a_2019_1047.t1 a_1721_1395# VSS.t525 VSS.t524 sg13_lv_nmos ad=0.1406p pd=1.12u as=0.1331p ps=1.12u w=0.74u l=0.13u
X350 a_15964_289# a_15765_463# a_5731_289# VSS.t84 sg13_lv_nmos ad=0.2183p pd=1.33u as=0.2516p ps=2.16u w=0.74u l=0.13u
X351 a_13470_1044# a_2019_1047.t6 a_13368_1044# VSS.t537 sg13_lv_nmos ad=0.2516p pd=2.16u as=0.1406p ps=1.12u w=0.74u l=0.13u
X352 VSS.t157 a_13123_1842# a_13557_1842# VSS.t156 sg13_lv_nmos ad=0.1406p pd=1.12u as=0.2516p ps=2.16u w=0.74u l=0.13u
X353 VDD VSS.t566 VDD VDD sg13_lv_pmos ad=0.34p pd=2.68u as=0 ps=0 w=1u l=1u
X354 VSS.t163 a_3171_1047.t3 a_24084_1008# VSS.t162 sg13_lv_nmos ad=0.2516p pd=2.16u as=0.2516p ps=2.16u w=0.74u l=0.13u
X355 a_25913_1842# a_25717_1842# VSS.t181 VSS.t180 sg13_lv_nmos ad=0.2516p pd=2.16u as=0.1406p ps=1.12u w=0.74u l=0.13u
X356 a_21353_1842# a_21157_1842# VDD VDD sg13_lv_pmos ad=0.3808p pd=2.92u as=0.2128p ps=1.5u w=1.12u l=0.13u
X357 VSS.t278 VDD VSS.t277 VSS.t276 sg13_lv_nmos ad=0.1428p pd=1.52u as=0 ps=0 w=0.42u l=1u
X358 a_2297_331# MUX_SEL2 VDD VDD sg13_lv_pmos ad=0.1596p pd=1.22u as=0.2856p ps=2.36u w=0.84u l=0.13u
X359 VDD a_7043_1842# a_7477_1842# VDD sg13_lv_pmos ad=0.2128p pd=1.5u as=0.3808p ps=2.92u w=1.12u l=0.13u
X360 a_2873_331# MUX_SEL3 VDD VDD sg13_lv_pmos ad=0.1596p pd=1.22u as=0.2856p ps=2.36u w=0.84u l=0.13u
X361 a_8155_1044# a_7945_1044# VDD VDD sg13_lv_pmos ad=0.2128p pd=1.5u as=0.252p ps=1.57u w=1.12u l=0.13u
X362 VSS.t43 a_18117_1842# a_18585_1044# VSS.t42 sg13_lv_nmos ad=0.1665p pd=1.19u as=0.2516p ps=2.16u w=0.74u l=0.13u
X363 a_27048_1044# a_26477_1842# VDD VDD sg13_lv_pmos ad=0.2128p pd=1.5u as=0.3808p ps=2.92u w=1.12u l=0.13u
X364 a_5768_1044# a_5197_1842# VDD VDD sg13_lv_pmos ad=0.2128p pd=1.5u as=0.3808p ps=2.92u w=1.12u l=0.13u
X365 a_13991_2470# a_13753_1842# a_13883_1842# VDD sg13_lv_pmos ad=0.2128p pd=1.5u as=0.3808p ps=2.92u w=1.12u l=0.2u
X366 VSS.t160 a_3171_1047.t6 a_14964_1008# VSS.t159 sg13_lv_nmos ad=0.2516p pd=2.16u as=0.2516p ps=2.16u w=0.74u l=0.13u
X367 VDD a_2019_311# a_17865_519# VDD sg13_lv_pmos ad=0.3808p pd=2.92u as=0.3808p ps=2.92u w=1.12u l=0.13u
X368 DELAY_OUT_LAST a_27997_1842# VSS.t530 VSS.t546 sg13_lv_nmos ad=0.2516p pd=2.16u as=0.1406p ps=1.12u w=0.74u l=0.13u
X369 a_11195_1044# a_10985_1044# VSS.t68 VSS.t67 sg13_lv_nmos ad=0.1406p pd=1.12u as=0.1665p ps=1.19u w=0.74u l=0.13u
X370 VDD a_24197_1842# a_24665_1044# VDD sg13_lv_pmos ad=0.252p pd=1.57u as=0.3808p ps=2.92u w=1.12u l=0.13u
X371 a_6913_1842# a_6717_1842# VSS.t80 VSS.t543 sg13_lv_nmos ad=0.2516p pd=2.16u as=0.1406p ps=1.12u w=0.74u l=0.13u
X372 VSS.t480 DELAY_VBIASN.t12 a_18551_1842# VSS.t479 sg13_lv_nmos ad=0.2516p pd=2.16u as=0.1406p ps=1.12u w=0.74u l=0.6u
X373 a_16510_1044# a_18004_1008# a_17928_1044# VDD sg13_lv_pmos ad=0.3808p pd=2.92u as=0.2128p ps=1.5u w=1.12u l=0.13u
X374 VDD a_12363_1842# a_12797_1842# VDD sg13_lv_pmos ad=0.2128p pd=1.5u as=0.3808p ps=2.92u w=1.12u l=0.13u
X375 VSS.t144 MUX_SEL3 a_3543_331# VSS.t555 sg13_lv_nmos ad=0.1331p pd=1.12u as=0.1216p ps=1.02u w=0.64u l=0.13u
X376 a_22590_1044# a_2595_1047.t3 a_23355_1044# VSS.t81 sg13_lv_nmos ad=0.2516p pd=2.16u as=0.1406p ps=1.12u w=0.74u l=0.13u
X377 VSS.t486 DELAY_VBIASN.t7 a_22351_1842# VSS.t485 sg13_lv_nmos ad=0.2516p pd=2.16u as=0.1406p ps=1.12u w=0.74u l=0.6u
X378 VDD a_3171_1047.t4 a_21044_1008# VDD sg13_lv_pmos ad=0.3808p pd=2.92u as=0.3808p ps=2.92u w=1.12u l=0.13u
X379 VDD VSS.t569 VDD VDD sg13_lv_pmos ad=0.19p pd=1.38u as=0 ps=0 w=1u l=1u
X380 a_16271_2470# a_16033_1842# a_16163_1842# VDD sg13_lv_pmos ad=0.2128p pd=1.5u as=0.3808p ps=2.92u w=1.12u l=0.2u
X381 VDD VSS.t583 VDD VDD sg13_lv_pmos ad=0.19p pd=1.38u as=0 ps=0 w=1u l=1u
X382 a_19833_1842# a_19637_1842# VSS.t378 VSS.t395 sg13_lv_nmos ad=0.2516p pd=2.16u as=0.1406p ps=1.12u w=0.74u l=0.13u
X383 VDD a_2019_311# a_5705_519# VDD sg13_lv_pmos ad=0.3808p pd=2.92u as=0.3808p ps=2.92u w=1.12u l=0.13u
X384 a_20071_2470# a_19833_1842# a_19963_1842# VDD sg13_lv_pmos ad=0.2128p pd=1.5u as=0.3808p ps=2.92u w=1.12u l=0.2u
X385 a_9193_1842# a_8997_1842# VSS.t36 VSS.t425 sg13_lv_nmos ad=0.2516p pd=2.16u as=0.1406p ps=1.12u w=0.74u l=0.13u
X386 a_24631_1842# a_24393_1842# a_24523_1842# VSS.t142 sg13_lv_nmos ad=0.1406p pd=1.12u as=0.2516p ps=2.16u w=0.74u l=0.2u
X387 VDD VSS.t582 VDD VDD sg13_lv_pmos ad=0.34p pd=2.68u as=0 ps=0 w=1u l=1u
X388 VSS.t87 a_2019_1047.t7 a_10404_1008# VSS.t86 sg13_lv_nmos ad=0.2516p pd=2.16u as=0.2516p ps=2.16u w=0.74u l=0.13u
X389 VDD a_14643_1842# a_15077_1842# VDD sg13_lv_pmos ad=0.2128p pd=1.5u as=0.3808p ps=2.92u w=1.12u l=0.13u
X390 VDD a_1544_289# a_2297_331# VDD sg13_lv_pmos ad=0.1918p pd=1.5u as=0.1596p ps=1.22u w=0.84u l=0.13u
X391 a_23633_1842# a_23437_1842# VSS.t175 VSS.t174 sg13_lv_nmos ad=0.2516p pd=2.16u as=0.1406p ps=1.12u w=0.74u l=0.13u
X392 VSS.t273 VDD VSS.t272 VSS.t271 sg13_lv_nmos ad=0.1428p pd=1.52u as=0 ps=0 w=0.42u l=1u
X393 a_2019_311# a_1721_331# VDD VDD sg13_lv_pmos ad=0.2128p pd=1.5u as=0.1918p ps=1.5u w=1.12u l=0.13u
X394 VSS.t155 a_9323_1842# a_9757_1842# VSS.t423 sg13_lv_nmos ad=0.1406p pd=1.12u as=0.2516p ps=2.16u w=0.74u l=0.13u
X395 a_26395_1044# a_26185_1044# VSS.t127 VSS.t126 sg13_lv_nmos ad=0.1406p pd=1.12u as=0.1665p ps=1.19u w=0.74u l=0.13u
X396 VDD DELAY_VBIASP.t13 a_17791_2470# VDD sg13_lv_pmos ad=0.3808p pd=2.92u as=0.2128p ps=1.5u w=1.12u l=0.6u
X397 VSS.t22 a_3747_1047.t3 a_24951_1008# VSS.t21 sg13_lv_nmos ad=0.2516p pd=2.16u as=0.2516p ps=2.16u w=0.74u l=0.13u
X398 VSS.t238 VDD VSS.t237 VSS.t236 sg13_lv_nmos ad=0.1428p pd=1.52u as=0 ps=0 w=0.42u l=1u
X399 VSS.t268 VDD VSS.t267 VSS.t266 sg13_lv_nmos ad=0.1428p pd=1.52u as=0 ps=0 w=0.42u l=1u
X400 a_3747_1047.t0 a_3449_1395# VDD VDD sg13_lv_pmos ad=0.2128p pd=1.5u as=0.1918p ps=1.5u w=1.12u l=0.13u
X401 a_13368_1044# a_12797_1842# VDD VDD sg13_lv_pmos ad=0.2128p pd=1.5u as=0.3808p ps=2.92u w=1.12u l=0.13u
X402 a_24008_1044# a_23437_1842# VSS.t173 VSS.t172 sg13_lv_nmos ad=0.1406p pd=1.12u as=0.2516p ps=2.16u w=0.74u l=0.13u
X403 VDD DELAY_VBIASP.t8 a_21591_2470# VDD sg13_lv_pmos ad=0.3808p pd=2.92u as=0.2128p ps=1.5u w=1.12u l=0.6u
X404 a_15964_289# MUX_SEL4 a_5731_289# VDD sg13_lv_pmos ad=0.3304p pd=1.71u as=0.3808p ps=2.92u w=1.12u l=0.13u
X405 a_4350_1044# a_6711_1008# a_6635_1044# VDD sg13_lv_pmos ad=0.3808p pd=2.92u as=0.2128p ps=1.5u w=1.12u l=0.13u
X406 a_2873_1395# MUX_SEL1 VDD VDD sg13_lv_pmos ad=0.1596p pd=1.22u as=0.2856p ps=2.36u w=0.84u l=0.13u
X407 a_1256_1044# MUX_SEL0 VSS.t495 VSS.t494 sg13_lv_nmos ad=0.2516p pd=2.16u as=0.2516p ps=2.16u w=0.74u l=0.13u
X408 VSS.t235 VDD VSS.t233 VSS.t234 sg13_lv_nmos ad=79.8f pd=0.8u as=0 ps=0 w=0.42u l=1u
X409 a_19550_1044# a_20391_1008# a_20315_1044# VDD sg13_lv_pmos ad=0.3808p pd=2.92u as=0.2128p ps=1.5u w=1.12u l=0.13u
X410 VDD VDD VDD VDD sg13_lv_pmos ad=0.2128p pd=1.5u as=0 ps=0 w=1.12u l=0.2u
X411 a_5631_1842# a_5393_1842# a_5523_1842# VSS.t69 sg13_lv_nmos ad=0.1406p pd=1.12u as=0.2516p ps=2.16u w=0.74u l=0.2u
X412 a_14513_1842# a_14317_1842# VSS.t404 VSS.t403 sg13_lv_nmos ad=0.2516p pd=2.16u as=0.1406p ps=1.12u w=0.74u l=0.13u
X413 VSS.t19 a_2595_311.t2 a_20905_519# VSS.t18 sg13_lv_nmos ad=0.2516p pd=2.16u as=0.2516p ps=2.16u w=0.74u l=0.13u
X414 VDD a_7477_1842# a_7945_1044# VDD sg13_lv_pmos ad=0.252p pd=1.57u as=0.3808p ps=2.92u w=1.12u l=0.13u
X415 a_13470_1044# a_3171_1047.t6 a_14888_1044# VSS.t158 sg13_lv_nmos ad=0.2516p pd=2.16u as=0.1406p ps=1.12u w=0.74u l=0.13u
X416 a_4633_1842# a_4437_1842# VSS.t346 VSS.t345 sg13_lv_nmos ad=0.2516p pd=2.16u as=0.1406p ps=1.12u w=0.74u l=0.13u
X417 a_1256_289# MUX_SEL2 VSS.t307 VSS.t306 sg13_lv_nmos ad=0.2516p pd=2.16u as=0.2516p ps=2.16u w=0.74u l=0.13u
X418 VSS.t202 a_2019_1047.t2 a_25604_1008# VSS.t201 sg13_lv_nmos ad=0.2516p pd=2.16u as=0.2516p ps=2.16u w=0.74u l=0.13u
X419 a_16108_289# MUX_SEL4 a_15964_289# VSS.t182 sg13_lv_nmos ad=0.2516p pd=2.16u as=0.2183p ps=1.33u w=0.74u l=0.13u
X420 a_22873_1842# a_22677_1842# VDD VDD sg13_lv_pmos ad=0.3808p pd=2.92u as=0.2128p ps=1.5u w=1.12u l=0.13u
X421 a_21835_1044# a_21625_1044# VSS.t100 VSS.t99 sg13_lv_nmos ad=0.1406p pd=1.12u as=0.1665p ps=1.19u w=0.74u l=0.13u
X422 VSS.t62 a_2595_1047.t4 a_20391_1008# VSS.t61 sg13_lv_nmos ad=0.2516p pd=2.16u as=0.2516p ps=2.16u w=0.74u l=0.13u
X423 a_9675_1044# a_9465_1044# VDD VDD sg13_lv_pmos ad=0.2128p pd=1.5u as=0.252p ps=1.57u w=1.12u l=0.13u
X424 VSS.t68 a_10517_1842# a_10985_1044# VSS.t140 sg13_lv_nmos ad=0.1665p pd=1.19u as=0.2516p ps=2.16u w=0.74u l=0.13u
X425 VDD a_2595_1047.t8 a_8231_1008# VDD sg13_lv_pmos ad=0.3808p pd=2.92u as=0.3808p ps=2.92u w=1.12u l=0.13u
X426 a_18551_1842# a_18313_1842# a_18443_1842# VSS.t185 sg13_lv_nmos ad=0.1406p pd=1.12u as=0.2516p ps=2.16u w=0.74u l=0.2u
X427 a_22351_1842# a_22113_1842# a_22243_1842# VSS.t34 sg13_lv_nmos ad=0.1406p pd=1.12u as=0.2516p ps=2.16u w=0.74u l=0.2u
X428 VSS.t205 a_3747_1047.t5 a_18871_1008# VSS.t204 sg13_lv_nmos ad=0.2516p pd=2.16u as=0.2516p ps=2.16u w=0.74u l=0.13u
X429 VSS.t32 a_16923_1842# a_17357_1842# VSS.t31 sg13_lv_nmos ad=0.1406p pd=1.12u as=0.2516p ps=2.16u w=0.74u l=0.13u
X430 VDD a_3171_311.t2 a_23945_519# VDD sg13_lv_pmos ad=0.3808p pd=2.92u as=0.3808p ps=2.92u w=1.12u l=0.13u
X431 a_2019_311# a_1721_331# VSS.t26 VSS.t52 sg13_lv_nmos ad=0.1406p pd=1.12u as=0.1331p ps=1.12u w=0.74u l=0.13u
X432 a_25153_1842# a_24957_1842# VDD VDD sg13_lv_pmos ad=0.3808p pd=2.92u as=0.2128p ps=1.5u w=1.12u l=0.13u
X433 a_17928_1044# a_17357_1842# VSS.t375 VSS.t374 sg13_lv_nmos ad=0.1406p pd=1.12u as=0.2516p ps=2.16u w=0.74u l=0.13u
X434 a_12715_1044# a_12505_1044# VSS.t46 VSS.t125 sg13_lv_nmos ad=0.1406p pd=1.12u as=0.1665p ps=1.19u w=0.74u l=0.13u
X435 VDD MUX_SEL4 a_15765_463# VDD sg13_lv_pmos ad=0.3808p pd=2.92u as=0.3808p ps=2.92u w=1.12u l=0.13u
X436 a_19550_1044# a_3171_1047.t4 a_20968_1044# VSS.t322 sg13_lv_nmos ad=0.2516p pd=2.16u as=0.1406p ps=1.12u w=0.74u l=0.13u
X437 VSS.t450 DELAY_VBIASN.t22 a_10951_1842# VSS.t449 sg13_lv_nmos ad=0.2516p pd=2.16u as=0.1406p ps=1.12u w=0.74u l=0.6u
X438 a_19550_1044# a_19524_1008# a_19448_1044# VDD sg13_lv_pmos ad=0.3808p pd=2.92u as=0.2128p ps=1.5u w=1.12u l=0.13u
X439 a_7288_1044# a_6717_1842# VSS.t545 VSS.t544 sg13_lv_nmos ad=0.1406p pd=1.12u as=0.2516p ps=2.16u w=0.74u l=0.13u
X440 VSS.t94 a_20723_1842# a_21157_1842# VSS.t93 sg13_lv_nmos ad=0.1406p pd=1.12u as=0.2516p ps=2.16u w=0.74u l=0.13u
X441 a_1544_289# MUX_SEL3 VSS.t553 VSS.t552 sg13_lv_nmos ad=0.2516p pd=2.16u as=0.2516p ps=2.16u w=0.74u l=0.13u
X442 a_13470_1044# a_14311_1008# a_14235_1044# VDD sg13_lv_pmos ad=0.3808p pd=2.92u as=0.2128p ps=1.5u w=1.12u l=0.13u
X443 a_22590_1044# a_3747_1047.t3 a_24875_1044# VSS.t20 sg13_lv_nmos ad=0.2516p pd=2.16u as=0.1406p ps=1.12u w=0.74u l=0.13u
X444 VSS.t446 DELAY_VBIASN.t5 a_23871_1842# VSS.t445 sg13_lv_nmos ad=0.2516p pd=2.16u as=0.1406p ps=1.12u w=0.74u l=0.6u
X445 VDD a_2019_1047.t3 a_22564_1008# VDD sg13_lv_pmos ad=0.3808p pd=2.92u as=0.3808p ps=2.92u w=1.12u l=0.13u
X446 VSS.t127 a_25717_1842# a_26185_1044# VSS.t179 sg13_lv_nmos ad=0.1665p pd=1.19u as=0.2516p ps=2.16u w=0.74u l=0.13u
X447 a_13231_1842# a_12993_1842# a_13123_1842# VSS.t409 sg13_lv_nmos ad=0.1406p pd=1.12u as=0.2516p ps=2.16u w=0.74u l=0.2u
X448 VSS.t230 VDD VSS.t228 VSS.t229 sg13_lv_nmos ad=79.8f pd=0.8u as=0 ps=0 w=0.42u l=1u
X449 a_17791_2470# a_17553_1842# a_17683_1842# VDD sg13_lv_pmos ad=0.2128p pd=1.5u as=0.3808p ps=2.92u w=1.12u l=0.2u
X450 VSS.t124 a_4437_1842# a_4905_1044# VSS.t344 sg13_lv_nmos ad=0.1665p pd=1.19u as=0.2516p ps=2.16u w=0.74u l=0.13u
X451 VDD VSS.t570 VDD VDD sg13_lv_pmos ad=0.34p pd=2.68u as=0 ps=0 w=1u l=1u
X452 a_12233_1842# a_12037_1842# VSS.t6 VSS.t47 sg13_lv_nmos ad=0.2516p pd=2.16u as=0.1406p ps=1.12u w=0.74u l=0.13u
X453 VSS.t167 a_3449_1395# a_3747_1047.t1 VSS.t166 sg13_lv_nmos ad=0.2812p pd=2.24u as=0.1406p ps=1.12u w=0.74u l=0.13u
X454 VDD VSS.t584 VDD VDD sg13_lv_pmos ad=0.34p pd=2.68u as=0 ps=0 w=1u l=1u
X455 VDD VSS.t579 VDD VDD sg13_lv_pmos ad=0.19p pd=1.38u as=0 ps=0 w=1u l=1u
X456 VSS.t295 VDD VSS.t293 VSS.t294 sg13_lv_nmos ad=79.8f pd=0.8u as=0 ps=0 w=0.42u l=1u
X457 VSS.t109 a_3171_1047.t8 a_8884_1008# VSS.t108 sg13_lv_nmos ad=0.2516p pd=2.16u as=0.2516p ps=2.16u w=0.74u l=0.13u
X458 a_21591_2470# a_21353_1842# a_21483_1842# VDD sg13_lv_pmos ad=0.2128p pd=1.5u as=0.3808p ps=2.92u w=1.12u l=0.2u
X459 VDD a_2873_1395# a_3171_1047.t0 VDD sg13_lv_pmos ad=0.4256p pd=3u as=0.2128p ps=1.5u w=1.12u l=0.13u
X460 a_6153_1842# a_5957_1842# VDD VDD sg13_lv_pmos ad=0.3808p pd=2.92u as=0.2128p ps=1.5u w=1.12u l=0.13u
X461 VDD a_16163_1842# a_16597_1842# VDD sg13_lv_pmos ad=0.2128p pd=1.5u as=0.3808p ps=2.92u w=1.12u l=0.13u
X462 a_3543_1395# MUX_SEL0 a_3449_1395# VSS.t497 sg13_lv_nmos ad=0.1216p pd=1.02u as=0.2176p ps=1.96u w=0.64u l=0.13u
X463 VDD a_1544_1044# a_2297_1395# VDD sg13_lv_pmos ad=0.1918p pd=1.5u as=0.1596p ps=1.22u w=0.84u l=0.13u
X464 VDD DELAY_VBIASP.t23 a_10191_2470# VDD sg13_lv_pmos ad=0.3808p pd=2.92u as=0.2128p ps=1.5u w=1.12u l=0.6u
X465 a_17275_1044# a_17065_1044# VDD VDD sg13_lv_pmos ad=0.2128p pd=1.5u as=0.252p ps=1.57u w=1.12u l=0.13u
X466 a_2019_1047.t0 a_1721_1395# VDD VDD sg13_lv_pmos ad=0.2128p pd=1.5u as=0.1918p ps=1.5u w=1.12u l=0.13u
X467 a_27915_1044# a_27705_1044# VSS.t210 VSS.t209 sg13_lv_nmos ad=0.1406p pd=1.12u as=0.1665p ps=1.19u w=0.74u l=0.13u
X468 VSS.t444 DELAY_VBIASN.t2 a_26151_1842# VSS.t443 sg13_lv_nmos ad=0.2516p pd=2.16u as=0.1406p ps=1.12u w=0.74u l=0.6u
X469 VDD a_3747_1047.t6 a_15831_1008# VDD sg13_lv_pmos ad=0.3808p pd=2.92u as=0.3808p ps=2.92u w=1.12u l=0.13u
X470 VDD a_19963_1842# a_20397_1842# VDD sg13_lv_pmos ad=0.2128p pd=1.5u as=0.3808p ps=2.92u w=1.12u l=0.13u
X471 VSS.t298 VDD VSS.t297 VSS.t296 sg13_lv_nmos ad=0.1428p pd=1.52u as=0 ps=0 w=0.42u l=1u
X472 VSS.t454 DELAY_VBIASN.t30 a_4871_1842# VSS.t453 sg13_lv_nmos ad=0.2516p pd=2.16u as=0.1406p ps=1.12u w=0.74u l=0.6u
X473 a_14888_1044# a_14317_1842# VDD VDD sg13_lv_pmos ad=0.2128p pd=1.5u as=0.3808p ps=2.92u w=1.12u l=0.13u
X474 a_4350_1044# a_4324_1008# a_4248_1044# VDD sg13_lv_pmos ad=0.3808p pd=2.92u as=0.2128p ps=1.5u w=1.12u l=0.13u
X475 a_1256_289# MUX_SEL2 VDD VDD sg13_lv_pmos ad=0.3808p pd=2.92u as=0.3808p ps=2.92u w=1.12u l=0.13u
X476 VSS.t362 VSS.t359 VSS.t361 VSS.t360 sg13_lv_nmos ad=0.2516p pd=2.16u as=0 ps=0 w=0.74u l=0.6u
X477 a_16108_289# a_15765_463# a_15964_289# VDD sg13_lv_pmos ad=0.3808p pd=2.92u as=0.3304p ps=1.71u w=1.12u l=0.13u
X478 a_11473_1842# a_11277_1842# VDD VDD sg13_lv_pmos ad=0.3808p pd=2.92u as=0.2128p ps=1.5u w=1.12u l=0.13u
X479 VDD a_8997_1842# a_9465_1044# VDD sg13_lv_pmos ad=0.252p pd=1.57u as=0.3808p ps=2.92u w=1.12u l=0.13u
X480 a_27433_1842# a_27237_1842# VSS.t336 VSS.t335 sg13_lv_nmos ad=0.2516p pd=2.16u as=0.1406p ps=1.12u w=0.74u l=0.13u
X481 a_2391_331# MUX_SEL2 a_2297_331# VSS.t308 sg13_lv_nmos ad=0.1216p pd=1.02u as=0.2176p ps=1.96u w=0.64u l=0.13u
X482 a_2967_331# MUX_SEL3 a_2873_331# VSS.t554 sg13_lv_nmos ad=0.1216p pd=1.02u as=0.2176p ps=1.96u w=0.64u l=0.13u
X483 VDD a_2019_1047.t5 a_16484_1008# VDD sg13_lv_pmos ad=0.3808p pd=2.92u as=0.3808p ps=2.92u w=1.12u l=0.13u
X484 a_7390_1044# a_2595_1047.t8 a_8155_1044# VSS.t116 sg13_lv_nmos ad=0.2516p pd=2.16u as=0.1406p ps=1.12u w=0.74u l=0.13u
X485 VSS.t458 DELAY_VBIASN.t27 a_7151_1842# VSS.t457 sg13_lv_nmos ad=0.2516p pd=2.16u as=0.1406p ps=1.12u w=0.74u l=0.6u
X486 VDD a_3171_1047.t9 a_5844_1008# VDD sg13_lv_pmos ad=0.3808p pd=2.92u as=0.3808p ps=2.92u w=1.12u l=0.13u
X487 VDD DELAY_VBIASP.t3 a_25391_2470# VDD sg13_lv_pmos ad=0.3808p pd=2.92u as=0.2128p ps=1.5u w=1.12u l=0.6u
X488 VDD a_2595_1047.t7 a_11271_1008# VDD sg13_lv_pmos ad=0.3808p pd=2.92u as=0.3808p ps=2.92u w=1.12u l=0.13u
X489 VDD VSS.t587 VDD VDD sg13_lv_pmos ad=0.19p pd=1.38u as=0 ps=0 w=1u l=1u
X490 VSS.t46 a_12037_1842# a_12505_1044# VSS.t45 sg13_lv_nmos ad=0.1665p pd=1.19u as=0.2516p ps=2.16u w=0.74u l=0.13u
X491 VDD a_3747_1047.t8 a_9751_1008# VDD sg13_lv_pmos ad=0.3808p pd=2.92u as=0.3808p ps=2.92u w=1.12u l=0.13u
X492 a_9431_1842# a_9193_1842# a_9323_1842# VSS.t419 sg13_lv_nmos ad=0.1406p pd=1.12u as=0.2516p ps=2.16u w=0.74u l=0.2u
X493 a_18313_1842# a_18117_1842# VSS.t41 VSS.t40 sg13_lv_nmos ad=0.2516p pd=2.16u as=0.1406p ps=1.12u w=0.74u l=0.13u
X494 MUX_OUT a_16851_309# VSS.t518 VSS.t517 sg13_lv_nmos ad=0.1406p pd=1.12u as=0.1371p ps=1.12u w=0.74u l=0.13u
X495 VSS.t290 VDD VSS.t288 VSS.t289 sg13_lv_nmos ad=79.8f pd=0.8u as=0 ps=0 w=0.42u l=1u
X496 a_23871_1842# a_23633_1842# a_23763_1842# VSS.t523 sg13_lv_nmos ad=0.1406p pd=1.12u as=0.2516p ps=2.16u w=0.74u l=0.2u
X497 a_8433_1842# a_8237_1842# VSS.t4 VSS.t385 sg13_lv_nmos ad=0.2516p pd=2.16u as=0.1406p ps=1.12u w=0.74u l=0.13u
X498 VSS.t342 a_18443_1842# a_18877_1842# VSS.t410 sg13_lv_nmos ad=0.1406p pd=1.12u as=0.2516p ps=2.16u w=0.74u l=0.13u
X499 VSS.t255 VDD VSS.t253 VSS.t254 sg13_lv_nmos ad=79.8f pd=0.8u as=0 ps=0 w=0.42u l=1u
X500 a_22113_1842# a_21917_1842# VSS.t49 VSS.t48 sg13_lv_nmos ad=0.2516p pd=2.16u as=0.1406p ps=1.12u w=0.74u l=0.13u
X501 a_1544_289# MUX_SEL3 VDD VDD sg13_lv_pmos ad=0.3808p pd=2.92u as=0.3808p ps=2.92u w=1.12u l=0.13u
X502 a_26673_1842# a_26477_1842# VDD VDD sg13_lv_pmos ad=0.3808p pd=2.92u as=0.2128p ps=1.5u w=1.12u l=0.13u
X503 a_10328_1044# a_9757_1842# VSS.t153 VSS.t152 sg13_lv_nmos ad=0.1406p pd=1.12u as=0.2516p ps=2.16u w=0.74u l=0.13u
X504 VSS.t258 VDD VSS.t257 VSS.t256 sg13_lv_nmos ad=0.1428p pd=1.52u as=0 ps=0 w=0.42u l=1u
X505 a_22590_1044# a_2019_1047.t3 a_22488_1044# VSS.t540 sg13_lv_nmos ad=0.2516p pd=2.16u as=0.1406p ps=1.12u w=0.74u l=0.13u
X506 VSS.t460 DELAY_VBIASN.t20 a_12471_1842# VSS.t459 sg13_lv_nmos ad=0.2516p pd=2.16u as=0.1406p ps=1.12u w=0.74u l=0.6u
X507 a_8808_1044# a_8237_1842# VSS.t387 VSS.t386 sg13_lv_nmos ad=0.1406p pd=1.12u as=0.2516p ps=2.16u w=0.74u l=0.13u
X508 VSS.t187 a_22243_1842# a_22677_1842# VSS.t186 sg13_lv_nmos ad=0.1406p pd=1.12u as=0.2516p ps=2.16u w=0.74u l=0.13u
X509 VDD DELAY_VBIASP.t28 a_6391_2470# VDD sg13_lv_pmos ad=0.3808p pd=2.92u as=0.2128p ps=1.5u w=1.12u l=0.6u
X510 a_13470_1044# a_15831_1008# a_15755_1044# VDD sg13_lv_pmos ad=0.3808p pd=2.92u as=0.2128p ps=1.5u w=1.12u l=0.13u
X511 a_1544_1044# MUX_SEL1 VDD VDD sg13_lv_pmos ad=0.3808p pd=2.92u as=0.3808p ps=2.92u w=1.12u l=0.13u
X512 VDD DELAY_VBIASP.t9 a_20831_2470# VDD sg13_lv_pmos ad=0.3808p pd=2.92u as=0.2128p ps=1.5u w=1.12u l=0.6u
X513 VDD a_2595_1047.t2 a_26471_1008# VDD sg13_lv_pmos ad=0.3808p pd=2.92u as=0.3808p ps=2.92u w=1.12u l=0.13u
X514 a_4350_1044# a_5191_1008# a_5115_1044# VDD sg13_lv_pmos ad=0.3808p pd=2.92u as=0.2128p ps=1.5u w=1.12u l=0.13u
X515 VDD a_16597_1842# a_17065_1044# VDD sg13_lv_pmos ad=0.252p pd=1.57u as=0.3808p ps=2.92u w=1.12u l=0.13u
X516 VSS.t210 a_27237_1842# a_27705_1044# VSS.t334 sg13_lv_nmos ad=0.1665p pd=1.19u as=0.2516p ps=2.16u w=0.74u l=0.13u
X517 a_10191_2470# a_9953_1842# a_10083_1842# VDD sg13_lv_pmos ad=0.2128p pd=1.5u as=0.3808p ps=2.92u w=1.12u l=0.2u
X518 a_2595_1047.t1 a_2297_1395# VSS.t120 VSS.t119 sg13_lv_nmos ad=0.1406p pd=1.12u as=0.1331p ps=1.12u w=0.74u l=0.13u
X519 a_26151_1842# a_25913_1842# a_26043_1842# VSS.t351 sg13_lv_nmos ad=0.1406p pd=1.12u as=0.2516p ps=2.16u w=0.74u l=0.2u
X520 VSS.t393 a_2019_311# a_17865_519# VSS.t392 sg13_lv_nmos ad=0.2516p pd=2.16u as=0.2516p ps=2.16u w=0.74u l=0.13u
X521 VSS.t28 a_1544_289# a_2391_331# VSS.t27 sg13_lv_nmos ad=0.1331p pd=1.12u as=0.1216p ps=1.02u w=0.64u l=0.13u
X522 a_4871_1842# a_4633_1842# a_4763_1842# VSS.t151 sg13_lv_nmos ad=0.1406p pd=1.12u as=0.2516p ps=2.16u w=0.74u l=0.2u
X523 a_13753_1842# a_13557_1842# VSS.t157 VSS.t417 sg13_lv_nmos ad=0.2516p pd=2.16u as=0.1406p ps=1.12u w=0.74u l=0.13u
X524 a_1815_1395# a_1256_1044# a_1721_1395# VSS.t188 sg13_lv_nmos ad=0.1216p pd=1.02u as=0.2176p ps=1.96u w=0.64u l=0.13u
X525 a_7673_1842# a_7477_1842# VDD VDD sg13_lv_pmos ad=0.3808p pd=2.92u as=0.2128p ps=1.5u w=1.12u l=0.13u
X526 VDD VSS.t580 VDD VDD sg13_lv_pmos ad=0.34p pd=2.68u as=0 ps=0 w=1u l=1u
X527 a_1721_331# a_1256_289# VDD VDD sg13_lv_pmos ad=0.1596p pd=1.22u as=0.2856p ps=2.36u w=0.84u l=0.13u
X528 VSS.t406 a_24523_1842# a_24957_1842# VSS.t405 sg13_lv_nmos ad=0.1406p pd=1.12u as=0.2516p ps=2.16u w=0.74u l=0.13u
X529 a_6635_1044# a_6425_1044# VSS.t192 VSS.t191 sg13_lv_nmos ad=0.1406p pd=1.12u as=0.1665p ps=1.19u w=0.74u l=0.13u
X530 VSS.t72 a_2595_1047.t9 a_5191_1008# VSS.t71 sg13_lv_nmos ad=0.2516p pd=2.16u as=0.2516p ps=2.16u w=0.74u l=0.13u
X531 a_20315_1044# a_20105_1044# VSS.t397 VSS.t516 sg13_lv_nmos ad=0.1406p pd=1.12u as=0.1665p ps=1.19u w=0.74u l=0.13u
X532 VDD DELAY_VBIASP.t21 a_11711_2470# VDD sg13_lv_pmos ad=0.3808p pd=2.92u as=0.2128p ps=1.5u w=1.12u l=0.6u
X533 a_18795_1044# a_18585_1044# VDD VDD sg13_lv_pmos ad=0.2128p pd=1.5u as=0.252p ps=1.57u w=1.12u l=0.13u
X534 a_25528_1044# a_24957_1842# VSS.t501 VSS.t500 sg13_lv_nmos ad=0.1406p pd=1.12u as=0.2516p ps=2.16u w=0.74u l=0.13u
X535 VSS.t492 DELAY_VBIASN.t0 a_27671_1842# VSS.t491 sg13_lv_nmos ad=0.2516p pd=2.16u as=0.1406p ps=1.12u w=0.74u l=0.6u
X536 a_5731_289# a_3747_311.t3 a_13470_1044# VSS.t509 sg13_lv_nmos ad=0.2516p pd=2.16u as=0.2516p ps=2.16u w=0.74u l=0.13u
X537 a_25630_1044# a_27124_1008# a_27048_1044# VDD sg13_lv_pmos ad=0.3808p pd=2.92u as=0.2128p ps=1.5u w=1.12u l=0.13u
X538 VDD a_2595_1047.t5 a_17351_1008# VDD sg13_lv_pmos ad=0.3808p pd=2.92u as=0.3808p ps=2.92u w=1.12u l=0.13u
X539 VDD a_21483_1842# a_21917_1842# VDD sg13_lv_pmos ad=0.2128p pd=1.5u as=0.3808p ps=2.92u w=1.12u l=0.13u
X540 a_4350_1044# a_5844_1008# a_5768_1044# VDD sg13_lv_pmos ad=0.3808p pd=2.92u as=0.2128p ps=1.5u w=1.12u l=0.13u
X541 VSS.t520 a_16851_309# MUX_OUT VSS.t519 sg13_lv_nmos ad=0.2516p pd=2.16u as=0.1406p ps=1.12u w=0.74u l=0.13u
X542 VSS.t390 a_2019_311# a_5705_519# VSS.t389 sg13_lv_nmos ad=0.2516p pd=2.16u as=0.2516p ps=2.16u w=0.74u l=0.13u
X543 VDD a_1544_289# a_1721_331# VDD sg13_lv_pmos ad=0.1918p pd=1.5u as=0.1596p ps=1.22u w=0.84u l=0.13u
X544 a_7151_1842# a_6913_1842# a_7043_1842# VSS.t522 sg13_lv_nmos ad=0.1406p pd=1.12u as=0.2516p ps=2.16u w=0.74u l=0.2u
X545 a_16033_1842# a_15837_1842# VSS.t370 VSS.t369 sg13_lv_nmos ad=0.2516p pd=2.16u as=0.1406p ps=1.12u w=0.74u l=0.13u
X546 MUX_OUT a_16851_309# VDD VDD sg13_lv_pmos ad=0.2128p pd=1.5u as=0.2086p ps=1.5u w=1.12u l=0.13u
X547 a_25391_2470# a_25153_1842# a_25283_1842# VDD sg13_lv_pmos ad=0.2128p pd=1.5u as=0.3808p ps=2.92u w=1.12u l=0.2u
X548 VDD VSS.t592 VDD VDD sg13_lv_pmos ad=0.34p pd=2.68u as=0 ps=0 w=1u l=1u
X549 a_12993_1842# a_12797_1842# VDD VDD sg13_lv_pmos ad=0.3808p pd=2.92u as=0.2128p ps=1.5u w=1.12u l=0.13u
X550 a_16408_1044# a_15837_1842# VSS.t372 VSS.t371 sg13_lv_nmos ad=0.1406p pd=1.12u as=0.2516p ps=2.16u w=0.74u l=0.13u
X551 VSS.t415 a_5523_1842# a_5957_1842# VSS.t508 sg13_lv_nmos ad=0.1406p pd=1.12u as=0.2516p ps=2.16u w=0.74u l=0.13u
X552 VDD DELAY_VBIASP.t18 a_13991_2470# VDD sg13_lv_pmos ad=0.3808p pd=2.92u as=0.2128p ps=1.5u w=1.12u l=0.6u
X553 a_5731_289# a_2019_311# a_4350_1044# VSS.t388 sg13_lv_nmos ad=0.2516p pd=2.16u as=0.2516p ps=2.16u w=0.74u l=0.13u
X554 a_7390_1044# a_3747_1047.t8 a_9675_1044# VSS.t328 sg13_lv_nmos ad=0.2516p pd=2.16u as=0.1406p ps=1.12u w=0.74u l=0.13u
X555 VDD a_23763_1842# a_24197_1842# VDD sg13_lv_pmos ad=0.2128p pd=1.5u as=0.3808p ps=2.92u w=1.12u l=0.13u
X556 VSS.t448 DELAY_VBIASN.t25 a_8671_1842# VSS.t447 sg13_lv_nmos ad=0.2516p pd=2.16u as=0.1406p ps=1.12u w=0.74u l=0.6u
X557 VDD a_2019_1047.t8 a_7364_1008# VDD sg13_lv_pmos ad=0.3808p pd=2.92u as=0.3808p ps=2.92u w=1.12u l=0.13u
X558 VDD DELAY_VBIASP.t1 a_26911_2470# VDD sg13_lv_pmos ad=0.3808p pd=2.92u as=0.2128p ps=1.5u w=1.12u l=0.6u
X559 VDD VSS.t563 VDD VDD sg13_lv_pmos ad=0.19p pd=1.38u as=0 ps=0 w=1u l=1u
X560 a_12471_1842# a_12233_1842# a_12363_1842# VSS.t137 sg13_lv_nmos ad=0.1406p pd=1.12u as=0.2516p ps=2.16u w=0.74u l=0.2u
X561 a_22488_1044# a_21917_1842# VDD VDD sg13_lv_pmos ad=0.2128p pd=1.5u as=0.3808p ps=2.92u w=1.12u l=0.13u
X562 VDD a_2595_311.t3 a_8745_519# VDD sg13_lv_pmos ad=0.3808p pd=2.92u as=0.3808p ps=2.92u w=1.12u l=0.13u
X563 VSS.t106 a_3171_1047.t5 a_18004_1008# VSS.t105 sg13_lv_nmos ad=0.2516p pd=2.16u as=0.2516p ps=2.16u w=0.74u l=0.13u
X564 a_6391_2470# a_6153_1842# a_6283_1842# VDD sg13_lv_pmos ad=0.2128p pd=1.5u as=0.3808p ps=2.92u w=1.12u l=0.2u
X565 a_15273_1842# a_15077_1842# VDD VDD sg13_lv_pmos ad=0.3808p pd=2.92u as=0.2128p ps=1.5u w=1.12u l=0.13u
X566 a_14235_1044# a_14025_1044# VSS.t24 VSS.t23 sg13_lv_nmos ad=0.1406p pd=1.12u as=0.1665p ps=1.19u w=0.74u l=0.13u
X567 VSS.t39 a_3747_1047.t7 a_12791_1008# VSS.t38 sg13_lv_nmos ad=0.2516p pd=2.16u as=0.2516p ps=2.16u w=0.74u l=0.13u
X568 a_9953_1842# a_9757_1842# VSS.t155 VSS.t154 sg13_lv_nmos ad=0.2516p pd=2.16u as=0.1406p ps=1.12u w=0.74u l=0.13u
X569 VSS.t136 a_10843_1842# a_11277_1842# VSS.t547 sg13_lv_nmos ad=0.1406p pd=1.12u as=0.2516p ps=2.16u w=0.74u l=0.13u
X570 VSS.t288 VDD VSS.t287 VSS.t286 sg13_lv_nmos ad=0.1428p pd=1.52u as=0 ps=0 w=0.42u l=1u
X571 VDD a_15403_1842# a_15837_1842# VDD sg13_lv_pmos ad=0.2128p pd=1.5u as=0.3808p ps=2.92u w=1.12u l=0.13u
X572 VSS.t253 VDD VSS.t252 VSS.t251 sg13_lv_nmos ad=0.1428p pd=1.52u as=0 ps=0 w=0.42u l=1u
X573 a_11848_1044# a_11277_1842# VSS.t134 VSS.t133 sg13_lv_nmos ad=0.1406p pd=1.12u as=0.2516p ps=2.16u w=0.74u l=0.13u
X574 VDD a_4763_1842# a_5197_1842# VDD sg13_lv_pmos ad=0.2128p pd=1.5u as=0.3808p ps=2.92u w=1.12u l=0.13u
X575 VSS.t265 VDD VSS.t263 VSS.t264 sg13_lv_nmos ad=79.8f pd=0.8u as=0 ps=0 w=0.42u l=1u
X576 a_13470_1044# a_13444_1008# a_13368_1044# VDD sg13_lv_pmos ad=0.3808p pd=2.92u as=0.2128p ps=1.5u w=1.12u l=0.13u
X577 VDD a_3449_1395# a_3747_1047.t0 VDD sg13_lv_pmos ad=0.4256p pd=3u as=0.2128p ps=1.5u w=1.12u l=0.13u
X578 VDD a_3171_1047.t3 a_24084_1008# VDD sg13_lv_pmos ad=0.3808p pd=2.92u as=0.3808p ps=2.92u w=1.12u l=0.13u
X579 a_3449_1395# MUX_SEL0 VDD VDD sg13_lv_pmos ad=0.1596p pd=1.22u as=0.2856p ps=2.36u w=0.84u l=0.13u
X580 VDD DELAY_VBIASP.t26 a_7911_2470# VDD sg13_lv_pmos ad=0.3808p pd=2.92u as=0.2128p ps=1.5u w=1.12u l=0.6u
X581 VDD VSS.t595 VDD VDD sg13_lv_pmos ad=0.19p pd=1.38u as=0 ps=0 w=1u l=1u
X582 VDD VSS.t594 VDD VDD sg13_lv_pmos ad=0.34p pd=2.68u as=0 ps=0 w=1u l=1u
X583 VDD a_16851_309# MUX_OUT VDD sg13_lv_pmos ad=0.7336p pd=3.55u as=0.2128p ps=1.5u w=1.12u l=0.13u
X584 VSS.t215 a_3171_311.t2 a_23945_519# VSS.t214 sg13_lv_nmos ad=0.2516p pd=2.16u as=0.2516p ps=2.16u w=0.74u l=0.13u
X585 VDD a_18117_1842# a_18585_1044# VDD sg13_lv_pmos ad=0.252p pd=1.57u as=0.3808p ps=2.92u w=1.12u l=0.13u
X586 VSS.t397 a_19637_1842# a_20105_1044# VSS.t396 sg13_lv_nmos ad=0.1665p pd=1.19u as=0.2516p ps=2.16u w=0.74u l=0.13u
X587 a_11711_2470# a_11473_1842# a_11603_1842# VDD sg13_lv_pmos ad=0.2128p pd=1.5u as=0.3808p ps=2.92u w=1.12u l=0.2u
X588 a_27671_1842# a_27433_1842# a_27563_1842# VSS.t428 sg13_lv_nmos ad=0.1406p pd=1.12u as=0.2516p ps=2.16u w=0.74u l=0.2u
X589 VSS.t184 MUX_SEL4 a_15765_463# VSS.t183 sg13_lv_nmos ad=0.2516p pd=2.16u as=0.2516p ps=2.16u w=0.74u l=0.13u
X590 a_5731_289# a_14825_519# a_13470_1044# VDD sg13_lv_pmos ad=0.3808p pd=2.92u as=0.3808p ps=2.92u w=1.12u l=0.13u
X591 a_16510_1044# a_2595_1047.t5 a_17275_1044# VSS.t113 sg13_lv_nmos ad=0.2516p pd=2.16u as=0.1406p ps=1.12u w=0.74u l=0.13u
X592 VSS.t476 DELAY_VBIASN.t15 a_16271_1842# VSS.t475 sg13_lv_nmos ad=0.2516p pd=2.16u as=0.1406p ps=1.12u w=0.74u l=0.6u
X593 VDD VSS.t568 VDD VDD sg13_lv_pmos ad=0.34p pd=2.68u as=0 ps=0 w=1u l=1u
X594 VDD a_3171_1047.t6 a_14964_1008# VDD sg13_lv_pmos ad=0.3808p pd=2.92u as=0.3808p ps=2.92u w=1.12u l=0.13u
X595 VDD a_10083_1842# a_10517_1842# VDD sg13_lv_pmos ad=0.2128p pd=1.5u as=0.3808p ps=2.92u w=1.12u l=0.13u
X596 VSS.t2 a_3747_1047.t2 a_27991_1008# VSS.t1 sg13_lv_nmos ad=0.2516p pd=2.16u as=0.2516p ps=2.16u w=0.74u l=0.13u
X597 VSS.t368 a_26043_1842# a_26477_1842# VSS.t367 sg13_lv_nmos ad=0.1406p pd=1.12u as=0.2516p ps=2.16u w=0.74u l=0.13u
X598 a_11195_1044# a_10985_1044# VDD VDD sg13_lv_pmos ad=0.2128p pd=1.5u as=0.252p ps=1.57u w=1.12u l=0.13u
X599 VSS.t321 a_3747_1047.t9 a_6711_1008# VSS.t320 sg13_lv_nmos ad=0.2516p pd=2.16u as=0.2516p ps=2.16u w=0.74u l=0.13u
X600 a_16108_289# a_2595_311.t2 a_19550_1044# VSS.t17 sg13_lv_nmos ad=0.2516p pd=2.16u as=0.2516p ps=2.16u w=0.74u l=0.13u
X601 VSS.t434 DELAY_VBIASN.t10 a_20071_1842# VSS.t433 sg13_lv_nmos ad=0.2516p pd=2.16u as=0.1406p ps=1.12u w=0.74u l=0.6u
X602 VDD DELAY_VBIASP.t4 a_24631_2470# VDD sg13_lv_pmos ad=0.3808p pd=2.92u as=0.2128p ps=1.5u w=1.12u l=0.6u
X603 a_22590_1044# a_23431_1008# a_23355_1044# VDD sg13_lv_pmos ad=0.3808p pd=2.92u as=0.2128p ps=1.5u w=1.12u l=0.13u
X604 VSS.t245 VDD VSS.t243 VSS.t244 sg13_lv_nmos ad=79.8f pd=0.8u as=0 ps=0 w=0.42u l=1u
X605 a_8671_1842# a_8433_1842# a_8563_1842# VSS.t502 sg13_lv_nmos ad=0.1406p pd=1.12u as=0.2516p ps=2.16u w=0.74u l=0.2u
X606 a_17553_1842# a_17357_1842# VSS.t32 VSS.t376 sg13_lv_nmos ad=0.2516p pd=2.16u as=0.1406p ps=1.12u w=0.74u l=0.13u
X607 a_5731_289# a_5705_519# a_4350_1044# VDD sg13_lv_pmos ad=0.3808p pd=2.92u as=0.3808p ps=2.92u w=1.12u l=0.13u
X608 VDD VDD VDD VDD sg13_lv_pmos ad=0.3808p pd=2.92u as=0 ps=0 w=1.12u l=0.13u
X609 a_26911_2470# a_26673_1842# a_26803_1842# VDD sg13_lv_pmos ad=0.2128p pd=1.5u as=0.3808p ps=2.92u w=1.12u l=0.2u
X610 a_7390_1044# a_2019_1047.t8 a_7288_1044# VSS.t197 sg13_lv_nmos ad=0.2516p pd=2.16u as=0.1406p ps=1.12u w=0.74u l=0.13u
X611 a_21353_1842# a_21157_1842# VSS.t94 VSS.t408 sg13_lv_nmos ad=0.2516p pd=2.16u as=0.1406p ps=1.12u w=0.74u l=0.13u
X612 VSS.t8 a_7043_1842# a_7477_1842# VSS.t507 sg13_lv_nmos ad=0.1406p pd=1.12u as=0.2516p ps=2.16u w=0.74u l=0.13u
X613 VDD DELAY_VBIASP.t16 a_15511_2470# VDD sg13_lv_pmos ad=0.3808p pd=2.92u as=0.2128p ps=1.5u w=1.12u l=0.6u
X614 VDD a_2019_1047.t7 a_10404_1008# VDD sg13_lv_pmos ad=0.3808p pd=2.92u as=0.3808p ps=2.92u w=1.12u l=0.13u
X615 VDD a_25283_1842# a_25717_1842# VDD sg13_lv_pmos ad=0.2128p pd=1.5u as=0.3808p ps=2.92u w=1.12u l=0.13u
X616 VDD DELAY_VBIASP.t29 a_5631_2470# VDD sg13_lv_pmos ad=0.3808p pd=2.92u as=0.2128p ps=1.5u w=1.12u l=0.6u
X617 a_26395_1044# a_26185_1044# VDD VDD sg13_lv_pmos ad=0.2128p pd=1.5u as=0.252p ps=1.57u w=1.12u l=0.13u
X618 VDD a_3747_1047.t3 a_24951_1008# VDD sg13_lv_pmos ad=0.3808p pd=2.92u as=0.3808p ps=2.92u w=1.12u l=0.13u
X619 VDD VSS.t571 VDD VDD sg13_lv_pmos ad=0.19p pd=1.38u as=0 ps=0 w=1u l=1u
X620 a_13991_1842# a_13753_1842# a_13883_1842# VSS.t498 sg13_lv_nmos ad=0.1406p pd=1.12u as=0.2516p ps=2.16u w=0.74u l=0.2u
X621 a_24008_1044# a_23437_1842# VDD VDD sg13_lv_pmos ad=0.2128p pd=1.5u as=0.3808p ps=2.92u w=1.12u l=0.13u
X622 VDD VSS.t585 VDD VDD sg13_lv_pmos ad=0.19p pd=1.38u as=0 ps=0 w=1u l=1u
X623 VSS.t315 a_2019_1047.t4 a_19524_1008# VSS.t314 sg13_lv_nmos ad=0.2516p pd=2.16u as=0.2516p ps=2.16u w=0.74u l=0.13u
X624 a_7911_2470# a_7673_1842# a_7803_1842# VDD sg13_lv_pmos ad=0.2128p pd=1.5u as=0.3808p ps=2.92u w=1.12u l=0.2u
X625 a_16793_1842# a_16597_1842# VDD VDD sg13_lv_pmos ad=0.3808p pd=2.92u as=0.2128p ps=1.5u w=1.12u l=0.13u
X626 VSS.t165 MUX_SEL1 a_3543_1395# VSS.t515 sg13_lv_nmos ad=0.1331p pd=1.12u as=0.1216p ps=1.02u w=0.64u l=0.13u
X627 a_15755_1044# a_15545_1044# VSS.t66 VSS.t65 sg13_lv_nmos ad=0.1406p pd=1.12u as=0.1665p ps=1.19u w=0.74u l=0.13u
X628 a_2595_1047.t0 a_2297_1395# VDD VDD sg13_lv_pmos ad=0.2128p pd=1.5u as=0.1918p ps=1.5u w=1.12u l=0.13u
X629 VSS.t533 a_2595_1047.t6 a_14311_1008# VSS.t532 sg13_lv_nmos ad=0.2516p pd=2.16u as=0.2516p ps=2.16u w=0.74u l=0.13u
X630 VSS.t169 a_12363_1842# a_12797_1842# VSS.t411 sg13_lv_nmos ad=0.1406p pd=1.12u as=0.2516p ps=2.16u w=0.74u l=0.13u
X631 a_5115_1044# a_4905_1044# VSS.t124 VSS.t123 sg13_lv_nmos ad=0.1406p pd=1.12u as=0.1665p ps=1.19u w=0.74u l=0.13u
X632 a_1256_1044# MUX_SEL0 VDD VDD sg13_lv_pmos ad=0.3808p pd=2.92u as=0.3808p ps=2.92u w=1.12u l=0.13u
X633 VDD a_27563_1842# a_27997_1842# VDD sg13_lv_pmos ad=0.2128p pd=1.5u as=0.3808p ps=2.92u w=1.12u l=0.13u
X634 a_20593_1842# a_20397_1842# VDD VDD sg13_lv_pmos ad=0.3808p pd=2.92u as=0.2128p ps=1.5u w=1.12u l=0.13u
X635 a_1721_1395# a_1256_1044# VDD VDD sg13_lv_pmos ad=0.1596p pd=1.22u as=0.2856p ps=2.36u w=0.84u l=0.13u
X636 VDD a_6283_1842# a_6717_1842# VDD sg13_lv_pmos ad=0.2128p pd=1.5u as=0.3808p ps=2.92u w=1.12u l=0.13u
X637 a_13470_1044# a_14964_1008# a_14888_1044# VDD sg13_lv_pmos ad=0.3808p pd=2.92u as=0.2128p ps=1.5u w=1.12u l=0.13u
X638 VSS.t263 VDD VSS.t262 VSS.t261 sg13_lv_nmos ad=0.1428p pd=1.52u as=0 ps=0 w=0.42u l=1u
X639 VDD a_2019_1047.t2 a_25604_1008# VDD sg13_lv_pmos ad=0.3808p pd=2.92u as=0.3808p ps=2.92u w=1.12u l=0.13u
X640 a_16271_1842# a_16033_1842# a_16163_1842# VSS.t44 sg13_lv_nmos ad=0.1406p pd=1.12u as=0.2516p ps=2.16u w=0.74u l=0.2u
X641 a_21835_1044# a_21625_1044# VDD VDD sg13_lv_pmos ad=0.2128p pd=1.5u as=0.252p ps=1.57u w=1.12u l=0.13u
X642 VDD VSS.t596 VDD VDD sg13_lv_pmos ad=0.34p pd=2.68u as=0 ps=0 w=1u l=1u
X643 VDD a_2595_1047.t4 a_20391_1008# VDD sg13_lv_pmos ad=0.3808p pd=2.92u as=0.3808p ps=2.92u w=1.12u l=0.13u
X644 a_19073_1842# a_18877_1842# VDD VDD sg13_lv_pmos ad=0.3808p pd=2.92u as=0.2128p ps=1.5u w=1.12u l=0.13u
X645 VDD a_10517_1842# a_10985_1044# VDD sg13_lv_pmos ad=0.252p pd=1.57u as=0.3808p ps=2.92u w=1.12u l=0.13u
X646 VSS.t100 a_21157_1842# a_21625_1044# VSS.t407 sg13_lv_nmos ad=0.1665p pd=1.19u as=0.2516p ps=2.16u w=0.74u l=0.13u
X647 a_20071_1842# a_19833_1842# a_19963_1842# VSS.t132 sg13_lv_nmos ad=0.1406p pd=1.12u as=0.2516p ps=2.16u w=0.74u l=0.2u
X648 VSS.t400 a_14643_1842# a_15077_1842# VSS.t399 sg13_lv_nmos ad=0.1406p pd=1.12u as=0.2516p ps=2.16u w=0.74u l=0.13u
X649 a_1815_331# a_1256_289# a_1721_331# VSS.t88 sg13_lv_nmos ad=0.1216p pd=1.02u as=0.2176p ps=1.96u w=0.64u l=0.13u
X650 VDD a_19203_1842# a_19637_1842# VDD sg13_lv_pmos ad=0.2128p pd=1.5u as=0.3808p ps=2.92u w=1.12u l=0.13u
X651 VSS.t318 a_2019_1047.t9 a_4324_1008# VSS.t317 sg13_lv_nmos ad=0.2516p pd=2.16u as=0.2516p ps=2.16u w=0.74u l=0.13u
X652 a_16108_289# a_20905_519# a_19550_1044# VDD sg13_lv_pmos ad=0.3808p pd=2.92u as=0.3808p ps=2.92u w=1.12u l=0.13u
X653 a_16510_1044# a_3747_1047.t5 a_18795_1044# VSS.t203 sg13_lv_nmos ad=0.2516p pd=2.16u as=0.1406p ps=1.12u w=0.74u l=0.13u
X654 VDD a_8563_1842# a_8997_1842# VDD sg13_lv_pmos ad=0.2128p pd=1.5u as=0.3808p ps=2.92u w=1.12u l=0.13u
X655 VDD DELAY_VBIASP.t19 a_13231_2470# VDD sg13_lv_pmos ad=0.3808p pd=2.92u as=0.2128p ps=1.5u w=1.12u l=0.6u
X656 VSS.t478 DELAY_VBIASN.t13 a_17791_1842# VSS.t477 sg13_lv_nmos ad=0.2516p pd=2.16u as=0.1406p ps=1.12u w=0.74u l=0.6u
X657 VSS.t233 VDD VSS.t232 VSS.t231 sg13_lv_nmos ad=0.1428p pd=1.52u as=0 ps=0 w=0.42u l=1u
X658 VDD a_3747_1047.t5 a_18871_1008# VDD sg13_lv_pmos ad=0.3808p pd=2.92u as=0.3808p ps=2.92u w=1.12u l=0.13u
X659 VDD a_23003_1842# a_23437_1842# VDD sg13_lv_pmos ad=0.2128p pd=1.5u as=0.3808p ps=2.92u w=1.12u l=0.13u
X660 a_12715_1044# a_12505_1044# VDD VDD sg13_lv_pmos ad=0.2128p pd=1.5u as=0.252p ps=1.57u w=1.12u l=0.13u
X661 a_19550_1044# a_21044_1008# a_20968_1044# VDD sg13_lv_pmos ad=0.3808p pd=2.92u as=0.2128p ps=1.5u w=1.12u l=0.13u
X662 a_17928_1044# a_17357_1842# VDD VDD sg13_lv_pmos ad=0.2128p pd=1.5u as=0.3808p ps=2.92u w=1.12u l=0.13u
X663 VSS.t452 DELAY_VBIASN.t8 a_21591_1842# VSS.t451 sg13_lv_nmos ad=0.2516p pd=2.16u as=0.1406p ps=1.12u w=0.74u l=0.6u
X664 VSS.t26 a_1544_289# a_1815_331# VSS.t25 sg13_lv_nmos ad=0.1331p pd=1.12u as=0.1216p ps=1.02u w=0.64u l=0.13u
X665 a_7288_1044# a_6717_1842# VDD VDD sg13_lv_pmos ad=0.2128p pd=1.5u as=0.3808p ps=2.92u w=1.12u l=0.13u
X666 a_15511_2470# a_15273_1842# a_15403_1842# VDD sg13_lv_pmos ad=0.2128p pd=1.5u as=0.3808p ps=2.92u w=1.12u l=0.2u
X667 VSS.t361 VSS.t363 VSS.t365 VSS.t364 sg13_lv_nmos ad=0.1406p pd=1.12u as=0 ps=0 w=0.74u l=0.2u
X668 a_22590_1044# a_24951_1008# a_24875_1044# VDD sg13_lv_pmos ad=0.3808p pd=2.92u as=0.2128p ps=1.5u w=1.12u l=0.13u
X669 VSS.t305 VDD VSS.t303 VSS.t304 sg13_lv_nmos ad=79.8f pd=0.8u as=0 ps=0 w=0.42u l=1u
X670 a_10430_1044# a_2019_1047.t7 a_10328_1044# VSS.t85 sg13_lv_nmos ad=0.2516p pd=2.16u as=0.1406p ps=1.12u w=0.74u l=0.13u
X671 VDD a_25717_1842# a_26185_1044# VDD sg13_lv_pmos ad=0.252p pd=1.57u as=0.3808p ps=2.92u w=1.12u l=0.13u
X672 VDD a_13883_1842# a_14317_1842# VDD sg13_lv_pmos ad=0.2128p pd=1.5u as=0.3808p ps=2.92u w=1.12u l=0.13u
X673 VDD a_4437_1842# a_4905_1044# VDD sg13_lv_pmos ad=0.252p pd=1.57u as=0.3808p ps=2.92u w=1.12u l=0.13u
X674 a_4157_1313# DELAY_IN VSS.t350 VSS.t349 sg13_lv_nmos ad=0.2516p pd=2.16u as=0.2553p ps=2.17u w=0.74u l=0.13u
X675 a_7390_1044# a_3171_1047.t8 a_8808_1044# VSS.t107 sg13_lv_nmos ad=0.2516p pd=2.16u as=0.1406p ps=1.12u w=0.74u l=0.13u
X676 a_22873_1842# a_22677_1842# VSS.t187 VSS.t550 sg13_lv_nmos ad=0.2516p pd=2.16u as=0.1406p ps=1.12u w=0.74u l=0.13u
X677 VDD a_3171_1047.t8 a_8884_1008# VDD sg13_lv_pmos ad=0.3808p pd=2.92u as=0.3808p ps=2.92u w=1.12u l=0.13u
C0 VDD a_5957_1842# 0.85848f
C1 a_6717_1842# a_7043_1842# 0.01427f
C2 VDD a_5115_1044# 0.15389f
C3 a_9757_1842# a_10404_1008# 0.02011f
C4 a_8563_1842# DELAY_VBIASN 0.07254f
C5 VDD a_25391_2470# 0.01806f
C6 a_9757_1842# DELAY_VBIASP 0.0414f
C7 a_26471_1008# a_25630_1044# 0.28268f
C8 a_18117_1842# a_18877_1842# 0.02912f
C9 a_16793_1842# DELAY_VBIASP 0.11222f
C10 a_1544_289# a_1721_331# 0.36963f
C11 a_20315_1044# VDD 0.15389f
C12 a_4248_1044# a_4157_1313# 0.11672f
C13 DELAY_VBIASN a_15403_1842# 0.07254f
C14 DELAY_VBIASP a_16597_1842# 0.0414f
C15 a_5731_289# a_5705_519# 0.28954f
C16 DELAY_VBIASN a_4003_1842# 0.06486f
C17 VDD a_19963_1842# 0.4973f
C18 a_13231_1842# a_13123_1842# 0.01163f
C19 a_21483_1842# a_19550_1044# 0.01012f
C20 a_15964_289# a_15837_1842# 0.02f
C21 a_26471_1008# a_26185_1044# 0.01885f
C22 a_18585_1044# VDD 0.29722f
C23 a_18117_1842# a_16510_1044# 0.05231f
C24 a_17357_1842# a_17351_1008# 0.02349f
C25 a_9751_1008# a_9465_1044# 0.01885f
C26 a_4248_1044# VDD 0.17587f
C27 a_4437_1842# a_4633_1842# 0.73897f
C28 a_16163_1842# a_16271_2470# 0.01697f
C29 VDD a_24008_1044# 0.17499f
C30 a_21157_1842# a_21625_1044# 0.2079f
C31 a_27997_1842# DELAY_VBIASN 0.04176f
C32 a_15964_289# a_16851_309# 0.16757f
C33 a_4111_1842# a_4003_1842# 0.01163f
C34 a_7477_1842# a_8237_1842# 0.01669f
C35 a_16108_289# a_18877_1842# 0.0157f
C36 a_16408_1044# a_15837_1842# 0.10864f
C37 a_22590_1044# a_24875_1044# 0.39036f
C38 a_9675_1044# a_9751_1008# 0.01194f
C39 a_10191_2470# VDD 0.01806f
C40 a_8237_1842# VDD 0.86909f
C41 a_19550_1044# a_21044_1008# 0.28279f
C42 a_12233_1842# a_12797_1842# 0.0114f
C43 MUX_SEL4 a_3449_331# 0.05166f
C44 a_26471_1008# VDD 0.28336f
C45 a_14751_1842# a_14643_1842# 0.01163f
C46 a_27237_1842# a_27433_1842# 0.77122f
C47 a_26803_1842# a_26477_1842# 0.01427f
C48 DELAY_VBIASP a_25153_1842# 0.11222f
C49 a_25913_1842# a_26043_1842# 0.70845f
C50 a_23111_2470# VDD 0.01806f
C51 a_13368_1044# a_13444_1008# 0.01176f
C52 DELAY_VBIASP a_6153_1842# 0.11222f
C53 a_8745_519# a_7390_1044# 0.01756f
C54 DELAY_VBIASN a_5957_1842# 0.09156f
C55 a_8808_1044# VDD 0.17499f
C56 a_22113_1842# VDD 0.49426f
C57 a_16510_1044# a_16108_289# 0.56108f
C58 a_15831_1008# a_15755_1044# 0.01194f
C59 a_21483_1842# a_21591_2470# 0.01697f
C60 a_27563_1842# a_27671_2470# 0.01697f
C61 a_24665_1044# a_24197_1842# 0.2079f
C62 a_8155_1044# a_8231_1008# 0.01194f
C63 a_21917_1842# a_21483_1842# 0.6972f
C64 a_16510_1044# a_18877_1842# 0.02479f
C65 MUX_OUT MUX_SEL1 0.09357f
C66 a_9757_1842# a_10083_1842# 0.01427f
C67 a_8671_1842# a_8563_1842# 0.01163f
C68 a_22677_1842# a_22564_1008# 0.05157f
C69 MUX_OUT a_16108_289# 0.24265f
C70 VDD a_13123_1842# 0.49727f
C71 DELAY_VBIASN a_19963_1842# 0.07254f
C72 a_25391_2470# a_25283_1842# 0.01697f
C73 a_16408_1044# a_16484_1008# 0.01176f
C74 a_19550_1044# a_16108_289# 0.58202f
C75 a_12505_1044# a_12791_1008# 0.01885f
C76 a_8433_1842# a_8563_1842# 0.70845f
C77 a_14317_1842# a_13883_1842# 0.6972f
C78 a_10843_1842# VDD 0.4973f
C79 VDD a_21835_1044# 0.15406f
C80 a_17683_1842# VDD 0.49671f
C81 a_6717_1842# a_6711_1008# 0.02354f
C82 VDD a_23633_1842# 0.49417f
C83 a_25630_1044# a_26043_1842# 0.01012f
C84 MUX_SEL4 a_7390_1044# 0.34655f
C85 a_3449_331# VDD 0.46596f
C86 DELAY_VBIASP a_18443_1842# 0.06627f
C87 a_10517_1842# a_10430_1044# 0.1088f
C88 a_5197_1842# a_5393_1842# 0.76914f
C89 a_12037_1842# a_11603_1842# 0.6972f
C90 a_8997_1842# VDD 0.85848f
C91 a_10083_1842# DELAY_VBIASP 0.06627f
C92 a_12993_1842# a_13557_1842# 0.0114f
C93 a_22488_1044# a_22590_1044# 0.37183f
C94 a_13444_1008# a_12797_1842# 0.02011f
C95 a_8237_1842# DELAY_VBIASN 0.09974f
C96 a_1544_1044# a_2297_1395# 0.28651f
C97 VDD a_15837_1842# 0.87963f
C98 VDD a_12715_1044# 0.15406f
C99 a_4350_1044# a_5844_1008# 0.28279f
C100 a_10517_1842# a_11277_1842# 0.01669f
C101 MUX_SEL4 a_6717_1842# 0.0195f
C102 a_10713_1842# a_11277_1842# 0.0114f
C103 a_22113_1842# DELAY_VBIASN 0.0961f
C104 a_6425_1044# a_6711_1008# 0.01885f
C105 VDD a_16851_309# 0.51536f
C106 VDD a_14964_1008# 0.28225f
C107 a_17553_1842# a_18117_1842# 0.0114f
C108 a_10430_1044# a_11848_1044# 0.38994f
C109 a_9193_1842# a_9757_1842# 0.0114f
C110 a_19448_1044# a_19524_1008# 0.01176f
C111 a_23437_1842# a_23003_1842# 0.6972f
C112 a_25630_1044# a_26395_1044# 0.39037f
C113 a_27433_1842# VDD 0.49285f
C114 VDD a_26043_1842# 0.4973f
C115 a_21917_1842# a_16108_289# 0.0157f
C116 a_7477_1842# a_7390_1044# 0.1088f
C117 DELAY_VBIASN a_13123_1842# 0.07254f
C118 DELAY_VBIASP a_14317_1842# 0.0414f
C119 VDD a_7390_1044# 0.8686f
C120 a_18585_1044# a_18871_1008# 0.01885f
C121 MUX_SEL4 a_1721_331# 0.05813f
C122 MUX_OUT a_1544_289# 0.69943f
C123 a_11277_1842# a_11848_1044# 0.10863f
C124 a_26185_1044# a_26395_1044# 0.09424f
C125 a_7364_1008# a_7390_1044# 0.277f
C126 a_12037_1842# DELAY_VBIASP 0.04141f
C127 a_10843_1842# DELAY_VBIASN 0.07254f
C128 a_16484_1008# VDD 0.28597f
C129 a_16033_1842# a_16597_1842# 0.0114f
C130 a_26673_1842# DELAY_VBIASP 0.11222f
C131 a_13470_1044# a_14317_1842# 0.08038f
C132 a_17683_1842# DELAY_VBIASN 0.07254f
C133 DELAY_VBIASN a_23633_1842# 0.0961f
C134 DELAY_VBIASP a_23763_1842# 0.06627f
C135 VDD a_5393_1842# 0.49417f
C136 a_6717_1842# a_7477_1842# 0.06198f
C137 a_16108_289# a_24957_1842# 0.0157f
C138 a_9193_1842# DELAY_VBIASP 0.11222f
C139 a_8997_1842# DELAY_VBIASN 0.09156f
C140 VDD a_24631_2470# 0.01806f
C141 a_5631_2470# VDD 0.01806f
C142 a_6717_1842# VDD 0.87726f
C143 a_15077_1842# a_15837_1842# 0.02912f
C144 a_22590_1044# a_24523_1842# 0.01012f
C145 a_1256_289# a_1721_331# 0.13421f
C146 a_7364_1008# a_6717_1842# 0.02011f
C147 DELAY_VBIASP a_16033_1842# 0.11222f
C148 VDD a_26395_1044# 0.15389f
C149 a_19524_1008# VDD 0.28633f
C150 a_24393_1842# a_24523_1842# 0.70845f
C151 a_21591_1842# a_21483_1842# 0.01163f
C152 DELAY_VBIASN a_15837_1842# 0.09992f
C153 a_11848_1044# a_11924_1008# 0.01176f
C154 a_20593_1842# VDD 0.49417f
C155 MUX_SEL0 MUX_SEL1 3.14917f
C156 VDD a_20397_1842# 0.86909f
C157 a_21917_1842# a_19550_1044# 0.02479f
C158 a_20071_2470# a_19963_1842# 0.01697f
C159 MUX_SEL4 a_10430_1044# 0.24983f
C160 a_4350_1044# a_6283_1842# 0.01012f
C161 a_7911_1842# a_7803_1842# 0.01163f
C162 a_14964_1008# a_15077_1842# 0.02055f
C163 a_17065_1044# VDD 0.30218f
C164 a_9675_1044# a_9465_1044# 0.09424f
C165 a_1721_331# VDD 0.45259f
C166 a_8433_1842# a_8237_1842# 0.76914f
C167 a_27563_1842# DELAY_VBIASP 0.06629f
C168 a_27433_1842# DELAY_VBIASN 0.0961f
C169 a_22677_1842# a_23145_1044# 0.19203f
C170 a_27997_1842# DELAY_OUT_LAST 0.70955f
C171 DELAY_IN DELAY_VBIASP 0.07719f
C172 DELAY_VBIASN a_26043_1842# 0.07254f
C173 VDD a_17031_2470# 0.01806f
C174 a_15964_289# a_16108_289# 0.42202f
C175 a_6425_1044# VDD 0.29722f
C176 a_18551_2470# a_18443_1842# 0.01697f
C177 a_6391_1842# a_6283_1842# 0.01163f
C178 DELAY_VBIASN a_7390_1044# 0.02115f
C179 a_7477_1842# a_7673_1842# 0.73897f
C180 a_16163_1842# VDD 0.4973f
C181 a_15831_1008# a_15837_1842# 0.02354f
C182 a_22590_1044# a_24084_1008# 0.28279f
C183 a_9431_2470# VDD 0.01806f
C184 a_25604_1008# a_24957_1842# 0.02011f
C185 a_7673_1842# VDD 0.49294f
C186 MUX_SEL3 a_3449_331# 0.28429f
C187 MUX_SEL4 a_2873_331# 0.04916f
C188 MUX_OUT a_2297_331# 0.01179f
C189 a_14025_1044# a_13557_1842# 0.19203f
C190 a_27237_1842# a_26803_1842# 0.6972f
C191 a_27237_1842# a_26477_1842# 0.03319f
C192 a_25913_1842# a_26477_1842# 0.0114f
C193 DELAY_VBIASP a_24523_1842# 0.06627f
C194 a_22351_2470# VDD 0.01806f
C195 DELAY_VBIASP a_5523_1842# 0.06627f
C196 DELAY_VBIASN a_5393_1842# 0.0961f
C197 a_5731_289# a_7390_1044# 0.41331f
C198 a_13368_1044# a_13470_1044# 0.37183f
C199 a_8231_1008# VDD 0.28336f
C200 a_21483_1842# VDD 0.4973f
C201 a_16510_1044# a_15964_289# 0.05416f
C202 a_21353_1842# a_21483_1842# 0.70845f
C203 a_6717_1842# DELAY_VBIASN 0.09992f
C204 MUX_SEL4 MUX_SEL1 0.03574f
C205 VDD a_10430_1044# 0.88416f
C206 a_16923_1842# a_17031_2470# 0.01697f
C207 a_1256_289# a_2873_331# 0.27926f
C208 a_1544_289# a_2297_331# 0.27303f
C209 a_20593_1842# DELAY_VBIASN 0.0961f
C210 a_22677_1842# a_22590_1044# 0.1088f
C211 MUX_OUT a_15964_289# 0.01307f
C212 MUX_SEL4 a_16108_289# 0.1283f
C213 VDD a_13557_1842# 0.86707f
C214 DELAY_VBIASN a_20397_1842# 0.09974f
C215 a_5844_1008# a_5957_1842# 0.02055f
C216 a_16408_1044# a_16510_1044# 0.37183f
C217 a_16108_289# a_25630_1044# 0.55833f
C218 a_12505_1044# a_12715_1044# 0.09424f
C219 a_13753_1842# a_13883_1842# 0.70845f
C220 a_8433_1842# a_8997_1842# 0.0114f
C221 a_11277_1842# VDD 0.86909f
C222 a_4871_1842# a_4763_1842# 0.01163f
C223 VDD a_21044_1008# 0.28225f
C224 a_18117_1842# VDD 0.85848f
C225 VDD a_23003_1842# 0.4973f
C226 a_19448_1044# a_18877_1842# 0.10864f
C227 a_25630_1044# a_26477_1842# 0.08038f
C228 a_10430_1044# a_12363_1842# 0.01012f
C229 a_2873_331# VDD 0.46491f
C230 DELAY_VBIASP a_12797_1842# 0.0414f
C231 a_18877_1842# a_19203_1842# 0.01427f
C232 a_5197_1842# a_4763_1842# 0.6972f
C233 a_11473_1842# a_11603_1842# 0.70845f
C234 a_27237_1842# a_27705_1044# 0.2079f
C235 a_16163_1842# DELAY_VBIASN 0.07254f
C236 a_23431_1008# a_23437_1842# 0.02349f
C237 VDD a_15273_1842# 0.49285f
C238 DELAY_VBIASP a_22243_1842# 0.06627f
C239 a_7803_1842# DELAY_VBIASP 0.06627f
C240 a_22590_1044# a_24197_1842# 0.05231f
C241 a_7673_1842# DELAY_VBIASN 0.0961f
C242 a_1256_1044# a_2297_1395# 0.04619f
C243 a_24197_1842# a_24393_1842# 0.77122f
C244 VDD a_11924_1008# 0.28225f
C245 VDD MUX_SEL1 0.50267f
C246 a_4350_1044# a_5768_1044# 0.38994f
C247 a_10517_1842# a_10713_1842# 0.73897f
C248 MUX_SEL4 MUX_OUT 0.91933f
C249 a_21483_1842# DELAY_VBIASN 0.07254f
C250 a_22677_1842# DELAY_VBIASP 0.0414f
C251 a_11711_1842# a_11603_1842# 0.01163f
C252 VDD a_16108_289# 1.25759f
C253 a_17357_1842# a_17683_1842# 0.01427f
C254 a_6425_1044# a_6635_1044# 0.09424f
C255 VDD a_14888_1044# 0.17499f
C256 a_20071_1842# a_19963_1842# 0.01163f
C257 DELAY_VBIASP a_14513_1842# 0.11222f
C258 a_10430_1044# a_11271_1008# 0.28268f
C259 DELAY_VBIASN a_10430_1044# 0.02115f
C260 a_22873_1842# a_23003_1842# 0.70845f
C261 a_19448_1044# a_19550_1044# 0.37183f
C262 a_25630_1044# a_25604_1008# 0.277f
C263 a_26803_1842# VDD 0.49671f
C264 VDD a_26477_1842# 0.86909f
C265 VDD a_18877_1842# 0.87825f
C266 a_19524_1008# a_19637_1842# 0.05157f
C267 DELAY_VBIASN a_13557_1842# 0.08375f
C268 a_19637_1842# a_20397_1842# 0.01669f
C269 DELAY_VBIASP a_13753_1842# 0.11222f
C270 VDD a_7288_1044# 0.17274f
C271 a_4350_1044# a_4324_1008# 0.277f
C272 a_18585_1044# a_18795_1044# 0.09424f
C273 MUX_SEL4 a_1544_289# 0.47529f
C274 MUX_OUT a_1256_289# 0.1134f
C275 a_27705_1044# a_25630_1044# 0.03208f
C276 DELAY_VBIASP a_4437_1842# 0.0414f
C277 a_11277_1842# a_11271_1008# 0.02349f
C278 a_18551_1842# a_18443_1842# 0.01163f
C279 a_5731_289# a_10430_1044# 0.41176f
C280 a_11277_1842# DELAY_VBIASN 0.09974f
C281 a_7364_1008# a_7288_1044# 0.01176f
C282 a_11473_1842# DELAY_VBIASP 0.11222f
C283 a_16510_1044# VDD 0.8795f
C284 a_18313_1842# DELAY_VBIASP 0.11222f
C285 a_18117_1842# DELAY_VBIASN 0.09156f
C286 DELAY_VBIASN a_23003_1842# 0.07254f
C287 DELAY_VBIASP a_24197_1842# 0.04141f
C288 VDD a_4763_1842# 0.4973f
C289 a_6717_1842# a_6913_1842# 0.76914f
C290 a_8563_1842# DELAY_VBIASP 0.06627f
C291 a_27563_1842# a_27671_1842# 0.01163f
C292 MUX_OUT VDD 0.35871f
C293 a_15077_1842# a_15273_1842# 0.77122f
C294 a_1256_289# a_1544_289# 1.25711f
C295 a_9323_1842# a_7390_1044# 0.01012f
C296 DELAY_VBIASP a_15403_1842# 0.06627f
C297 DELAY_VBIASN a_15273_1842# 0.0961f
C298 VDD a_25604_1008# 0.28633f
C299 a_19550_1044# VDD 0.89766f
C300 a_17791_2470# VDD 0.01806f
C301 a_4111_2470# a_4003_1842# 0.01697f
C302 DELAY_VBIASP a_4003_1842# 0.05992f
C303 VDD a_19833_1842# 0.49294f
C304 a_25391_1842# a_25283_1842# 0.01163f
C305 a_13470_1044# a_15403_1842# 0.01012f
C306 a_20723_1842# a_20397_1842# 0.01427f
C307 a_20593_1842# a_20723_1842# 0.70845f
C308 a_16923_1842# a_16510_1044# 0.01012f
C309 a_15545_1044# VDD 0.29918f
C310 a_27705_1044# VDD 0.29918f
C311 a_27048_1044# a_27124_1008# 0.01176f
C312 a_1544_289# VDD 0.39113f
C313 a_26803_1842# DELAY_VBIASN 0.07254f
C314 DELAY_VBIASN a_26477_1842# 0.10224f
C315 DELAY_VBIASN a_18877_1842# 0.09992f
C316 a_27997_1842# DELAY_VBIASP 0.04001f
C317 VDD a_16271_2470# 0.01806f
C318 a_4905_1044# VDD 0.30126f
C319 a_15765_463# a_16108_289# 0.42004f
C320 a_4324_1008# a_4437_1842# 0.05157f
C321 a_13470_1044# a_15755_1044# 0.39036f
C322 a_12505_1044# a_10430_1044# 0.03208f
C323 a_21625_1044# a_21911_1008# 0.01885f
C324 a_7477_1842# a_7043_1842# 0.69698f
C325 a_5731_289# a_16108_289# 0.01334f
C326 a_22590_1044# a_24008_1044# 0.38994f
C327 a_7043_1842# VDD 0.49723f
C328 a_8671_2470# VDD 0.01806f
C329 a_12037_1842# a_12797_1842# 0.02912f
C330 MUX_SEL4 a_2297_331# 0.04338f
C331 MUX_SEL3 a_2873_331# 0.12606f
C332 MUX_SEL2 a_3449_331# 0.10741f
C333 a_16510_1044# DELAY_VBIASN 0.02115f
C334 a_4350_1044# a_2019_311# 0.02042f
C335 a_18313_1842# a_18443_1842# 0.70845f
C336 a_10328_1044# a_10430_1044# 0.37183f
C337 a_21591_2470# VDD 0.01806f
C338 DELAY_VBIASP a_5957_1842# 0.04141f
C339 DELAY_VBIASN a_4763_1842# 0.07254f
C340 a_8155_1044# VDD 0.15389f
C341 a_21917_1842# VDD 0.87825f
C342 a_21353_1842# a_21917_1842# 0.0114f
C343 VDD a_23431_1008# 0.28336f
C344 a_14317_1842# a_14513_1842# 0.76914f
C345 a_19550_1044# DELAY_VBIASN 0.02115f
C346 a_1256_289# a_2297_331# 0.04261f
C347 a_9431_2470# a_9323_1842# 0.01697f
C348 DELAY_VBIASP a_19963_1842# 0.06627f
C349 VDD a_12993_1842# 0.49426f
C350 DELAY_VBIASN a_19833_1842# 0.0961f
C351 MUX_SEL4 a_15964_289# 0.5544f
C352 a_5957_1842# a_6153_1842# 0.77122f
C353 a_10517_1842# VDD 0.86707f
C354 a_15545_1044# a_15077_1842# 0.2079f
C355 MUX_SEL4 a_8745_519# 0.04472f
C356 MUX_OUT a_5731_289# 1.04829f
C357 a_13753_1842# a_14317_1842# 0.0114f
C358 a_23355_1044# a_23431_1008# 0.01194f
C359 a_10713_1842# VDD 0.49294f
C360 VDD a_24957_1842# 0.87825f
C361 a_17553_1842# VDD 0.49417f
C362 a_27237_1842# a_25630_1044# 0.05253f
C363 a_18871_1008# a_18877_1842# 0.02354f
C364 VDD a_23437_1842# 0.86909f
C365 a_18877_1842# a_19637_1842# 0.06198f
C366 a_2297_331# VDD 0.46496f
C367 a_14025_1044# a_14311_1008# 0.01885f
C368 a_4633_1842# a_4763_1842# 0.70845f
C369 a_3449_1395# MUX_SEL1 0.29404f
C370 a_11473_1842# a_12037_1842# 0.0114f
C371 a_16510_1044# a_18871_1008# 0.26208f
C372 a_13368_1044# a_12797_1842# 0.10864f
C373 VDD a_14643_1842# 0.49671f
C374 a_7043_1842# DELAY_VBIASN 0.07254f
C375 a_8237_1842# DELAY_VBIASP 0.0414f
C376 a_9953_1842# a_10517_1842# 0.0114f
C377 a_24197_1842# a_23763_1842# 0.6972f
C378 VDD a_11848_1044# 0.17499f
C379 VDD MUX_SEL0 0.56365f
C380 a_4350_1044# a_5191_1008# 0.28268f
C381 MUX_SEL3 MUX_OUT 0.79533f
C382 a_5705_519# a_2019_311# 0.13872f
C383 a_15831_1008# a_15545_1044# 0.01885f
C384 MUX_SEL1 a_2873_1395# 0.13092f
C385 a_21917_1842# DELAY_VBIASN 0.09992f
C386 a_22113_1842# DELAY_VBIASP 0.11222f
C387 a_17357_1842# a_18117_1842# 0.03319f
C388 VDD a_14311_1008# 0.28336f
C389 VDD a_15964_289# 0.31312f
C390 a_20105_1044# a_20391_1008# 0.01885f
C391 a_8997_1842# a_9757_1842# 0.02912f
C392 a_9751_1008# a_7390_1044# 0.26208f
C393 a_10430_1044# a_11195_1044# 0.39037f
C394 a_8745_519# VDD 0.29292f
C395 a_22873_1842# a_23437_1842# 0.0114f
C396 a_27237_1842# VDD 0.85969f
C397 a_25528_1044# a_25604_1008# 0.01176f
C398 VDD a_25913_1842# 0.49294f
C399 a_19550_1044# a_19637_1842# 0.1088f
C400 VDD a_6711_1008# 0.2822f
C401 a_19637_1842# a_19833_1842# 0.73897f
C402 DELAY_VBIASP a_13123_1842# 0.06627f
C403 DELAY_VBIASN a_12993_1842# 0.0961f
C404 a_4248_1044# a_4324_1008# 0.01176f
C405 a_10517_1842# DELAY_VBIASN 0.08375f
C406 MUX_SEL2 a_1721_331# 0.01315f
C407 MUX_SEL4 a_1256_289# 0.65005f
C408 MUX_SEL3 a_1544_289# 0.15976f
C409 DELAY_IN a_4437_1842# 0.05007f
C410 a_1544_1044# MUX_SEL1 0.1672f
C411 a_26185_1044# a_25630_1044# 0.03209f
C412 a_10713_1842# DELAY_VBIASN 0.0961f
C413 a_16408_1044# VDD 0.17274f
C414 a_10843_1842# DELAY_VBIASP 0.06627f
C415 a_15837_1842# a_16597_1842# 0.06198f
C416 a_2019_311# a_17865_519# 0.13959f
C417 a_17553_1842# DELAY_VBIASN 0.0961f
C418 MUX_SEL4 a_4157_1313# 0.08229f
C419 VDD a_11711_2470# 0.01806f
C420 DELAY_VBIASN a_24957_1842# 0.09992f
C421 a_17683_1842# DELAY_VBIASP 0.06627f
C422 a_13444_1008# a_13557_1842# 0.05157f
C423 DELAY_VBIASP a_23633_1842# 0.11222f
C424 DELAY_VBIASN a_23437_1842# 0.09974f
C425 VDD a_5197_1842# 0.86909f
C426 a_6717_1842# a_6283_1842# 0.6972f
C427 a_8997_1842# DELAY_VBIASP 0.04141f
C428 a_18117_1842# a_18004_1008# 0.02055f
C429 a_27991_1008# a_27705_1044# 0.01885f
C430 MUX_SEL4 VDD 2.63176f
C431 a_15077_1842# a_14643_1842# 0.6972f
C432 a_9757_1842# a_7390_1044# 0.02479f
C433 a_24957_1842# a_25283_1842# 0.01427f
C434 a_19448_1044# VDD 0.17274f
C435 DELAY_VBIASP a_15837_1842# 0.0414f
C436 VDD a_25630_1044# 0.89531f
C437 DELAY_VBIASN a_14643_1842# 0.07254f
C438 DELAY_IN a_4003_1842# 0.54998f
C439 VDD a_19203_1842# 0.49737f
C440 a_10191_2470# a_10083_1842# 0.01697f
C441 a_16108_289# a_26985_519# 0.2906f
C442 a_20593_1842# a_21157_1842# 0.0114f
C443 a_13470_1044# a_15837_1842# 0.02479f
C444 a_21157_1842# a_20397_1842# 0.03319f
C445 a_14025_1044# VDD 0.30409f
C446 a_17357_1842# a_16510_1044# 0.08038f
C447 a_26185_1044# VDD 0.30409f
C448 a_16484_1008# a_16597_1842# 0.05157f
C449 a_1256_289# VDD 0.40292f
C450 a_27997_1842# a_27563_1842# 0.69646f
C451 DELAY_VBIASN a_25913_1842# 0.0961f
C452 a_27433_1842# DELAY_VBIASP 0.11222f
C453 a_27237_1842# DELAY_VBIASN 0.09456f
C454 DELAY_VBIASP a_26043_1842# 0.06627f
C455 VDD a_15511_2470# 0.01806f
C456 a_22677_1842# a_22243_1842# 0.69698f
C457 a_4157_1313# VDD 0.48935f
C458 a_15765_463# a_15964_289# 0.061f
C459 a_13470_1044# a_14964_1008# 0.28279f
C460 MUX_OUT a_1544_1044# 0.04258f
C461 a_14235_1044# a_14311_1008# 0.01194f
C462 a_4350_1044# a_4437_1842# 0.1088f
C463 a_10985_1044# a_10430_1044# 0.03209f
C464 a_5731_289# a_15964_289# 0.2778f
C465 a_21625_1044# a_21835_1044# 0.09424f
C466 a_7151_2470# a_7043_1842# 0.01697f
C467 a_6913_1842# a_7043_1842# 0.70845f
C468 a_7911_2470# VDD 0.01806f
C469 a_5731_289# a_8745_519# 0.28635f
C470 a_7477_1842# VDD 0.86707f
C471 a_25528_1044# a_24957_1842# 0.10864f
C472 MUX_SEL3 a_2297_331# 0.01595f
C473 MUX_SEL2 a_2873_331# 0.01422f
C474 a_24084_1008# a_24197_1842# 0.02055f
C475 a_4350_1044# a_5705_519# 0.02005f
C476 a_25717_1842# a_26477_1842# 0.01669f
C477 a_7364_1008# a_7477_1842# 0.05157f
C478 a_4871_2470# a_4763_1842# 0.01697f
C479 a_20831_2470# VDD 0.01806f
C480 DELAY_VBIASP a_5393_1842# 0.11222f
C481 DELAY_VBIASN a_5197_1842# 0.09974f
C482 a_21353_1842# VDD 0.49285f
C483 a_7364_1008# VDD 0.28633f
C484 a_13123_1842# a_13231_2470# 0.01697f
C485 a_17065_1044# a_16597_1842# 0.19203f
C486 a_6717_1842# DELAY_VBIASP 0.0414f
C487 a_16510_1044# a_18004_1008# 0.28279f
C488 a_17275_1044# a_17351_1008# 0.01194f
C489 a_9465_1044# a_8997_1842# 0.2079f
C490 a_6635_1044# a_6711_1008# 0.01194f
C491 VDD a_23355_1044# 0.15389f
C492 DELAY_VBIASN a_25630_1044# 0.02756f
C493 a_21917_1842# a_22564_1008# 0.02011f
C494 a_12791_1008# a_12797_1842# 0.02354f
C495 a_20593_1842# DELAY_VBIASP 0.11222f
C496 VDD a_12363_1842# 0.4973f
C497 MUX_SEL4 a_15765_463# 0.65508f
C498 DELAY_VBIASP a_20397_1842# 0.0414f
C499 DELAY_VBIASN a_19203_1842# 0.07254f
C500 a_5957_1842# a_5523_1842# 0.6972f
C501 a_9953_1842# VDD 0.49426f
C502 MUX_SEL4 a_5731_289# 4.60702f
C503 a_16163_1842# a_16597_1842# 0.69698f
C504 a_5115_1044# a_5191_1008# 0.01194f
C505 a_6717_1842# a_6153_1842# 0.0114f
C506 a_16923_1842# VDD 0.4973f
C507 VDD a_22873_1842# 0.49294f
C508 a_25604_1008# a_25717_1842# 0.05157f
C509 a_14751_2470# a_14643_1842# 0.01697f
C510 a_21157_1842# a_21044_1008# 0.02055f
C511 a_18877_1842# a_19073_1842# 0.76914f
C512 a_14025_1044# a_14235_1044# 0.09424f
C513 a_4633_1842# a_5197_1842# 0.0114f
C514 a_3449_1395# MUX_SEL0 0.10753f
C515 a_4157_1313# DELAY_VBIASN 0.01202f
C516 a_11277_1842# a_11603_1842# 0.01427f
C517 a_16163_1842# DELAY_VBIASP 0.06627f
C518 a_9465_1044# a_7390_1044# 0.03208f
C519 a_16510_1044# a_18795_1044# 0.39036f
C520 a_22590_1044# a_23003_1842# 0.01012f
C521 a_7673_1842# DELAY_VBIASP 0.11222f
C522 a_7477_1842# DELAY_VBIASN 0.08375f
C523 VDD a_15077_1842# 0.85963f
C524 a_4350_1044# a_5957_1842# 0.05231f
C525 a_23633_1842# a_23763_1842# 0.70845f
C526 VDD a_11271_1008# 0.28336f
C527 a_20315_1044# a_20391_1008# 0.01194f
C528 a_4350_1044# a_5115_1044# 0.39037f
C529 VDD DELAY_VBIASN 0.9333f
C530 a_20968_1044# a_20397_1842# 0.10863f
C531 MUX_SEL3 MUX_SEL4 0.75489f
C532 MUX_SEL2 MUX_OUT 0.08497f
C533 a_3449_331# a_2019_311# 0.01176f
C534 a_21483_1842# DELAY_VBIASP 0.06627f
C535 a_21353_1842# DELAY_VBIASN 0.0961f
C536 MUX_SEL0 a_2873_1395# 0.01504f
C537 a_4437_1842# a_4003_1842# 0.69698f
C538 VDD a_15765_463# 0.35368f
C539 a_20105_1044# a_20315_1044# 0.09424f
C540 VDD a_14235_1044# 0.15389f
C541 a_17357_1842# a_17553_1842# 0.76914f
C542 a_11785_519# a_10430_1044# 0.02058f
C543 a_9675_1044# a_7390_1044# 0.39036f
C544 a_8997_1842# a_9193_1842# 0.77122f
C545 a_10430_1044# a_10404_1008# 0.277f
C546 a_5731_289# VDD 0.6143f
C547 a_25528_1044# a_25630_1044# 0.37183f
C548 a_14964_1008# a_14317_1842# 0.02312f
C549 VDD a_25283_1842# 0.49737f
C550 DELAY_VBIASN a_12363_1842# 0.07254f
C551 VDD a_6635_1044# 0.15406f
C552 DELAY_VBIASP a_13557_1842# 0.0414f
C553 a_19637_1842# a_19203_1842# 0.69698f
C554 a_22590_1044# a_16108_289# 0.58202f
C555 a_4248_1044# a_4350_1044# 0.37183f
C556 a_9953_1842# DELAY_VBIASN 0.0961f
C557 MUX_SEL3 a_1256_289# 1.41161f
C558 MUX_SEL2 a_1544_289# 0.07405f
C559 a_1544_1044# MUX_SEL0 0.07603f
C560 a_1256_1044# MUX_SEL1 1.44243f
C561 a_11277_1842# DELAY_VBIASP 0.0414f
C562 a_15831_1008# VDD 0.2816f
C563 a_24008_1044# a_24084_1008# 0.01176f
C564 a_15837_1842# a_16033_1842# 0.76914f
C565 a_2019_311# a_16851_309# 0.01299f
C566 a_27991_1008# a_25630_1044# 0.26208f
C567 a_13470_1044# a_13557_1842# 0.1088f
C568 a_18117_1842# DELAY_VBIASP 0.04141f
C569 a_16923_1842# DELAY_VBIASN 0.07254f
C570 DELAY_VBIASN a_22873_1842# 0.0961f
C571 DELAY_VBIASP a_23003_1842# 0.06627f
C572 VDD a_4633_1842# 0.49285f
C573 a_3449_331# DELAY_IN 0.01017f
C574 a_13991_1842# a_13883_1842# 0.01163f
C575 a_27915_1044# a_27705_1044# 0.09424f
C576 MUX_SEL3 VDD 0.4053f
C577 a_24957_1842# a_25717_1842# 0.06198f
C578 DELAY_VBIASN a_15077_1842# 0.09156f
C579 DELAY_VBIASP a_15273_1842# 0.11222f
C580 VDD a_25528_1044# 0.17274f
C581 a_18871_1008# VDD 0.2822f
C582 VDD a_19637_1842# 0.86707f
C583 a_16108_289# a_23945_519# 0.2906f
C584 a_12471_1842# a_12363_1842# 0.01163f
C585 a_21157_1842# a_19550_1044# 0.05231f
C586 a_8237_1842# a_7803_1842# 0.6972f
C587 a_12505_1044# VDD 0.29722f
C588 a_24665_1044# VDD 0.29722f
C589 a_16510_1044# a_16597_1842# 0.1088f
C590 a_20968_1044# a_21044_1008# 0.01176f
C591 a_15511_1842# a_15403_1842# 0.01163f
C592 a_27991_1008# VDD 0.28201f
C593 a_27433_1842# a_27563_1842# 0.70845f
C594 DELAY_VBIASP a_26477_1842# 0.04144f
C595 DELAY_VBIASP a_18877_1842# 0.0414f
C596 DELAY_VBIASN a_25283_1842# 0.07254f
C597 a_26803_1842# DELAY_VBIASP 0.06627f
C598 VDD a_14751_2470# 0.01806f
C599 a_8884_1008# a_8237_1842# 0.02312f
C600 a_22113_1842# a_22243_1842# 0.70845f
C601 a_3449_1395# VDD 0.46731f
C602 a_8433_1842# VDD 0.49417f
C603 MUX_SEL4 a_1544_1044# 0.03407f
C604 a_13470_1044# a_14888_1044# 0.38994f
C605 MUX_OUT a_1256_1044# 0.02466f
C606 a_10328_1044# VDD 0.17274f
C607 a_12797_1842# a_13123_1842# 0.01427f
C608 a_5731_289# a_15765_463# 0.23301f
C609 a_6913_1842# a_7477_1842# 0.0114f
C610 a_23145_1044# a_23431_1008# 0.01885f
C611 a_7151_2470# VDD 0.01806f
C612 a_8808_1044# a_8884_1008# 0.01176f
C613 a_22113_1842# a_22677_1842# 0.0114f
C614 a_6913_1842# VDD 0.49426f
C615 a_24951_1008# a_24957_1842# 0.02354f
C616 MUX_SEL2 a_2297_331# 0.10655f
C617 a_25717_1842# a_25913_1842# 0.73897f
C618 a_10985_1044# a_10517_1842# 0.19203f
C619 a_1721_331# a_2019_311# 0.18452f
C620 a_20071_2470# VDD 0.01806f
C621 DELAY_VBIASP a_4763_1842# 0.06627f
C622 a_9431_1842# a_9323_1842# 0.01163f
C623 DELAY_VBIASN a_4633_1842# 0.0961f
C624 VDD a_2873_1395# 0.46517f
C625 a_20723_1842# VDD 0.49671f
C626 a_26803_1842# a_26911_2470# 0.01697f
C627 a_10951_2470# a_10843_1842# 0.01697f
C628 a_26151_2470# a_26043_1842# 0.01697f
C629 a_20723_1842# a_20831_2470# 0.01697f
C630 a_26985_519# a_25630_1044# 0.02165f
C631 a_16510_1044# a_17928_1044# 0.38994f
C632 MUX_SEL4 a_14825_519# 0.03307f
C633 a_21157_1842# a_21917_1842# 0.02912f
C634 MUX_SEL2 MUX_SEL0 0.01204f
C635 a_12233_1842# VDD 0.49285f
C636 VDD a_22564_1008# 0.28633f
C637 a_8563_1842# a_8237_1842# 0.01427f
C638 MUX_SEL0 a_1721_1395# 0.01315f
C639 DELAY_VBIASP a_19833_1842# 0.11222f
C640 DELAY_VBIASN a_19637_1842# 0.08375f
C641 a_5393_1842# a_5523_1842# 0.70845f
C642 a_9323_1842# VDD 0.4973f
C643 a_24631_2470# a_24523_1842# 0.01697f
C644 a_5844_1008# a_5197_1842# 0.02312f
C645 a_16163_1842# a_16033_1842# 0.70845f
C646 a_1544_1044# VDD 0.45079f
C647 a_12037_1842# a_10430_1044# 0.05231f
C648 a_13557_1842# a_14317_1842# 0.01669f
C649 a_22590_1044# a_23431_1008# 0.28268f
C650 a_5631_2470# a_5523_1842# 0.01697f
C651 a_8884_1008# a_8997_1842# 0.02055f
C652 a_17357_1842# VDD 0.86909f
C653 a_25630_1044# a_25717_1842# 0.1088f
C654 a_12233_1842# a_12363_1842# 0.70845f
C655 a_18877_1842# a_18443_1842# 0.6972f
C656 a_15545_1044# a_13470_1044# 0.03208f
C657 VDD a_23871_2470# 0.01806f
C658 a_8433_1842# DELAY_VBIASN 0.0961f
C659 a_17351_1008# a_17065_1044# 0.01885f
C660 a_11277_1842# a_12037_1842# 0.03319f
C661 a_21835_1044# a_21911_1008# 0.01194f
C662 a_22590_1044# a_24957_1842# 0.02479f
C663 VDD a_26985_519# 0.29292f
C664 a_26185_1044# a_25717_1842# 0.19203f
C665 a_7945_1044# a_7390_1044# 0.03209f
C666 a_22590_1044# a_23437_1842# 0.08038f
C667 a_7043_1842# DELAY_VBIASP 0.06627f
C668 a_24393_1842# a_24957_1842# 0.0114f
C669 a_6913_1842# DELAY_VBIASN 0.0961f
C670 a_9757_1842# a_10517_1842# 0.06198f
C671 a_14825_519# VDD 0.29292f
C672 a_27124_1008# a_26477_1842# 0.02312f
C673 VDD a_11195_1044# 0.15389f
C674 a_16510_1044# a_18443_1842# 0.01012f
C675 a_23633_1842# a_24197_1842# 0.0114f
C676 a_19550_1044# a_20968_1044# 0.38994f
C677 a_4871_2470# VDD 0.01806f
C678 VDD DELAY_OUT_LAST 0.46312f
C679 a_7803_1842# a_7390_1044# 0.01012f
C680 a_20391_1008# a_20397_1842# 0.02349f
C681 MUX_SEL2 MUX_SEL4 0.01978f
C682 a_4350_1044# a_6717_1842# 0.02479f
C683 a_20723_1842# DELAY_VBIASN 0.07254f
C684 a_21917_1842# DELAY_VBIASP 0.0414f
C685 VDD a_13444_1008# 0.28633f
C686 a_21625_1044# a_19550_1044# 0.03208f
C687 a_17357_1842# a_16923_1842# 0.6972f
C688 a_16271_1842# a_16163_1842# 0.01163f
C689 a_8884_1008# a_7390_1044# 0.28279f
C690 a_12037_1842# a_11924_1008# 0.02055f
C691 a_12233_1842# DELAY_VBIASN 0.0961f
C692 a_18004_1008# VDD 0.28225f
C693 a_8997_1842# a_8563_1842# 0.6972f
C694 a_14888_1044# a_14317_1842# 0.10863f
C695 VDD a_25717_1842# 0.86707f
C696 DELAY_VBIASP a_12993_1842# 0.11222f
C697 a_19073_1842# a_19203_1842# 0.70845f
C698 VDD a_5844_1008# 0.28225f
C699 a_10517_1842# a_10404_1008# 0.05157f
C700 VDD a_27671_2470# 0.01806f
C701 a_10517_1842# DELAY_VBIASP 0.0414f
C702 a_9323_1842# DELAY_VBIASN 0.07254f
C703 MUX_SEL2 a_1256_289# 0.33134f
C704 a_1256_1044# MUX_SEL0 0.3314f
C705 a_10713_1842# DELAY_VBIASP 0.11222f
C706 a_26673_1842# a_26803_1842# 0.70845f
C707 a_2019_311# a_16108_289# 0.33889f
C708 a_15837_1842# a_15403_1842# 0.6972f
C709 a_26673_1842# a_26477_1842# 0.76914f
C710 DELAY_VBIASP a_24957_1842# 0.0414f
C711 a_17553_1842# DELAY_VBIASP 0.11222f
C712 a_27915_1044# a_25630_1044# 0.39036f
C713 a_17357_1842# DELAY_VBIASN 0.09974f
C714 a_4350_1044# a_6425_1044# 0.03208f
C715 DELAY_VBIASP a_23437_1842# 0.0414f
C716 a_12715_1044# a_12791_1008# 0.01194f
C717 a_10191_1842# a_10083_1842# 0.01163f
C718 a_11603_1842# a_11711_2470# 0.01697f
C719 MUX_SEL2 VDD 0.50938f
C720 a_24957_1842# a_25153_1842# 0.76914f
C721 DELAY_VBIASP a_14643_1842# 0.06627f
C722 VDD a_24951_1008# 0.2822f
C723 a_20831_1842# a_20723_1842# 0.01163f
C724 a_18795_1044# VDD 0.15406f
C725 a_16510_1044# a_2019_311# 0.03139f
C726 a_11195_1044# a_11271_1008# 0.01194f
C727 DELAY_OUT_LAST DELAY_VBIASN 0.04786f
C728 VDD a_19073_1842# 0.49426f
C729 VDD a_1721_1395# 0.4533f
C730 DELAY_IN MUX_SEL1 0.01858f
C731 a_16108_289# a_20905_519# 0.2906f
C732 a_19311_2470# a_19203_1842# 0.01697f
C733 a_7151_1842# a_7043_1842# 0.01163f
C734 a_7673_1842# a_7803_1842# 0.70845f
C735 a_10985_1044# VDD 0.30409f
C736 a_8231_1008# a_7945_1044# 0.01885f
C737 a_23145_1044# VDD 0.30409f
C738 a_5731_289# a_14825_519# 0.28056f
C739 a_27915_1044# VDD 0.15389f
C740 MUX_OUT a_2019_311# 8.45486f
C741 a_10430_1044# a_12797_1842# 0.02479f
C742 a_27433_1842# a_27997_1842# 0.0114f
C743 a_27237_1842# DELAY_VBIASP 0.06189f
C744 a_22351_2470# a_22243_1842# 0.01697f
C745 MUX_SEL4 a_9757_1842# 0.01829f
C746 DELAY_VBIASP a_25913_1842# 0.11222f
C747 DELAY_VBIASN a_25717_1842# 0.08411f
C748 VDD a_13991_2470# 0.01806f
C749 a_8808_1044# a_8237_1842# 0.10863f
C750 MUX_SEL4 a_1256_1044# 0.04908f
C751 a_13470_1044# a_14311_1008# 0.28268f
C752 a_9751_1008# VDD 0.2822f
C753 a_12797_1842# a_13557_1842# 0.06198f
C754 a_23145_1044# a_23355_1044# 0.09424f
C755 a_6391_2470# VDD 0.01806f
C756 a_6283_1842# VDD 0.4973f
C757 a_25717_1842# a_25283_1842# 0.69698f
C758 a_10517_1842# a_10083_1842# 0.69698f
C759 a_1544_289# a_2019_311# 0.01747f
C760 DELAY_VBIASP a_5197_1842# 0.0414f
C761 a_19311_2470# VDD 0.01806f
C762 VDD a_13883_1842# 0.4973f
C763 a_21157_1842# VDD 0.85848f
C764 MUX_SEL4 a_11785_519# 0.03255f
C765 a_16510_1044# a_17351_1008# 0.28268f
C766 a_19550_1044# a_20905_519# 0.02165f
C767 a_21157_1842# a_21353_1842# 0.77122f
C768 a_11603_1842# VDD 0.49671f
C769 VDD a_22590_1044# 0.89557f
C770 VDD a_24393_1842# 0.49285f
C771 DELAY_VBIASP a_25630_1044# 0.01522f
C772 a_8997_1842# a_8237_1842# 0.03319f
C773 a_21917_1842# a_22488_1044# 0.10864f
C774 DELAY_VBIASN a_19073_1842# 0.0961f
C775 DELAY_VBIASP a_19203_1842# 0.06627f
C776 MUX_SEL4 a_13470_1044# 0.256f
C777 a_5393_1842# a_5957_1842# 0.0114f
C778 a_9757_1842# VDD 0.87771f
C779 a_5768_1044# a_5197_1842# 0.10863f
C780 a_1256_1044# VDD 0.475f
C781 a_10985_1044# a_11271_1008# 0.01885f
C782 a_13557_1842# a_13753_1842# 0.73897f
C783 a_22590_1044# a_23355_1044# 0.39037f
C784 a_6717_1842# a_5957_1842# 0.02912f
C785 a_16793_1842# VDD 0.49277f
C786 VDD a_16597_1842# 0.86876f
C787 a_14025_1044# a_13470_1044# 0.03209f
C788 a_11277_1842# a_11473_1842# 0.76914f
C789 a_17275_1044# a_17065_1044# 0.09424f
C790 VDD a_23945_519# 0.29292f
C791 a_18117_1842# a_18313_1842# 0.77122f
C792 a_6283_1842# DELAY_VBIASN 0.07254f
C793 a_7477_1842# DELAY_VBIASP 0.0414f
C794 a_10430_1044# a_12791_1008# 0.26208f
C795 a_4350_1044# a_4763_1842# 0.01012f
C796 a_27237_1842# a_27124_1008# 0.02055f
C797 a_11785_519# VDD 0.29292f
C798 a_9757_1842# a_9953_1842# 0.76914f
C799 a_27048_1044# a_26477_1842# 0.10863f
C800 VDD a_10404_1008# 0.28633f
C801 a_23437_1842# a_23763_1842# 0.01427f
C802 a_19550_1044# a_20391_1008# 0.28268f
C803 a_4111_2470# VDD 0.01866f
C804 VDD DELAY_VBIASP 13.3418f
C805 a_8237_1842# a_7390_1044# 0.08038f
C806 a_14317_1842# a_14643_1842# 0.01427f
C807 MUX_SEL2 MUX_SEL3 3.21891f
C808 a_2297_331# a_2019_311# 0.04011f
C809 a_21353_1842# DELAY_VBIASP 0.11222f
C810 a_21157_1842# DELAY_VBIASN 0.09156f
C811 a_20397_1842# a_19963_1842# 0.6972f
C812 DELAY_VBIASN a_13883_1842# 0.07254f
C813 a_6425_1044# a_5957_1842# 0.2079f
C814 MUX_SEL1 a_2297_1395# 0.01995f
C815 VDD a_13470_1044# 0.87936f
C816 a_16793_1842# a_16923_1842# 0.70845f
C817 a_20105_1044# a_19550_1044# 0.03209f
C818 a_4905_1044# a_5191_1008# 0.01885f
C819 a_19311_1842# a_19203_1842# 0.01163f
C820 a_8808_1044# a_7390_1044# 0.38994f
C821 a_17928_1044# VDD 0.17499f
C822 a_11603_1842# DELAY_VBIASN 0.07254f
C823 DELAY_VBIASN a_22590_1044# 0.02115f
C824 a_18795_1044# a_18871_1008# 0.01194f
C825 a_14311_1008# a_14317_1842# 0.02349f
C826 VDD a_25153_1842# 0.49426f
C827 DELAY_VBIASN a_24393_1842# 0.0961f
C828 VDD a_6153_1842# 0.49285f
C829 a_19073_1842# a_19637_1842# 0.0114f
C830 VDD a_5768_1044# 0.17499f
C831 a_22351_1842# a_22243_1842# 0.01163f
C832 a_23871_1842# a_23763_1842# 0.01163f
C833 DELAY_VBIASP a_12363_1842# 0.06627f
C834 a_9953_1842# DELAY_VBIASP 0.11222f
C835 VDD a_26911_2470# 0.01806f
C836 a_9757_1842# DELAY_VBIASN 0.09992f
C837 a_24665_1044# a_24951_1008# 0.01885f
C838 a_15273_1842# a_15403_1842# 0.70845f
C839 a_2019_311# a_15964_289# 0.02413f
C840 a_26673_1842# a_27237_1842# 0.0114f
C841 a_27124_1008# a_25630_1044# 0.28279f
C842 a_18313_1842# a_18877_1842# 0.0114f
C843 a_16923_1842# DELAY_VBIASP 0.06627f
C844 a_26471_1008# a_26395_1044# 0.01194f
C845 a_16793_1842# DELAY_VBIASN 0.0961f
C846 a_20968_1044# VDD 0.17499f
C847 a_4324_1008# a_4157_1313# 0.02463f
C848 a_4350_1044# a_4905_1044# 0.03209f
C849 DELAY_VBIASP a_22873_1842# 0.11222f
C850 DELAY_VBIASN a_16597_1842# 0.08375f
C851 a_26151_1842# a_26043_1842# 0.01163f
C852 a_26803_1842# a_26911_1842# 0.01163f
C853 a_17357_1842# a_18004_1008# 0.02312f
C854 a_21625_1044# VDD 0.29722f
C855 a_4324_1008# VDD 0.28597f
C856 a_24957_1842# a_24523_1842# 0.6972f
C857 a_8997_1842# a_7390_1044# 0.05231f
C858 a_27915_1044# a_27991_1008# 0.01194f
C859 a_17031_1842# a_16923_1842# 0.01163f
C860 DELAY_VBIASP a_15077_1842# 0.04141f
C861 VDD a_24875_1044# 0.15406f
C862 DELAY_VBIASP DELAY_VBIASN 3.50557f
C863 VDD a_18443_1842# 0.4973f
C864 DELAY_IN MUX_SEL0 0.14089f
C865 a_16108_289# a_17865_519# 0.29564f
C866 a_9465_1044# VDD 0.29722f
C867 a_24631_1842# a_24523_1842# 0.01163f
C868 a_13470_1044# a_15077_1842# 0.05231f
C869 a_7673_1842# a_8237_1842# 0.0114f
C870 a_10083_1842# VDD 0.49727f
C871 a_8155_1044# a_7945_1044# 0.09424f
C872 a_16484_1008# a_15837_1842# 0.02011f
C873 DELAY_VBIASN a_13470_1044# 0.02115f
C874 a_19550_1044# a_21911_1008# 0.26208f
C875 a_5731_289# a_11785_519# 0.28056f
C876 a_27124_1008# VDD 0.28225f
C877 MUX_SEL4 a_2019_311# 0.90276f
C878 DELAY_VBIASP a_25283_1842# 0.06627f
C879 DELAY_VBIASN a_25153_1842# 0.0961f
C880 VDD a_13231_2470# 0.01806f
C881 a_8231_1008# a_8237_1842# 0.02349f
C882 a_21917_1842# a_22243_1842# 0.01427f
C883 DELAY_VBIASN a_6153_1842# 0.0961f
C884 a_13470_1044# a_14235_1044# 0.39037f
C885 a_9675_1044# VDD 0.15406f
C886 a_12797_1842# a_12993_1842# 0.76914f
C887 a_18117_1842# a_18585_1044# 0.2079f
C888 a_16510_1044# a_17865_519# 0.02165f
C889 a_24665_1044# a_22590_1044# 0.03208f
C890 a_5731_289# a_13470_1044# 0.41365f
C891 a_10951_1842# a_10843_1842# 0.01163f
C892 a_1544_1044# a_1721_1395# 0.38063f
C893 a_21917_1842# a_22677_1842# 0.06198f
C894 a_4905_1044# a_4437_1842# 0.19203f
C895 a_24084_1008# a_23437_1842# 0.02312f
C896 a_25153_1842# a_25283_1842# 0.70845f
C897 a_9953_1842# a_10083_1842# 0.70845f
C898 a_1256_289# a_2019_311# 0.02904f
C899 a_18551_2470# VDD 0.01806f
C900 DELAY_VBIASP a_4633_1842# 0.11222f
C901 VDD a_14317_1842# 0.86909f
C902 a_15831_1008# a_13470_1044# 0.26208f
C903 a_4157_1313# a_2019_311# 0.01018f
C904 a_16510_1044# a_17275_1044# 0.39037f
C905 a_21157_1842# a_20723_1842# 0.6972f
C906 a_12037_1842# VDD 0.85848f
C907 MUX_SEL4 DELAY_IN 0.0663f
C908 a_5631_1842# a_5523_1842# 0.01163f
C909 a_10328_1044# a_9757_1842# 0.10864f
C910 VDD a_22488_1044# 0.17274f
C911 a_26673_1842# VDD 0.49417f
C912 VDD a_23763_1842# 0.49671f
C913 a_27563_1842# a_25630_1044# 0.01024f
C914 a_2019_311# VDD 1.43004f
C915 a_21917_1842# a_21911_1008# 0.02354f
C916 a_8671_2470# a_8563_1842# 0.01697f
C917 DELAY_VBIASN a_18443_1842# 0.07254f
C918 DELAY_VBIASP a_19637_1842# 0.0414f
C919 a_23111_2470# a_23003_1842# 0.01697f
C920 a_15545_1044# a_15755_1044# 0.09424f
C921 a_22677_1842# a_23437_1842# 0.01669f
C922 a_5197_1842# a_5523_1842# 0.01427f
C923 a_9193_1842# VDD 0.49285f
C924 a_16163_1842# a_15837_1842# 0.01427f
C925 a_10843_1842# a_10430_1044# 0.01012f
C926 a_10985_1044# a_11195_1044# 0.09424f
C927 a_5191_1008# a_5197_1842# 0.02349f
C928 a_13557_1842# a_13123_1842# 0.69698f
C929 a_10083_1842# DELAY_VBIASN 0.07254f
C930 a_22590_1044# a_22564_1008# 0.277f
C931 a_1256_1044# a_2873_1395# 0.28892f
C932 VDD a_16033_1842# 0.49413f
C933 a_4350_1044# a_6711_1008# 0.26208f
C934 a_4157_1313# DELAY_IN 0.50642f
C935 a_8433_1842# DELAY_VBIASP 0.11222f
C936 a_10328_1044# a_10404_1008# 0.01176f
C937 a_11277_1842# a_10843_1842# 0.6972f
C938 a_16510_1044# a_18585_1044# 0.03208f
C939 a_14513_1842# a_14643_1842# 0.70845f
C940 VDD a_20905_519# 0.29292f
C941 a_18117_1842# a_17683_1842# 0.6972f
C942 a_24197_1842# a_24957_1842# 0.02912f
C943 a_6913_1842# DELAY_VBIASP 0.11222f
C944 a_10430_1044# a_12715_1044# 0.39036f
C945 a_4350_1044# a_5197_1842# 0.08038f
C946 a_26471_1008# a_26477_1842# 0.02349f
C947 a_9757_1842# a_9323_1842# 0.6972f
C948 a_19550_1044# a_20315_1044# 0.39037f
C949 a_23437_1842# a_24197_1842# 0.03319f
C950 a_27563_1842# VDD 0.49811f
C951 VDD DELAY_IN 1.33375f
C952 a_1256_1044# a_1544_1044# 1.26509f
C953 a_14317_1842# a_15077_1842# 0.03319f
C954 a_19550_1044# a_19963_1842# 0.01012f
C955 DELAY_VBIASN a_14317_1842# 0.09974f
C956 a_20593_1842# a_20397_1842# 0.76914f
C957 MUX_SEL0 a_2297_1395# 0.10655f
C958 a_20723_1842# DELAY_VBIASP 0.06627f
C959 a_19833_1842# a_19963_1842# 0.70845f
C960 MUX_SEL4 a_4350_1044# 0.31434f
C961 a_16793_1842# a_17357_1842# 0.0114f
C962 a_4905_1044# a_5115_1044# 0.09424f
C963 VDD a_13368_1044# 0.17274f
C964 a_17357_1842# a_16597_1842# 0.01669f
C965 a_8231_1008# a_7390_1044# 0.28268f
C966 MUX_SEL4 a_12797_1842# 0.01829f
C967 a_12233_1842# DELAY_VBIASP 0.11222f
C968 a_12037_1842# DELAY_VBIASN 0.09156f
C969 a_17351_1008# VDD 0.28565f
C970 a_26673_1842# DELAY_VBIASN 0.0961f
C971 VDD a_24523_1842# 0.4973f
C972 DELAY_VBIASN a_23763_1842# 0.07254f
C973 VDD a_5523_1842# 0.49671f
C974 VDD a_5191_1008# 0.28565f
C975 a_9323_1842# DELAY_VBIASP 0.06627f
C976 VDD a_26151_2470# 0.01806f
C977 a_9193_1842# DELAY_VBIASN 0.0961f
C978 a_24665_1044# a_24875_1044# 0.09424f
C979 a_15273_1842# a_15837_1842# 0.0114f
C980 a_2019_311# a_15765_463# 0.05969f
C981 a_17357_1842# DELAY_VBIASP 0.0414f
C982 a_27048_1044# a_25630_1044# 0.38994f
C983 DELAY_VBIASN a_16033_1842# 0.0961f
C984 a_4350_1044# a_4157_1313# 0.04624f
C985 a_20391_1008# VDD 0.28336f
C986 a_5731_289# a_2019_311# 1.15781f
C987 a_17791_1842# a_17683_1842# 0.01163f
C988 a_17357_1842# a_17928_1044# 0.10863f
C989 a_20105_1044# VDD 0.30409f
C990 a_4350_1044# VDD 0.87635f
C991 a_4437_1842# a_5197_1842# 0.01669f
C992 VDD a_24084_1008# 0.28225f
C993 a_7945_1044# a_7477_1842# 0.19203f
C994 VDD a_12797_1842# 0.87771f
C995 a_27563_1842# DELAY_VBIASN 0.07259f
C996 DELAY_VBIASP DELAY_OUT_LAST 0.21225f
C997 DELAY_IN DELAY_VBIASN 0.07156f
C998 a_16108_289# a_16851_309# 0.06181f
C999 a_7945_1044# VDD 0.30409f
C1000 a_14888_1044# a_14964_1008# 0.01176f
C1001 a_14825_519# a_13470_1044# 0.02058f
C1002 a_7911_2470# a_7803_1842# 0.01697f
C1003 a_23111_1842# a_23003_1842# 0.01163f
C1004 a_22590_1044# a_24951_1008# 0.26208f
C1005 a_10951_2470# VDD 0.01806f
C1006 a_19550_1044# a_21835_1044# 0.39036f
C1007 VDD a_22243_1842# 0.49737f
C1008 a_7803_1842# VDD 0.4973f
C1009 MUX_SEL4 a_5705_519# 0.03556f
C1010 MUX_SEL3 a_2019_311# 0.06209f
C1011 a_27048_1044# VDD 0.17499f
C1012 a_17683_1842# a_17791_2470# 0.01697f
C1013 a_21044_1008# a_20397_1842# 0.02312f
C1014 VDD a_12471_2470# 0.01806f
C1015 a_26477_1842# a_26043_1842# 0.6972f
C1016 DELAY_VBIASP a_25717_1842# 0.0414f
C1017 DELAY_VBIASN a_24523_1842# 0.07254f
C1018 a_13470_1044# a_13444_1008# 0.277f
C1019 DELAY_VBIASN a_5523_1842# 0.07254f
C1020 a_12505_1044# a_12037_1842# 0.2079f
C1021 a_22677_1842# VDD 0.86707f
C1022 a_8884_1008# VDD 0.28225f
C1023 a_12797_1842# a_12363_1842# 0.6972f
C1024 a_13883_1842# a_13991_2470# 0.01697f
C1025 a_6391_2470# a_6283_1842# 0.01697f
C1026 a_16510_1044# a_16851_309# 0.02131f
C1027 a_23145_1044# a_22590_1044# 0.03209f
C1028 a_17928_1044# a_18004_1008# 0.01176f
C1029 a_1256_1044# a_1721_1395# 0.13421f
C1030 VDD a_14513_1842# 0.49417f
C1031 a_21917_1842# a_22113_1842# 0.76914f
C1032 a_7288_1044# a_7390_1044# 0.37183f
C1033 a_24008_1044# a_23437_1842# 0.10863f
C1034 a_4157_1313# a_4437_1842# 0.01771f
C1035 a_25153_1842# a_25717_1842# 0.0114f
C1036 VDD a_13753_1842# 0.49294f
C1037 MUX_OUT a_16851_309# 0.45865f
C1038 VDD a_2297_1395# 0.46536f
C1039 a_12363_1842# a_12471_2470# 0.01697f
C1040 a_16510_1044# a_16484_1008# 0.277f
C1041 VDD a_4437_1842# 0.86998f
C1042 a_11473_1842# VDD 0.49417f
C1043 a_5768_1044# a_5844_1008# 0.01176f
C1044 a_9751_1008# a_9757_1842# 0.02354f
C1045 VDD a_21911_1008# 0.2822f
C1046 a_18313_1842# VDD 0.49285f
C1047 a_4350_1044# DELAY_VBIASN 0.02115f
C1048 VDD a_24197_1842# 0.85848f
C1049 a_6717_1842# a_7288_1044# 0.10864f
C1050 a_19524_1008# a_18877_1842# 0.02011f
C1051 a_15511_2470# a_15403_1842# 0.01697f
C1052 a_5705_519# VDD 0.29556f
C1053 DELAY_VBIASP a_19073_1842# 0.11222f
C1054 DELAY_VBIASN a_12797_1842# 0.09992f
C1055 a_5197_1842# a_5957_1842# 0.03319f
C1056 a_22677_1842# a_22873_1842# 0.73897f
C1057 a_8563_1842# VDD 0.49671f
C1058 a_11277_1842# a_10430_1044# 0.08038f
C1059 a_12037_1842# a_12233_1842# 0.77122f
C1060 a_12993_1842# a_13123_1842# 0.70845f
C1061 a_4350_1044# a_5731_289# 0.41099f
C1062 a_22488_1044# a_22564_1008# 0.01176f
C1063 DELAY_VBIASN a_22243_1842# 0.07254f
C1064 a_7803_1842# DELAY_VBIASN 0.07254f
C1065 VDD a_15403_1842# 0.4973f
C1066 VDD a_4003_1842# 0.61559f
C1067 VDD a_12791_1008# 0.2822f
C1068 a_4350_1044# a_6635_1044# 0.39036f
C1069 a_3449_1395# DELAY_IN 0.01058f
C1070 a_16510_1044# a_17065_1044# 0.03209f
C1071 a_10713_1842# a_10843_1842# 0.70845f
C1072 a_22677_1842# DELAY_VBIASN 0.08375f
C1073 a_14513_1842# a_15077_1842# 0.0114f
C1074 VDD a_17865_519# 0.29444f
C1075 a_17553_1842# a_17683_1842# 0.70845f
C1076 VDD a_15755_1044# 0.15389f
C1077 DELAY_VBIASN a_14513_1842# 0.0961f
C1078 a_6283_1842# DELAY_VBIASP 0.06627f
C1079 a_10430_1044# a_11924_1008# 0.28279f
C1080 a_9193_1842# a_9323_1842# 0.70845f
C1081 a_23437_1842# a_23633_1842# 0.76914f
C1082 a_19550_1044# a_19524_1008# 0.277f
C1083 a_27997_1842# VDD 0.76025f
C1084 a_19550_1044# a_20397_1842# 0.08038f
C1085 a_23871_2470# a_23763_1842# 0.01697f
C1086 a_21157_1842# DELAY_VBIASP 0.04141f
C1087 DELAY_VBIASN a_13753_1842# 0.0961f
C1088 DELAY_VBIASP a_13883_1842# 0.06627f
C1089 a_19833_1842# a_20397_1842# 0.0114f
C1090 a_22590_1044# a_23945_519# 0.02165f
C1091 a_16793_1842# a_16597_1842# 0.73897f
C1092 a_11277_1842# a_11924_1008# 0.02312f
C1093 DELAY_VBIASN a_4437_1842# 0.08375f
C1094 a_8155_1044# a_7390_1044# 0.39037f
C1095 a_17275_1044# VDD 0.15389f
C1096 a_11473_1842# DELAY_VBIASN 0.0961f
C1097 a_20105_1044# a_19637_1842# 0.19203f
C1098 a_11603_1842# DELAY_VBIASP 0.06627f
C1099 a_24875_1044# a_24951_1008# 0.01194f
C1100 a_13470_1044# a_13883_1842# 0.01012f
C1101 a_18313_1842# DELAY_VBIASN 0.0961f
C1102 a_6283_1842# a_6153_1842# 0.70845f
C1103 DELAY_VBIASN a_24197_1842# 0.09156f
C1104 DELAY_VBIASP a_24393_1842# 0.11222f
R0 DELAY_VBIASN.n1 DELAY_VBIASN.t31 34.3755
R1 DELAY_VBIASN.n1 DELAY_VBIASN.t30 33.0005
R2 DELAY_VBIASN.n2 DELAY_VBIASN.t29 33.0005
R3 DELAY_VBIASN.n3 DELAY_VBIASN.t28 33.0005
R4 DELAY_VBIASN.n4 DELAY_VBIASN.t27 33.0005
R5 DELAY_VBIASN.n5 DELAY_VBIASN.t26 33.0005
R6 DELAY_VBIASN.n6 DELAY_VBIASN.t25 33.0005
R7 DELAY_VBIASN.n7 DELAY_VBIASN.t24 33.0005
R8 DELAY_VBIASN.n8 DELAY_VBIASN.t23 33.0005
R9 DELAY_VBIASN.n9 DELAY_VBIASN.t22 33.0005
R10 DELAY_VBIASN.n10 DELAY_VBIASN.t21 33.0005
R11 DELAY_VBIASN.n11 DELAY_VBIASN.t20 33.0005
R12 DELAY_VBIASN.n12 DELAY_VBIASN.t19 33.0005
R13 DELAY_VBIASN.n13 DELAY_VBIASN.t18 33.0005
R14 DELAY_VBIASN.n14 DELAY_VBIASN.t17 33.0005
R15 DELAY_VBIASN.n15 DELAY_VBIASN.t16 33.0005
R16 DELAY_VBIASN.n16 DELAY_VBIASN.t15 33.0005
R17 DELAY_VBIASN.n17 DELAY_VBIASN.t14 33.0005
R18 DELAY_VBIASN.n18 DELAY_VBIASN.t13 33.0005
R19 DELAY_VBIASN.n19 DELAY_VBIASN.t12 33.0005
R20 DELAY_VBIASN.n20 DELAY_VBIASN.t11 33.0005
R21 DELAY_VBIASN.n21 DELAY_VBIASN.t10 33.0005
R22 DELAY_VBIASN.n22 DELAY_VBIASN.t9 33.0005
R23 DELAY_VBIASN.n23 DELAY_VBIASN.t8 33.0005
R24 DELAY_VBIASN.n24 DELAY_VBIASN.t7 33.0005
R25 DELAY_VBIASN.n25 DELAY_VBIASN.t6 33.0005
R26 DELAY_VBIASN.n26 DELAY_VBIASN.t5 33.0005
R27 DELAY_VBIASN.n27 DELAY_VBIASN.t4 33.0005
R28 DELAY_VBIASN.n28 DELAY_VBIASN.t3 33.0005
R29 DELAY_VBIASN.n29 DELAY_VBIASN.t2 33.0005
R30 DELAY_VBIASN.n30 DELAY_VBIASN.t1 33.0005
R31 DELAY_VBIASN.n0 DELAY_VBIASN.t0 33.0005
R32 DELAY_VBIASN DELAY_VBIASN.n0 1.55517
R33 DELAY_VBIASN.n0 DELAY_VBIASN.n30 1.3755
R34 DELAY_VBIASN.n30 DELAY_VBIASN.n29 1.3755
R35 DELAY_VBIASN.n29 DELAY_VBIASN.n28 1.3755
R36 DELAY_VBIASN.n28 DELAY_VBIASN.n27 1.3755
R37 DELAY_VBIASN.n27 DELAY_VBIASN.n26 1.3755
R38 DELAY_VBIASN.n26 DELAY_VBIASN.n25 1.3755
R39 DELAY_VBIASN.n25 DELAY_VBIASN.n24 1.3755
R40 DELAY_VBIASN.n24 DELAY_VBIASN.n23 1.3755
R41 DELAY_VBIASN.n23 DELAY_VBIASN.n22 1.3755
R42 DELAY_VBIASN.n22 DELAY_VBIASN.n21 1.3755
R43 DELAY_VBIASN.n21 DELAY_VBIASN.n20 1.3755
R44 DELAY_VBIASN.n20 DELAY_VBIASN.n19 1.3755
R45 DELAY_VBIASN.n19 DELAY_VBIASN.n18 1.3755
R46 DELAY_VBIASN.n18 DELAY_VBIASN.n17 1.3755
R47 DELAY_VBIASN.n17 DELAY_VBIASN.n16 1.3755
R48 DELAY_VBIASN.n16 DELAY_VBIASN.n15 1.3755
R49 DELAY_VBIASN.n15 DELAY_VBIASN.n14 1.3755
R50 DELAY_VBIASN.n14 DELAY_VBIASN.n13 1.3755
R51 DELAY_VBIASN.n13 DELAY_VBIASN.n12 1.3755
R52 DELAY_VBIASN.n12 DELAY_VBIASN.n11 1.3755
R53 DELAY_VBIASN.n11 DELAY_VBIASN.n10 1.3755
R54 DELAY_VBIASN.n10 DELAY_VBIASN.n9 1.3755
R55 DELAY_VBIASN.n9 DELAY_VBIASN.n8 1.3755
R56 DELAY_VBIASN.n8 DELAY_VBIASN.n7 1.3755
R57 DELAY_VBIASN.n7 DELAY_VBIASN.n6 1.3755
R58 DELAY_VBIASN.n6 DELAY_VBIASN.n5 1.3755
R59 DELAY_VBIASN.n5 DELAY_VBIASN.n4 1.3755
R60 DELAY_VBIASN.n4 DELAY_VBIASN.n3 1.3755
R61 DELAY_VBIASN.n3 DELAY_VBIASN.n2 1.3755
R62 DELAY_VBIASN.n2 DELAY_VBIASN.n1 1.3755
R63 DELAY_VBIASP.n1 DELAY_VBIASP.t31 34.3685
R64 DELAY_VBIASP.n1 DELAY_VBIASP.t30 33.0005
R65 DELAY_VBIASP.n2 DELAY_VBIASP.t29 33.0005
R66 DELAY_VBIASP.n3 DELAY_VBIASP.t28 33.0005
R67 DELAY_VBIASP.n4 DELAY_VBIASP.t27 33.0005
R68 DELAY_VBIASP.n5 DELAY_VBIASP.t26 33.0005
R69 DELAY_VBIASP.n6 DELAY_VBIASP.t25 33.0005
R70 DELAY_VBIASP.n7 DELAY_VBIASP.t24 33.0005
R71 DELAY_VBIASP.n8 DELAY_VBIASP.t23 33.0005
R72 DELAY_VBIASP.n9 DELAY_VBIASP.t22 33.0005
R73 DELAY_VBIASP.n10 DELAY_VBIASP.t21 33.0005
R74 DELAY_VBIASP.n11 DELAY_VBIASP.t20 33.0005
R75 DELAY_VBIASP.n12 DELAY_VBIASP.t19 33.0005
R76 DELAY_VBIASP.n13 DELAY_VBIASP.t18 33.0005
R77 DELAY_VBIASP.n14 DELAY_VBIASP.t17 33.0005
R78 DELAY_VBIASP.n15 DELAY_VBIASP.t16 33.0005
R79 DELAY_VBIASP.n16 DELAY_VBIASP.t15 33.0005
R80 DELAY_VBIASP.n17 DELAY_VBIASP.t14 33.0005
R81 DELAY_VBIASP.n18 DELAY_VBIASP.t13 33.0005
R82 DELAY_VBIASP.n19 DELAY_VBIASP.t12 33.0005
R83 DELAY_VBIASP.n20 DELAY_VBIASP.t11 33.0005
R84 DELAY_VBIASP.n21 DELAY_VBIASP.t10 33.0005
R85 DELAY_VBIASP.n22 DELAY_VBIASP.t9 33.0005
R86 DELAY_VBIASP.n23 DELAY_VBIASP.t8 33.0005
R87 DELAY_VBIASP.n24 DELAY_VBIASP.t7 33.0005
R88 DELAY_VBIASP.n25 DELAY_VBIASP.t6 33.0005
R89 DELAY_VBIASP.n26 DELAY_VBIASP.t5 33.0005
R90 DELAY_VBIASP.n27 DELAY_VBIASP.t4 33.0005
R91 DELAY_VBIASP.n28 DELAY_VBIASP.t3 33.0005
R92 DELAY_VBIASP.n29 DELAY_VBIASP.t2 33.0005
R93 DELAY_VBIASP.n30 DELAY_VBIASP.t1 33.0005
R94 DELAY_VBIASP.n0 DELAY_VBIASP.t0 33.0005
R95 DELAY_VBIASP DELAY_VBIASP.n0 1.70586
R96 DELAY_VBIASP.n0 DELAY_VBIASP.n30 1.36852
R97 DELAY_VBIASP.n30 DELAY_VBIASP.n29 1.36852
R98 DELAY_VBIASP.n29 DELAY_VBIASP.n28 1.36852
R99 DELAY_VBIASP.n28 DELAY_VBIASP.n27 1.36852
R100 DELAY_VBIASP.n27 DELAY_VBIASP.n26 1.36852
R101 DELAY_VBIASP.n26 DELAY_VBIASP.n25 1.36852
R102 DELAY_VBIASP.n25 DELAY_VBIASP.n24 1.36852
R103 DELAY_VBIASP.n24 DELAY_VBIASP.n23 1.36852
R104 DELAY_VBIASP.n23 DELAY_VBIASP.n22 1.36852
R105 DELAY_VBIASP.n22 DELAY_VBIASP.n21 1.36852
R106 DELAY_VBIASP.n21 DELAY_VBIASP.n20 1.36852
R107 DELAY_VBIASP.n20 DELAY_VBIASP.n19 1.36852
R108 DELAY_VBIASP.n19 DELAY_VBIASP.n18 1.36852
R109 DELAY_VBIASP.n18 DELAY_VBIASP.n17 1.36852
R110 DELAY_VBIASP.n17 DELAY_VBIASP.n16 1.36852
R111 DELAY_VBIASP.n16 DELAY_VBIASP.n15 1.36852
R112 DELAY_VBIASP.n15 DELAY_VBIASP.n14 1.36852
R113 DELAY_VBIASP.n14 DELAY_VBIASP.n13 1.36852
R114 DELAY_VBIASP.n13 DELAY_VBIASP.n12 1.36852
R115 DELAY_VBIASP.n12 DELAY_VBIASP.n11 1.36852
R116 DELAY_VBIASP.n11 DELAY_VBIASP.n10 1.36852
R117 DELAY_VBIASP.n10 DELAY_VBIASP.n9 1.36852
R118 DELAY_VBIASP.n9 DELAY_VBIASP.n8 1.36852
R119 DELAY_VBIASP.n8 DELAY_VBIASP.n7 1.36852
R120 DELAY_VBIASP.n7 DELAY_VBIASP.n6 1.36852
R121 DELAY_VBIASP.n6 DELAY_VBIASP.n5 1.36852
R122 DELAY_VBIASP.n5 DELAY_VBIASP.n4 1.36852
R123 DELAY_VBIASP.n4 DELAY_VBIASP.n3 1.36852
R124 DELAY_VBIASP.n3 DELAY_VBIASP.n2 1.36852
R125 DELAY_VBIASP.n2 DELAY_VBIASP.n1 1.36852
R126 VSS.n32 VSS.n390 7907.02
R127 VSS.n50 VSS.n425 469.783
R128 VSS.n46 VSS.n414 469.783
R129 VSS.n40 VSS.n31 469.783
R130 VSS.n3 VSS.t221 58.3205
R131 VSS.n495 VSS.n17 454.007
R132 VSS.t249 VSS.n52 321.57
R133 VSS.n44 VSS.t266 402.185
R134 VSS.n549 VSS.n27 454.007
R135 VSS.n38 VSS.t296 402.185
R136 VSS.n424 VSS.n418 454.007
R137 VSS.t18 VSS.n23 116.469
R138 VSS.n21 VSS.n25 0.00292781
R139 VSS.t148 VSS.n6 442.469
R140 VSS.t554 VSS.n446 437.62
R141 VSS.n64 VSS.t521 44.8755
R142 VSS.n33 VSS.t301 413.695
R143 VSS.t286 VSS.n56 413.695
R144 VSS.t271 VSS.n57 413.695
R145 VSS.t256 VSS.n58 413.695
R146 VSS.t241 VSS.n60 413.695
R147 VSS.t226 VSS.n62 413.695
R148 VSS.n452 VSS.t555 403.072
R149 VSS.n17 VSS.t236 402.185
R150 VSS.n27 VSS.t281 402.185
R151 VSS.n65 VSS.t182 412.901
R152 VSS.n450 VSS.t128 391.555
R153 VSS.n449 VSS.t53 380.038
R154 VSS.t25 VSS.n448 357.007
R155 VSS.t27 VSS.n447 333.974
R156 VSS.t88 VSS.n11 384.904
R157 VSS.n58 VSS.t259 97.2238
R158 VSS.n57 VSS.t274 97.2238
R159 VSS.n33 VSS.t304 97.2238
R160 VSS.t143 VSS.n55 332.017
R161 VSS.n3 VSS.t219 101.742
R162 VSS.n495 VSS.t234 305.183
R163 VSS.n44 VSS.t264 321.57
R164 VSS.n549 VSS.t279 305.183
R165 VSS.n38 VSS.t294 321.57
R166 VSS.n451 VSS.t147 299.425
R167 VSS.t216 VSS.n4 105.688
R168 VSS.t231 VSS.n54 310.053
R169 VSS.t246 VSS.n19 310.053
R170 VSS.t261 VSS.n418 293.666
R171 VSS.n24 VSS.n22 0.0022108
R172 VSS.t291 VSS.n25 310.053
R173 VSS.t311 VSS.n30 116.469
R174 VSS.t213 VSS.n28 110.547
R175 VSS.t17 VSS.n23 110.547
R176 VSS.t391 VSS.n36 110.543
R177 VSS.t509 VSS.n59 110.546
R178 VSS.t11 VSS.n20 110.547
R179 VSS.n61 VSS.t195 212.157
R180 VSS.n29 VSS.t389 116.468
R181 VSS.n451 VSS.t89 287.909
R182 VSS.t309 VSS.n6 269.724
R183 VSS.t145 VSS.n55 106.362
R184 VSS.t517 VSS.n35 332.017
R185 VSS.t510 VSS.n59 116.469
R186 VSS.t12 VSS.n20 116.468
R187 VSS.t195 VSS.n54 258.235
R188 VSS.n13 VSS.n29 0.00596635
R189 VSS.t392 VSS.n424 258.233
R190 VSS.t214 VSS.n28 116.468
R191 VSS.t129 VSS.n8 258.231
R192 VSS.t308 VSS.n447 253.359
R193 VSS.t506 VSS.n226 252.375
R194 VSS.t131 VSS.n237 252.375
R195 VSS.n899 VSS.t348 252.375
R196 VSS.t151 VSS.n216 252.375
R197 VSS.n818 VSS.t419 252.375
R198 VSS.n800 VSS.t343 252.375
R199 VSS.n269 VSS.t137 252.375
R200 VSS.n279 VSS.t498 252.375
R201 VSS.n289 VSS.t394 252.375
R202 VSS.n300 VSS.t33 252.375
R203 VSS.n710 VSS.t185 252.375
R204 VSS.t132 VSS.n320 252.375
R205 VSS.t418 VSS.n332 252.375
R206 VSS.t366 VSS.n343 252.375
R207 VSS.n636 VSS.t142 252.375
R208 VSS.n616 VSS.t351 252.375
R209 VSS.n596 VSS.t428 252.375
R210 VSS.t522 VSS.n234 252.117
R211 VSS.t548 VSS.n307 252.117
R212 VSS.n340 VSS.t34 252.117
R213 VSS.t379 VSS.n360 252.117
R214 VSS.n867 VSS.t69 252.115
R215 VSS.n828 VSS.t502 252.115
R216 VSS.t347 VSS.n108 252.115
R217 VSS.t337 VSS.n111 252.115
R218 VSS.n774 VSS.t409 252.115
R219 VSS.t373 VSS.n119 252.115
R220 VSS.n738 VSS.t44 252.115
R221 VSS.n700 VSS.t551 252.115
R222 VSS.n682 VSS.t92 252.115
R223 VSS.t523 VSS.n136 252.115
R224 VSS.n607 VSS.t150 252.115
R225 VSS.t437 VSS.n215 250.837
R226 VSS.t453 VSS.n218 250.837
R227 VSS.t429 VSS.n224 250.837
R228 VSS.t455 VSS.n229 250.837
R229 VSS.t457 VSS.n236 250.837
R230 VSS.t463 VSS.n239 250.837
R231 VSS.t447 VSS.n245 250.837
R232 VSS.t465 VSS.n249 250.837
R233 VSS.t461 VSS.n256 250.837
R234 VSS.t449 VSS.n260 250.837
R235 VSS.t467 VSS.n267 250.837
R236 VSS.t459 VSS.n271 250.837
R237 VSS.t431 VSS.n277 250.837
R238 VSS.t469 VSS.n281 250.837
R239 VSS.t473 VSS.n287 250.837
R240 VSS.t471 VSS.n291 250.837
R241 VSS.t475 VSS.n298 250.837
R242 VSS.t441 VSS.n302 250.837
R243 VSS.t477 VSS.n309 250.837
R244 VSS.t479 VSS.n312 250.837
R245 VSS.t483 VSS.n318 250.837
R246 VSS.t433 VSS.n323 250.837
R247 VSS.t481 VSS.n330 250.837
R248 VSS.t451 VSS.n335 250.837
R249 VSS.t485 VSS.n342 250.837
R250 VSS.t435 VSS.n345 250.837
R251 VSS.t445 VSS.n352 250.837
R252 VSS.t489 VSS.n355 250.837
R253 VSS.t487 VSS.n362 250.837
R254 VSS.t443 VSS.n365 250.837
R255 VSS.t439 VSS.n372 250.837
R256 VSS.t491 VSS.n374 250.837
R257 VSS.n13 VSS.n14 0.315147
R258 VSS.n1 VSS.n2 0.00166569
R259 VSS.n16 VSS.t239 240.956
R260 VSS.n49 VSS.t254 240.956
R261 VSS.n45 VSS.t269 240.956
R262 VSS.n26 VSS.t284 240.956
R263 VSS.n39 VSS.t299 240.956
R264 VSS.n868 VSS.t176 234.114
R265 VSS.n849 VSS.t543 234.114
R266 VSS.n829 VSS.t385 234.114
R267 VSS.n810 VSS.t154 234.114
R268 VSS.n792 VSS.t135 234.114
R269 VSS.n775 VSS.t168 234.114
R270 VSS.n757 VSS.t403 234.114
R271 VSS.n739 VSS.t369 234.114
R272 VSS.n721 VSS.t376 234.114
R273 VSS.n701 VSS.t341 234.114
R274 VSS.n683 VSS.t558 234.114
R275 VSS.n665 VSS.t48 234.114
R276 VSS.n646 VSS.t174 234.114
R277 VSS.n628 VSS.t499 234.114
R278 VSS.n608 VSS.t562 234.114
R279 VSS.n587 VSS.t546 234.114
R280 VSS.t52 VSS.n448 230.327
R281 VSS.t224 VSS.n2 117.528
R282 VSS.t239 VSS.n15 229.441
R283 VSS.t254 VSS.n50 229.44
R284 VSS.t269 VSS.n46 229.44
R285 VSS.t299 VSS.n40 229.44
R286 VSS.t306 VSS.n14 117.216
R287 VSS.t152 VSS.n255 225.361
R288 VSS.t133 VSS.n266 225.361
R289 VSS.t371 VSS.n297 225.361
R290 VSS.t556 VSS.n329 225.361
R291 VSS.t172 VSS.n351 225.361
R292 VSS.t560 VSS.n371 225.361
R293 VSS.n886 VSS.t63 225.359
R294 VSS.n866 VSS.t177 225.359
R295 VSS.n848 VSS.t544 225.359
R296 VSS.t386 VSS.n105 225.359
R297 VSS.t170 VSS.n115 225.359
R298 VSS.n756 VSS.t401 225.359
R299 VSS.n720 VSS.t374 225.359
R300 VSS.t339 VSS.n128 225.359
R301 VSS.t50 VSS.n133 225.359
R302 VSS.n627 VSS.t500 225.359
R303 VSS.n880 VSS.t316 211.982
R304 VSS.n841 VSS.t197 211.982
R305 VSS.n658 VSS.t540 211.982
R306 VSS.n620 VSS.t200 211.982
R307 VSS.n600 VSS.t57 211.982
R308 VSS.n225 VSS.t110 211.982
R309 VSS.n246 VSS.t107 211.982
R310 VSS.n257 VSS.t85 211.982
R311 VSS.n268 VSS.t325 211.982
R312 VSS.n278 VSS.t537 211.982
R313 VSS.n288 VSS.t158 211.982
R314 VSS.n299 VSS.t331 211.982
R315 VSS.n310 VSS.t104 211.982
R316 VSS.n319 VSS.t313 211.982
R317 VSS.n331 VSS.t322 211.982
R318 VSS.n353 VSS.t161 211.982
R319 VSS.n449 VSS.t52 207.294
R320 VSS.n9 VSS.t308 200.649
R321 VSS.n450 VSS.t129 195.778
R322 VSS.t413 VSS.n228 195.26
R323 VSS.t424 VSS.n248 195.26
R324 VSS.t140 VSS.n259 195.26
R325 VSS.t396 VSS.n322 195.26
R326 VSS.t407 VSS.n334 195.26
R327 VSS.t179 VSS.n364 195.26
R328 VSS.n876 VSS.t344 195.26
R329 VSS.n837 VSS.t9 195.26
R330 VSS.t45 VSS.n113 195.26
R331 VSS.t416 VSS.n117 195.26
R332 VSS.t420 VSS.n121 195.26
R333 VSS.t384 VSS.n124 195.26
R334 VSS.n709 VSS.t42 195.26
R335 VSS.n654 VSS.t549 195.26
R336 VSS.t504 VSS.n138 195.26
R337 VSS.n595 VSS.t334 195.26
R338 VSS.t349 VSS.n13 114.148
R339 VSS.t519 VSS.n35 106.362
R340 VSS.n13 VSS.n55 6.82737
R341 VSS.n874 VSS.t123 187.292
R342 VSS.n855 VSS.t191 187.292
R343 VSS.n835 VSS.t528 187.292
R344 VSS.n816 VSS.t55 187.292
R345 VSS.n798 VSS.t67 187.292
R346 VSS.n781 VSS.t125 187.292
R347 VSS.n763 VSS.t23 187.292
R348 VSS.n745 VSS.t65 187.292
R349 VSS.n727 VSS.t97 187.292
R350 VSS.n707 VSS.t193 187.292
R351 VSS.n689 VSS.t516 187.292
R352 VSS.n671 VSS.t99 187.292
R353 VSS.n652 VSS.t211 187.292
R354 VSS.n634 VSS.t536 187.292
R355 VSS.n614 VSS.t126 187.292
R356 VSS.n593 VSS.t209 187.292
R357 VSS.n452 VSS.t309 184.262
R358 VSS.n29 VSS.t388 110.547
R359 VSS.n34 VSS.n36 0.00954674
R360 VSS.n61 VSS.t194 110.543
R361 VSS.n34 VSS.n59 0.00588066
R362 VSS.n21 VSS.n28 0.00596633
R363 VSS.t310 VSS.n30 110.546
R364 VSS.t71 VSS.n222 173.913
R365 VSS.t320 VSS.n233 173.913
R366 VSS.t117 VSS.n243 173.913
R367 VSS.n253 VSS.t329 173.913
R368 VSS.n264 VSS.t15 173.913
R369 VSS.t38 VSS.n275 173.913
R370 VSS.n285 VSS.t532 173.913
R371 VSS.t74 VSS.n295 173.913
R372 VSS.t114 VSS.n306 173.913
R373 VSS.t204 VSS.n316 173.913
R374 VSS.t61 VSS.n327 173.913
R375 VSS.t77 VSS.n339 173.913
R376 VSS.n349 VSS.t82 173.913
R377 VSS.t21 VSS.n359 173.913
R378 VSS.t102 VSS.n369 173.913
R379 VSS.t1 VSS.n378 173.913
R380 VSS.n390 VSS.n381 173.913
R381 VSS.t317 VSS.t345 163.881
R382 VSS.t111 VSS.t414 163.881
R383 VSS.t198 VSS.t7 163.881
R384 VSS.t108 VSS.t425 163.881
R385 VSS.t86 VSS.t141 163.881
R386 VSS.t326 VSS.t47 163.881
R387 VSS.t538 VSS.t417 163.881
R388 VSS.t159 VSS.t421 163.881
R389 VSS.t332 VSS.t382 163.881
R390 VSS.t105 VSS.t40 163.881
R391 VSS.t314 VSS.t395 163.881
R392 VSS.t323 VSS.t408 163.881
R393 VSS.t541 VSS.t550 163.881
R394 VSS.t162 VSS.t503 163.881
R395 VSS.t201 VSS.t180 163.881
R396 VSS.t58 VSS.t335 163.881
R397 VSS.n53 VSS.t231 160.341
R398 VSS.n48 VSS.t246 160.341
R399 VSS.n43 VSS.t261 160.341
R400 VSS.n24 VSS.t276 105.686
R401 VSS.n37 VSS.t291 160.341
R402 VSS.t514 VSS.n92 157.062
R403 VSS.t497 VSS.n94 156.429
R404 VSS.t508 VSS.n225 155.126
R405 VSS.t35 VSS.n246 155.126
R406 VSS.t95 VSS.n257 155.126
R407 VSS.t5 VSS.n268 155.126
R408 VSS.t156 VSS.n278 155.126
R409 VSS.t399 VSS.n288 155.126
R410 VSS.t559 VSS.n299 155.126
R411 VSS.t91 VSS.n310 155.126
R412 VSS.t377 VSS.n319 155.126
R413 VSS.t93 VSS.n331 155.126
R414 VSS.t380 VSS.n353 155.126
R415 VSS.n880 VSS.t427 155.125
R416 VSS.n841 VSS.t507 155.125
R417 VSS.n658 VSS.t186 155.125
R418 VSS.n620 VSS.t426 155.125
R419 VSS.n600 VSS.t398 155.125
R420 VSS.t147 VSS.n7 153.971
R421 VSS.n900 VSS.t166 153.846
R422 VSS.n874 VSS.t70 153.846
R423 VSS.n855 VSS.t319 153.846
R424 VSS.n835 VSS.t116 153.846
R425 VSS.n816 VSS.t328 153.846
R426 VSS.n798 VSS.t14 153.846
R427 VSS.n781 VSS.t37 153.846
R428 VSS.n763 VSS.t531 153.846
R429 VSS.n745 VSS.t73 153.846
R430 VSS.n727 VSS.t113 153.846
R431 VSS.n707 VSS.t203 153.846
R432 VSS.n689 VSS.t60 153.846
R433 VSS.n671 VSS.t76 153.846
R434 VSS.n652 VSS.t81 153.846
R435 VSS.n634 VSS.t20 153.846
R436 VSS.n614 VSS.t101 153.846
R437 VSS.n593 VSS.t0 153.846
R438 VSS.t207 VSS.n94 153.327
R439 VSS.t515 VSS.n95 153.236
R440 VSS.t89 VSS.n446 149.713
R441 VSS.t234 VSS.n53 148.826
R442 VSS.t249 VSS.n48 148.826
R443 VSS.t264 VSS.n43 148.826
R444 VSS.t294 VSS.n37 148.826
R445 VSS.t138 VSS.n221 147.157
R446 VSS.t79 VSS.n232 147.157
R447 VSS.t3 VSS.n242 147.157
R448 VSS.t423 VSS.n252 147.157
R449 VSS.t547 VSS.n263 147.157
R450 VSS.t411 VSS.n274 147.157
R451 VSS.t422 VSS.n284 147.157
R452 VSS.t493 VSS.n294 147.157
R453 VSS.t31 VSS.n305 147.157
R454 VSS.t410 VSS.n315 147.157
R455 VSS.t29 VSS.n326 147.157
R456 VSS.t338 VSS.n338 147.157
R457 VSS.t412 VSS.n348 147.157
R458 VSS.t405 VSS.n358 147.157
R459 VSS.t367 VSS.n368 147.157
R460 VSS.t529 VSS.n377 147.157
R461 VSS.n580 VSS.t364 145.093
R462 VSS.t360 VSS.n580 138.404
R463 VSS.n33 VSS.n32 0.00760728
R464 VSS.t289 VSS.n56 97.2238
R465 VSS.n57 VSS.n22 0.00760728
R466 VSS.n58 VSS.n34 0.00760728
R467 VSS.t244 VSS.n60 97.2238
R468 VSS.t229 VSS.n62 97.2238
R469 VSS.t552 VSS.n11 97.2225
R470 VSS.n913 VSS.t188 134.661
R471 VSS.n586 VSS.t360 131.974
R472 VSS.n5 VSS.t143 130.939
R473 VSS.n64 VSS.t517 131.005
R474 VSS.n910 VSS.t119 126.945
R475 VSS.n911 VSS.t526 123.212
R476 VSS.n95 VSS.t497 120.691
R477 VSS.n12 VSS.t27 119.422
R478 VSS.t512 VSS.n913 117.858
R479 VSS.t364 VSS.n381 117.058
R480 VSS.t535 VSS.n88 115.745
R481 VSS.t534 VSS.n90 108.276
R482 VSS.t427 VSS.n877 107.023
R483 VSS.n868 VSS.t138 107.023
R484 VSS.n857 VSS.t508 107.023
R485 VSS.n849 VSS.t79 107.023
R486 VSS.t507 VSS.n838 107.023
R487 VSS.n829 VSS.t3 107.023
R488 VSS.n819 VSS.t35 107.023
R489 VSS.n810 VSS.t423 107.023
R490 VSS.n801 VSS.t95 107.023
R491 VSS.n792 VSS.t547 107.023
R492 VSS.n783 VSS.t5 107.023
R493 VSS.n775 VSS.t411 107.023
R494 VSS.n765 VSS.t156 107.023
R495 VSS.n757 VSS.t422 107.023
R496 VSS.n747 VSS.t399 107.023
R497 VSS.n739 VSS.t493 107.023
R498 VSS.n729 VSS.t559 107.023
R499 VSS.n721 VSS.t31 107.023
R500 VSS.n711 VSS.t91 107.023
R501 VSS.n701 VSS.t410 107.023
R502 VSS.n691 VSS.t377 107.023
R503 VSS.n683 VSS.t29 107.023
R504 VSS.n673 VSS.t93 107.023
R505 VSS.n665 VSS.t338 107.023
R506 VSS.t186 VSS.n655 107.023
R507 VSS.n646 VSS.t412 107.023
R508 VSS.n637 VSS.t380 107.023
R509 VSS.n628 VSS.t405 107.023
R510 VSS.t426 VSS.n617 107.023
R511 VSS.n608 VSS.t367 107.023
R512 VSS.t398 VSS.n597 107.023
R513 VSS.n587 VSS.t529 107.023
R514 VSS.n900 VSS.t353 100.335
R515 VSS.t70 VSS.n221 100.335
R516 VSS.t319 VSS.n232 100.335
R517 VSS.t116 VSS.n242 100.335
R518 VSS.t328 VSS.n252 100.335
R519 VSS.t14 VSS.n263 100.335
R520 VSS.t37 VSS.n274 100.335
R521 VSS.t531 VSS.n284 100.335
R522 VSS.t73 VSS.n294 100.335
R523 VSS.t113 VSS.n305 100.335
R524 VSS.t203 VSS.n315 100.335
R525 VSS.t60 VSS.n326 100.335
R526 VSS.t76 VSS.n338 100.335
R527 VSS.t81 VSS.n348 100.335
R528 VSS.t20 VSS.n358 100.335
R529 VSS.t101 VSS.n368 100.335
R530 VSS.t0 VSS.n377 100.335
R531 VSS.n909 VSS.t206 97.0758
R532 VSS.n10 VSS.t25 96.3896
R533 VSS.t121 VSS.n92 93.5889
R534 VSS.n909 VSS.t189 93.3421
R535 VSS.n586 VSS.t1 88.4945
R536 VSS.t329 VSS.n108 88.2366
R537 VSS.t15 VSS.n111 88.2366
R538 VSS.t532 VSS.n119 88.2366
R539 VSS.t82 VSS.n136 88.2366
R540 VSS.n867 VSS.t71 88.2366
R541 VSS.n828 VSS.t117 88.2366
R542 VSS.n774 VSS.t38 88.2366
R543 VSS.n738 VSS.t74 88.2366
R544 VSS.n700 VSS.t204 88.2366
R545 VSS.n682 VSS.t61 88.2366
R546 VSS.n607 VSS.t102 88.2366
R547 VSS.n234 VSS.t320 88.2359
R548 VSS.n307 VSS.t114 88.2359
R549 VSS.n340 VSS.t77 88.2359
R550 VSS.n360 VSS.t21 88.2359
R551 VSS.n914 VSS.t494 88.133
R552 VSS.n390 VSS.n66 88.4708
R553 VSS.t353 VSS.t164 86.957
R554 VSS.t166 VSS.t357 86.957
R555 VSS.t88 VSS.n10 84.8733
R556 VSS.t494 VSS.n87 82.7875
R557 VSS.n90 VSS.t496 82.1411
R558 VSS.t496 VSS.n89 75.0671
R559 VSS.t164 VSS.n96 74.8579
R560 VSS.t524 VSS.n88 74.6738
R561 VSS.t53 VSS.n9 73.9692
R562 VSS.n877 VSS.t317 70.2346
R563 VSS.n857 VSS.t111 70.2346
R564 VSS.n838 VSS.t198 70.2346
R565 VSS.n819 VSS.t108 70.2346
R566 VSS.n801 VSS.t86 70.2346
R567 VSS.n783 VSS.t326 70.2346
R568 VSS.n765 VSS.t538 70.2346
R569 VSS.n747 VSS.t159 70.2346
R570 VSS.n729 VSS.t332 70.2346
R571 VSS.n711 VSS.t105 70.2346
R572 VSS.n691 VSS.t314 70.2346
R573 VSS.n673 VSS.t323 70.2346
R574 VSS.n655 VSS.t541 70.2346
R575 VSS.n637 VSS.t162 70.2346
R576 VSS.n617 VSS.t201 70.2346
R577 VSS.n597 VSS.t58 70.2346
R578 VSS.n3 VSS.n1 0.00115721
R579 VSS.t236 VSS.n16 68.211
R580 VSS.t251 VSS.n49 68.211
R581 VSS.t266 VSS.n45 68.211
R582 VSS.t281 VSS.n26 68.211
R583 VSS.t296 VSS.n39 68.211
R584 VSS.n911 VSS.t524 67.2065
R585 VSS.t344 VSS.n875 66.8901
R586 VSS.t123 VSS.n218 66.8901
R587 VSS.n856 VSS.t413 66.8901
R588 VSS.t191 VSS.n229 66.8901
R589 VSS.t9 VSS.n836 66.8901
R590 VSS.t528 VSS.n239 66.8901
R591 VSS.n817 VSS.t424 66.8901
R592 VSS.t55 VSS.n249 66.8901
R593 VSS.n799 VSS.t140 66.8901
R594 VSS.t67 VSS.n260 66.8901
R595 VSS.n782 VSS.t45 66.8901
R596 VSS.t125 VSS.n271 66.8901
R597 VSS.n764 VSS.t416 66.8901
R598 VSS.t23 VSS.n281 66.8901
R599 VSS.n746 VSS.t420 66.8901
R600 VSS.t65 VSS.n291 66.8901
R601 VSS.n728 VSS.t384 66.8901
R602 VSS.t97 VSS.n302 66.8901
R603 VSS.t42 VSS.n708 66.8901
R604 VSS.t193 VSS.n312 66.8901
R605 VSS.n690 VSS.t396 66.8901
R606 VSS.t516 VSS.n323 66.8901
R607 VSS.n672 VSS.t407 66.8901
R608 VSS.t99 VSS.n335 66.8901
R609 VSS.t549 VSS.n653 66.8901
R610 VSS.t211 VSS.n345 66.8901
R611 VSS.n635 VSS.t504 66.8901
R612 VSS.t536 VSS.n355 66.8901
R613 VSS.n615 VSS.t179 66.8901
R614 VSS.t126 VSS.n365 66.8901
R615 VSS.t334 VSS.n594 66.8901
R616 VSS.t209 VSS.n374 66.8901
R617 VSS.n910 VSS.t121 63.4728
R618 VSS.t189 VSS.n93 62.2523
R619 VSS.t128 VSS.n12 61.8407
R620 VSS.t206 VSS.n908 58.5186
R621 VSS.t182 VSS.n63 56.6955
R622 VSS.n442 VSS.t226 56.0825
R623 VSS.n15 VSS.t241 56.6955
R624 VSS.n425 VSS.t256 56.0825
R625 VSS.n414 VSS.t271 56.0825
R626 VSS.n42 VSS.t286 56.6955
R627 VSS.t301 VSS.n31 56.0825
R628 VSS.n914 VSS.t512 54.532
R629 VSS.t555 VSS.n5 50.3244
R630 VSS.t316 VSS.n215 50.1677
R631 VSS.t110 VSS.n224 50.1677
R632 VSS.t197 VSS.n236 50.1677
R633 VSS.t107 VSS.n245 50.1677
R634 VSS.t85 VSS.n256 50.1677
R635 VSS.t325 VSS.n267 50.1677
R636 VSS.t537 VSS.n277 50.1677
R637 VSS.t158 VSS.n287 50.1677
R638 VSS.t331 VSS.n298 50.1677
R639 VSS.t104 VSS.n309 50.1677
R640 VSS.t313 VSS.n318 50.1677
R641 VSS.t322 VSS.n330 50.1677
R642 VSS.t540 VSS.n342 50.1677
R643 VSS.t161 VSS.n352 50.1677
R644 VSS.t200 VSS.n362 50.1677
R645 VSS.t57 VSS.n372 50.1677
R646 VSS.n91 VSS.t534 47.3176
R647 VSS.n912 VSS.t535 39.8503
R648 VSS.t63 VSS.n885 36.7898
R649 VSS.t177 VSS.n865 36.7898
R650 VSS.t544 VSS.n847 36.7898
R651 VSS.n827 VSS.t386 36.7898
R652 VSS.n809 VSS.t152 36.7898
R653 VSS.n791 VSS.t133 36.7898
R654 VSS.n773 VSS.t170 36.7898
R655 VSS.t401 VSS.n755 36.7898
R656 VSS.n737 VSS.t371 36.7898
R657 VSS.t374 VSS.n719 36.7898
R658 VSS.n699 VSS.t339 36.7898
R659 VSS.n681 VSS.t556 36.7898
R660 VSS.n664 VSS.t50 36.7898
R661 VSS.n645 VSS.t172 36.7898
R662 VSS.t500 VSS.n626 36.7898
R663 VSS.n606 VSS.t560 36.7898
R664 VSS.t188 VSS.n912 36.1166
R665 VSS.t526 VSS.n89 33.9948
R666 VSS.t119 VSS.n91 28.6493
R667 VSS.t345 VSS.n216 28.2938
R668 VSS.t425 VSS.n818 28.2938
R669 VSS.t141 VSS.n800 28.2938
R670 VSS.t47 VSS.n269 28.2938
R671 VSS.t417 VSS.n279 28.2938
R672 VSS.t421 VSS.n289 28.2938
R673 VSS.t382 VSS.n300 28.2938
R674 VSS.t40 VSS.n710 28.2938
R675 VSS.t395 VSS.n320 28.2938
R676 VSS.t408 VSS.n332 28.2938
R677 VSS.t550 VSS.n343 28.2938
R678 VSS.t503 VSS.n636 28.2938
R679 VSS.t180 VSS.n616 28.2938
R680 VSS.t335 VSS.n596 28.2938
R681 VSS.t414 VSS.n226 28.2928
R682 VSS.t7 VSS.n237 28.2928
R683 VSS.n96 VSS.t515 28.0359
R684 VSS.n7 VSS.t148 27.2918
R685 VSS.t183 VSS.n63 21.1052
R686 VSS.n65 VSS.t84 20.3065
R687 VSS.t357 VSS.n899 21.6048
R688 VSS.t176 VSS.n222 20.0674
R689 VSS.t543 VSS.n233 20.0674
R690 VSS.t385 VSS.n243 20.0674
R691 VSS.t154 VSS.n253 20.0674
R692 VSS.t135 VSS.n264 20.0674
R693 VSS.t168 VSS.n275 20.0674
R694 VSS.t403 VSS.n285 20.0674
R695 VSS.t369 VSS.n295 20.0674
R696 VSS.t376 VSS.n306 20.0674
R697 VSS.t341 VSS.n316 20.0674
R698 VSS.t558 VSS.n327 20.0674
R699 VSS.t48 VSS.n339 20.0674
R700 VSS.t174 VSS.n349 20.0674
R701 VSS.t499 VSS.n359 20.0674
R702 VSS.t562 VSS.n369 20.0674
R703 VSS.t546 VSS.n378 20.0674
R704 VSS.t502 VSS.n105 18.0025
R705 VSS.t137 VSS.n113 18.0025
R706 VSS.t409 VSS.n115 18.0025
R707 VSS.t498 VSS.n117 18.0025
R708 VSS.t394 VSS.n121 18.0025
R709 VSS.t33 VSS.n124 18.0025
R710 VSS.t551 VSS.n128 18.0025
R711 VSS.t34 VSS.n133 18.0025
R712 VSS.t142 VSS.n138 18.0025
R713 VSS.t348 VSS.n886 18.0025
R714 VSS.n876 VSS.t151 18.0025
R715 VSS.t69 VSS.n866 18.0025
R716 VSS.n848 VSS.t522 18.0025
R717 VSS.n837 VSS.t131 18.0025
R718 VSS.n756 VSS.t373 18.0025
R719 VSS.n720 VSS.t548 18.0025
R720 VSS.t185 VSS.n709 18.0025
R721 VSS.n654 VSS.t366 18.0025
R722 VSS.n627 VSS.t379 18.0025
R723 VSS.t428 VSS.n595 18.0025
R724 VSS.n228 VSS.t506 18.0017
R725 VSS.t419 VSS.n248 18.0017
R726 VSS.n255 VSS.t347 18.0017
R727 VSS.t343 VSS.n259 18.0017
R728 VSS.n266 VSS.t337 18.0017
R729 VSS.t44 VSS.n297 18.0017
R730 VSS.n322 VSS.t132 18.0017
R731 VSS.t92 VSS.n329 18.0017
R732 VSS.n334 VSS.t418 18.0017
R733 VSS.n351 VSS.t523 18.0017
R734 VSS.t351 VSS.n364 18.0017
R735 VSS.t150 VSS.n371 18.0017
R736 VSS.n908 VSS.t207 17.4483
R737 VSS.n929 VSS.t190 17.3368
R738 VSS.n925 VSS.t120 17.3368
R739 VSS.n921 VSS.t525 17.3368
R740 VSS.n459 VSS.t26 17.3368
R741 VSS.n463 VSS.t28 17.3368
R742 VSS.n467 VSS.t90 17.3368
R743 VSS.n471 VSS.t144 17.3368
R744 VSS.n905 VSS.t165 17.3368
R745 VSS.n527 VSS.t518 17.2607
R746 VSS.n445 VSS.t218 17.2313
R747 VSS.n484 VSS.t223 17.2313
R748 VSS.n488 VSS.t228 17.2313
R749 VSS.n436 VSS.t233 17.2313
R750 VSS.n500 VSS.t238 17.2313
R751 VSS.n504 VSS.t243 17.2313
R752 VSS.n428 VSS.t248 17.2313
R753 VSS.n515 VSS.t253 17.2313
R754 VSS.n519 VSS.t258 17.2313
R755 VSS.n417 VSS.t263 17.2313
R756 VSS.n538 VSS.t268 17.2313
R757 VSS.n542 VSS.t273 17.2313
R758 VSS.n408 VSS.t278 17.2313
R759 VSS.n554 VSS.t283 17.2313
R760 VSS.n558 VSS.t288 17.2313
R761 VSS.n400 VSS.t293 17.2313
R762 VSS.n569 VSS.t298 17.2313
R763 VSS.n573 VSS.t303 17.2313
R764 VSS.n916 VSS.n915 17.0005
R765 VSS.n915 VSS.n88 17.0005
R766 VSS.n915 VSS.n911 17.0005
R767 VSS.n915 VSS.n90 17.0005
R768 VSS.n915 VSS.n910 17.0005
R769 VSS.n915 VSS.n909 17.0005
R770 VSS.n915 VSS.n907 17.0005
R771 VSS.n915 VSS.n214 17.0005
R772 VSS.n915 VSS.n220 17.0005
R773 VSS.n915 VSS.n231 17.0005
R774 VSS.n915 VSS.n241 17.0005
R775 VSS.n915 VSS.n251 17.0005
R776 VSS.n915 VSS.n262 17.0005
R777 VSS.n915 VSS.n273 17.0005
R778 VSS.n915 VSS.n283 17.0005
R779 VSS.n915 VSS.n293 17.0005
R780 VSS.n915 VSS.n304 17.0005
R781 VSS.n915 VSS.n314 17.0005
R782 VSS.n915 VSS.n325 17.0005
R783 VSS.n915 VSS.n337 17.0005
R784 VSS.n915 VSS.n347 17.0005
R785 VSS.n915 VSS.n357 17.0005
R786 VSS.n915 VSS.n367 17.0005
R787 VSS.n915 VSS.n376 17.0005
R788 VSS.n915 VSS.n379 17.0005
R789 VSS.n915 VSS.n585 17.0005
R790 VSS.n915 VSS.n380 17.0005
R791 VSS.n915 VSS.n579 17.0005
R792 VSS.n915 VSS.n382 17.0005
R793 VSS.n915 VSS.n212 17.0005
R794 VSS.n915 VSS.n98 17.0005
R795 VSS.n41 VSS.n83 5.65652
R796 VSS.n21 VSS.n80 5.65652
R797 VSS.n22 VSS.n549 17.0005
R798 VSS.n47 VSS.n418 17.0005
R799 VSS.n35 VSS.n34 6.82739
R800 VSS.n65 VSS.n34 0.800314
R801 VSS.n51 VSS.n52 0.00104691
R802 VSS.n51 VSS.n19 0.00107219
R803 VSS.n18 VSS.n71 5.65652
R804 VSS.n0 VSS.n495 17.0005
R805 VSS.n0 VSS.n54 0.0010374
R806 VSS.n1 VSS.n68 5.65652
R807 VSS.n4 VSS.n13 0.00353491
R808 VSS.n13 VSS.n452 17.0005
R809 VSS.n13 VSS.n451 17.0005
R810 VSS.n13 VSS.n446 17.0005
R811 VSS.n13 VSS.n450 17.0005
R812 VSS.n13 VSS.n447 17.0005
R813 VSS.n13 VSS.n449 17.0005
R814 VSS.n13 VSS.n448 17.0005
R815 VSS.n454 VSS.n13 17.0005
R816 VSS.n453 VSS.t217 17.0005
R817 VSS.n444 VSS.t220 17.0005
R818 VSS.n482 VSS.t222 17.0005
R819 VSS.n440 VSS.t225 17.0005
R820 VSS.n439 VSS.t227 17.0005
R821 VSS.n438 VSS.t230 17.0005
R822 VSS.n437 VSS.t232 17.0005
R823 VSS.n435 VSS.t235 17.0005
R824 VSS.n498 VSS.t237 17.0005
R825 VSS.n432 VSS.t240 17.0005
R826 VSS.n431 VSS.t242 17.0005
R827 VSS.n430 VSS.t245 17.0005
R828 VSS.n429 VSS.t247 17.0005
R829 VSS.n427 VSS.t250 17.0005
R830 VSS.n513 VSS.t252 17.0005
R831 VSS.n422 VSS.t255 17.0005
R832 VSS.n421 VSS.t257 17.0005
R833 VSS.n420 VSS.t260 17.0005
R834 VSS.n419 VSS.t262 17.0005
R835 VSS.n416 VSS.t265 17.0005
R836 VSS.n536 VSS.t267 17.0005
R837 VSS.n412 VSS.t270 17.0005
R838 VSS.n411 VSS.t272 17.0005
R839 VSS.n410 VSS.t275 17.0005
R840 VSS.n409 VSS.t277 17.0005
R841 VSS.n407 VSS.t280 17.0005
R842 VSS.n552 VSS.t282 17.0005
R843 VSS.n404 VSS.t285 17.0005
R844 VSS.n403 VSS.t287 17.0005
R845 VSS.n402 VSS.t290 17.0005
R846 VSS.n401 VSS.t292 17.0005
R847 VSS.n399 VSS.t295 17.0005
R848 VSS.n567 VSS.t297 17.0005
R849 VSS.n396 VSS.t300 17.0005
R850 VSS.n395 VSS.t302 17.0005
R851 VSS.n392 VSS.t305 17.0005
R852 VSS.n8 VSS.t554 16.3876
R853 VSS.n444 VSS.t597 15.3099
R854 VSS.n440 VSS.t595 15.3099
R855 VSS.n438 VSS.t593 15.3099
R856 VSS.n435 VSS.t591 15.3099
R857 VSS.n432 VSS.t589 15.3099
R858 VSS.n430 VSS.t587 15.3099
R859 VSS.n427 VSS.t585 15.3099
R860 VSS.n422 VSS.t583 15.3099
R861 VSS.n420 VSS.t581 15.3099
R862 VSS.n416 VSS.t579 15.3099
R863 VSS.n412 VSS.t577 15.3099
R864 VSS.n410 VSS.t575 15.3099
R865 VSS.n407 VSS.t573 15.3099
R866 VSS.n404 VSS.t571 15.3099
R867 VSS.n402 VSS.t569 15.3099
R868 VSS.n399 VSS.t567 15.3099
R869 VSS.n396 VSS.t565 15.3099
R870 VSS.n392 VSS.t563 15.3099
R871 VSS.n453 VSS.t598 15.2696
R872 VSS.n482 VSS.t596 15.2696
R873 VSS.n439 VSS.t594 15.2696
R874 VSS.n437 VSS.t592 15.2696
R875 VSS.n498 VSS.t590 15.2696
R876 VSS.n431 VSS.t588 15.2696
R877 VSS.n429 VSS.t586 15.2696
R878 VSS.n513 VSS.t584 15.2696
R879 VSS.n421 VSS.t582 15.2696
R880 VSS.n419 VSS.t580 15.2696
R881 VSS.n536 VSS.t578 15.2696
R882 VSS.n411 VSS.t576 15.2696
R883 VSS.n409 VSS.t574 15.2696
R884 VSS.n552 VSS.t572 15.2696
R885 VSS.n403 VSS.t570 15.2696
R886 VSS.n401 VSS.t568 15.2696
R887 VSS.n567 VSS.t566 15.2696
R888 VSS.n395 VSS.t564 15.2696
R889 VSS.n581 VSS.t359 15.1276
R890 VSS.n385 VSS.t363 15.0005
R891 VSS.n892 VSS.t356 15.0005
R892 VSS.n902 VSS.t352 15.0005
R893 VSS.n93 VSS.t514 13.7147
R894 VSS.n147 VSS.t530 8.85039
R895 VSS.n149 VSS.t336 8.85039
R896 VSS.n151 VSS.t368 8.85039
R897 VSS.n153 VSS.t181 8.85039
R898 VSS.n155 VSS.t406 8.85039
R899 VSS.n157 VSS.t381 8.85039
R900 VSS.n159 VSS.t175 8.85039
R901 VSS.n161 VSS.t187 8.85039
R902 VSS.n163 VSS.t49 8.85039
R903 VSS.n165 VSS.t94 8.85039
R904 VSS.n167 VSS.t30 8.85039
R905 VSS.n169 VSS.t378 8.85039
R906 VSS.n171 VSS.t342 8.85039
R907 VSS.n173 VSS.t41 8.85039
R908 VSS.n175 VSS.t32 8.85039
R909 VSS.n177 VSS.t383 8.85039
R910 VSS.n179 VSS.t370 8.85039
R911 VSS.n181 VSS.t400 8.85039
R912 VSS.n183 VSS.t404 8.85039
R913 VSS.n185 VSS.t157 8.85039
R914 VSS.n187 VSS.t169 8.85039
R915 VSS.n189 VSS.t6 8.85039
R916 VSS.n191 VSS.t136 8.85039
R917 VSS.n193 VSS.t96 8.85039
R918 VSS.n195 VSS.t155 8.85039
R919 VSS.n197 VSS.t36 8.85039
R920 VSS.n199 VSS.t4 8.85039
R921 VSS.n201 VSS.t8 8.85039
R922 VSS.n203 VSS.t80 8.85039
R923 VSS.n205 VSS.t415 8.85039
R924 VSS.n207 VSS.t139 8.85039
R925 VSS.n209 VSS.t346 8.85039
R926 VSS.n931 VSS.t208 8.80385
R927 VSS.n927 VSS.t122 8.80385
R928 VSS.n923 VSS.t527 8.80385
R929 VSS.n896 VSS.t167 8.80385
R930 VSS.n461 VSS.t54 8.80285
R931 VSS.n465 VSS.t130 8.80285
R932 VSS.n469 VSS.t149 8.80285
R933 VSS.n473 VSS.t146 8.80285
R934 VSS.n588 VSS.t2 8.77423
R935 VSS.n375 VSS.t210 8.77423
R936 VSS.n598 VSS.t59 8.77423
R937 VSS.n604 VSS.t561 8.77423
R938 VSS.n609 VSS.t103 8.77423
R939 VSS.n366 VSS.t127 8.77423
R940 VSS.n618 VSS.t202 8.77423
R941 VSS.n624 VSS.t501 8.77423
R942 VSS.n629 VSS.t22 8.77423
R943 VSS.n356 VSS.t505 8.77423
R944 VSS.n638 VSS.t163 8.77423
R945 VSS.n643 VSS.t173 8.77423
R946 VSS.n647 VSS.t83 8.77423
R947 VSS.n346 VSS.t212 8.77423
R948 VSS.n656 VSS.t542 8.77423
R949 VSS.n662 VSS.t51 8.77423
R950 VSS.n666 VSS.t78 8.77423
R951 VSS.n336 VSS.t100 8.77423
R952 VSS.n674 VSS.t324 8.77423
R953 VSS.n679 VSS.t557 8.77423
R954 VSS.n684 VSS.t62 8.77423
R955 VSS.n324 VSS.t397 8.77423
R956 VSS.n692 VSS.t315 8.77423
R957 VSS.n697 VSS.t340 8.77423
R958 VSS.n702 VSS.t205 8.77423
R959 VSS.n313 VSS.t43 8.77423
R960 VSS.n712 VSS.t106 8.77423
R961 VSS.n717 VSS.t375 8.77423
R962 VSS.n722 VSS.t115 8.77423
R963 VSS.n303 VSS.t98 8.77423
R964 VSS.n730 VSS.t333 8.77423
R965 VSS.n735 VSS.t372 8.77423
R966 VSS.n740 VSS.t75 8.77423
R967 VSS.n292 VSS.t66 8.77423
R968 VSS.n748 VSS.t160 8.77423
R969 VSS.n753 VSS.t402 8.77423
R970 VSS.n758 VSS.t533 8.77423
R971 VSS.n282 VSS.t24 8.77423
R972 VSS.n766 VSS.t539 8.77423
R973 VSS.n771 VSS.t171 8.77423
R974 VSS.n776 VSS.t39 8.77423
R975 VSS.n272 VSS.t46 8.77423
R976 VSS.n784 VSS.t327 8.77423
R977 VSS.n789 VSS.t134 8.77423
R978 VSS.n793 VSS.t16 8.77423
R979 VSS.n261 VSS.t68 8.77423
R980 VSS.n802 VSS.t87 8.77423
R981 VSS.n807 VSS.t153 8.77423
R982 VSS.n811 VSS.t330 8.77423
R983 VSS.n250 VSS.t56 8.77423
R984 VSS.n820 VSS.t109 8.77423
R985 VSS.n825 VSS.t387 8.77423
R986 VSS.n830 VSS.t118 8.77423
R987 VSS.n240 VSS.t10 8.77423
R988 VSS.n839 VSS.t199 8.77423
R989 VSS.n845 VSS.t545 8.77423
R990 VSS.n850 VSS.t321 8.77423
R991 VSS.n230 VSS.t192 8.77423
R992 VSS.n858 VSS.t112 8.77423
R993 VSS.n863 VSS.t178 8.77423
R994 VSS.n869 VSS.t72 8.77423
R995 VSS.n219 VSS.t124 8.77423
R996 VSS.n878 VSS.t318 8.77423
R997 VSS.n887 VSS.t64 8.77423
R998 VSS.n477 VSS.t390 8.77323
R999 VSS.n492 VSS.t196 8.77323
R1000 VSS.n508 VSS.t13 8.77323
R1001 VSS.n523 VSS.t511 8.77323
R1002 VSS.n525 VSS.t184 8.77323
R1003 VSS.n531 VSS.t393 8.77323
R1004 VSS.n546 VSS.t19 8.77323
R1005 VSS.n562 VSS.t215 8.77323
R1006 VSS.n389 VSS.t312 8.77323
R1007 VSS.n475 VSS.t350 8.76689
R1008 VSS.n529 VSS.t520 8.76678
R1009 VSS.n919 VSS.t513 8.75731
R1010 VSS.n917 VSS.t495 8.75731
R1011 VSS.n455 VSS.t307 8.75631
R1012 VSS.n457 VSS.t553 8.75631
R1013 VSS.n84 VSS.n32 4.22409
R1014 VSS.n566 VSS.n83 0.0180497
R1015 VSS.n82 VSS.n564 0.0633111
R1016 VSS.n81 VSS.n21 4.22409
R1017 VSS.n551 VSS.n80 0.0180497
R1018 VSS.n79 VSS.n548 0.0633111
R1019 VSS.n78 VSS.n22 4.22409
R1020 VSS.n77 VSS.n47 5.65652
R1021 VSS.n76 VSS.n533 0.0633111
R1022 VSS.n518 VSS.n75 0.0435295
R1023 VSS.n74 VSS.n51 5.65652
R1024 VSS.n73 VSS.n510 0.0633111
R1025 VSS.n503 VSS.n72 0.0435295
R1026 VSS.n497 VSS.n71 0.0180497
R1027 VSS.n70 VSS.n494 0.0633111
R1028 VSS.n487 VSS.n69 0.0435295
R1029 VSS.n481 VSS.n68 0.0180497
R1030 VSS.n67 VSS.n479 0.0633111
R1031 VSS.n915 VSS.n900 8.5005
R1032 VSS.n915 VSS.n885 8.5005
R1033 VSS.n915 VSS.n215 8.5005
R1034 VSS.n915 VSS.n877 8.5005
R1035 VSS.n915 VSS.n875 8.5005
R1036 VSS.n915 VSS.n218 8.5005
R1037 VSS.n915 VSS.n874 8.5005
R1038 VSS.n915 VSS.n221 8.5005
R1039 VSS.n915 VSS.n868 8.5005
R1040 VSS.n915 VSS.n222 8.5005
R1041 VSS.n915 VSS.n865 8.5005
R1042 VSS.n915 VSS.n224 8.5005
R1043 VSS.n915 VSS.n857 8.5005
R1044 VSS.n915 VSS.n856 8.5005
R1045 VSS.n915 VSS.n229 8.5005
R1046 VSS.n915 VSS.n855 8.5005
R1047 VSS.n915 VSS.n232 8.5005
R1048 VSS.n915 VSS.n849 8.5005
R1049 VSS.n915 VSS.n233 8.5005
R1050 VSS.n915 VSS.n847 8.5005
R1051 VSS.n915 VSS.n236 8.5005
R1052 VSS.n915 VSS.n838 8.5005
R1053 VSS.n915 VSS.n836 8.5005
R1054 VSS.n915 VSS.n239 8.5005
R1055 VSS.n915 VSS.n835 8.5005
R1056 VSS.n915 VSS.n242 8.5005
R1057 VSS.n915 VSS.n829 8.5005
R1058 VSS.n915 VSS.n243 8.5005
R1059 VSS.n915 VSS.n827 8.5005
R1060 VSS.n915 VSS.n245 8.5005
R1061 VSS.n915 VSS.n819 8.5005
R1062 VSS.n915 VSS.n817 8.5005
R1063 VSS.n915 VSS.n249 8.5005
R1064 VSS.n915 VSS.n816 8.5005
R1065 VSS.n915 VSS.n252 8.5005
R1066 VSS.n915 VSS.n810 8.5005
R1067 VSS.n915 VSS.n253 8.5005
R1068 VSS.n915 VSS.n809 8.5005
R1069 VSS.n915 VSS.n256 8.5005
R1070 VSS.n915 VSS.n801 8.5005
R1071 VSS.n915 VSS.n799 8.5005
R1072 VSS.n915 VSS.n260 8.5005
R1073 VSS.n915 VSS.n798 8.5005
R1074 VSS.n915 VSS.n263 8.5005
R1075 VSS.n915 VSS.n792 8.5005
R1076 VSS.n915 VSS.n264 8.5005
R1077 VSS.n915 VSS.n791 8.5005
R1078 VSS.n915 VSS.n267 8.5005
R1079 VSS.n915 VSS.n783 8.5005
R1080 VSS.n915 VSS.n782 8.5005
R1081 VSS.n915 VSS.n271 8.5005
R1082 VSS.n915 VSS.n781 8.5005
R1083 VSS.n915 VSS.n274 8.5005
R1084 VSS.n915 VSS.n775 8.5005
R1085 VSS.n915 VSS.n275 8.5005
R1086 VSS.n915 VSS.n773 8.5005
R1087 VSS.n915 VSS.n277 8.5005
R1088 VSS.n915 VSS.n765 8.5005
R1089 VSS.n915 VSS.n764 8.5005
R1090 VSS.n915 VSS.n281 8.5005
R1091 VSS.n915 VSS.n763 8.5005
R1092 VSS.n915 VSS.n284 8.5005
R1093 VSS.n915 VSS.n757 8.5005
R1094 VSS.n915 VSS.n285 8.5005
R1095 VSS.n915 VSS.n755 8.5005
R1096 VSS.n915 VSS.n287 8.5005
R1097 VSS.n915 VSS.n747 8.5005
R1098 VSS.n915 VSS.n746 8.5005
R1099 VSS.n915 VSS.n291 8.5005
R1100 VSS.n915 VSS.n745 8.5005
R1101 VSS.n915 VSS.n294 8.5005
R1102 VSS.n915 VSS.n739 8.5005
R1103 VSS.n915 VSS.n295 8.5005
R1104 VSS.n915 VSS.n737 8.5005
R1105 VSS.n915 VSS.n298 8.5005
R1106 VSS.n915 VSS.n729 8.5005
R1107 VSS.n915 VSS.n728 8.5005
R1108 VSS.n915 VSS.n302 8.5005
R1109 VSS.n915 VSS.n727 8.5005
R1110 VSS.n915 VSS.n305 8.5005
R1111 VSS.n915 VSS.n721 8.5005
R1112 VSS.n915 VSS.n306 8.5005
R1113 VSS.n915 VSS.n719 8.5005
R1114 VSS.n915 VSS.n309 8.5005
R1115 VSS.n915 VSS.n711 8.5005
R1116 VSS.n915 VSS.n708 8.5005
R1117 VSS.n915 VSS.n312 8.5005
R1118 VSS.n915 VSS.n707 8.5005
R1119 VSS.n915 VSS.n315 8.5005
R1120 VSS.n915 VSS.n701 8.5005
R1121 VSS.n915 VSS.n316 8.5005
R1122 VSS.n915 VSS.n699 8.5005
R1123 VSS.n915 VSS.n318 8.5005
R1124 VSS.n915 VSS.n691 8.5005
R1125 VSS.n915 VSS.n690 8.5005
R1126 VSS.n915 VSS.n323 8.5005
R1127 VSS.n915 VSS.n689 8.5005
R1128 VSS.n915 VSS.n326 8.5005
R1129 VSS.n915 VSS.n683 8.5005
R1130 VSS.n915 VSS.n327 8.5005
R1131 VSS.n915 VSS.n681 8.5005
R1132 VSS.n915 VSS.n330 8.5005
R1133 VSS.n915 VSS.n673 8.5005
R1134 VSS.n915 VSS.n672 8.5005
R1135 VSS.n915 VSS.n335 8.5005
R1136 VSS.n915 VSS.n671 8.5005
R1137 VSS.n915 VSS.n338 8.5005
R1138 VSS.n915 VSS.n665 8.5005
R1139 VSS.n915 VSS.n339 8.5005
R1140 VSS.n915 VSS.n664 8.5005
R1141 VSS.n915 VSS.n342 8.5005
R1142 VSS.n915 VSS.n655 8.5005
R1143 VSS.n915 VSS.n653 8.5005
R1144 VSS.n915 VSS.n345 8.5005
R1145 VSS.n915 VSS.n652 8.5005
R1146 VSS.n915 VSS.n348 8.5005
R1147 VSS.n915 VSS.n646 8.5005
R1148 VSS.n915 VSS.n349 8.5005
R1149 VSS.n915 VSS.n645 8.5005
R1150 VSS.n915 VSS.n352 8.5005
R1151 VSS.n915 VSS.n637 8.5005
R1152 VSS.n915 VSS.n635 8.5005
R1153 VSS.n915 VSS.n355 8.5005
R1154 VSS.n915 VSS.n634 8.5005
R1155 VSS.n915 VSS.n358 8.5005
R1156 VSS.n915 VSS.n628 8.5005
R1157 VSS.n915 VSS.n359 8.5005
R1158 VSS.n915 VSS.n626 8.5005
R1159 VSS.n915 VSS.n362 8.5005
R1160 VSS.n915 VSS.n617 8.5005
R1161 VSS.n915 VSS.n615 8.5005
R1162 VSS.n915 VSS.n365 8.5005
R1163 VSS.n915 VSS.n614 8.5005
R1164 VSS.n915 VSS.n368 8.5005
R1165 VSS.n915 VSS.n608 8.5005
R1166 VSS.n915 VSS.n369 8.5005
R1167 VSS.n915 VSS.n606 8.5005
R1168 VSS.n915 VSS.n372 8.5005
R1169 VSS.n915 VSS.n597 8.5005
R1170 VSS.n915 VSS.n594 8.5005
R1171 VSS.n915 VSS.n374 8.5005
R1172 VSS.n915 VSS.n593 8.5005
R1173 VSS.n915 VSS.n377 8.5005
R1174 VSS.n915 VSS.n587 8.5005
R1175 VSS.n915 VSS.n378 8.5005
R1176 VSS.n915 VSS.n381 8.5005
R1177 VSS.n571 VSS.n41 8.49319
R1178 VSS.n556 VSS.n21 8.49319
R1179 VSS.n540 VSS.n47 8.49319
R1180 VSS.n517 VSS.n51 8.49319
R1181 VSS.n502 VSS.n18 8.49319
R1182 VSS.n486 VSS.n1 8.49319
R1183 VSS.n930 VSS.n915 8.47732
R1184 VSS.n915 VSS.n213 8.47732
R1185 VSS.n915 VSS.n884 8.47732
R1186 VSS.n915 VSS.n864 8.47732
R1187 VSS.n915 VSS.n846 8.47732
R1188 VSS.n915 VSS.n826 8.47732
R1189 VSS.n915 VSS.n808 8.47732
R1190 VSS.n915 VSS.n790 8.47732
R1191 VSS.n915 VSS.n772 8.47732
R1192 VSS.n915 VSS.n754 8.47732
R1193 VSS.n915 VSS.n736 8.47732
R1194 VSS.n915 VSS.n718 8.47732
R1195 VSS.n915 VSS.n698 8.47732
R1196 VSS.n915 VSS.n680 8.47732
R1197 VSS.n915 VSS.n663 8.47732
R1198 VSS.n915 VSS.n644 8.47732
R1199 VSS.n915 VSS.n625 8.47732
R1200 VSS.n915 VSS.n605 8.47732
R1201 VSS.n915 VSS.n97 8.47732
R1202 VSS.n915 VSS.n146 8.47732
R1203 VSS.n915 VSS.n145 8.47732
R1204 VSS.n387 VSS.n66 8.48044
R1205 VSS.n84 VSS.n573 0.176279
R1206 VSS.n565 VSS.n41 8.47732
R1207 VSS.n41 VSS.n82 4.21421
R1208 VSS.n558 VSS.n81 0.176279
R1209 VSS.n550 VSS.n22 8.47732
R1210 VSS.n22 VSS.n79 4.21421
R1211 VSS.n542 VSS.n78 0.176279
R1212 VSS.n534 VSS.n47 8.47732
R1213 VSS.n47 VSS.n76 4.21421
R1214 VSS.n75 VSS.n34 4.22409
R1215 VSS.n511 VSS.n51 8.47732
R1216 VSS.n51 VSS.n73 4.21421
R1217 VSS.n72 VSS.n18 4.22409
R1218 VSS.n496 VSS.n0 8.47732
R1219 VSS.n0 VSS.n70 4.21421
R1220 VSS.n69 VSS.n0 4.22409
R1221 VSS.n480 VSS.n1 8.47732
R1222 VSS.n1 VSS.n67 4.21421
R1223 VSS.n468 VSS.n13 8.47732
R1224 VSS.n384 VSS.t365 8.46888
R1225 VSS.n577 VSS.t361 8.46888
R1226 VSS.n583 VSS.t362 8.46631
R1227 VSS.n590 VSS.t492 8.46631
R1228 VSS.n602 VSS.t440 8.46631
R1229 VSS.n611 VSS.t444 8.46631
R1230 VSS.n622 VSS.t488 8.46631
R1231 VSS.n631 VSS.t490 8.46631
R1232 VSS.n641 VSS.t446 8.46631
R1233 VSS.n649 VSS.t436 8.46631
R1234 VSS.n660 VSS.t486 8.46631
R1235 VSS.n668 VSS.t452 8.46631
R1236 VSS.n677 VSS.t482 8.46631
R1237 VSS.n686 VSS.t434 8.46631
R1238 VSS.n695 VSS.t484 8.46631
R1239 VSS.n704 VSS.t480 8.46631
R1240 VSS.n715 VSS.t478 8.46631
R1241 VSS.n724 VSS.t442 8.46631
R1242 VSS.n733 VSS.t476 8.46631
R1243 VSS.n742 VSS.t472 8.46631
R1244 VSS.n751 VSS.t474 8.46631
R1245 VSS.n760 VSS.t470 8.46631
R1246 VSS.n769 VSS.t432 8.46631
R1247 VSS.n778 VSS.t460 8.46631
R1248 VSS.n787 VSS.t468 8.46631
R1249 VSS.n795 VSS.t450 8.46631
R1250 VSS.n805 VSS.t462 8.46631
R1251 VSS.n813 VSS.t466 8.46631
R1252 VSS.n823 VSS.t448 8.46631
R1253 VSS.n832 VSS.t464 8.46631
R1254 VSS.n843 VSS.t458 8.46631
R1255 VSS.n852 VSS.t456 8.46631
R1256 VSS.n861 VSS.t430 8.46631
R1257 VSS.n871 VSS.t454 8.46631
R1258 VSS.n882 VSS.t438 8.46631
R1259 VSS.n894 VSS.t358 8.46519
R1260 VSS.n889 VSS.t354 8.46519
R1261 VSS.n903 VSS.t355 8.46519
R1262 VSS.n933 VSS.n85 6.99673
R1263 VSS.n915 VSS.n388 5.63777
R1264 VSS.n922 VSS.n915 5.62581
R1265 VSS.n926 VSS.n915 5.62581
R1266 VSS.n932 VSS.n915 5.62581
R1267 VSS.n915 VSS.n879 5.62581
R1268 VSS.n915 VSS.n223 5.62581
R1269 VSS.n915 VSS.n859 5.62581
R1270 VSS.n915 VSS.n235 5.62581
R1271 VSS.n915 VSS.n840 5.62581
R1272 VSS.n915 VSS.n244 5.62581
R1273 VSS.n915 VSS.n821 5.62581
R1274 VSS.n915 VSS.n254 5.62581
R1275 VSS.n915 VSS.n803 5.62581
R1276 VSS.n915 VSS.n265 5.62581
R1277 VSS.n915 VSS.n785 5.62581
R1278 VSS.n915 VSS.n276 5.62581
R1279 VSS.n915 VSS.n767 5.62581
R1280 VSS.n915 VSS.n286 5.62581
R1281 VSS.n915 VSS.n749 5.62581
R1282 VSS.n915 VSS.n296 5.62581
R1283 VSS.n915 VSS.n731 5.62581
R1284 VSS.n915 VSS.n308 5.62581
R1285 VSS.n915 VSS.n713 5.62581
R1286 VSS.n915 VSS.n317 5.62581
R1287 VSS.n915 VSS.n693 5.62581
R1288 VSS.n915 VSS.n328 5.62581
R1289 VSS.n915 VSS.n675 5.62581
R1290 VSS.n915 VSS.n341 5.62581
R1291 VSS.n915 VSS.n657 5.62581
R1292 VSS.n915 VSS.n350 5.62581
R1293 VSS.n915 VSS.n639 5.62581
R1294 VSS.n915 VSS.n361 5.62581
R1295 VSS.n915 VSS.n619 5.62581
R1296 VSS.n915 VSS.n370 5.62581
R1297 VSS.n915 VSS.n599 5.62581
R1298 VSS.n915 VSS.n210 5.62581
R1299 VSS.n915 VSS.n208 5.62581
R1300 VSS.n915 VSS.n206 5.62581
R1301 VSS.n915 VSS.n204 5.62581
R1302 VSS.n915 VSS.n202 5.62581
R1303 VSS.n915 VSS.n200 5.62581
R1304 VSS.n915 VSS.n198 5.62581
R1305 VSS.n915 VSS.n196 5.62581
R1306 VSS.n915 VSS.n194 5.62581
R1307 VSS.n915 VSS.n192 5.62581
R1308 VSS.n915 VSS.n190 5.62581
R1309 VSS.n915 VSS.n188 5.62581
R1310 VSS.n915 VSS.n186 5.62581
R1311 VSS.n915 VSS.n184 5.62581
R1312 VSS.n915 VSS.n182 5.62581
R1313 VSS.n915 VSS.n180 5.62581
R1314 VSS.n915 VSS.n178 5.62581
R1315 VSS.n915 VSS.n176 5.62581
R1316 VSS.n915 VSS.n174 5.62581
R1317 VSS.n915 VSS.n172 5.62581
R1318 VSS.n915 VSS.n170 5.62581
R1319 VSS.n915 VSS.n168 5.62581
R1320 VSS.n915 VSS.n166 5.62581
R1321 VSS.n915 VSS.n164 5.62581
R1322 VSS.n915 VSS.n162 5.62581
R1323 VSS.n915 VSS.n160 5.62581
R1324 VSS.n915 VSS.n158 5.62581
R1325 VSS.n915 VSS.n156 5.62581
R1326 VSS.n915 VSS.n154 5.62581
R1327 VSS.n915 VSS.n152 5.62581
R1328 VSS.n915 VSS.n150 5.62581
R1329 VSS.n915 VSS.n148 5.62581
R1330 VSS.n915 VSS.n143 5.62581
R1331 VSS.n32 VSS.n394 5.62581
R1332 VSS.n41 VSS.n398 5.62581
R1333 VSS.n559 VSS.n21 5.62581
R1334 VSS.n21 VSS.n406 5.62581
R1335 VSS.n543 VSS.n22 5.62581
R1336 VSS.n47 VSS.n415 5.62581
R1337 VSS.n528 VSS.n34 5.62581
R1338 VSS.n520 VSS.n34 5.62581
R1339 VSS.n51 VSS.n426 5.62581
R1340 VSS.n505 VSS.n18 5.62581
R1341 VSS.n18 VSS.n434 5.62581
R1342 VSS.n489 VSS.n0 5.62581
R1343 VSS.n1 VSS.n443 5.62581
R1344 VSS.n474 VSS.n13 5.62581
R1345 VSS.n472 VSS.n13 5.62581
R1346 VSS.n464 VSS.n13 5.62581
R1347 VSS.n460 VSS.n13 5.62581
R1348 VSS.n454 VSS.n85 4.28471
R1349 VSS.n41 VSS.n570 4.21914
R1350 VSS.n21 VSS.n555 4.21914
R1351 VSS.n47 VSS.n539 4.21914
R1352 VSS.n51 VSS.n516 4.21914
R1353 VSS.n18 VSS.n501 4.21914
R1354 VSS.n1 VSS.n485 4.21914
R1355 VSS.n915 VSS.n144 4.20662
R1356 VSS.n918 VSS.n915 4.19244
R1357 VSS.n915 VSS.n898 4.19244
R1358 VSS.n456 VSS.n13 4.19244
R1359 VSS VSS.n85 3.80469
R1360 VSS.n885 VSS.t437 3.34498
R1361 VSS.n875 VSS.t453 3.34498
R1362 VSS.n865 VSS.t429 3.34498
R1363 VSS.n856 VSS.t455 3.34498
R1364 VSS.n847 VSS.t457 3.34498
R1365 VSS.n836 VSS.t463 3.34498
R1366 VSS.n827 VSS.t447 3.34498
R1367 VSS.n817 VSS.t465 3.34498
R1368 VSS.n809 VSS.t461 3.34498
R1369 VSS.n799 VSS.t449 3.34498
R1370 VSS.n791 VSS.t467 3.34498
R1371 VSS.n782 VSS.t459 3.34498
R1372 VSS.n773 VSS.t431 3.34498
R1373 VSS.n764 VSS.t469 3.34498
R1374 VSS.n755 VSS.t473 3.34498
R1375 VSS.n746 VSS.t471 3.34498
R1376 VSS.n737 VSS.t475 3.34498
R1377 VSS.n728 VSS.t441 3.34498
R1378 VSS.n719 VSS.t477 3.34498
R1379 VSS.n708 VSS.t479 3.34498
R1380 VSS.n699 VSS.t483 3.34498
R1381 VSS.n690 VSS.t433 3.34498
R1382 VSS.n681 VSS.t481 3.34498
R1383 VSS.n672 VSS.t451 3.34498
R1384 VSS.n664 VSS.t485 3.34498
R1385 VSS.n653 VSS.t435 3.34498
R1386 VSS.n645 VSS.t445 3.34498
R1387 VSS.n635 VSS.t489 3.34498
R1388 VSS.n626 VSS.t487 3.34498
R1389 VSS.n615 VSS.t443 3.34498
R1390 VSS.n606 VSS.t439 3.34498
R1391 VSS.n594 VSS.t491 3.34498
R1392 VSS.n924 VSS.n915 3.3265
R1393 VSS.n928 VSS.n915 3.3265
R1394 VSS.n915 VSS.n873 3.3265
R1395 VSS.n915 VSS.n854 3.3265
R1396 VSS.n915 VSS.n834 3.3265
R1397 VSS.n915 VSS.n815 3.3265
R1398 VSS.n915 VSS.n797 3.3265
R1399 VSS.n915 VSS.n780 3.3265
R1400 VSS.n915 VSS.n762 3.3265
R1401 VSS.n915 VSS.n744 3.3265
R1402 VSS.n915 VSS.n726 3.3265
R1403 VSS.n915 VSS.n706 3.3265
R1404 VSS.n915 VSS.n688 3.3265
R1405 VSS.n915 VSS.n670 3.3265
R1406 VSS.n915 VSS.n651 3.3265
R1407 VSS.n915 VSS.n633 3.3265
R1408 VSS.n915 VSS.n613 3.3265
R1409 VSS.n915 VSS.n592 3.3265
R1410 VSS.n563 VSS.n21 3.3265
R1411 VSS.n547 VSS.n22 3.3265
R1412 VSS.n532 VSS.n34 3.3265
R1413 VSS.n509 VSS.n18 3.3265
R1414 VSS.n493 VSS.n0 3.3265
R1415 VSS.n478 VSS.n13 3.3265
R1416 VSS.n470 VSS.n13 3.3265
R1417 VSS.n466 VSS.n13 3.3265
R1418 VSS.n462 VSS.n13 3.3265
R1419 VSS.n906 VSS 3.16675
R1420 VSS.n575 VSS.n574 3.01826
R1421 VSS.n915 VSS.n86 2.83376
R1422 VSS.n920 VSS.n915 2.74446
R1423 VSS.n915 VSS.n217 2.74446
R1424 VSS.n915 VSS.n227 2.74446
R1425 VSS.n915 VSS.n238 2.74446
R1426 VSS.n915 VSS.n247 2.74446
R1427 VSS.n915 VSS.n258 2.74446
R1428 VSS.n915 VSS.n270 2.74446
R1429 VSS.n915 VSS.n280 2.74446
R1430 VSS.n915 VSS.n290 2.74446
R1431 VSS.n915 VSS.n301 2.74446
R1432 VSS.n915 VSS.n311 2.74446
R1433 VSS.n915 VSS.n321 2.74446
R1434 VSS.n915 VSS.n333 2.74446
R1435 VSS.n915 VSS.n344 2.74446
R1436 VSS.n915 VSS.n354 2.74446
R1437 VSS.n915 VSS.n363 2.74446
R1438 VSS.n915 VSS.n373 2.74446
R1439 VSS.n915 VSS.n211 2.74446
R1440 VSS.n458 VSS.n13 2.74446
R1441 VSS.n915 VSS.n99 2.32483
R1442 VSS.n915 VSS.n100 2.32483
R1443 VSS.n915 VSS.n101 2.32483
R1444 VSS.n915 VSS.n102 2.32483
R1445 VSS.n915 VSS.n103 2.32483
R1446 VSS.n915 VSS.n104 2.32483
R1447 VSS.n915 VSS.n106 2.32483
R1448 VSS.n915 VSS.n107 2.32483
R1449 VSS.n915 VSS.n109 2.32483
R1450 VSS.n915 VSS.n110 2.32483
R1451 VSS.n915 VSS.n112 2.32483
R1452 VSS.n915 VSS.n114 2.32483
R1453 VSS.n915 VSS.n116 2.32483
R1454 VSS.n915 VSS.n118 2.32483
R1455 VSS.n915 VSS.n120 2.32483
R1456 VSS.n915 VSS.n122 2.32483
R1457 VSS.n915 VSS.n123 2.32483
R1458 VSS.n915 VSS.n125 2.32483
R1459 VSS.n915 VSS.n126 2.32483
R1460 VSS.n915 VSS.n127 2.32483
R1461 VSS.n915 VSS.n129 2.32483
R1462 VSS.n915 VSS.n130 2.32483
R1463 VSS.n915 VSS.n131 2.32483
R1464 VSS.n915 VSS.n132 2.32483
R1465 VSS.n915 VSS.n134 2.32483
R1466 VSS.n915 VSS.n135 2.32483
R1467 VSS.n915 VSS.n137 2.32483
R1468 VSS.n915 VSS.n139 2.32483
R1469 VSS.n915 VSS.n140 2.32483
R1470 VSS.n915 VSS.n141 2.32483
R1471 VSS.n915 VSS.n142 2.32483
R1472 VSS.n526 VSS.n34 2.00687
R1473 VSS.n915 VSS.n87 1.64417
R1474 VSS.n915 VSS.n912 1.64417
R1475 VSS.n915 VSS.n91 1.64417
R1476 VSS.n915 VSS.n93 1.64417
R1477 VSS.n915 VSS.n908 1.64417
R1478 VSS.n32 VSS.n391 1.56144
R1479 VSS.n561 VSS.n21 1.56144
R1480 VSS.n545 VSS.n22 1.56144
R1481 VSS.n522 VSS.n34 1.56144
R1482 VSS.n507 VSS.n18 1.56144
R1483 VSS.n491 VSS.n0 1.56144
R1484 VSS.n530 VSS.n34 1.12565
R1485 VSS.n574 VSS.n32 0.92982
R1486 VSS.n476 VSS.n475 0.909006
R1487 VSS.n477 VSS.n476 0.898984
R1488 VSS.n524 VSS.n34 0.849178
R1489 VSS.n524 VSS.n523 0.728316
R1490 VSS.n525 VSS.n524 0.69965
R1491 VSS.n574 VSS.n389 0.69304
R1492 VSS.n32 VSS.n31 0.613782
R1493 VSS.n414 VSS.n22 0.613782
R1494 VSS.n64 VSS.n34 0.547872
R1495 VSS.n425 VSS.n34 0.613782
R1496 VSS.n442 VSS.n0 0.613782
R1497 VSS.n13 VSS.n5 0.613782
R1498 VSS.n13 VSS.n7 0.613782
R1499 VSS.n13 VSS.n12 0.613782
R1500 VSS.n13 VSS.n10 0.613782
R1501 VSS.n14 VSS.n87 4666.38
R1502 VSS.n530 VSS.n529 0.603496
R1503 VSS.n915 VSS.n66 0.00104694
R1504 VSS.n915 VSS.n95 0.556705
R1505 VSS.n531 VSS.n530 0.540438
R1506 VSS VSS.n933 0.48296
R1507 VSS.n584 VSS.n583 0.419816
R1508 VSS.n591 VSS.n590 0.419816
R1509 VSS.n603 VSS.n602 0.419816
R1510 VSS.n612 VSS.n611 0.419816
R1511 VSS.n623 VSS.n622 0.419816
R1512 VSS.n632 VSS.n631 0.419816
R1513 VSS.n642 VSS.n641 0.419816
R1514 VSS.n650 VSS.n649 0.419816
R1515 VSS.n661 VSS.n660 0.419816
R1516 VSS.n669 VSS.n668 0.419816
R1517 VSS.n678 VSS.n677 0.419816
R1518 VSS.n687 VSS.n686 0.419816
R1519 VSS.n696 VSS.n695 0.419816
R1520 VSS.n705 VSS.n704 0.419816
R1521 VSS.n716 VSS.n715 0.419816
R1522 VSS.n725 VSS.n724 0.419816
R1523 VSS.n734 VSS.n733 0.419816
R1524 VSS.n743 VSS.n742 0.419816
R1525 VSS.n752 VSS.n751 0.419816
R1526 VSS.n761 VSS.n760 0.419816
R1527 VSS.n770 VSS.n769 0.419816
R1528 VSS.n779 VSS.n778 0.419816
R1529 VSS.n788 VSS.n787 0.419816
R1530 VSS.n796 VSS.n795 0.419816
R1531 VSS.n806 VSS.n805 0.419816
R1532 VSS.n814 VSS.n813 0.419816
R1533 VSS.n824 VSS.n823 0.419816
R1534 VSS.n833 VSS.n832 0.419816
R1535 VSS.n844 VSS.n843 0.419816
R1536 VSS.n853 VSS.n852 0.419816
R1537 VSS.n862 VSS.n861 0.419816
R1538 VSS.n872 VSS.n871 0.419816
R1539 VSS.n883 VSS.n882 0.419816
R1540 VSS.n492 VSS.n491 0.413418
R1541 VSS.n508 VSS.n507 0.413418
R1542 VSS.n523 VSS.n522 0.413418
R1543 VSS.n546 VSS.n545 0.413418
R1544 VSS.n562 VSS.n561 0.413418
R1545 VSS.n391 VSS.n389 0.413418
R1546 VSS.n476 VSS.n13 0.405836
R1547 VSS.n894 VSS.n893 0.385697
R1548 VSS.n889 VSS.n888 0.385697
R1549 VSS.n583 VSS.n582 0.383459
R1550 VSS.n590 VSS.n589 0.383459
R1551 VSS.n602 VSS.n601 0.383459
R1552 VSS.n611 VSS.n610 0.383459
R1553 VSS.n622 VSS.n621 0.383459
R1554 VSS.n631 VSS.n630 0.383459
R1555 VSS.n641 VSS.n640 0.383459
R1556 VSS.n649 VSS.n648 0.383459
R1557 VSS.n660 VSS.n659 0.383459
R1558 VSS.n668 VSS.n667 0.383459
R1559 VSS.n677 VSS.n676 0.383459
R1560 VSS.n686 VSS.n685 0.383459
R1561 VSS.n695 VSS.n694 0.383459
R1562 VSS.n704 VSS.n703 0.383459
R1563 VSS.n715 VSS.n714 0.383459
R1564 VSS.n724 VSS.n723 0.383459
R1565 VSS.n733 VSS.n732 0.383459
R1566 VSS.n742 VSS.n741 0.383459
R1567 VSS.n751 VSS.n750 0.383459
R1568 VSS.n760 VSS.n759 0.383459
R1569 VSS.n769 VSS.n768 0.383459
R1570 VSS.n778 VSS.n777 0.383459
R1571 VSS.n787 VSS.n786 0.383459
R1572 VSS.n795 VSS.n794 0.383459
R1573 VSS.n805 VSS.n804 0.383459
R1574 VSS.n813 VSS.n812 0.383459
R1575 VSS.n823 VSS.n822 0.383459
R1576 VSS.n832 VSS.n831 0.383459
R1577 VSS.n843 VSS.n842 0.383459
R1578 VSS.n852 VSS.n851 0.383459
R1579 VSS.n861 VSS.n860 0.383459
R1580 VSS.n871 VSS.n870 0.383459
R1581 VSS.n882 VSS.n881 0.383459
R1582 VSS.n527 VSS.n526 0.380519
R1583 VSS.n904 VSS.n903 0.379351
R1584 VSS.n578 VSS.n577 0.37817
R1585 VSS.n526 VSS.n525 0.359515
R1586 VSS.n209 VSS.n99 0.351341
R1587 VSS.n207 VSS.n100 0.351341
R1588 VSS.n205 VSS.n101 0.351341
R1589 VSS.n203 VSS.n102 0.351341
R1590 VSS.n201 VSS.n103 0.351341
R1591 VSS.n199 VSS.n104 0.351341
R1592 VSS.n197 VSS.n106 0.351341
R1593 VSS.n195 VSS.n107 0.351341
R1594 VSS.n193 VSS.n109 0.351341
R1595 VSS.n191 VSS.n110 0.351341
R1596 VSS.n189 VSS.n112 0.351341
R1597 VSS.n187 VSS.n114 0.351341
R1598 VSS.n185 VSS.n116 0.351341
R1599 VSS.n183 VSS.n118 0.351341
R1600 VSS.n181 VSS.n120 0.351341
R1601 VSS.n179 VSS.n122 0.351341
R1602 VSS.n177 VSS.n123 0.351341
R1603 VSS.n175 VSS.n125 0.351341
R1604 VSS.n173 VSS.n126 0.351341
R1605 VSS.n171 VSS.n127 0.351341
R1606 VSS.n169 VSS.n129 0.351341
R1607 VSS.n167 VSS.n130 0.351341
R1608 VSS.n165 VSS.n131 0.351341
R1609 VSS.n163 VSS.n132 0.351341
R1610 VSS.n161 VSS.n134 0.351341
R1611 VSS.n159 VSS.n135 0.351341
R1612 VSS.n157 VSS.n137 0.351341
R1613 VSS.n155 VSS.n139 0.351341
R1614 VSS.n153 VSS.n140 0.351341
R1615 VSS.n151 VSS.n141 0.351341
R1616 VSS.n149 VSS.n142 0.351341
R1617 VSS.n384 VSS.n383 0.345929
R1618 VSS.n577 VSS.n576 0.345929
R1619 VSS.n393 VSS.n391 0.340858
R1620 VSS.n561 VSS.n560 0.340858
R1621 VSS.n545 VSS.n544 0.340858
R1622 VSS.n522 VSS.n521 0.340858
R1623 VSS.n507 VSS.n506 0.340858
R1624 VSS.n491 VSS.n490 0.340858
R1625 VSS.n921 VSS.n920 0.318018
R1626 VSS.n459 VSS.n458 0.316299
R1627 VSS.n870 VSS.n99 0.311066
R1628 VSS.n860 VSS.n100 0.311066
R1629 VSS.n851 VSS.n101 0.311066
R1630 VSS.n842 VSS.n102 0.311066
R1631 VSS.n831 VSS.n103 0.311066
R1632 VSS.n822 VSS.n104 0.311066
R1633 VSS.n812 VSS.n106 0.311066
R1634 VSS.n804 VSS.n107 0.311066
R1635 VSS.n794 VSS.n109 0.311066
R1636 VSS.n786 VSS.n110 0.311066
R1637 VSS.n777 VSS.n112 0.311066
R1638 VSS.n768 VSS.n114 0.311066
R1639 VSS.n759 VSS.n116 0.311066
R1640 VSS.n750 VSS.n118 0.311066
R1641 VSS.n741 VSS.n120 0.311066
R1642 VSS.n732 VSS.n122 0.311066
R1643 VSS.n723 VSS.n123 0.311066
R1644 VSS.n714 VSS.n125 0.311066
R1645 VSS.n703 VSS.n126 0.311066
R1646 VSS.n694 VSS.n127 0.311066
R1647 VSS.n685 VSS.n129 0.311066
R1648 VSS.n676 VSS.n130 0.311066
R1649 VSS.n667 VSS.n131 0.311066
R1650 VSS.n659 VSS.n132 0.311066
R1651 VSS.n648 VSS.n134 0.311066
R1652 VSS.n640 VSS.n135 0.311066
R1653 VSS.n630 VSS.n137 0.311066
R1654 VSS.n621 VSS.n139 0.311066
R1655 VSS.n610 VSS.n140 0.311066
R1656 VSS.n601 VSS.n141 0.311066
R1657 VSS.n589 VSS.n142 0.311066
R1658 VSS.n219 VSS.n217 0.284268
R1659 VSS.n230 VSS.n227 0.284268
R1660 VSS.n240 VSS.n238 0.284268
R1661 VSS.n250 VSS.n247 0.284268
R1662 VSS.n261 VSS.n258 0.284268
R1663 VSS.n272 VSS.n270 0.284268
R1664 VSS.n282 VSS.n280 0.284268
R1665 VSS.n292 VSS.n290 0.284268
R1666 VSS.n303 VSS.n301 0.284268
R1667 VSS.n313 VSS.n311 0.284268
R1668 VSS.n324 VSS.n321 0.284268
R1669 VSS.n336 VSS.n333 0.284268
R1670 VSS.n346 VSS.n344 0.284268
R1671 VSS.n356 VSS.n354 0.284268
R1672 VSS.n366 VSS.n363 0.284268
R1673 VSS.n375 VSS.n373 0.284268
R1674 VSS.n903 VSS.n902 0.279928
R1675 VSS.n458 VSS.n457 0.274268
R1676 VSS.n466 VSS.n465 0.274227
R1677 VSS.n478 VSS.n477 0.274227
R1678 VSS.n493 VSS.n492 0.274227
R1679 VSS.n509 VSS.n508 0.274227
R1680 VSS.n532 VSS.n531 0.274227
R1681 VSS.n547 VSS.n546 0.274227
R1682 VSS.n563 VSS.n562 0.274227
R1683 VSS.n928 VSS.n927 0.272997
R1684 VSS.n920 VSS.n919 0.272549
R1685 VSS.n893 VSS.n211 0.271299
R1686 VSS.n915 VSS.n886 0.267794
R1687 VSS.n915 VSS.n880 0.267794
R1688 VSS.n915 VSS.n876 0.267794
R1689 VSS.n915 VSS.n867 0.267794
R1690 VSS.n915 VSS.n866 0.267794
R1691 VSS.n915 VSS.n225 0.267794
R1692 VSS.n915 VSS.n228 0.267794
R1693 VSS.n915 VSS.n234 0.267794
R1694 VSS.n915 VSS.n848 0.267794
R1695 VSS.n915 VSS.n841 0.267794
R1696 VSS.n915 VSS.n837 0.267794
R1697 VSS.n915 VSS.n828 0.267794
R1698 VSS.n915 VSS.n246 0.267794
R1699 VSS.n915 VSS.n248 0.267794
R1700 VSS.n915 VSS.n255 0.267794
R1701 VSS.n915 VSS.n257 0.267794
R1702 VSS.n915 VSS.n259 0.267794
R1703 VSS.n915 VSS.n266 0.267794
R1704 VSS.n915 VSS.n268 0.267794
R1705 VSS.n915 VSS.n774 0.267794
R1706 VSS.n915 VSS.n278 0.267794
R1707 VSS.n915 VSS.n756 0.267794
R1708 VSS.n915 VSS.n288 0.267794
R1709 VSS.n915 VSS.n738 0.267794
R1710 VSS.n915 VSS.n297 0.267794
R1711 VSS.n915 VSS.n299 0.267794
R1712 VSS.n915 VSS.n307 0.267794
R1713 VSS.n915 VSS.n720 0.267794
R1714 VSS.n915 VSS.n310 0.267794
R1715 VSS.n915 VSS.n709 0.267794
R1716 VSS.n915 VSS.n700 0.267794
R1717 VSS.n915 VSS.n319 0.267794
R1718 VSS.n915 VSS.n322 0.267794
R1719 VSS.n915 VSS.n682 0.267794
R1720 VSS.n915 VSS.n329 0.267794
R1721 VSS.n915 VSS.n331 0.267794
R1722 VSS.n915 VSS.n334 0.267794
R1723 VSS.n915 VSS.n340 0.267794
R1724 VSS.n915 VSS.n658 0.267794
R1725 VSS.n915 VSS.n654 0.267794
R1726 VSS.n915 VSS.n351 0.267794
R1727 VSS.n915 VSS.n353 0.267794
R1728 VSS.n915 VSS.n360 0.267794
R1729 VSS.n915 VSS.n627 0.267794
R1730 VSS.n915 VSS.n620 0.267794
R1731 VSS.n915 VSS.n364 0.267794
R1732 VSS.n915 VSS.n607 0.267794
R1733 VSS.n915 VSS.n371 0.267794
R1734 VSS.n915 VSS.n600 0.267794
R1735 VSS.n915 VSS.n595 0.267794
R1736 VSS.n915 VSS.n580 0.267794
R1737 VSS.n915 VSS.n96 0.267794
R1738 VSS.n915 VSS.n105 0.267794
R1739 VSS.n915 VSS.n108 0.267794
R1740 VSS.n915 VSS.n111 0.267794
R1741 VSS.n915 VSS.n113 0.267794
R1742 VSS.n915 VSS.n115 0.267794
R1743 VSS.n915 VSS.n117 0.267794
R1744 VSS.n915 VSS.n119 0.267794
R1745 VSS.n915 VSS.n121 0.267794
R1746 VSS.n915 VSS.n124 0.267794
R1747 VSS.n915 VSS.n128 0.267794
R1748 VSS.n915 VSS.n133 0.267794
R1749 VSS.n915 VSS.n136 0.267794
R1750 VSS.n915 VSS.n138 0.267794
R1751 VSS.n881 VSS.n211 0.265518
R1752 VSS.n387 VSS.n144 0.259448
R1753 VSS.n385 VSS.n384 0.251101
R1754 VSS.n471 VSS.n470 0.245497
R1755 VSS.n873 VSS.n872 0.244247
R1756 VSS.n854 VSS.n853 0.244247
R1757 VSS.n834 VSS.n833 0.244247
R1758 VSS.n815 VSS.n814 0.244247
R1759 VSS.n797 VSS.n796 0.244247
R1760 VSS.n780 VSS.n779 0.244247
R1761 VSS.n762 VSS.n761 0.244247
R1762 VSS.n744 VSS.n743 0.244247
R1763 VSS.n726 VSS.n725 0.244247
R1764 VSS.n706 VSS.n705 0.244247
R1765 VSS.n688 VSS.n687 0.244247
R1766 VSS.n670 VSS.n669 0.244247
R1767 VSS.n651 VSS.n650 0.244247
R1768 VSS.n633 VSS.n632 0.244247
R1769 VSS.n613 VSS.n612 0.244247
R1770 VSS.n592 VSS.n591 0.244247
R1771 VSS.n878 VSS.n217 0.240049
R1772 VSS.n858 VSS.n227 0.240049
R1773 VSS.n839 VSS.n238 0.240049
R1774 VSS.n820 VSS.n247 0.240049
R1775 VSS.n802 VSS.n258 0.240049
R1776 VSS.n784 VSS.n270 0.240049
R1777 VSS.n766 VSS.n280 0.240049
R1778 VSS.n748 VSS.n290 0.240049
R1779 VSS.n730 VSS.n301 0.240049
R1780 VSS.n712 VSS.n311 0.240049
R1781 VSS.n692 VSS.n321 0.240049
R1782 VSS.n674 VSS.n333 0.240049
R1783 VSS.n656 VSS.n344 0.240049
R1784 VSS.n638 VSS.n354 0.240049
R1785 VSS.n618 VSS.n363 0.240049
R1786 VSS.n598 VSS.n373 0.240049
R1787 VSS.n479 VSS.n478 0.237997
R1788 VSS.n494 VSS.n493 0.237997
R1789 VSS.n510 VSS.n509 0.237997
R1790 VSS.n533 VSS.n532 0.237997
R1791 VSS.n548 VSS.n547 0.237997
R1792 VSS.n564 VSS.n563 0.237997
R1793 VSS.n462 VSS.n461 0.234227
R1794 VSS.n924 VSS.n923 0.232997
R1795 VSS.n925 VSS.n924 0.231727
R1796 VSS.n463 VSS.n462 0.230497
R1797 VSS.n873 VSS.n869 0.224227
R1798 VSS.n854 VSS.n850 0.224227
R1799 VSS.n834 VSS.n830 0.224227
R1800 VSS.n815 VSS.n811 0.224227
R1801 VSS.n797 VSS.n793 0.224227
R1802 VSS.n780 VSS.n776 0.224227
R1803 VSS.n762 VSS.n758 0.224227
R1804 VSS.n744 VSS.n740 0.224227
R1805 VSS.n726 VSS.n722 0.224227
R1806 VSS.n706 VSS.n702 0.224227
R1807 VSS.n688 VSS.n684 0.224227
R1808 VSS.n670 VSS.n666 0.224227
R1809 VSS.n651 VSS.n647 0.224227
R1810 VSS.n633 VSS.n629 0.224227
R1811 VSS.n613 VSS.n609 0.224227
R1812 VSS.n592 VSS.n588 0.224227
R1813 VSS.n470 VSS.n469 0.219227
R1814 VSS.n895 VSS.n894 0.21012
R1815 VSS.n891 VSS.n889 0.21012
R1816 VSS.n388 VSS.n387 0.206787
R1817 VSS.n919 VSS.n918 0.201058
R1818 VSS.n457 VSS.n456 0.200293
R1819 VSS.n929 VSS.n928 0.191727
R1820 VSS.n467 VSS.n466 0.190497
R1821 VSS.n879 VSS.n878 0.186138
R1822 VSS.n859 VSS.n858 0.186138
R1823 VSS.n840 VSS.n839 0.186138
R1824 VSS.n821 VSS.n820 0.186138
R1825 VSS.n803 VSS.n802 0.186138
R1826 VSS.n785 VSS.n784 0.186138
R1827 VSS.n767 VSS.n766 0.186138
R1828 VSS.n749 VSS.n748 0.186138
R1829 VSS.n731 VSS.n730 0.186138
R1830 VSS.n713 VSS.n712 0.186138
R1831 VSS.n693 VSS.n692 0.186138
R1832 VSS.n675 VSS.n674 0.186138
R1833 VSS.n657 VSS.n656 0.186138
R1834 VSS.n639 VSS.n638 0.186138
R1835 VSS.n619 VSS.n618 0.186138
R1836 VSS.n599 VSS.n598 0.186138
R1837 VSS.n475 VSS.n474 0.1833
R1838 VSS.n898 VSS.n897 0.179043
R1839 VSS.n383 VSS.n144 0.177116
R1840 VSS.n933 VSS.n932 0.167388
R1841 VSS.n147 VSS.n143 0.16705
R1842 VSS.n485 VSS.n484 0.166269
R1843 VSS.n501 VSS.n500 0.166269
R1844 VSS.n516 VSS.n515 0.166269
R1845 VSS.n539 VSS.n538 0.166269
R1846 VSS.n555 VSS.n554 0.166269
R1847 VSS.n570 VSS.n569 0.166269
R1848 VSS.n474 VSS.n473 0.164888
R1849 VSS.n881 VSS.n210 0.16205
R1850 VSS.n870 VSS.n208 0.16205
R1851 VSS.n860 VSS.n206 0.16205
R1852 VSS.n851 VSS.n204 0.16205
R1853 VSS.n842 VSS.n202 0.16205
R1854 VSS.n831 VSS.n200 0.16205
R1855 VSS.n822 VSS.n198 0.16205
R1856 VSS.n812 VSS.n196 0.16205
R1857 VSS.n804 VSS.n194 0.16205
R1858 VSS.n794 VSS.n192 0.16205
R1859 VSS.n786 VSS.n190 0.16205
R1860 VSS.n777 VSS.n188 0.16205
R1861 VSS.n768 VSS.n186 0.16205
R1862 VSS.n759 VSS.n184 0.16205
R1863 VSS.n750 VSS.n182 0.16205
R1864 VSS.n741 VSS.n180 0.16205
R1865 VSS.n732 VSS.n178 0.16205
R1866 VSS.n723 VSS.n176 0.16205
R1867 VSS.n714 VSS.n174 0.16205
R1868 VSS.n703 VSS.n172 0.16205
R1869 VSS.n694 VSS.n170 0.16205
R1870 VSS.n685 VSS.n168 0.16205
R1871 VSS.n676 VSS.n166 0.16205
R1872 VSS.n667 VSS.n164 0.16205
R1873 VSS.n659 VSS.n162 0.16205
R1874 VSS.n648 VSS.n160 0.16205
R1875 VSS.n640 VSS.n158 0.16205
R1876 VSS.n630 VSS.n156 0.16205
R1877 VSS.n621 VSS.n154 0.16205
R1878 VSS.n610 VSS.n152 0.16205
R1879 VSS.n601 VSS.n150 0.16205
R1880 VSS.n589 VSS.n148 0.16205
R1881 VSS.n915 VSS.n913 0.16137
R1882 VSS.n915 VSS.n92 0.16137
R1883 VSS.n915 VSS.n94 0.16137
R1884 VSS.n898 VSS.n887 0.161058
R1885 VSS.n456 VSS.n455 0.161058
R1886 VSS.n918 VSS.n917 0.160293
R1887 VSS.n869 VSS.n223 0.15705
R1888 VSS.n850 VSS.n235 0.15705
R1889 VSS.n830 VSS.n244 0.15705
R1890 VSS.n811 VSS.n254 0.15705
R1891 VSS.n793 VSS.n265 0.15705
R1892 VSS.n776 VSS.n276 0.15705
R1893 VSS.n758 VSS.n286 0.15705
R1894 VSS.n740 VSS.n296 0.15705
R1895 VSS.n722 VSS.n308 0.15705
R1896 VSS.n702 VSS.n317 0.15705
R1897 VSS.n684 VSS.n328 0.15705
R1898 VSS.n666 VSS.n341 0.15705
R1899 VSS.n647 VSS.n350 0.15705
R1900 VSS.n629 VSS.n361 0.15705
R1901 VSS.n609 VSS.n370 0.15705
R1902 VSS.n481 VSS.n444 0.155582
R1903 VSS.n441 VSS.n440 0.155582
R1904 VSS.n490 VSS.n438 0.155582
R1905 VSS.n497 VSS.n435 0.155582
R1906 VSS.n433 VSS.n432 0.155582
R1907 VSS.n506 VSS.n430 0.155582
R1908 VSS.n512 VSS.n427 0.155582
R1909 VSS.n423 VSS.n422 0.155582
R1910 VSS.n521 VSS.n420 0.155582
R1911 VSS.n535 VSS.n416 0.155582
R1912 VSS.n413 VSS.n412 0.155582
R1913 VSS.n544 VSS.n410 0.155582
R1914 VSS.n551 VSS.n407 0.155582
R1915 VSS.n405 VSS.n404 0.155582
R1916 VSS.n560 VSS.n402 0.155582
R1917 VSS.n566 VSS.n399 0.155582
R1918 VSS.n397 VSS.n396 0.155582
R1919 VSS.n393 VSS.n392 0.155582
R1920 VSS.n883 VSS.n879 0.1508
R1921 VSS.n862 VSS.n859 0.1508
R1922 VSS.n844 VSS.n840 0.1508
R1923 VSS.n824 VSS.n821 0.1508
R1924 VSS.n806 VSS.n803 0.1508
R1925 VSS.n788 VSS.n785 0.1508
R1926 VSS.n770 VSS.n767 0.1508
R1927 VSS.n752 VSS.n749 0.1508
R1928 VSS.n734 VSS.n731 0.1508
R1929 VSS.n716 VSS.n713 0.1508
R1930 VSS.n696 VSS.n693 0.1508
R1931 VSS.n678 VSS.n675 0.1508
R1932 VSS.n661 VSS.n657 0.1508
R1933 VSS.n642 VSS.n639 0.1508
R1934 VSS.n623 VSS.n619 0.1508
R1935 VSS.n603 VSS.n599 0.1508
R1936 VSS.n464 VSS.n463 0.149888
R1937 VSS.n926 VSS.n925 0.14955
R1938 VSS.n479 VSS.n453 0.149476
R1939 VSS.n483 VSS.n482 0.149476
R1940 VSS.n487 VSS.n439 0.149476
R1941 VSS.n494 VSS.n437 0.149476
R1942 VSS.n499 VSS.n498 0.149476
R1943 VSS.n503 VSS.n431 0.149476
R1944 VSS.n510 VSS.n429 0.149476
R1945 VSS.n514 VSS.n513 0.149476
R1946 VSS.n518 VSS.n421 0.149476
R1947 VSS.n533 VSS.n419 0.149476
R1948 VSS.n537 VSS.n536 0.149476
R1949 VSS.n541 VSS.n411 0.149476
R1950 VSS.n548 VSS.n409 0.149476
R1951 VSS.n553 VSS.n552 0.149476
R1952 VSS.n557 VSS.n403 0.149476
R1953 VSS.n564 VSS.n401 0.149476
R1954 VSS.n568 VSS.n567 0.149476
R1955 VSS.n572 VSS.n395 0.149476
R1956 VSS.n902 VSS.n901 0.148577
R1957 VSS.n923 VSS.n922 0.147388
R1958 VSS.n461 VSS.n460 0.14705
R1959 VSS.n930 VSS.n929 0.142118
R1960 VSS.n468 VSS.n467 0.142118
R1961 VSS.n388 VSS.n386 0.141022
R1962 VSS.n472 VSS.n471 0.134888
R1963 VSS.n528 VSS.n527 0.134888
R1964 VSS.n481 VSS.n480 0.129618
R1965 VSS.n497 VSS.n496 0.129618
R1966 VSS.n512 VSS.n511 0.129618
R1967 VSS.n535 VSS.n534 0.129618
R1968 VSS.n551 VSS.n550 0.129618
R1969 VSS.n566 VSS.n565 0.129618
R1970 VSS.n386 VSS.n385 0.127569
R1971 VSS.n484 VSS.n443 0.126138
R1972 VSS.n500 VSS.n434 0.126138
R1973 VSS.n515 VSS.n426 0.126138
R1974 VSS.n538 VSS.n415 0.126138
R1975 VSS.n554 VSS.n406 0.126138
R1976 VSS.n569 VSS.n398 0.126138
R1977 VSS.n887 VSS.n884 0.125868
R1978 VSS.n864 VSS.n863 0.125868
R1979 VSS.n846 VSS.n845 0.125868
R1980 VSS.n826 VSS.n825 0.125868
R1981 VSS.n808 VSS.n807 0.125868
R1982 VSS.n790 VSS.n789 0.125868
R1983 VSS.n772 VSS.n771 0.125868
R1984 VSS.n754 VSS.n753 0.125868
R1985 VSS.n736 VSS.n735 0.125868
R1986 VSS.n718 VSS.n717 0.125868
R1987 VSS.n698 VSS.n697 0.125868
R1988 VSS.n680 VSS.n679 0.125868
R1989 VSS.n663 VSS.n662 0.125868
R1990 VSS.n644 VSS.n643 0.125868
R1991 VSS.n625 VSS.n624 0.125868
R1992 VSS.n605 VSS.n604 0.125868
R1993 VSS.n67 VSS.n445 0.156005
R1994 VSS.n70 VSS.n436 0.156005
R1995 VSS.n73 VSS.n428 0.156005
R1996 VSS.n76 VSS.n417 0.156005
R1997 VSS.n79 VSS.n408 0.156005
R1998 VSS.n82 VSS.n400 0.156005
R1999 VSS.n582 VSS.n146 0.124618
R2000 VSS.n932 VSS.n931 0.12455
R2001 VSS.n576 VSS.n146 0.122118
R2002 VSS.n473 VSS.n472 0.12205
R2003 VSS.n490 VSS.n489 0.12205
R2004 VSS.n506 VSS.n505 0.12205
R2005 VSS.n521 VSS.n520 0.12205
R2006 VSS.n529 VSS.n528 0.12205
R2007 VSS.n544 VSS.n543 0.12205
R2008 VSS.n560 VSS.n559 0.12205
R2009 VSS.n394 VSS.n393 0.12205
R2010 VSS.n210 VSS.n209 0.119888
R2011 VSS.n208 VSS.n207 0.119888
R2012 VSS.n206 VSS.n205 0.119888
R2013 VSS.n204 VSS.n203 0.119888
R2014 VSS.n202 VSS.n201 0.119888
R2015 VSS.n200 VSS.n199 0.119888
R2016 VSS.n198 VSS.n197 0.119888
R2017 VSS.n196 VSS.n195 0.119888
R2018 VSS.n194 VSS.n193 0.119888
R2019 VSS.n192 VSS.n191 0.119888
R2020 VSS.n190 VSS.n189 0.119888
R2021 VSS.n188 VSS.n187 0.119888
R2022 VSS.n186 VSS.n185 0.119888
R2023 VSS.n184 VSS.n183 0.119888
R2024 VSS.n182 VSS.n181 0.119888
R2025 VSS.n180 VSS.n179 0.119888
R2026 VSS.n178 VSS.n177 0.119888
R2027 VSS.n176 VSS.n175 0.119888
R2028 VSS.n174 VSS.n173 0.119888
R2029 VSS.n172 VSS.n171 0.119888
R2030 VSS.n170 VSS.n169 0.119888
R2031 VSS.n168 VSS.n167 0.119888
R2032 VSS.n166 VSS.n165 0.119888
R2033 VSS.n164 VSS.n163 0.119888
R2034 VSS.n162 VSS.n161 0.119888
R2035 VSS.n160 VSS.n159 0.119888
R2036 VSS.n158 VSS.n157 0.119888
R2037 VSS.n156 VSS.n155 0.119888
R2038 VSS.n154 VSS.n153 0.119888
R2039 VSS.n152 VSS.n151 0.119888
R2040 VSS.n150 VSS.n149 0.119888
R2041 VSS.n148 VSS.n147 0.119888
R2042 VSS.n582 VSS.n143 0.114888
R2043 VSS.n931 VSS.n930 0.114618
R2044 VSS.n469 VSS.n468 0.114618
R2045 VSS.n863 VSS.n223 0.113638
R2046 VSS.n845 VSS.n235 0.113638
R2047 VSS.n825 VSS.n244 0.113638
R2048 VSS.n807 VSS.n254 0.113638
R2049 VSS.n789 VSS.n265 0.113638
R2050 VSS.n771 VSS.n276 0.113638
R2051 VSS.n753 VSS.n286 0.113638
R2052 VSS.n735 VSS.n296 0.113638
R2053 VSS.n717 VSS.n308 0.113638
R2054 VSS.n697 VSS.n317 0.113638
R2055 VSS.n679 VSS.n328 0.113638
R2056 VSS.n662 VSS.n341 0.113638
R2057 VSS.n643 VSS.n350 0.113638
R2058 VSS.n624 VSS.n361 0.113638
R2059 VSS.n604 VSS.n370 0.113638
R2060 VSS.n460 VSS.n459 0.109888
R2061 VSS.n922 VSS.n921 0.10955
R2062 VSS.n927 VSS.n926 0.107388
R2063 VSS.n465 VSS.n464 0.10705
R2064 VSS.n489 VSS.n488 0.106138
R2065 VSS.n505 VSS.n504 0.106138
R2066 VSS.n520 VSS.n519 0.106138
R2067 VSS.n543 VSS.n542 0.106138
R2068 VSS.n559 VSS.n558 0.106138
R2069 VSS.n573 VSS.n394 0.106138
R2070 VSS.n487 VSS.n486 0.105361
R2071 VSS.n503 VSS.n502 0.105361
R2072 VSS.n518 VSS.n517 0.105361
R2073 VSS.n541 VSS.n540 0.105361
R2074 VSS.n557 VSS.n556 0.105361
R2075 VSS.n572 VSS.n571 0.105361
R2076 VSS.n443 VSS.n441 0.10205
R2077 VSS.n434 VSS.n433 0.10205
R2078 VSS.n426 VSS.n423 0.10205
R2079 VSS.n415 VSS.n413 0.10205
R2080 VSS.n406 VSS.n405 0.10205
R2081 VSS.n398 VSS.n397 0.10205
R2082 VSS.n480 VSS.n445 0.0983676
R2083 VSS.n496 VSS.n436 0.0983676
R2084 VSS.n511 VSS.n428 0.0983676
R2085 VSS.n534 VSS.n417 0.0983676
R2086 VSS.n550 VSS.n408 0.0983676
R2087 VSS.n565 VSS.n400 0.0983676
R2088 VSS.n892 VSS.n891 0.094
R2089 VSS.n895 VSS.n892 0.094
R2090 VSS.n901 VSS.n212 0.08925
R2091 VSS.n884 VSS.n883 0.0883676
R2092 VSS.n864 VSS.n862 0.0883676
R2093 VSS.n846 VSS.n844 0.0883676
R2094 VSS.n826 VSS.n824 0.0883676
R2095 VSS.n808 VSS.n806 0.0883676
R2096 VSS.n790 VSS.n788 0.0883676
R2097 VSS.n772 VSS.n770 0.0883676
R2098 VSS.n754 VSS.n752 0.0883676
R2099 VSS.n736 VSS.n734 0.0883676
R2100 VSS.n718 VSS.n716 0.0883676
R2101 VSS.n698 VSS.n696 0.0883676
R2102 VSS.n680 VSS.n678 0.0883676
R2103 VSS.n663 VSS.n661 0.0883676
R2104 VSS.n644 VSS.n642 0.0883676
R2105 VSS.n625 VSS.n623 0.0883676
R2106 VSS.n605 VSS.n603 0.0883676
R2107 VSS.n585 VSS.n584 0.088
R2108 VSS.n488 VSS.n69 0.176279
R2109 VSS.n504 VSS.n72 0.176279
R2110 VSS.n519 VSS.n75 0.176279
R2111 VSS.n78 VSS.n541 0.0435295
R2112 VSS.n81 VSS.n557 0.0435295
R2113 VSS.n84 VSS.n572 0.0435295
R2114 VSS.n891 VSS.n890 0.0851154
R2115 VSS.n897 VSS.n895 0.0851154
R2116 VSS.n579 VSS.n575 0.0805
R2117 VSS.n917 VSS.n916 0.078
R2118 VSS.n455 VSS.n454 0.078
R2119 VSS.n383 VSS.n145 0.0771176
R2120 VSS.n890 VSS.n213 0.0746176
R2121 VSS.n888 VSS.n97 0.0746176
R2122 VSS.n578 VSS.n380 0.07425
R2123 VSS.n576 VSS.n145 0.0696176
R2124 VSS.n890 VSS.n214 0.06925
R2125 VSS.n888 VSS.n98 0.06925
R2126 VSS.n483 VSS.n68 0.103847
R2127 VSS.n499 VSS.n71 0.103847
R2128 VSS.n514 VSS.n74 0.103847
R2129 VSS.n537 VSS.n77 0.103847
R2130 VSS.n553 VSS.n80 0.103847
R2131 VSS.n568 VSS.n83 0.103847
R2132 VSS.n588 VSS.n379 0.06175
R2133 VSS.n893 VSS.n98 0.05925
R2134 VSS.n907 VSS.n905 0.05675
R2135 VSS.n904 VSS.n213 0.0546176
R2136 VSS.n901 VSS.n97 0.0546176
R2137 VSS.n570 VSS.n568 0.0543074
R2138 VSS.n555 VSS.n553 0.0543074
R2139 VSS.n539 VSS.n537 0.0543074
R2140 VSS.n516 VSS.n514 0.0543074
R2141 VSS.n501 VSS.n499 0.0543074
R2142 VSS.n485 VSS.n483 0.0543074
R2143 VSS.n74 VSS.n512 0.0180497
R2144 VSS.n77 VSS.n535 0.0180497
R2145 VSS.n581 VSS.n380 0.04925
R2146 VSS.n220 VSS.n219 0.048
R2147 VSS.n231 VSS.n230 0.048
R2148 VSS.n241 VSS.n240 0.048
R2149 VSS.n251 VSS.n250 0.048
R2150 VSS.n262 VSS.n261 0.048
R2151 VSS.n273 VSS.n272 0.048
R2152 VSS.n283 VSS.n282 0.048
R2153 VSS.n293 VSS.n292 0.048
R2154 VSS.n304 VSS.n303 0.048
R2155 VSS.n314 VSS.n313 0.048
R2156 VSS.n325 VSS.n324 0.048
R2157 VSS.n337 VSS.n336 0.048
R2158 VSS.n347 VSS.n346 0.048
R2159 VSS.n357 VSS.n356 0.048
R2160 VSS.n367 VSS.n366 0.048
R2161 VSS.n376 VSS.n375 0.048
R2162 VSS.n585 VSS.n581 0.04675
R2163 VSS.n872 VSS.n220 0.0405
R2164 VSS.n853 VSS.n231 0.0405
R2165 VSS.n833 VSS.n241 0.0405
R2166 VSS.n814 VSS.n251 0.0405
R2167 VSS.n796 VSS.n262 0.0405
R2168 VSS.n779 VSS.n273 0.0405
R2169 VSS.n761 VSS.n283 0.0405
R2170 VSS.n743 VSS.n293 0.0405
R2171 VSS.n725 VSS.n304 0.0405
R2172 VSS.n705 VSS.n314 0.0405
R2173 VSS.n687 VSS.n325 0.0405
R2174 VSS.n669 VSS.n337 0.0405
R2175 VSS.n650 VSS.n347 0.0405
R2176 VSS.n632 VSS.n357 0.0405
R2177 VSS.n612 VSS.n367 0.0405
R2178 VSS.n591 VSS.n376 0.0405
R2179 VSS.n916 VSS 0.038
R2180 VSS.n905 VSS.n904 0.033
R2181 VSS.n897 VSS.n896 0.033
R2182 VSS.n386 VSS.n382 0.02925
R2183 VSS.n896 VSS.n214 0.02675
R2184 VSS.n32 VSS.n30 0.00588067
R2185 VSS.n56 VSS.n21 0.00760728
R2186 VSS.n23 VSS.n22 0.00596634
R2187 VSS.t392 VSS.n36 212.157
R2188 VSS.n63 VSS.n34 0.00206574
R2189 VSS.n20 VSS.n18 0.00596633
R2190 VSS.n60 VSS.n18 0.00760728
R2191 VSS.n61 VSS.n0 0.00954671
R2192 VSS.n62 VSS.n0 0.00760728
R2193 VSS.n13 VSS.n6 0.023135
R2194 VSS.n13 VSS.n11 0.00760717
R2195 VSS.n579 VSS.n578 0.02175
R2196 VSS.n915 VSS.n914 0.0166972
R2197 VSS.n915 VSS.n89 0.0166972
R2198 VSS.n571 VSS.n397 0.0166107
R2199 VSS.n556 VSS.n405 0.0166107
R2200 VSS.n540 VSS.n413 0.0166107
R2201 VSS.n517 VSS.n423 0.0166107
R2202 VSS.n502 VSS.n433 0.0166107
R2203 VSS.n486 VSS.n441 0.0166107
R2204 VSS.n575 VSS.n382 0.0155
R2205 VSS.n906 VSS.n86 0.0112403
R2206 VSS.n933 VSS.n86 0.0095322
R2207 VSS.n915 VSS.n226 0.00938635
R2208 VSS.n915 VSS.n237 0.00938635
R2209 VSS.n915 VSS.n818 0.00937856
R2210 VSS.n915 VSS.n800 0.00937856
R2211 VSS.n915 VSS.n300 0.00937856
R2212 VSS.n915 VSS.n710 0.00937856
R2213 VSS.n915 VSS.n343 0.00937856
R2214 VSS.n915 VSS.n636 0.00937856
R2215 VSS.n915 VSS.n616 0.00937856
R2216 VSS.n915 VSS.n596 0.00937856
R2217 VSS.n915 VSS.n586 0.00937856
R2218 VSS.n915 VSS.n899 0.00937856
R2219 VSS.n915 VSS.n216 0.00937856
R2220 VSS.n915 VSS.n269 0.00937856
R2221 VSS.n915 VSS.n279 0.00937856
R2222 VSS.n915 VSS.n289 0.00937856
R2223 VSS.n915 VSS.n320 0.00937856
R2224 VSS.n915 VSS.n332 0.00937856
R2225 VSS.n584 VSS.n379 0.008
R2226 VSS.n907 VSS.n906 0.00675
R2227 VSS.n906 VSS.n212 0.00675
R2228 VSS.n1 VSS.n0 0.0025
R2229 VSS.n0 VSS.n18 0.0025
R2230 VSS.n19 VSS.n18 0.00292781
R2231 VSS.n51 VSS.n34 0.0025
R2232 VSS.n47 VSS.n34 0.00201811
R2233 VSS.n41 VSS.n40 0.00179957
R2234 VSS.n41 VSS.n39 0.00179957
R2235 VSS.n41 VSS.n38 0.00104691
R2236 VSS.n41 VSS.n37 0.00179957
R2237 VSS.n42 VSS.t284 229.441
R2238 VSS.n21 VSS.n26 0.00179957
R2239 VSS.n21 VSS.n27 0.00179957
R2240 VSS.n47 VSS.n46 0.00179957
R2241 VSS.n47 VSS.n45 0.00179957
R2242 VSS.n47 VSS.n44 0.00104691
R2243 VSS.n47 VSS.n43 0.00179957
R2244 VSS.n51 VSS.n50 0.00179957
R2245 VSS.n51 VSS.n49 0.00179957
R2246 VSS.n52 VSS.t251 402.185
R2247 VSS.n41 VSS.n32 0.00351876
R2248 VSS.n13 VSS.n8 0.00281833
R2249 VSS.n424 VSS.n34 0.00252007
R2250 VSS.n47 VSS.n22 0.0025
R2251 VSS.n22 VSS.n21 0.0025
R2252 VSS.n24 VSS.t279 148.827
R2253 VSS.n13 VSS.n9 0.00309914
R2254 VSS.n1 VSS.n4 0.00249124
R2255 VSS.n41 VSS.n25 0.00107219
R2256 VSS.n42 VSS.n21 0.00203791
R2257 VSS.n18 VSS.n15 0.00203791
R2258 VSS.n51 VSS.n48 0.00179957
R2259 VSS.n18 VSS.n16 0.00179957
R2260 VSS.n18 VSS.n17 0.00179957
R2261 VSS.n0 VSS.n53 0.00179957
R2262 VSS.n2 VSS.n442 469.784
R2263 a_3747_311.n0 a_3747_311.t2 52.0388
R2264 a_3747_311.t1 a_3747_311.n0 35.4491
R2265 a_3747_311.n0 a_3747_311.t3 33.5891
R2266 a_3747_311.t0 a_3747_311.t1 5.61942
R2267 a_3171_311.n0 a_3171_311.t2 51.8377
R2268 a_3171_311.n0 a_3171_311.t3 33.3881
R2269 a_3171_311.t1 a_3171_311.n0 31.8923
R2270 a_3171_311.t0 a_3171_311.t1 5.61777
R2271 a_2595_311.n0 a_2595_311.t2 51.6367
R2272 a_2595_311.n0 a_2595_311.t3 33.187
R2273 a_2595_311.t1 a_2595_311.n0 27.993
R2274 a_2595_311.t0 a_2595_311.t1 5.73018
R2275 a_3747_1047.n0 a_3747_1047.t2 38.0081
R2276 a_3747_1047.n0 a_3747_1047.t3 33.3957
R2277 a_3747_1047.n1 a_3747_1047.t4 33.3957
R2278 a_3747_1047.n2 a_3747_1047.t5 33.3957
R2279 a_3747_1047.n3 a_3747_1047.t6 33.3957
R2280 a_3747_1047.n4 a_3747_1047.t7 33.3957
R2281 a_3747_1047.n5 a_3747_1047.t8 33.3957
R2282 a_3747_1047.n6 a_3747_1047.t9 33.3957
R2283 a_3747_1047.t1 a_3747_1047.n6 23.2419
R2284 a_3747_1047.t0 a_3747_1047.t1 5.61942
R2285 a_3747_1047.n6 a_3747_1047.n5 4.61291
R2286 a_3747_1047.n5 a_3747_1047.n4 4.61291
R2287 a_3747_1047.n4 a_3747_1047.n3 4.61291
R2288 a_3747_1047.n3 a_3747_1047.n2 4.61291
R2289 a_3747_1047.n2 a_3747_1047.n1 4.61291
R2290 a_3747_1047.n1 a_3747_1047.n0 4.61291
R2291 a_3171_1047.n0 a_3171_1047.t2 37.8054
R2292 a_3171_1047.n0 a_3171_1047.t3 33.193
R2293 a_3171_1047.n1 a_3171_1047.t4 33.193
R2294 a_3171_1047.n2 a_3171_1047.t5 33.193
R2295 a_3171_1047.n3 a_3171_1047.t6 33.193
R2296 a_3171_1047.n4 a_3171_1047.t7 33.193
R2297 a_3171_1047.n5 a_3171_1047.t8 33.193
R2298 a_3171_1047.n6 a_3171_1047.t9 33.193
R2299 a_3171_1047.t1 a_3171_1047.n6 23.0313
R2300 a_3171_1047.t0 a_3171_1047.t1 5.61777
R2301 a_3171_1047.n6 a_3171_1047.n5 4.61291
R2302 a_3171_1047.n5 a_3171_1047.n4 4.61291
R2303 a_3171_1047.n4 a_3171_1047.n3 4.61291
R2304 a_3171_1047.n3 a_3171_1047.n2 4.61291
R2305 a_3171_1047.n2 a_3171_1047.n1 4.61291
R2306 a_3171_1047.n1 a_3171_1047.n0 4.61291
R2307 a_2595_1047.n0 a_2595_1047.t2 37.7691
R2308 a_2595_1047.n0 a_2595_1047.t3 33.1567
R2309 a_2595_1047.n1 a_2595_1047.t4 33.1567
R2310 a_2595_1047.n2 a_2595_1047.t5 33.1567
R2311 a_2595_1047.n3 a_2595_1047.t6 33.1567
R2312 a_2595_1047.n4 a_2595_1047.t7 33.1567
R2313 a_2595_1047.n5 a_2595_1047.t8 33.1567
R2314 a_2595_1047.n6 a_2595_1047.t9 33.1567
R2315 a_2595_1047.t1 a_2595_1047.n6 22.7941
R2316 a_2595_1047.t0 a_2595_1047.t1 5.65522
R2317 a_2595_1047.n6 a_2595_1047.n5 4.61291
R2318 a_2595_1047.n5 a_2595_1047.n4 4.61291
R2319 a_2595_1047.n4 a_2595_1047.n3 4.61291
R2320 a_2595_1047.n3 a_2595_1047.n2 4.61291
R2321 a_2595_1047.n2 a_2595_1047.n1 4.61291
R2322 a_2595_1047.n1 a_2595_1047.n0 4.61291
R2323 a_2019_1047.n0 a_2019_1047.t2 37.9701
R2324 a_2019_1047.n0 a_2019_1047.t3 33.3577
R2325 a_2019_1047.n1 a_2019_1047.t4 33.3577
R2326 a_2019_1047.n2 a_2019_1047.t5 33.3577
R2327 a_2019_1047.n3 a_2019_1047.t6 33.3577
R2328 a_2019_1047.n4 a_2019_1047.t7 33.3577
R2329 a_2019_1047.n5 a_2019_1047.t8 33.3577
R2330 a_2019_1047.t1 a_2019_1047.t9 22.5945
R2331 a_2019_1047.t0 a_2019_1047.t1 5.62052
R2332 a_2019_1047.t9 a_2019_1047.n5 4.61291
R2333 a_2019_1047.n5 a_2019_1047.n4 4.61291
R2334 a_2019_1047.n4 a_2019_1047.n3 4.61291
R2335 a_2019_1047.n3 a_2019_1047.n2 4.61291
R2336 a_2019_1047.n2 a_2019_1047.n1 4.61291
R2337 a_2019_1047.n1 a_2019_1047.n0 4.61291
C1105 MUX_OUT VSS 3.24058f
C1106 MUX_SEL4 VSS 1.60778f
C1107 MUX_SEL3 VSS 0.90686f
C1108 MUX_SEL2 VSS 1.81137f
C1109 MUX_SEL1 VSS 0.95076f
C1110 MUX_SEL0 VSS 1.55166f
C1111 DELAY_VBIASN VSS 12.41106f
C1112 DELAY_OUT_LAST VSS 0.39284f
C1113 DELAY_VBIASP VSS 4.13999f
C1114 DELAY_IN VSS 1.91954f
C1115 VDD VSS 46.2831f
C1116 a_26985_519# VSS 0.17928f ; **FLOATING
C1117 a_23945_519# VSS 0.17928f ; **FLOATING
C1118 a_20905_519# VSS 0.17928f ; **FLOATING
C1119 a_17865_519# VSS 0.17593f ; **FLOATING
C1120 a_16851_309# VSS 0.38699f ; **FLOATING
C1121 a_16108_289# VSS 3.85084f ; **FLOATING
C1122 a_15964_289# VSS 0.17613f ; **FLOATING
C1123 a_15765_463# VSS 0.36132f ; **FLOATING
C1124 a_14825_519# VSS 0.17928f ; **FLOATING
C1125 a_11785_519# VSS 0.17928f ; **FLOATING
C1126 a_8745_519# VSS 0.17928f ; **FLOATING
C1127 a_5731_289# VSS 3.39133f ; **FLOATING
C1128 a_2019_311# VSS 1.61601f ; **FLOATING
C1129 a_5705_519# VSS 0.17638f ; **FLOATING
C1130 a_3449_331# VSS 0.18478f ; **FLOATING
C1131 a_2873_331# VSS 0.18321f ; **FLOATING
C1132 a_2297_331# VSS 0.18321f ; **FLOATING
C1133 a_1721_331# VSS 0.17001f ; **FLOATING
C1134 a_1544_289# VSS 0.30014f ; **FLOATING
C1135 a_1256_289# VSS 0.84266f ; **FLOATING
C1136 a_27991_1008# VSS 0.18706f ; **FLOATING
C1137 a_27915_1044# VSS 0.10926f ; **FLOATING
C1138 a_27124_1008# VSS 0.17878f ; **FLOATING
C1139 a_27048_1044# VSS 0.12122f ; **FLOATING
C1140 a_26471_1008# VSS 0.18175f ; **FLOATING
C1141 a_26395_1044# VSS 0.11073f ; **FLOATING
C1142 a_25604_1008# VSS 0.18087f ; **FLOATING
C1143 a_25630_1044# VSS 0.34158f ; **FLOATING
C1144 a_25528_1044# VSS 0.12433f ; **FLOATING
C1145 a_24951_1008# VSS 0.18335f ; **FLOATING
C1146 a_24875_1044# VSS 0.11016f ; **FLOATING
C1147 a_24084_1008# VSS 0.17878f ; **FLOATING
C1148 a_24008_1044# VSS 0.12122f ; **FLOATING
C1149 a_23431_1008# VSS 0.18175f ; **FLOATING
C1150 a_23355_1044# VSS 0.11073f ; **FLOATING
C1151 a_22564_1008# VSS 0.18087f ; **FLOATING
C1152 a_22590_1044# VSS 0.33314f ; **FLOATING
C1153 a_22488_1044# VSS 0.12433f ; **FLOATING
C1154 a_21911_1008# VSS 0.18335f ; **FLOATING
C1155 a_21835_1044# VSS 0.11016f ; **FLOATING
C1156 a_21044_1008# VSS 0.17878f ; **FLOATING
C1157 a_20968_1044# VSS 0.12122f ; **FLOATING
C1158 a_20391_1008# VSS 0.18175f ; **FLOATING
C1159 a_20315_1044# VSS 0.11073f ; **FLOATING
C1160 a_19524_1008# VSS 0.18087f ; **FLOATING
C1161 a_19550_1044# VSS 0.33563f ; **FLOATING
C1162 a_19448_1044# VSS 0.12433f ; **FLOATING
C1163 a_18871_1008# VSS 0.18335f ; **FLOATING
C1164 a_18795_1044# VSS 0.11016f ; **FLOATING
C1165 a_18004_1008# VSS 0.17878f ; **FLOATING
C1166 a_17928_1044# VSS 0.12122f ; **FLOATING
C1167 a_17351_1008# VSS 0.18022f ; **FLOATING
C1168 a_17275_1044# VSS 0.10926f ; **FLOATING
C1169 a_16484_1008# VSS 0.18023f ; **FLOATING
C1170 a_16510_1044# VSS 0.28935f ; **FLOATING
C1171 a_16408_1044# VSS 0.1229f ; **FLOATING
C1172 a_15831_1008# VSS 0.17846f ; **FLOATING
C1173 a_15755_1044# VSS 0.10926f ; **FLOATING
C1174 a_14964_1008# VSS 0.17878f ; **FLOATING
C1175 a_14888_1044# VSS 0.12122f ; **FLOATING
C1176 a_14311_1008# VSS 0.18175f ; **FLOATING
C1177 a_14235_1044# VSS 0.11073f ; **FLOATING
C1178 a_13444_1008# VSS 0.18087f ; **FLOATING
C1179 a_13470_1044# VSS 0.30333f ; **FLOATING
C1180 a_13368_1044# VSS 0.12433f ; **FLOATING
C1181 a_12791_1008# VSS 0.18335f ; **FLOATING
C1182 a_12715_1044# VSS 0.11016f ; **FLOATING
C1183 a_11924_1008# VSS 0.17878f ; **FLOATING
C1184 a_11848_1044# VSS 0.12122f ; **FLOATING
C1185 a_11271_1008# VSS 0.18175f ; **FLOATING
C1186 a_11195_1044# VSS 0.11073f ; **FLOATING
C1187 a_10404_1008# VSS 0.18087f ; **FLOATING
C1188 a_10430_1044# VSS 0.31665f ; **FLOATING
C1189 a_10328_1044# VSS 0.12433f ; **FLOATING
C1190 a_9751_1008# VSS 0.18335f ; **FLOATING
C1191 a_9675_1044# VSS 0.11016f ; **FLOATING
C1192 a_8884_1008# VSS 0.17878f ; **FLOATING
C1193 a_8808_1044# VSS 0.12122f ; **FLOATING
C1194 a_8231_1008# VSS 0.18175f ; **FLOATING
C1195 a_8155_1044# VSS 0.11073f ; **FLOATING
C1196 a_7364_1008# VSS 0.18087f ; **FLOATING
C1197 a_7390_1044# VSS 0.31357f ; **FLOATING
C1198 a_7288_1044# VSS 0.12433f ; **FLOATING
C1199 a_6711_1008# VSS 0.18335f ; **FLOATING
C1200 a_6635_1044# VSS 0.11016f ; **FLOATING
C1201 a_5844_1008# VSS 0.17878f ; **FLOATING
C1202 a_5768_1044# VSS 0.12122f ; **FLOATING
C1203 a_5191_1008# VSS 0.18022f ; **FLOATING
C1204 a_5115_1044# VSS 0.10926f ; **FLOATING
C1205 a_4324_1008# VSS 0.18023f ; **FLOATING
C1206 a_4350_1044# VSS 0.26655f ; **FLOATING
C1207 a_4248_1044# VSS 0.12443f ; **FLOATING
C1208 a_27705_1044# VSS 0.25296f ; **FLOATING
C1209 a_26185_1044# VSS 0.23475f ; **FLOATING
C1210 a_24665_1044# VSS 0.25432f ; **FLOATING
C1211 a_23145_1044# VSS 0.23475f ; **FLOATING
C1212 a_21625_1044# VSS 0.25432f ; **FLOATING
C1213 a_20105_1044# VSS 0.23475f ; **FLOATING
C1214 a_18585_1044# VSS 0.25432f ; **FLOATING
C1215 a_17065_1044# VSS 0.23385f ; **FLOATING
C1216 a_15545_1044# VSS 0.25296f ; **FLOATING
C1217 a_14025_1044# VSS 0.23475f ; **FLOATING
C1218 a_12505_1044# VSS 0.25432f ; **FLOATING
C1219 a_10985_1044# VSS 0.23475f ; **FLOATING
C1220 a_9465_1044# VSS 0.25432f ; **FLOATING
C1221 a_7945_1044# VSS 0.23475f ; **FLOATING
C1222 a_6425_1044# VSS 0.25432f ; **FLOATING
C1223 a_4905_1044# VSS 0.23549f ; **FLOATING
C1224 a_4157_1313# VSS 0.32875f ; **FLOATING
C1225 a_3449_1395# VSS 0.18629f ; **FLOATING
C1226 a_2873_1395# VSS 0.18349f ; **FLOATING
C1227 a_2297_1395# VSS 0.18349f ; **FLOATING
C1228 a_1721_1395# VSS 0.17029f ; **FLOATING
C1229 a_1544_1044# VSS 0.29829f ; **FLOATING
C1230 a_1256_1044# VSS 0.82978f ; **FLOATING
C1231 a_27671_1842# VSS 0.01336f ; **FLOATING
C1232 a_26911_1842# VSS 0.01336f ; **FLOATING
C1233 a_26151_1842# VSS 0.01336f ; **FLOATING
C1234 a_25391_1842# VSS 0.01336f ; **FLOATING
C1235 a_24631_1842# VSS 0.01336f ; **FLOATING
C1236 a_23871_1842# VSS 0.01336f ; **FLOATING
C1237 a_23111_1842# VSS 0.01336f ; **FLOATING
C1238 a_22351_1842# VSS 0.01336f ; **FLOATING
C1239 a_21591_1842# VSS 0.01336f ; **FLOATING
C1240 a_20831_1842# VSS 0.01336f ; **FLOATING
C1241 a_20071_1842# VSS 0.01336f ; **FLOATING
C1242 a_19311_1842# VSS 0.01336f ; **FLOATING
C1243 a_18551_1842# VSS 0.01336f ; **FLOATING
C1244 a_17791_1842# VSS 0.01336f ; **FLOATING
C1245 a_17031_1842# VSS 0.01336f ; **FLOATING
C1246 a_16271_1842# VSS 0.01336f ; **FLOATING
C1247 a_15511_1842# VSS 0.01336f ; **FLOATING
C1248 a_14751_1842# VSS 0.01336f ; **FLOATING
C1249 a_13991_1842# VSS 0.01336f ; **FLOATING
C1250 a_13231_1842# VSS 0.01336f ; **FLOATING
C1251 a_12471_1842# VSS 0.01336f ; **FLOATING
C1252 a_11711_1842# VSS 0.01336f ; **FLOATING
C1253 a_10951_1842# VSS 0.01336f ; **FLOATING
C1254 a_10191_1842# VSS 0.01336f ; **FLOATING
C1255 a_9431_1842# VSS 0.01336f ; **FLOATING
C1256 a_8671_1842# VSS 0.01336f ; **FLOATING
C1257 a_7911_1842# VSS 0.01336f ; **FLOATING
C1258 a_7151_1842# VSS 0.01336f ; **FLOATING
C1259 a_6391_1842# VSS 0.01336f ; **FLOATING
C1260 a_5631_1842# VSS 0.01336f ; **FLOATING
C1261 a_4871_1842# VSS 0.01336f ; **FLOATING
C1262 a_4111_1842# VSS 0.0139f ; **FLOATING
C1263 a_27563_1842# VSS 0.51284f ; **FLOATING
C1264 a_27997_1842# VSS 0.6533f ; **FLOATING
C1265 a_27433_1842# VSS 0.45843f ; **FLOATING
C1266 a_26803_1842# VSS 0.50902f ; **FLOATING
C1267 a_27237_1842# VSS 0.93747f ; **FLOATING
C1268 a_26673_1842# VSS 0.45994f ; **FLOATING
C1269 a_26043_1842# VSS 0.51137f ; **FLOATING
C1270 a_26477_1842# VSS 0.96549f ; **FLOATING
C1271 a_25913_1842# VSS 0.46292f ; **FLOATING
C1272 a_25283_1842# VSS 0.50906f ; **FLOATING
C1273 a_25717_1842# VSS 0.87619f ; **FLOATING
C1274 a_25153_1842# VSS 0.45997f ; **FLOATING
C1275 a_24523_1842# VSS 0.51043f ; **FLOATING
C1276 a_24957_1842# VSS 0.97121f ; **FLOATING
C1277 a_24393_1842# VSS 0.45843f ; **FLOATING
C1278 a_23763_1842# VSS 0.50902f ; **FLOATING
C1279 a_24197_1842# VSS 0.93322f ; **FLOATING
C1280 a_23633_1842# VSS 0.45994f ; **FLOATING
C1281 a_23003_1842# VSS 0.51137f ; **FLOATING
C1282 a_23437_1842# VSS 0.96549f ; **FLOATING
C1283 a_22873_1842# VSS 0.46292f ; **FLOATING
C1284 a_22243_1842# VSS 0.50906f ; **FLOATING
C1285 a_22677_1842# VSS 0.87619f ; **FLOATING
C1286 a_22113_1842# VSS 0.45997f ; **FLOATING
C1287 a_21483_1842# VSS 0.51043f ; **FLOATING
C1288 a_21917_1842# VSS 0.97121f ; **FLOATING
C1289 a_21353_1842# VSS 0.45843f ; **FLOATING
C1290 a_20723_1842# VSS 0.50902f ; **FLOATING
C1291 a_21157_1842# VSS 0.93322f ; **FLOATING
C1292 a_20593_1842# VSS 0.45994f ; **FLOATING
C1293 a_19963_1842# VSS 0.51137f ; **FLOATING
C1294 a_20397_1842# VSS 0.96549f ; **FLOATING
C1295 a_19833_1842# VSS 0.46292f ; **FLOATING
C1296 a_19203_1842# VSS 0.50906f ; **FLOATING
C1297 a_19637_1842# VSS 0.87619f ; **FLOATING
C1298 a_19073_1842# VSS 0.45997f ; **FLOATING
C1299 a_18443_1842# VSS 0.51043f ; **FLOATING
C1300 a_18877_1842# VSS 0.97121f ; **FLOATING
C1301 a_18313_1842# VSS 0.45843f ; **FLOATING
C1302 a_17683_1842# VSS 0.50902f ; **FLOATING
C1303 a_18117_1842# VSS 0.93322f ; **FLOATING
C1304 a_17553_1842# VSS 0.45994f ; **FLOATING
C1305 a_16923_1842# VSS 0.51133f ; **FLOATING
C1306 a_17357_1842# VSS 0.96549f ; **FLOATING
C1307 a_16793_1842# VSS 0.46262f ; **FLOATING
C1308 a_16163_1842# VSS 0.50902f ; **FLOATING
C1309 a_16597_1842# VSS 0.87137f ; **FLOATING
C1310 a_16033_1842# VSS 0.45859f ; **FLOATING
C1311 a_15403_1842# VSS 0.51041f ; **FLOATING
C1312 a_15837_1842# VSS 0.9618f ; **FLOATING
C1313 a_15273_1842# VSS 0.45843f ; **FLOATING
C1314 a_14643_1842# VSS 0.50902f ; **FLOATING
C1315 a_15077_1842# VSS 0.93209f ; **FLOATING
C1316 a_14513_1842# VSS 0.45994f ; **FLOATING
C1317 a_13883_1842# VSS 0.51137f ; **FLOATING
C1318 a_14317_1842# VSS 0.96549f ; **FLOATING
C1319 a_13753_1842# VSS 0.46292f ; **FLOATING
C1320 a_13123_1842# VSS 0.50904f ; **FLOATING
C1321 a_13557_1842# VSS 0.87619f ; **FLOATING
C1322 a_12993_1842# VSS 0.45997f ; **FLOATING
C1323 a_12363_1842# VSS 0.51043f ; **FLOATING
C1324 a_12797_1842# VSS 0.96954f ; **FLOATING
C1325 a_12233_1842# VSS 0.45843f ; **FLOATING
C1326 a_11603_1842# VSS 0.50902f ; **FLOATING
C1327 a_12037_1842# VSS 0.93322f ; **FLOATING
C1328 a_11473_1842# VSS 0.45994f ; **FLOATING
C1329 a_10843_1842# VSS 0.51137f ; **FLOATING
C1330 a_11277_1842# VSS 0.96549f ; **FLOATING
C1331 a_10713_1842# VSS 0.46292f ; **FLOATING
C1332 a_10083_1842# VSS 0.50904f ; **FLOATING
C1333 a_10517_1842# VSS 0.87619f ; **FLOATING
C1334 a_9953_1842# VSS 0.45997f ; **FLOATING
C1335 a_9323_1842# VSS 0.51043f ; **FLOATING
C1336 a_9757_1842# VSS 0.96954f ; **FLOATING
C1337 a_9193_1842# VSS 0.45843f ; **FLOATING
C1338 a_8563_1842# VSS 0.50902f ; **FLOATING
C1339 a_8997_1842# VSS 0.93322f ; **FLOATING
C1340 a_8433_1842# VSS 0.45994f ; **FLOATING
C1341 a_7803_1842# VSS 0.51137f ; **FLOATING
C1342 a_8237_1842# VSS 0.96549f ; **FLOATING
C1343 a_7673_1842# VSS 0.46292f ; **FLOATING
C1344 a_7043_1842# VSS 0.50904f ; **FLOATING
C1345 a_7477_1842# VSS 0.87619f ; **FLOATING
C1346 a_6913_1842# VSS 0.45997f ; **FLOATING
C1347 a_6283_1842# VSS 0.51043f ; **FLOATING
C1348 a_6717_1842# VSS 0.96895f ; **FLOATING
C1349 a_6153_1842# VSS 0.45843f ; **FLOATING
C1350 a_5523_1842# VSS 0.50902f ; **FLOATING
C1351 a_5957_1842# VSS 0.93322f ; **FLOATING
C1352 a_5393_1842# VSS 0.45994f ; **FLOATING
C1353 a_4763_1842# VSS 0.51133f ; **FLOATING
C1354 a_5197_1842# VSS 0.96549f ; **FLOATING
C1355 a_4633_1842# VSS 0.4629f ; **FLOATING
C1356 a_4003_1842# VSS 0.58899f ; **FLOATING
C1357 a_4437_1842# VSS 0.87666f ; **FLOATING
C1358 a_2019_1047.t2 VSS 0.93017f ; **FLOATING
C1359 a_2019_1047.t3 VSS 0.70616f ; **FLOATING
C1360 a_2019_1047.n0 VSS 5.0083f ; **FLOATING
C1361 a_2019_1047.t4 VSS 0.70616f ; **FLOATING
C1362 a_2019_1047.n1 VSS 3.38825f ; **FLOATING
C1363 a_2019_1047.t5 VSS 0.70616f ; **FLOATING
C1364 a_2019_1047.n2 VSS 3.38825f ; **FLOATING
C1365 a_2019_1047.t6 VSS 0.70616f ; **FLOATING
C1366 a_2019_1047.n3 VSS 3.38825f ; **FLOATING
C1367 a_2019_1047.t7 VSS 0.70616f ; **FLOATING
C1368 a_2019_1047.n4 VSS 3.38825f ; **FLOATING
C1369 a_2019_1047.t8 VSS 0.70616f ; **FLOATING
C1370 a_2019_1047.n5 VSS 3.38825f ; **FLOATING
C1371 a_2019_1047.t9 VSS 5.45426f ; **FLOATING
C1372 a_2019_1047.t1 VSS 1.07246f ; **FLOATING
C1373 a_2019_1047.t0 VSS 0.30482f ; **FLOATING
C1374 a_2595_1047.t2 VSS 1.36702f ; **FLOATING
C1375 a_2595_1047.t3 VSS 1.02093f ; **FLOATING
C1376 a_2595_1047.n0 VSS 7.7612f ; **FLOATING
C1377 a_2595_1047.t4 VSS 1.02093f ; **FLOATING
C1378 a_2595_1047.n1 VSS 5.27337f ; **FLOATING
C1379 a_2595_1047.t5 VSS 1.02093f ; **FLOATING
C1380 a_2595_1047.n2 VSS 5.27337f ; **FLOATING
C1381 a_2595_1047.t6 VSS 1.02093f ; **FLOATING
C1382 a_2595_1047.n3 VSS 5.27337f ; **FLOATING
C1383 a_2595_1047.t7 VSS 1.02093f ; **FLOATING
C1384 a_2595_1047.n4 VSS 5.27337f ; **FLOATING
C1385 a_2595_1047.t8 VSS 1.02093f ; **FLOATING
C1386 a_2595_1047.n5 VSS 5.27337f ; **FLOATING
C1387 a_2595_1047.t9 VSS 1.02093f ; **FLOATING
C1388 a_2595_1047.n6 VSS 7.58543f ; **FLOATING
C1389 a_2595_1047.t1 VSS 1.75118f ; **FLOATING
C1390 a_2595_1047.t0 VSS 0.48227f ; **FLOATING
C1391 a_3171_1047.t2 VSS 1.38442f ; **FLOATING
C1392 a_3171_1047.t3 VSS 1.03733f ; **FLOATING
C1393 a_3171_1047.n0 VSS 7.77854f ; **FLOATING
C1394 a_3171_1047.t4 VSS 1.03733f ; **FLOATING
C1395 a_3171_1047.n1 VSS 5.28082f ; **FLOATING
C1396 a_3171_1047.t5 VSS 1.03733f ; **FLOATING
C1397 a_3171_1047.n2 VSS 5.28082f ; **FLOATING
C1398 a_3171_1047.t6 VSS 1.03733f ; **FLOATING
C1399 a_3171_1047.n3 VSS 5.28082f ; **FLOATING
C1400 a_3171_1047.t7 VSS 1.03733f ; **FLOATING
C1401 a_3171_1047.n4 VSS 5.28082f ; **FLOATING
C1402 a_3171_1047.t8 VSS 1.03733f ; **FLOATING
C1403 a_3171_1047.n5 VSS 5.28082f ; **FLOATING
C1404 a_3171_1047.t9 VSS 1.03733f ; **FLOATING
C1405 a_3171_1047.n6 VSS 7.68345f ; **FLOATING
C1406 a_3171_1047.t1 VSS 1.77026f ; **FLOATING
C1407 a_3171_1047.t0 VSS 0.48084f ; **FLOATING
C1408 a_3747_1047.t2 VSS 0.96886f ; **FLOATING
C1409 a_3747_1047.t3 VSS 0.73761f ; **FLOATING
C1410 a_3747_1047.n0 VSS 5.16753f ; **FLOATING
C1411 a_3747_1047.t4 VSS 0.73761f ; **FLOATING
C1412 a_3747_1047.n1 VSS 3.49318f ; **FLOATING
C1413 a_3747_1047.t5 VSS 0.73761f ; **FLOATING
C1414 a_3747_1047.n2 VSS 3.49318f ; **FLOATING
C1415 a_3747_1047.t6 VSS 0.73761f ; **FLOATING
C1416 a_3747_1047.n3 VSS 3.49318f ; **FLOATING
C1417 a_3747_1047.t7 VSS 0.73761f ; **FLOATING
C1418 a_3747_1047.n4 VSS 3.49318f ; **FLOATING
C1419 a_3747_1047.t8 VSS 0.73761f ; **FLOATING
C1420 a_3747_1047.n5 VSS 3.49318f ; **FLOATING
C1421 a_3747_1047.t9 VSS 0.73761f ; **FLOATING
C1422 a_3747_1047.n6 VSS 5.18696f ; **FLOATING
C1423 a_3747_1047.t1 VSS 1.18537f ; **FLOATING
C1424 a_3747_1047.t0 VSS 0.31338f ; **FLOATING
C1425 a_2595_311.t1 VSS 3.27037f ; **FLOATING
C1426 a_2595_311.t2 VSS 5.04145f ; **FLOATING
C1427 a_2595_311.t3 VSS 1.20632f ; **FLOATING
C1428 a_2595_311.n0 VSS 26.8668f ; **FLOATING
C1429 a_2595_311.t0 VSS 0.49572f ; **FLOATING
C1430 a_3171_311.t2 VSS 5.05009f ; **FLOATING
C1431 a_3171_311.t3 VSS 1.21149f ; **FLOATING
C1432 a_3171_311.n0 VSS 29.8499f ; **FLOATING
C1433 a_3171_311.t1 VSS 4.61154f ; **FLOATING
C1434 a_3171_311.t0 VSS 0.4973f ; **FLOATING
C1435 a_3747_311.t2 VSS 3.09203f ; **FLOATING
C1436 a_3747_311.t3 VSS 0.74422f ; **FLOATING
C1437 a_3747_311.n0 VSS 19.8885f ; **FLOATING
C1438 a_3747_311.t1 VSS 3.68893f ; **FLOATING
C1439 a_3747_311.t0 VSS 0.30537f ; **FLOATING
C1440 DELAY_VBIASP.n0 VSS 0.14465f ; **FLOATING
C1441 DELAY_VBIASP.t31 VSS 0.37042f ; **FLOATING
C1442 DELAY_VBIASP.t30 VSS 0.36213f ; **FLOATING
C1443 DELAY_VBIASP.n1 VSS 0.64895f ; **FLOATING
C1444 DELAY_VBIASP.t29 VSS 0.36213f ; **FLOATING
C1445 DELAY_VBIASP.n2 VSS 0.44908f ; **FLOATING
C1446 DELAY_VBIASP.t28 VSS 0.36213f ; **FLOATING
C1447 DELAY_VBIASP.n3 VSS 0.44908f ; **FLOATING
C1448 DELAY_VBIASP.t27 VSS 0.36213f ; **FLOATING
C1449 DELAY_VBIASP.n4 VSS 0.44908f ; **FLOATING
C1450 DELAY_VBIASP.t26 VSS 0.36213f ; **FLOATING
C1451 DELAY_VBIASP.n5 VSS 0.44908f ; **FLOATING
C1452 DELAY_VBIASP.t25 VSS 0.36213f ; **FLOATING
C1453 DELAY_VBIASP.n6 VSS 0.44908f ; **FLOATING
C1454 DELAY_VBIASP.t24 VSS 0.36213f ; **FLOATING
C1455 DELAY_VBIASP.n7 VSS 0.44908f ; **FLOATING
C1456 DELAY_VBIASP.t23 VSS 0.36213f ; **FLOATING
C1457 DELAY_VBIASP.n8 VSS 0.44908f ; **FLOATING
C1458 DELAY_VBIASP.t22 VSS 0.36213f ; **FLOATING
C1459 DELAY_VBIASP.n9 VSS 0.44908f ; **FLOATING
C1460 DELAY_VBIASP.t21 VSS 0.36213f ; **FLOATING
C1461 DELAY_VBIASP.n10 VSS 0.44908f ; **FLOATING
C1462 DELAY_VBIASP.t20 VSS 0.36213f ; **FLOATING
C1463 DELAY_VBIASP.n11 VSS 0.44908f ; **FLOATING
C1464 DELAY_VBIASP.t19 VSS 0.36213f ; **FLOATING
C1465 DELAY_VBIASP.n12 VSS 0.44908f ; **FLOATING
C1466 DELAY_VBIASP.t18 VSS 0.36213f ; **FLOATING
C1467 DELAY_VBIASP.n13 VSS 0.44908f ; **FLOATING
C1468 DELAY_VBIASP.t17 VSS 0.36213f ; **FLOATING
C1469 DELAY_VBIASP.n14 VSS 0.44908f ; **FLOATING
C1470 DELAY_VBIASP.t16 VSS 0.36213f ; **FLOATING
C1471 DELAY_VBIASP.n15 VSS 0.44908f ; **FLOATING
C1472 DELAY_VBIASP.t15 VSS 0.36213f ; **FLOATING
C1473 DELAY_VBIASP.n16 VSS 0.44908f ; **FLOATING
C1474 DELAY_VBIASP.t14 VSS 0.36213f ; **FLOATING
C1475 DELAY_VBIASP.n17 VSS 0.44908f ; **FLOATING
C1476 DELAY_VBIASP.t13 VSS 0.36213f ; **FLOATING
C1477 DELAY_VBIASP.n18 VSS 0.44908f ; **FLOATING
C1478 DELAY_VBIASP.t12 VSS 0.36213f ; **FLOATING
C1479 DELAY_VBIASP.n19 VSS 0.44908f ; **FLOATING
C1480 DELAY_VBIASP.t11 VSS 0.36213f ; **FLOATING
C1481 DELAY_VBIASP.n20 VSS 0.44908f ; **FLOATING
C1482 DELAY_VBIASP.t10 VSS 0.36213f ; **FLOATING
C1483 DELAY_VBIASP.n21 VSS 0.44908f ; **FLOATING
C1484 DELAY_VBIASP.t9 VSS 0.36213f ; **FLOATING
C1485 DELAY_VBIASP.n22 VSS 0.44908f ; **FLOATING
C1486 DELAY_VBIASP.t8 VSS 0.36213f ; **FLOATING
C1487 DELAY_VBIASP.n23 VSS 0.44908f ; **FLOATING
C1488 DELAY_VBIASP.t7 VSS 0.36213f ; **FLOATING
C1489 DELAY_VBIASP.n24 VSS 0.44908f ; **FLOATING
C1490 DELAY_VBIASP.t6 VSS 0.36213f ; **FLOATING
C1491 DELAY_VBIASP.n25 VSS 0.44908f ; **FLOATING
C1492 DELAY_VBIASP.t5 VSS 0.36213f ; **FLOATING
C1493 DELAY_VBIASP.n26 VSS 0.44908f ; **FLOATING
C1494 DELAY_VBIASP.t4 VSS 0.36213f ; **FLOATING
C1495 DELAY_VBIASP.n27 VSS 0.44908f ; **FLOATING
C1496 DELAY_VBIASP.t3 VSS 0.36213f ; **FLOATING
C1497 DELAY_VBIASP.n28 VSS 0.44908f ; **FLOATING
C1498 DELAY_VBIASP.t2 VSS 0.36213f ; **FLOATING
C1499 DELAY_VBIASP.n29 VSS 0.44908f ; **FLOATING
C1500 DELAY_VBIASP.t1 VSS 0.36213f ; **FLOATING
C1501 DELAY_VBIASP.n30 VSS 0.44908f ; **FLOATING
C1502 DELAY_VBIASP.t0 VSS 0.36213f ; **FLOATING
C1503 DELAY_VBIASN.n0 VSS 0.37703f ; **FLOATING
C1504 DELAY_VBIASN.t31 VSS 0.22492f ; **FLOATING
C1505 DELAY_VBIASN.t30 VSS 0.21832f ; **FLOATING
C1506 DELAY_VBIASN.n1 VSS 0.51667f ; **FLOATING
C1507 DELAY_VBIASN.t29 VSS 0.21832f ; **FLOATING
C1508 DELAY_VBIASN.n2 VSS 0.35838f ; **FLOATING
C1509 DELAY_VBIASN.t28 VSS 0.21832f ; **FLOATING
C1510 DELAY_VBIASN.n3 VSS 0.35838f ; **FLOATING
C1511 DELAY_VBIASN.t27 VSS 0.21832f ; **FLOATING
C1512 DELAY_VBIASN.n4 VSS 0.35838f ; **FLOATING
C1513 DELAY_VBIASN.t26 VSS 0.21832f ; **FLOATING
C1514 DELAY_VBIASN.n5 VSS 0.35838f ; **FLOATING
C1515 DELAY_VBIASN.t25 VSS 0.21832f ; **FLOATING
C1516 DELAY_VBIASN.n6 VSS 0.35838f ; **FLOATING
C1517 DELAY_VBIASN.t24 VSS 0.21832f ; **FLOATING
C1518 DELAY_VBIASN.n7 VSS 0.35838f ; **FLOATING
C1519 DELAY_VBIASN.t23 VSS 0.21832f ; **FLOATING
C1520 DELAY_VBIASN.n8 VSS 0.35838f ; **FLOATING
C1521 DELAY_VBIASN.t22 VSS 0.21832f ; **FLOATING
C1522 DELAY_VBIASN.n9 VSS 0.35838f ; **FLOATING
C1523 DELAY_VBIASN.t21 VSS 0.21832f ; **FLOATING
C1524 DELAY_VBIASN.n10 VSS 0.35838f ; **FLOATING
C1525 DELAY_VBIASN.t20 VSS 0.21832f ; **FLOATING
C1526 DELAY_VBIASN.n11 VSS 0.35838f ; **FLOATING
C1527 DELAY_VBIASN.t19 VSS 0.21832f ; **FLOATING
C1528 DELAY_VBIASN.n12 VSS 0.35838f ; **FLOATING
C1529 DELAY_VBIASN.t18 VSS 0.21832f ; **FLOATING
C1530 DELAY_VBIASN.n13 VSS 0.35838f ; **FLOATING
C1531 DELAY_VBIASN.t17 VSS 0.21832f ; **FLOATING
C1532 DELAY_VBIASN.n14 VSS 0.35838f ; **FLOATING
C1533 DELAY_VBIASN.t16 VSS 0.21832f ; **FLOATING
C1534 DELAY_VBIASN.n15 VSS 0.35838f ; **FLOATING
C1535 DELAY_VBIASN.t15 VSS 0.21832f ; **FLOATING
C1536 DELAY_VBIASN.n16 VSS 0.35838f ; **FLOATING
C1537 DELAY_VBIASN.t14 VSS 0.21832f ; **FLOATING
C1538 DELAY_VBIASN.n17 VSS 0.35838f ; **FLOATING
C1539 DELAY_VBIASN.t13 VSS 0.21832f ; **FLOATING
C1540 DELAY_VBIASN.n18 VSS 0.35838f ; **FLOATING
C1541 DELAY_VBIASN.t12 VSS 0.21832f ; **FLOATING
C1542 DELAY_VBIASN.n19 VSS 0.35838f ; **FLOATING
C1543 DELAY_VBIASN.t11 VSS 0.21832f ; **FLOATING
C1544 DELAY_VBIASN.n20 VSS 0.35838f ; **FLOATING
C1545 DELAY_VBIASN.t10 VSS 0.21832f ; **FLOATING
C1546 DELAY_VBIASN.n21 VSS 0.35838f ; **FLOATING
C1547 DELAY_VBIASN.t9 VSS 0.21832f ; **FLOATING
C1548 DELAY_VBIASN.n22 VSS 0.35838f ; **FLOATING
C1549 DELAY_VBIASN.t8 VSS 0.21832f ; **FLOATING
C1550 DELAY_VBIASN.n23 VSS 0.35838f ; **FLOATING
C1551 DELAY_VBIASN.t7 VSS 0.21832f ; **FLOATING
C1552 DELAY_VBIASN.n24 VSS 0.35838f ; **FLOATING
C1553 DELAY_VBIASN.t6 VSS 0.21832f ; **FLOATING
C1554 DELAY_VBIASN.n25 VSS 0.35838f ; **FLOATING
C1555 DELAY_VBIASN.t5 VSS 0.21832f ; **FLOATING
C1556 DELAY_VBIASN.n26 VSS 0.35838f ; **FLOATING
C1557 DELAY_VBIASN.t4 VSS 0.21832f ; **FLOATING
C1558 DELAY_VBIASN.n27 VSS 0.35838f ; **FLOATING
C1559 DELAY_VBIASN.t3 VSS 0.21832f ; **FLOATING
C1560 DELAY_VBIASN.n28 VSS 0.35838f ; **FLOATING
C1561 DELAY_VBIASN.t2 VSS 0.21832f ; **FLOATING
C1562 DELAY_VBIASN.n29 VSS 0.35838f ; **FLOATING
C1563 DELAY_VBIASN.t1 VSS 0.21832f ; **FLOATING
C1564 DELAY_VBIASN.n30 VSS 0.35838f ; **FLOATING
C1565 DELAY_VBIASN.t0 VSS 0.21832f ; **FLOATING
.ends
