* NGSPICE file created from hx_delay_line_with_mux.ext - technology: ihp-sg13g2

.subckt hx_delay_line_with_mux VSS VDD DELAY_OUT_LAST DELAY_IN MUX_SEL0 MUX_SEL1 MUX_OUT
+ MUX_SEL4 MUX_SEL2 MUX_SEL3 DELAY_VBIASN DELAY_VBIASP
X0 VDD a_4003_1842# a_4437_1842# VDD sg13_lv_pmos ad=0.2128p pd=1.5u as=0.3808p ps=2.92u w=1.12u l=0.13u
X1 VSS.t416 a_15077_1842# a_15545_1044# VSS.t415 sg13_lv_nmos ad=0.1665p pd=1.19u as=0.2516p ps=2.16u w=0.74u l=0.13u
X2 a_27915_1044# a_27705_1044# VDD VDD sg13_lv_pmos ad=0.2128p pd=1.5u as=0.252p ps=1.57u w=1.12u l=0.13u
X3 VSS.t264 VDD VSS.t262 VSS.t263 sg13_lv_nmos ad=79.8f pd=0.8u as=0 ps=0 w=0.42u l=1u
X4 a_10951_2470# a_10713_1842# a_10843_1842# VDD sg13_lv_pmos ad=0.2128p pd=1.5u as=0.3808p ps=2.92u w=1.12u l=0.2u
X5 VSS.t141 a_3171_1047.t7 a_11924_1008# VSS.t140 sg13_lv_nmos ad=0.2516p pd=2.16u as=0.2516p ps=2.16u w=0.74u l=0.13u
X6 VDD VSS.t572 VDD VDD sg13_lv_pmos ad=0.34p pd=2.68u as=0.30484n ps=1.54979m w=1u l=1u
X7 VSS.t153 a_1256_1044# a_2967_1395# VSS.t152 sg13_lv_nmos ad=0.1331p pd=1.12u as=0.1216p ps=1.02u w=0.64u l=0.13u
X8 VSS.t267 VDD VSS.t266 VSS.t265 sg13_lv_nmos ad=0.1428p pd=1.52u as=0 ps=0 w=0.42u l=1u
X9 a_25153_1842# a_24957_1842# VSS.t197 VSS.t196 sg13_lv_nmos ad=0.2516p pd=2.16u as=0.1406p ps=1.12u w=0.74u l=0.13u
X10 VDD VSS.t586 VDD VDD sg13_lv_pmos ad=0.34p pd=2.68u as=0 ps=0 w=1u l=1u
X11 a_25630_1044# a_2019_1047.t2 a_25528_1044# VSS.t210 sg13_lv_nmos ad=0.2516p pd=2.16u as=0.1406p ps=1.12u w=0.74u l=0.13u
X12 VDD DELAY_VBIASP.t11 a_19311_2470# VDD sg13_lv_pmos ad=0.3808p pd=2.92u as=0.2128p ps=1.5u w=1.12u l=0.6u
X13 a_16108_289# a_2019_311# a_16510_1044# VSS.t376 sg13_lv_nmos ad=0.2516p pd=2.16u as=0.2516p ps=2.16u w=0.74u l=0.13u
X14 VDD DELAY_VBIASP.t24 a_9431_2470# VDD sg13_lv_pmos ad=0.3808p pd=2.92u as=0.2128p ps=1.5u w=1.12u l=0.6u
X15 VSS.t332 VDD VSS.t331 VSS.t330 sg13_lv_nmos ad=0.1428p pd=1.52u as=0 ps=0 w=0.42u l=1u
X16 VDD DELAY_VBIASP.t6 a_23111_2470# VDD sg13_lv_pmos ad=0.3808p pd=2.92u as=0.2128p ps=1.5u w=1.12u l=0.6u
X17 a_7390_1044# a_8231_1008# a_8155_1044# VDD sg13_lv_pmos ad=0.3808p pd=2.92u as=0.2128p ps=1.5u w=1.12u l=0.13u
X18 VSS.t71 a_2595_311.t3 a_8745_519# VSS.t70 sg13_lv_nmos ad=0.2516p pd=2.16u as=0.2516p ps=2.16u w=0.74u l=0.13u
X19 a_17791_1842# a_17553_1842# a_17683_1842# VSS.t553 sg13_lv_nmos ad=0.1406p pd=1.12u as=0.2516p ps=2.16u w=0.74u l=0.2u
X20 VDD a_12037_1842# a_12505_1044# VDD sg13_lv_pmos ad=0.252p pd=1.57u as=0.3808p ps=2.92u w=1.12u l=0.13u
X21 a_16510_1044# a_2019_1047.t5 a_16408_1044# VSS.t87 sg13_lv_nmos ad=0.2516p pd=2.16u as=0.1406p ps=1.12u w=0.74u l=0.13u
X22 a_21591_1842# a_21353_1842# a_21483_1842# VSS.t168 sg13_lv_nmos ad=0.1406p pd=1.12u as=0.2516p ps=2.16u w=0.74u l=0.2u
X23 a_6153_1842# a_5957_1842# VSS.t171 VSS.t170 sg13_lv_nmos ad=0.2516p pd=2.16u as=0.1406p ps=1.12u w=0.74u l=0.13u
X24 VSS.t19 a_16163_1842# a_16597_1842# VSS.t18 sg13_lv_nmos ad=0.1406p pd=1.12u as=0.2516p ps=2.16u w=0.74u l=0.13u
X25 VSS.t135 a_3171_1047.t2 a_27124_1008# VSS.t134 sg13_lv_nmos ad=0.2516p pd=2.16u as=0.2516p ps=2.16u w=0.74u l=0.13u
X26 VDD a_11603_1842# a_12037_1842# VDD sg13_lv_pmos ad=0.2128p pd=1.5u as=0.3808p ps=2.92u w=1.12u l=0.13u
X27 VDD a_3171_311.t3 a_11785_519# VDD sg13_lv_pmos ad=0.3808p pd=2.92u as=0.3808p ps=2.92u w=1.12u l=0.13u
X28 a_24393_1842# a_24197_1842# VDD VDD sg13_lv_pmos ad=0.3808p pd=2.92u as=0.2128p ps=1.5u w=1.12u l=0.13u
X29 a_5731_289# a_2595_311.t3 a_7390_1044# VSS.t69 sg13_lv_nmos ad=0.2516p pd=2.16u as=0.2516p ps=2.16u w=0.74u l=0.13u
X30 a_10430_1044# a_2595_1047.t7 a_11195_1044# VSS.t46 sg13_lv_nmos ad=0.2516p pd=2.16u as=0.1406p ps=1.12u w=0.74u l=0.13u
X31 a_23355_1044# a_23145_1044# VSS.t199 VSS.t220 sg13_lv_nmos ad=0.1406p pd=1.12u as=0.1665p ps=1.19u w=0.74u l=0.13u
X32 VDD DELAY_VBIASP.t17 a_14751_2470# VDD sg13_lv_pmos ad=0.3808p pd=2.92u as=0.2128p ps=1.5u w=1.12u l=0.6u
X33 VSS.t437 DELAY_VBIASN.t23 a_10191_1842# VSS.t436 sg13_lv_nmos ad=0.2516p pd=2.16u as=0.1406p ps=1.12u w=0.74u l=0.6u
X34 VSS.t223 a_3747_1047.t4 a_21911_1008# VSS.t222 sg13_lv_nmos ad=0.2516p pd=2.16u as=0.2516p ps=2.16u w=0.74u l=0.13u
X35 VSS.t386 a_19963_1842# a_20397_1842# VSS.t385 sg13_lv_nmos ad=0.1406p pd=1.12u as=0.2516p ps=2.16u w=0.74u l=0.13u
X36 VDD DELAY_VBIASP.t31 a_4111_2470# VDD sg13_lv_pmos ad=0.3808p pd=2.92u as=0.2128p ps=1.5u w=1.12u l=0.6u
X37 a_10328_1044# a_9757_1842# VDD VDD sg13_lv_pmos ad=0.2128p pd=1.5u as=0.3808p ps=2.92u w=1.12u l=0.13u
X38 a_20968_1044# a_20397_1842# VSS.t420 VSS.t419 sg13_lv_nmos ad=0.1406p pd=1.12u as=0.2516p ps=2.16u w=0.74u l=0.13u
X39 a_22590_1044# a_22564_1008# a_22488_1044# VDD sg13_lv_pmos ad=0.3808p pd=2.92u as=0.2128p ps=1.5u w=1.12u l=0.13u
X40 VDD VSS.t589 VDD VDD sg13_lv_pmos ad=0.19p pd=1.38u as=0 ps=0 w=1u l=1u
X41 a_8808_1044# a_8237_1842# VDD VDD sg13_lv_pmos ad=0.2128p pd=1.5u as=0.3808p ps=2.92u w=1.12u l=0.13u
X42 a_4157_1313# DELAY_IN VDD VDD sg13_lv_pmos ad=0.3808p pd=2.92u as=0.3808p ps=2.92u w=1.12u l=0.13u
X43 a_17031_2470# a_16793_1842# a_16923_1842# VDD sg13_lv_pmos ad=0.2128p pd=1.5u as=0.3808p ps=2.92u w=1.12u l=0.2u
X44 a_11473_1842# a_11277_1842# VSS.t513 VSS.t512 sg13_lv_nmos ad=0.2516p pd=2.16u as=0.1406p ps=1.12u w=0.74u l=0.13u
X45 VSS.t324 VDD VSS.t322 VSS.t323 sg13_lv_nmos ad=79.8f pd=0.8u as=0 ps=0 w=0.42u l=1u
X46 a_19448_1044# a_18877_1842# VSS.t66 VSS.t65 sg13_lv_nmos ad=0.1406p pd=1.12u as=0.2516p ps=2.16u w=0.74u l=0.13u
X47 a_10430_1044# a_3171_1047.t7 a_11848_1044# VSS.t139 sg13_lv_nmos ad=0.2516p pd=2.16u as=0.1406p ps=1.12u w=0.74u l=0.13u
X48 a_20831_2470# a_20593_1842# a_20723_1842# VDD sg13_lv_pmos ad=0.2128p pd=1.5u as=0.3808p ps=2.92u w=1.12u l=0.2u
X49 VSS.t289 VDD VSS.t287 VSS.t288 sg13_lv_nmos ad=79.8f pd=0.8u as=0 ps=0 w=0.42u l=1u
X50 VDD a_27237_1842# a_27705_1044# VDD sg13_lv_pmos ad=0.252p pd=1.57u as=0.3808p ps=2.92u w=1.12u l=0.13u
X51 a_5393_1842# a_5197_1842# VDD VDD sg13_lv_pmos ad=0.3808p pd=2.92u as=0.2128p ps=1.5u w=1.12u l=0.13u
X52 VDD DELAY_VBIASP.t14 a_17031_2470# VDD sg13_lv_pmos ad=0.3808p pd=2.92u as=0.2128p ps=1.5u w=1.12u l=0.6u
X53 VDD a_26803_1842# a_27237_1842# VDD sg13_lv_pmos ad=0.2128p pd=1.5u as=0.3808p ps=2.92u w=1.12u l=0.13u
X54 VDD MUX_SEL1 a_3449_1395# VDD sg13_lv_pmos ad=0.1918p pd=1.5u as=0.1596p ps=1.22u w=0.84u l=0.13u
X55 a_25630_1044# a_2595_1047.t2 a_26395_1044# VSS.t20 sg13_lv_nmos ad=0.2516p pd=2.16u as=0.1406p ps=1.12u w=0.74u l=0.13u
X56 VSS.t481 DELAY_VBIASN.t3 a_25391_1842# VSS.t480 sg13_lv_nmos ad=0.2516p pd=2.16u as=0.1406p ps=1.12u w=0.74u l=0.6u
X57 a_6635_1044# a_6425_1044# VDD VDD sg13_lv_pmos ad=0.2128p pd=1.5u as=0.252p ps=1.57u w=1.12u l=0.13u
X58 a_20315_1044# a_20105_1044# VDD VDD sg13_lv_pmos ad=0.2128p pd=1.5u as=0.252p ps=1.57u w=1.12u l=0.13u
X59 VDD a_2595_1047.t9 a_5191_1008# VDD sg13_lv_pmos ad=0.3808p pd=2.92u as=0.3808p ps=2.92u w=1.12u l=0.13u
X60 a_19311_2470# a_19073_1842# a_19203_1842# VDD sg13_lv_pmos ad=0.2128p pd=1.5u as=0.3808p ps=2.92u w=1.12u l=0.2u
X61 VSS.t52 a_1721_1395# a_2019_1047.t1 VSS.t51 sg13_lv_nmos ad=0.2812p pd=2.24u as=0.1406p ps=1.12u w=0.74u l=0.13u
X62 a_25528_1044# a_24957_1842# VDD VDD sg13_lv_pmos ad=0.2128p pd=1.5u as=0.3808p ps=2.92u w=1.12u l=0.13u
X63 VSS.t155 a_5957_1842# a_6425_1044# VSS.t169 sg13_lv_nmos ad=0.1665p pd=1.19u as=0.2516p ps=2.16u w=0.74u l=0.13u
X64 VSS.t535 a_2019_1047.t6 a_13444_1008# VSS.t534 sg13_lv_nmos ad=0.2516p pd=2.16u as=0.2516p ps=2.16u w=0.74u l=0.13u
X65 a_23111_2470# a_22873_1842# a_23003_1842# VDD sg13_lv_pmos ad=0.2128p pd=1.5u as=0.3808p ps=2.92u w=1.12u l=0.2u
X66 VSS.t262 VDD VSS.t261 VSS.t260 sg13_lv_nmos ad=0.1428p pd=1.52u as=0 ps=0 w=0.42u l=1u
X67 VSS.t77 a_15964_289# a_16851_309# VSS.t80 sg13_lv_nmos ad=0.1371p pd=1.12u as=0.2176p ps=1.96u w=0.64u l=0.13u
X68 a_10713_1842# a_10517_1842# VDD VDD sg13_lv_pmos ad=0.3808p pd=2.92u as=0.2128p ps=1.5u w=1.12u l=0.13u
X69 VDD a_17683_1842# a_18117_1842# VDD sg13_lv_pmos ad=0.2128p pd=1.5u as=0.3808p ps=2.92u w=1.12u l=0.13u
X70 a_16108_289# a_17865_519# a_16510_1044# VDD sg13_lv_pmos ad=0.3808p pd=2.92u as=0.3808p ps=2.92u w=1.12u l=0.13u
X71 a_26673_1842# a_26477_1842# VSS.t186 VSS.t185 sg13_lv_nmos ad=0.2516p pd=2.16u as=0.1406p ps=1.12u w=0.74u l=0.13u
X72 VDD a_7803_1842# a_8237_1842# VDD sg13_lv_pmos ad=0.2128p pd=1.5u as=0.3808p ps=2.92u w=1.12u l=0.13u
X73 a_4248_1044# a_4157_1313# VSS.t526 VSS.t525 sg13_lv_nmos ad=0.1406p pd=1.12u as=0.2516p ps=2.16u w=0.74u l=0.13u
X74 a_16108_289# a_3171_311.t2 a_22590_1044# VSS.t121 sg13_lv_nmos ad=0.2516p pd=2.16u as=0.2516p ps=2.16u w=0.74u l=0.13u
X75 VSS.t427 DELAY_VBIASN.t28 a_6391_1842# VSS.t426 sg13_lv_nmos ad=0.2516p pd=2.16u as=0.1406p ps=1.12u w=0.74u l=0.6u
X76 a_16408_1044# a_15837_1842# VDD VDD sg13_lv_pmos ad=0.2128p pd=1.5u as=0.3808p ps=2.92u w=1.12u l=0.13u
X77 a_19550_1044# a_3747_1047.t4 a_21835_1044# VSS.t221 sg13_lv_nmos ad=0.2516p pd=2.16u as=0.1406p ps=1.12u w=0.74u l=0.13u
X78 VSS.t453 DELAY_VBIASN.t9 a_20831_1842# VSS.t452 sg13_lv_nmos ad=0.2516p pd=2.16u as=0.1406p ps=1.12u w=0.74u l=0.6u
X79 a_3171_311.t0 a_2873_331# VDD VDD sg13_lv_pmos ad=0.2128p pd=1.5u as=0.1918p ps=1.5u w=1.12u l=0.13u
X80 a_3747_311.t0 a_3449_331# VDD VDD sg13_lv_pmos ad=0.2128p pd=1.5u as=0.1918p ps=1.5u w=1.12u l=0.13u
X81 a_7390_1044# a_9751_1008# a_9675_1044# VDD sg13_lv_pmos ad=0.3808p pd=2.92u as=0.2128p ps=1.5u w=1.12u l=0.13u
X82 a_10191_1842# a_9953_1842# a_10083_1842# VSS.t532 sg13_lv_nmos ad=0.1406p pd=1.12u as=0.2516p ps=2.16u w=0.74u l=0.2u
X83 VSS.t199 a_22677_1842# a_23145_1044# VSS.t198 sg13_lv_nmos ad=0.1665p pd=1.19u as=0.2516p ps=2.16u w=0.74u l=0.13u
X84 a_14751_2470# a_14513_1842# a_14643_1842# VDD sg13_lv_pmos ad=0.2128p pd=1.5u as=0.3808p ps=2.92u w=1.12u l=0.2u
X85 a_5731_289# a_8745_519# a_7390_1044# VDD sg13_lv_pmos ad=0.3808p pd=2.92u as=0.3808p ps=2.92u w=1.12u l=0.13u
X86 VDD VDD VDD VDD sg13_lv_pmos ad=0.2128p pd=1.5u as=0 ps=0 w=1.12u l=0.13u
X87 a_4111_2470# DELAY_IN a_4003_1842# VDD sg13_lv_pmos ad=0.2128p pd=1.5u as=0.3808p ps=2.92u w=1.12u l=0.2u
X88 a_7673_1842# a_7477_1842# VSS.t166 VSS.t247 sg13_lv_nmos ad=0.2516p pd=2.16u as=0.1406p ps=1.12u w=0.74u l=0.13u
X89 VDD a_3171_1047.t5 a_18004_1008# VDD sg13_lv_pmos ad=0.3808p pd=2.92u as=0.3808p ps=2.92u w=1.12u l=0.13u
X90 VDD a_13123_1842# a_13557_1842# VDD sg13_lv_pmos ad=0.2128p pd=1.5u as=0.3808p ps=2.92u w=1.12u l=0.13u
X91 VDD a_3747_311.t2 a_26985_519# VDD sg13_lv_pmos ad=0.3808p pd=2.92u as=0.3808p ps=2.92u w=1.12u l=0.13u
X92 a_25913_1842# a_25717_1842# VDD VDD sg13_lv_pmos ad=0.3808p pd=2.92u as=0.2128p ps=1.5u w=1.12u l=0.13u
X93 a_10430_1044# a_3747_1047.t7 a_12715_1044# VSS.t213 sg13_lv_nmos ad=0.2516p pd=2.16u as=0.1406p ps=1.12u w=0.74u l=0.13u
X94 a_14235_1044# a_14025_1044# VDD VDD sg13_lv_pmos ad=0.2128p pd=1.5u as=0.252p ps=1.57u w=1.12u l=0.13u
X95 a_24875_1044# a_24665_1044# VSS.t180 VSS.t179 sg13_lv_nmos ad=0.1406p pd=1.12u as=0.1665p ps=1.19u w=0.74u l=0.13u
X96 VSS.t449 DELAY_VBIASN.t21 a_11711_1842# VSS.t448 sg13_lv_nmos ad=0.2516p pd=2.16u as=0.1406p ps=1.12u w=0.74u l=0.6u
X97 VDD a_3747_1047.t7 a_12791_1008# VDD sg13_lv_pmos ad=0.3808p pd=2.92u as=0.3808p ps=2.92u w=1.12u l=0.13u
X98 VSS.t31 a_2595_1047.t3 a_23431_1008# VSS.t30 sg13_lv_nmos ad=0.2516p pd=2.16u as=0.2516p ps=2.16u w=0.74u l=0.13u
X99 VSS.t17 a_21483_1842# a_21917_1842# VSS.t16 sg13_lv_nmos ad=0.1406p pd=1.12u as=0.2516p ps=2.16u w=0.74u l=0.13u
X100 VSS.t204 a_13557_1842# a_14025_1044# VSS.t203 sg13_lv_nmos ad=0.1665p pd=1.19u as=0.2516p ps=2.16u w=0.74u l=0.13u
X101 a_11848_1044# a_11277_1842# VDD VDD sg13_lv_pmos ad=0.2128p pd=1.5u as=0.3808p ps=2.92u w=1.12u l=0.13u
X102 VDD VSS.t565 VDD VDD sg13_lv_pmos ad=0.19p pd=1.38u as=0 ps=0 w=1u l=1u
X103 a_25391_1842# a_25153_1842# a_25283_1842# VSS.t554 sg13_lv_nmos ad=0.1406p pd=1.12u as=0.2516p ps=2.16u w=0.74u l=0.2u
X104 a_12993_1842# a_12797_1842# VSS.t371 VSS.t390 sg13_lv_nmos ad=0.2516p pd=2.16u as=0.1406p ps=1.12u w=0.74u l=0.13u
X105 DELAY_OUT_LAST a_27997_1842# VDD VDD sg13_lv_pmos ad=0.3808p pd=2.92u as=0.2128p ps=1.5u w=1.12u l=0.13u
X106 VDD VSS.t564 VDD VDD sg13_lv_pmos ad=0.34p pd=2.68u as=0 ps=0 w=1u l=1u
X107 VDD a_19637_1842# a_20105_1044# VDD sg13_lv_pmos ad=0.252p pd=1.57u as=0.3808p ps=2.92u w=1.12u l=0.13u
X108 VSS.t461 DELAY_VBIASN.t18 a_13991_1842# VSS.t460 sg13_lv_nmos ad=0.2516p pd=2.16u as=0.1406p ps=1.12u w=0.74u l=0.6u
X109 VSS.t322 VDD VSS.t321 VSS.t320 sg13_lv_nmos ad=0.1428p pd=1.52u as=0 ps=0 w=0.42u l=1u
X110 a_22590_1044# a_3171_1047.t3 a_24008_1044# VSS.t3 sg13_lv_nmos ad=0.2516p pd=2.16u as=0.1406p ps=1.12u w=0.74u l=0.13u
X111 a_6913_1842# a_6717_1842# VDD VDD sg13_lv_pmos ad=0.3808p pd=2.92u as=0.2128p ps=1.5u w=1.12u l=0.13u
X112 VDD DELAY_VBIASP.t12 a_18551_2470# VDD sg13_lv_pmos ad=0.3808p pd=2.92u as=0.2128p ps=1.5u w=1.12u l=0.6u
X113 VSS.t401 a_23763_1842# a_24197_1842# VSS.t400 sg13_lv_nmos ad=0.1406p pd=1.12u as=0.2516p ps=2.16u w=0.74u l=0.13u
X114 VSS.t287 VDD VSS.t286 VSS.t285 sg13_lv_nmos ad=0.1428p pd=1.52u as=0 ps=0 w=0.42u l=1u
X115 VDD a_1256_1044# a_2873_1395# VDD sg13_lv_pmos ad=0.1918p pd=1.5u as=0.1596p ps=1.22u w=0.84u l=0.13u
X116 a_3171_311.t1 a_2873_331# VSS.t95 VSS.t94 sg13_lv_nmos ad=0.1406p pd=1.12u as=0.1331p ps=1.12u w=0.74u l=0.13u
X117 VDD a_2873_331# a_3171_311.t0 VDD sg13_lv_pmos ad=0.4256p pd=3u as=0.2128p ps=1.5u w=1.12u l=0.13u
X118 a_16510_1044# a_17351_1008# a_17275_1044# VDD sg13_lv_pmos ad=0.3808p pd=2.92u as=0.2128p ps=1.5u w=1.12u l=0.13u
X119 a_25630_1044# a_3747_1047.t2 a_27915_1044# VSS.t148 sg13_lv_nmos ad=0.2516p pd=2.16u as=0.1406p ps=1.12u w=0.74u l=0.13u
X120 VSS.t485 DELAY_VBIASN.t1 a_26911_1842# VSS.t484 sg13_lv_nmos ad=0.2516p pd=2.16u as=0.1406p ps=1.12u w=0.74u l=0.6u
X121 a_3747_311.t1 a_3449_331# VSS.t91 VSS.t90 sg13_lv_nmos ad=0.1406p pd=1.12u as=0.1331p ps=1.12u w=0.74u l=0.13u
X122 VDD a_3449_331# a_3747_311.t0 VDD sg13_lv_pmos ad=0.4256p pd=3u as=0.2128p ps=1.5u w=1.12u l=0.13u
X123 VDD DELAY_VBIASP.t7 a_22351_2470# VDD sg13_lv_pmos ad=0.3808p pd=2.92u as=0.2128p ps=1.5u w=1.12u l=0.6u
X124 VDD a_3747_1047.t2 a_27991_1008# VDD sg13_lv_pmos ad=0.3808p pd=2.92u as=0.3808p ps=2.92u w=1.12u l=0.13u
X125 VDD VSS.t597 VDD VDD sg13_lv_pmos ad=0.19p pd=1.38u as=0 ps=0 w=1u l=1u
X126 VDD a_3747_1047.t9 a_6711_1008# VDD sg13_lv_pmos ad=0.3808p pd=2.92u as=0.3808p ps=2.92u w=1.12u l=0.13u
X127 a_6391_1842# a_6153_1842# a_6283_1842# VSS.t516 sg13_lv_nmos ad=0.1406p pd=1.12u as=0.2516p ps=2.16u w=0.74u l=0.2u
X128 a_15273_1842# a_15077_1842# VSS.t40 VSS.t414 sg13_lv_nmos ad=0.2516p pd=2.16u as=0.1406p ps=1.12u w=0.74u l=0.13u
X129 a_19833_1842# a_19637_1842# VDD VDD sg13_lv_pmos ad=0.3808p pd=2.92u as=0.2128p ps=1.5u w=1.12u l=0.13u
X130 a_16108_289# a_23945_519# a_22590_1044# VDD sg13_lv_pmos ad=0.3808p pd=2.92u as=0.3808p ps=2.92u w=1.12u l=0.13u
X131 a_9193_1842# a_8997_1842# VDD VDD sg13_lv_pmos ad=0.3808p pd=2.92u as=0.2128p ps=1.5u w=1.12u l=0.13u
X132 a_24631_2470# a_24393_1842# a_24523_1842# VDD sg13_lv_pmos ad=0.2128p pd=1.5u as=0.3808p ps=2.92u w=1.12u l=0.2u
X133 VSS.t54 a_15403_1842# a_15837_1842# VSS.t53 sg13_lv_nmos ad=0.1406p pd=1.12u as=0.2516p ps=2.16u w=0.74u l=0.13u
X134 a_8155_1044# a_7945_1044# VSS.t249 VSS.t547 sg13_lv_nmos ad=0.1406p pd=1.12u as=0.1665p ps=1.19u w=0.74u l=0.13u
X135 a_23633_1842# a_23437_1842# VDD VDD sg13_lv_pmos ad=0.3808p pd=2.92u as=0.2128p ps=1.5u w=1.12u l=0.13u
X136 VSS.t106 a_4763_1842# a_5197_1842# VSS.t490 sg13_lv_nmos ad=0.1406p pd=1.12u as=0.2516p ps=2.16u w=0.74u l=0.13u
X137 a_27048_1044# a_26477_1842# VSS.t184 VSS.t183 sg13_lv_nmos ad=0.1406p pd=1.12u as=0.2516p ps=2.16u w=0.74u l=0.13u
X138 VDD a_9323_1842# a_9757_1842# VDD sg13_lv_pmos ad=0.2128p pd=1.5u as=0.3808p ps=2.92u w=1.12u l=0.13u
X139 a_5768_1044# a_5197_1842# VSS.t108 VSS.t107 sg13_lv_nmos ad=0.1406p pd=1.12u as=0.2516p ps=2.16u w=0.74u l=0.13u
X140 a_7390_1044# a_7364_1008# a_7288_1044# VDD sg13_lv_pmos ad=0.3808p pd=2.92u as=0.2128p ps=1.5u w=1.12u l=0.13u
X141 VSS.t439 DELAY_VBIASN.t26 a_7911_1842# VSS.t438 sg13_lv_nmos ad=0.2516p pd=2.16u as=0.1406p ps=1.12u w=0.74u l=0.6u
X142 VDD VSS.t581 VDD VDD sg13_lv_pmos ad=0.19p pd=1.38u as=0 ps=0 w=1u l=1u
X143 a_11711_1842# a_11473_1842# a_11603_1842# VSS.t387 sg13_lv_nmos ad=0.1406p pd=1.12u as=0.2516p ps=2.16u w=0.74u l=0.2u
X144 VSS.t180 a_24197_1842# a_24665_1044# VSS.t523 sg13_lv_nmos ad=0.1665p pd=1.19u as=0.2516p ps=2.16u w=0.74u l=0.13u
X145 a_16510_1044# a_3171_1047.t5 a_17928_1044# VSS.t124 sg13_lv_nmos ad=0.2516p pd=2.16u as=0.1406p ps=1.12u w=0.74u l=0.13u
X146 VSS.t279 VDD VSS.t277 VSS.t278 sg13_lv_nmos ad=79.8f pd=0.8u as=0 ps=0 w=0.42u l=1u
X147 a_5631_2470# a_5393_1842# a_5523_1842# VDD sg13_lv_pmos ad=0.2128p pd=1.5u as=0.3808p ps=2.92u w=1.12u l=0.2u
X148 a_14513_1842# a_14317_1842# VDD VDD sg13_lv_pmos ad=0.3808p pd=2.92u as=0.2128p ps=1.5u w=1.12u l=0.13u
X149 a_4633_1842# a_4437_1842# VDD VDD sg13_lv_pmos ad=0.3808p pd=2.92u as=0.2128p ps=1.5u w=1.12u l=0.13u
X150 VSS.t363 a_10083_1842# a_10517_1842# VSS.t491 sg13_lv_nmos ad=0.1406p pd=1.12u as=0.2516p ps=2.16u w=0.74u l=0.13u
X151 VDD a_2019_1047.t4 a_19524_1008# VDD sg13_lv_pmos ad=0.3808p pd=2.92u as=0.3808p ps=2.92u w=1.12u l=0.13u
X152 VSS.t544 a_3171_1047.t4 a_21044_1008# VSS.t543 sg13_lv_nmos ad=0.2516p pd=2.16u as=0.2516p ps=2.16u w=0.74u l=0.13u
X153 VSS.t97 a_2873_331# a_3171_311.t1 VSS.t96 sg13_lv_nmos ad=0.2812p pd=2.24u as=0.1406p ps=1.12u w=0.74u l=0.13u
X154 VSS.t93 a_3449_331# a_3747_311.t1 VSS.t92 sg13_lv_nmos ad=0.2812p pd=2.24u as=0.1406p ps=1.12u w=0.74u l=0.13u
X155 a_15755_1044# a_15545_1044# VDD VDD sg13_lv_pmos ad=0.2128p pd=1.5u as=0.252p ps=1.57u w=1.12u l=0.13u
X156 VDD a_2595_1047.t6 a_14311_1008# VDD sg13_lv_pmos ad=0.3808p pd=2.92u as=0.3808p ps=2.92u w=1.12u l=0.13u
X157 VSS.t483 DELAY_VBIASN.t4 a_24631_1842# VSS.t482 sg13_lv_nmos ad=0.2516p pd=2.16u as=0.1406p ps=1.12u w=0.74u l=0.6u
X158 a_5115_1044# a_4905_1044# VDD VDD sg13_lv_pmos ad=0.2128p pd=1.5u as=0.252p ps=1.57u w=1.12u l=0.13u
X159 a_18551_2470# a_18313_1842# a_18443_1842# VDD sg13_lv_pmos ad=0.2128p pd=1.5u as=0.3808p ps=2.92u w=1.12u l=0.2u
X160 VDD VSS.t573 VDD VDD sg13_lv_pmos ad=0.19p pd=1.38u as=0 ps=0 w=1u l=1u
X161 a_3171_1047.t1 a_2873_1395# VSS.t153 VSS.t216 sg13_lv_nmos ad=0.1406p pd=1.12u as=0.1331p ps=1.12u w=0.74u l=0.13u
X162 VSS.t115 a_2297_1395# a_2595_1047.t1 VSS.t114 sg13_lv_nmos ad=0.2812p pd=2.24u as=0.1406p ps=1.12u w=0.74u l=0.13u
X163 a_22351_2470# a_22113_1842# a_22243_1842# VDD sg13_lv_pmos ad=0.2128p pd=1.5u as=0.3808p ps=2.92u w=1.12u l=0.2u
X164 VSS.t348 VSS.t345 VSS.t347 VSS.t346 sg13_lv_nmos ad=0.2516p pd=2.16u as=0 ps=0 w=0.74u l=0.13u
X165 a_26911_1842# a_26673_1842# a_26803_1842# VSS.t182 sg13_lv_nmos ad=0.1406p pd=1.12u as=0.2516p ps=2.16u w=0.74u l=0.2u
X166 VSS.t233 a_3171_311.t3 a_11785_519# VSS.t232 sg13_lv_nmos ad=0.2516p pd=2.16u as=0.2516p ps=2.16u w=0.74u l=0.13u
X167 VDD a_1721_1395# a_2019_1047.t0 VDD sg13_lv_pmos ad=0.4256p pd=3u as=0.2128p ps=1.5u w=1.12u l=0.13u
X168 VDD a_16923_1842# a_17357_1842# VDD sg13_lv_pmos ad=0.2128p pd=1.5u as=0.3808p ps=2.92u w=1.12u l=0.13u
X169 a_2391_1395# MUX_SEL0 a_2297_1395# VSS.t494 sg13_lv_nmos ad=0.1216p pd=1.02u as=0.2176p ps=1.96u w=0.64u l=0.13u
X170 VSS.t50 a_1544_1044# a_1815_1395# VSS.t224 sg13_lv_nmos ad=0.1331p pd=1.12u as=0.1216p ps=1.02u w=0.64u l=0.13u
X171 a_13368_1044# a_12797_1842# VSS.t389 VSS.t388 sg13_lv_nmos ad=0.1406p pd=1.12u as=0.2516p ps=2.16u w=0.74u l=0.13u
X172 a_5731_289# a_3171_311.t3 a_10430_1044# VSS.t231 sg13_lv_nmos ad=0.2516p pd=2.16u as=0.2516p ps=2.16u w=0.74u l=0.13u
X173 VDD a_21157_1842# a_21625_1044# VDD sg13_lv_pmos ad=0.252p pd=1.57u as=0.3808p ps=2.92u w=1.12u l=0.13u
X174 VDD DELAY_VBIASP.t22 a_10951_2470# VDD sg13_lv_pmos ad=0.3808p pd=2.92u as=0.2128p ps=1.5u w=1.12u l=0.6u
X175 VSS.t463 DELAY_VBIASN.t16 a_15511_1842# VSS.t462 sg13_lv_nmos ad=0.2516p pd=2.16u as=0.1406p ps=1.12u w=0.74u l=0.6u
X176 VDD a_20723_1842# a_21157_1842# VDD sg13_lv_pmos ad=0.2128p pd=1.5u as=0.3808p ps=2.92u w=1.12u l=0.13u
X177 VSS.t101 a_25283_1842# a_25717_1842# VSS.t369 sg13_lv_nmos ad=0.1406p pd=1.12u as=0.2516p ps=2.16u w=0.74u l=0.13u
X178 a_4350_1044# a_3747_1047.t9 a_6635_1044# VSS.t109 sg13_lv_nmos ad=0.2516p pd=2.16u as=0.1406p ps=1.12u w=0.74u l=0.13u
X179 VSS.t441 DELAY_VBIASN.t29 a_5631_1842# VSS.t440 sg13_lv_nmos ad=0.2516p pd=2.16u as=0.1406p ps=1.12u w=0.74u l=0.6u
X180 VDD a_2019_1047.t9 a_4324_1008# VDD sg13_lv_pmos ad=0.3808p pd=2.92u as=0.3808p ps=2.92u w=1.12u l=0.13u
X181 a_16510_1044# a_18871_1008# a_18795_1044# VDD sg13_lv_pmos ad=0.3808p pd=2.92u as=0.2128p ps=1.5u w=1.12u l=0.13u
X182 a_19550_1044# a_2595_1047.t4 a_20315_1044# VSS.t240 sg13_lv_nmos ad=0.2516p pd=2.16u as=0.1406p ps=1.12u w=0.74u l=0.13u
X183 VDD DELAY_VBIASP.t5 a_23871_2470# VDD sg13_lv_pmos ad=0.3808p pd=2.92u as=0.2128p ps=1.5u w=1.12u l=0.6u
X184 VSS.t249 a_7477_1842# a_7945_1044# VSS.t248 sg13_lv_nmos ad=0.1665p pd=1.19u as=0.2516p ps=2.16u w=0.74u l=0.13u
X185 a_13231_2470# a_12993_1842# a_13123_1842# VDD sg13_lv_pmos ad=0.2128p pd=1.5u as=0.3808p ps=2.92u w=1.12u l=0.2u
X186 VDD VSS.t598 VDD VDD sg13_lv_pmos ad=0.34p pd=2.68u as=0 ps=0 w=1u l=1u
X187 a_12233_1842# a_12037_1842# VDD VDD sg13_lv_pmos ad=0.3808p pd=2.92u as=0.2128p ps=1.5u w=1.12u l=0.13u
X188 a_7911_1842# a_7673_1842# a_7803_1842# VSS.t505 sg13_lv_nmos ad=0.1406p pd=1.12u as=0.2516p ps=2.16u w=0.74u l=0.2u
X189 a_16793_1842# a_16597_1842# VSS.t19 VSS.t58 sg13_lv_nmos ad=0.2516p pd=2.16u as=0.1406p ps=1.12u w=0.74u l=0.13u
X190 VDD a_3747_311.t3 a_14825_519# VDD sg13_lv_pmos ad=0.3808p pd=2.92u as=0.3808p ps=2.92u w=1.12u l=0.13u
X191 VSS.t507 a_27563_1842# a_27997_1842# VSS.t506 sg13_lv_nmos ad=0.1406p pd=1.12u as=0.2516p ps=2.16u w=0.74u l=0.13u
X192 a_9675_1044# a_9465_1044# VSS.t73 VSS.t72 sg13_lv_nmos ad=0.1406p pd=1.12u as=0.1665p ps=1.19u w=0.74u l=0.13u
X193 a_20593_1842# a_20397_1842# VSS.t386 VSS.t418 sg13_lv_nmos ad=0.2516p pd=2.16u as=0.1406p ps=1.12u w=0.74u l=0.13u
X194 VSS.t45 a_2595_1047.t8 a_8231_1008# VSS.t44 sg13_lv_nmos ad=0.2516p pd=2.16u as=0.2516p ps=2.16u w=0.74u l=0.13u
X195 VSS.t42 a_6283_1842# a_6717_1842# VSS.t41 sg13_lv_nmos ad=0.1406p pd=1.12u as=0.2516p ps=2.16u w=0.74u l=0.13u
X196 a_10430_1044# a_10404_1008# a_10328_1044# VDD sg13_lv_pmos ad=0.3808p pd=2.92u as=0.2128p ps=1.5u w=1.12u l=0.13u
X197 VDD DELAY_VBIASP.t2 a_26151_2470# VDD sg13_lv_pmos ad=0.3808p pd=2.92u as=0.2128p ps=1.5u w=1.12u l=0.6u
X198 a_7390_1044# a_8884_1008# a_8808_1044# VDD sg13_lv_pmos ad=0.3808p pd=2.92u as=0.2128p ps=1.5u w=1.12u l=0.13u
X199 VDD DELAY_VBIASP.t30 a_4871_2470# VDD sg13_lv_pmos ad=0.3808p pd=2.92u as=0.2128p ps=1.5u w=1.12u l=0.6u
X200 a_3449_331# MUX_SEL2 VDD VDD sg13_lv_pmos ad=0.1596p pd=1.22u as=0.2856p ps=2.36u w=0.84u l=0.13u
X201 VDD VSS.t575 VDD VDD sg13_lv_pmos ad=0.19p pd=1.38u as=0 ps=0 w=1u l=1u
X202 a_19073_1842# a_18877_1842# VSS.t68 VSS.t67 sg13_lv_nmos ad=0.2516p pd=2.16u as=0.1406p ps=1.12u w=0.74u l=0.13u
X203 VDD a_15077_1842# a_15545_1044# VDD sg13_lv_pmos ad=0.252p pd=1.57u as=0.3808p ps=2.92u w=1.12u l=0.13u
X204 a_19550_1044# a_2019_1047.t4 a_19448_1044# VSS.t539 sg13_lv_nmos ad=0.2516p pd=2.16u as=0.1406p ps=1.12u w=0.74u l=0.13u
X205 VDD VDD VDD VDD sg13_lv_pmos ad=0.3808p pd=2.92u as=0 ps=0 w=1.12u l=0.6u
X206 VSS.t339 VDD VSS.t337 VSS.t338 sg13_lv_nmos ad=79.8f pd=0.8u as=0 ps=0 w=0.42u l=1u
X207 VSS.t161 a_19203_1842# a_19637_1842# VSS.t413 sg13_lv_nmos ad=0.1406p pd=1.12u as=0.2516p ps=2.16u w=0.74u l=0.13u
X208 VDD VSS.t577 VDD VDD sg13_lv_pmos ad=0.19p pd=1.38u as=0 ps=0 w=1u l=1u
X209 VDD VSS.t588 VDD VDD sg13_lv_pmos ad=0.34p pd=2.68u as=0 ps=0 w=1u l=1u
X210 a_27433_1842# a_27237_1842# VDD VDD sg13_lv_pmos ad=0.3808p pd=2.92u as=0.2128p ps=1.5u w=1.12u l=0.13u
X211 VDD a_1256_289# a_2873_331# VDD sg13_lv_pmos ad=0.1918p pd=1.5u as=0.1596p ps=1.22u w=0.84u l=0.13u
X212 a_13470_1044# a_2595_1047.t6 a_14235_1044# VSS.t26 sg13_lv_nmos ad=0.2516p pd=2.16u as=0.1406p ps=1.12u w=0.74u l=0.13u
X213 VSS.t405 a_8563_1842# a_8997_1842# VSS.t557 sg13_lv_nmos ad=0.1406p pd=1.12u as=0.2516p ps=2.16u w=0.74u l=0.13u
X214 VSS.t459 DELAY_VBIASN.t19 a_13231_1842# VSS.t458 sg13_lv_nmos ad=0.2516p pd=2.16u as=0.1406p ps=1.12u w=0.74u l=0.6u
X215 VDD a_3171_1047.t7 a_11924_1008# VDD sg13_lv_pmos ad=0.3808p pd=2.92u as=0.3808p ps=2.92u w=1.12u l=0.13u
X216 VSS.t538 a_2019_1047.t3 a_22564_1008# VSS.t537 sg13_lv_nmos ad=0.2516p pd=2.16u as=0.2516p ps=2.16u w=0.74u l=0.13u
X217 VSS.t209 a_23003_1842# a_23437_1842# VSS.t208 sg13_lv_nmos ad=0.1406p pd=1.12u as=0.2516p ps=2.16u w=0.74u l=0.13u
X218 VSS.t342 VDD VSS.t341 VSS.t340 sg13_lv_nmos ad=0.1428p pd=1.52u as=0 ps=0 w=0.42u l=1u
X219 VDD DELAY_VBIASP.t27 a_7151_2470# VDD sg13_lv_pmos ad=0.3808p pd=2.92u as=0.2128p ps=1.5u w=1.12u l=0.6u
X220 a_25630_1044# a_25604_1008# a_25528_1044# VDD sg13_lv_pmos ad=0.3808p pd=2.92u as=0.2128p ps=1.5u w=1.12u l=0.13u
X221 a_15511_1842# a_15273_1842# a_15403_1842# VSS.t402 sg13_lv_nmos ad=0.1406p pd=1.12u as=0.2516p ps=2.16u w=0.74u l=0.2u
X222 a_18313_1842# a_18117_1842# VDD VDD sg13_lv_pmos ad=0.3808p pd=2.92u as=0.2128p ps=1.5u w=1.12u l=0.13u
X223 a_5731_289# a_11785_519# a_10430_1044# VDD sg13_lv_pmos ad=0.3808p pd=2.92u as=0.3808p ps=2.92u w=1.12u l=0.13u
X224 VSS.t259 VDD VSS.t257 VSS.t258 sg13_lv_nmos ad=79.8f pd=0.8u as=0 ps=0 w=0.42u l=1u
X225 a_9431_2470# a_9193_1842# a_9323_1842# VDD sg13_lv_pmos ad=0.2128p pd=1.5u as=0.3808p ps=2.92u w=1.12u l=0.2u
X226 a_17275_1044# a_17065_1044# VSS.t57 VSS.t227 sg13_lv_nmos ad=0.1406p pd=1.12u as=0.1665p ps=1.19u w=0.74u l=0.13u
X227 VDD VSS.t574 VDD VDD sg13_lv_pmos ad=0.34p pd=2.68u as=0 ps=0 w=1u l=1u
X228 VSS.t144 a_3747_1047.t6 a_15831_1008# VSS.t143 sg13_lv_nmos ad=0.2516p pd=2.16u as=0.2516p ps=2.16u w=0.74u l=0.13u
X229 a_23871_2470# a_23633_1842# a_23763_1842# VDD sg13_lv_pmos ad=0.2128p pd=1.5u as=0.3808p ps=2.92u w=1.12u l=0.2u
X230 VSS.t361 a_13883_1842# a_14317_1842# VSS.t360 sg13_lv_nmos ad=0.1406p pd=1.12u as=0.2516p ps=2.16u w=0.74u l=0.13u
X231 VSS.t193 a_3747_311.t2 a_26985_519# VSS.t192 sg13_lv_nmos ad=0.2516p pd=2.16u as=0.2516p ps=2.16u w=0.74u l=0.13u
X232 a_8433_1842# a_8237_1842# VDD VDD sg13_lv_pmos ad=0.3808p pd=2.92u as=0.2128p ps=1.5u w=1.12u l=0.13u
X233 VDD a_18443_1842# a_18877_1842# VDD sg13_lv_pmos ad=0.2128p pd=1.5u as=0.3808p ps=2.92u w=1.12u l=0.13u
X234 a_22113_1842# a_21917_1842# VDD VDD sg13_lv_pmos ad=0.3808p pd=2.92u as=0.2128p ps=1.5u w=1.12u l=0.13u
X235 a_4350_1044# a_2019_1047.t9 a_4248_1044# VSS.t234 sg13_lv_nmos ad=0.2516p pd=2.16u as=0.1406p ps=1.12u w=0.74u l=0.13u
X236 a_14888_1044# a_14317_1842# VSS.t395 VSS.t394 sg13_lv_nmos ad=0.1406p pd=1.12u as=0.2516p ps=2.16u w=0.74u l=0.13u
X237 a_16108_289# a_3747_311.t2 a_25630_1044# VSS.t191 sg13_lv_nmos ad=0.2516p pd=2.16u as=0.2516p ps=2.16u w=0.74u l=0.13u
X238 VDD DELAY_VBIASP.t20 a_12471_2470# VDD sg13_lv_pmos ad=0.3808p pd=2.92u as=0.2128p ps=1.5u w=1.12u l=0.6u
X239 VSS.t174 a_4003_1842# a_4437_1842# VSS.t501 sg13_lv_nmos ad=0.1406p pd=1.12u as=0.2516p ps=2.16u w=0.74u l=0.13u
X240 a_16510_1044# a_16484_1008# a_16408_1044# VDD sg13_lv_pmos ad=0.3808p pd=2.92u as=0.2128p ps=1.5u w=1.12u l=0.13u
X241 VDD a_22243_1842# a_22677_1842# VDD sg13_lv_pmos ad=0.2128p pd=1.5u as=0.3808p ps=2.92u w=1.12u l=0.13u
X242 VDD a_3171_1047.t2 a_27124_1008# VDD sg13_lv_pmos ad=0.3808p pd=2.92u as=0.3808p ps=2.92u w=1.12u l=0.13u
X243 VDD MUX_SEL3 a_3449_331# VDD sg13_lv_pmos ad=0.1918p pd=1.5u as=0.1596p ps=1.22u w=0.84u l=0.13u
X244 a_2595_311.t0 a_2297_331# VDD VDD sg13_lv_pmos ad=0.2128p pd=1.5u as=0.1918p ps=1.5u w=1.12u l=0.13u
X245 a_10430_1044# a_11271_1008# a_11195_1044# VDD sg13_lv_pmos ad=0.3808p pd=2.92u as=0.2128p ps=1.5u w=1.12u l=0.13u
X246 a_23355_1044# a_23145_1044# VDD VDD sg13_lv_pmos ad=0.2128p pd=1.5u as=0.252p ps=1.57u w=1.12u l=0.13u
X247 VDD a_3747_1047.t4 a_21911_1008# VDD sg13_lv_pmos ad=0.3808p pd=2.92u as=0.3808p ps=2.92u w=1.12u l=0.13u
X248 VSS.t73 a_8997_1842# a_9465_1044# VSS.t403 sg13_lv_nmos ad=0.1665p pd=1.19u as=0.2516p ps=2.16u w=0.74u l=0.13u
X249 a_20968_1044# a_20397_1842# VDD VDD sg13_lv_pmos ad=0.2128p pd=1.5u as=0.3808p ps=2.92u w=1.12u l=0.13u
X250 a_10951_1842# a_10713_1842# a_10843_1842# VSS.t380 sg13_lv_nmos ad=0.1406p pd=1.12u as=0.2516p ps=2.16u w=0.74u l=0.2u
X251 VSS.t89 a_2019_1047.t5 a_16484_1008# VSS.t88 sg13_lv_nmos ad=0.2516p pd=2.16u as=0.2516p ps=2.16u w=0.74u l=0.13u
X252 a_26151_2470# a_25913_1842# a_26043_1842# VDD sg13_lv_pmos ad=0.2128p pd=1.5u as=0.3808p ps=2.92u w=1.12u l=0.2u
X253 a_13753_1842# a_13557_1842# VDD VDD sg13_lv_pmos ad=0.3808p pd=2.92u as=0.2128p ps=1.5u w=1.12u l=0.13u
X254 VDD a_1721_331# a_2019_311# VDD sg13_lv_pmos ad=0.4256p pd=3u as=0.2128p ps=1.5u w=1.12u l=0.13u
X255 a_4871_2470# a_4633_1842# a_4763_1842# VDD sg13_lv_pmos ad=0.2128p pd=1.5u as=0.3808p ps=2.92u w=1.12u l=0.2u
X256 VSS.t132 a_3171_1047.t9 a_5844_1008# VSS.t131 sg13_lv_nmos ad=0.2516p pd=2.16u as=0.2516p ps=2.16u w=0.74u l=0.13u
X257 VSS.t299 VDD VSS.t297 VSS.t298 sg13_lv_nmos ad=79.8f pd=0.8u as=0 ps=0 w=0.42u l=1u
X258 VDD a_2595_311.t2 a_20905_519# VDD sg13_lv_pmos ad=0.3808p pd=2.92u as=0.3808p ps=2.92u w=1.12u l=0.13u
X259 VDD a_2297_331# a_2595_311.t0 VDD sg13_lv_pmos ad=0.4256p pd=3u as=0.2128p ps=1.5u w=1.12u l=0.13u
X260 VSS.t48 a_2595_1047.t7 a_11271_1008# VSS.t47 sg13_lv_nmos ad=0.2516p pd=2.16u as=0.2516p ps=2.16u w=0.74u l=0.13u
X261 VSS.t457 DELAY_VBIASN.t11 a_19311_1842# VSS.t456 sg13_lv_nmos ad=0.2516p pd=2.16u as=0.1406p ps=1.12u w=0.74u l=0.6u
X262 VDD a_24523_1842# a_24957_1842# VDD sg13_lv_pmos ad=0.2128p pd=1.5u as=0.3808p ps=2.92u w=1.12u l=0.13u
X263 VSS.t230 a_3747_1047.t8 a_9751_1008# VSS.t229 sg13_lv_nmos ad=0.2516p pd=2.16u as=0.2516p ps=2.16u w=0.74u l=0.13u
X264 VSS.t445 DELAY_VBIASN.t24 a_9431_1842# VSS.t444 sg13_lv_nmos ad=0.2516p pd=2.16u as=0.1406p ps=1.12u w=0.74u l=0.6u
X265 a_19448_1044# a_18877_1842# VDD VDD sg13_lv_pmos ad=0.2128p pd=1.5u as=0.3808p ps=2.92u w=1.12u l=0.13u
X266 VSS.t479 DELAY_VBIASN.t6 a_23111_1842# VSS.t478 sg13_lv_nmos ad=0.2516p pd=2.16u as=0.1406p ps=1.12u w=0.74u l=0.6u
X267 a_10430_1044# a_11924_1008# a_11848_1044# VDD sg13_lv_pmos ad=0.3808p pd=2.92u as=0.2128p ps=1.5u w=1.12u l=0.13u
X268 VDD DELAY_VBIASP.t0 a_27671_2470# VDD sg13_lv_pmos ad=0.3808p pd=2.92u as=0.2128p ps=1.5u w=1.12u l=0.6u
X269 a_25630_1044# a_26471_1008# a_26395_1044# VDD sg13_lv_pmos ad=0.3808p pd=2.92u as=0.2128p ps=1.5u w=1.12u l=0.13u
X270 a_7151_2470# a_6913_1842# a_7043_1842# VDD sg13_lv_pmos ad=0.2128p pd=1.5u as=0.3808p ps=2.92u w=1.12u l=0.2u
X271 a_16033_1842# a_15837_1842# VDD VDD sg13_lv_pmos ad=0.3808p pd=2.92u as=0.2128p ps=1.5u w=1.12u l=0.13u
X272 VDD a_15964_289# a_16851_309# VDD sg13_lv_pmos ad=0.2086p pd=1.5u as=0.34p ps=2.68u w=1u l=0.13u
X273 VDD VSS.t576 VDD VDD sg13_lv_pmos ad=0.34p pd=2.68u as=0 ps=0 w=1u l=1u
X274 VSS.t60 a_11603_1842# a_12037_1842# VSS.t59 sg13_lv_nmos ad=0.1406p pd=1.12u as=0.2516p ps=2.16u w=0.74u l=0.13u
X275 VSS.t319 VDD VSS.t317 VSS.t318 sg13_lv_nmos ad=79.8f pd=0.8u as=0 ps=0 w=0.42u l=1u
X276 VDD VSS.t590 VDD VDD sg13_lv_pmos ad=0.34p pd=2.68u as=0 ps=0 w=1u l=1u
X277 VDD a_5957_1842# a_6425_1044# VDD sg13_lv_pmos ad=0.252p pd=1.57u as=0.3808p ps=2.92u w=1.12u l=0.13u
X278 a_24393_1842# a_24197_1842# VSS.t401 VSS.t524 sg13_lv_nmos ad=0.2516p pd=2.16u as=0.1406p ps=1.12u w=0.74u l=0.13u
X279 a_3747_1047.t1 a_3449_1395# VSS.t7 VSS.t6 sg13_lv_nmos ad=0.1406p pd=1.12u as=0.1331p ps=1.12u w=0.74u l=0.13u
X280 a_1544_1044# MUX_SEL1 VSS.t519 VSS.t518 sg13_lv_nmos ad=0.2516p pd=2.16u as=0.2516p ps=2.16u w=0.74u l=0.13u
X281 VDD VSS.t578 VDD VDD sg13_lv_pmos ad=0.34p pd=2.68u as=0 ps=0 w=1u l=1u
X282 a_3171_1047.t0 a_2873_1395# VDD VDD sg13_lv_pmos ad=0.2128p pd=1.5u as=0.1918p ps=1.5u w=1.12u l=0.13u
X283 a_13470_1044# a_3747_1047.t6 a_15755_1044# VSS.t142 sg13_lv_nmos ad=0.2516p pd=2.16u as=0.1406p ps=1.12u w=0.74u l=0.13u
X284 VDD a_5523_1842# a_5957_1842# VDD sg13_lv_pmos ad=0.2128p pd=1.5u as=0.3808p ps=2.92u w=1.12u l=0.13u
X285 VDD a_2297_1395# a_2595_1047.t0 VDD sg13_lv_pmos ad=0.4256p pd=3u as=0.2128p ps=1.5u w=1.12u l=0.13u
X286 VSS.t455 DELAY_VBIASN.t17 a_14751_1842# VSS.t454 sg13_lv_nmos ad=0.2516p pd=2.16u as=0.1406p ps=1.12u w=0.74u l=0.6u
X287 a_2967_1395# MUX_SEL1 a_2873_1395# VSS.t520 sg13_lv_nmos ad=0.1216p pd=1.02u as=0.2176p ps=1.96u w=0.64u l=0.13u
X288 a_4350_1044# a_2595_1047.t9 a_5115_1044# VSS.t84 sg13_lv_nmos ad=0.2516p pd=2.16u as=0.1406p ps=1.12u w=0.74u l=0.13u
X289 VDD a_2019_1047.t6 a_13444_1008# VDD sg13_lv_pmos ad=0.3808p pd=2.92u as=0.3808p ps=2.92u w=1.12u l=0.13u
X290 VSS.t22 a_2595_1047.t2 a_26471_1008# VSS.t21 sg13_lv_nmos ad=0.2516p pd=2.16u as=0.2516p ps=2.16u w=0.74u l=0.13u
X291 a_2595_311.t1 a_2297_331# VSS.t36 VSS.t35 sg13_lv_nmos ad=0.1406p pd=1.12u as=0.1331p ps=1.12u w=0.74u l=0.13u
X292 VSS.t429 DELAY_VBIASN.t31 a_4111_1842# VSS.t428 sg13_lv_nmos ad=0.2516p pd=2.16u as=0.1406p ps=1.12u w=0.74u l=0.6u
X293 a_2297_1395# MUX_SEL0 VDD VDD sg13_lv_pmos ad=0.1596p pd=1.22u as=0.2856p ps=2.36u w=0.84u l=0.13u
X294 VSS.t57 a_16597_1842# a_17065_1044# VSS.t56 sg13_lv_nmos ad=0.1665p pd=1.19u as=0.2516p ps=2.16u w=0.74u l=0.13u
X295 VDD DELAY_VBIASP.t25 a_8671_2470# VDD sg13_lv_pmos ad=0.3808p pd=2.92u as=0.2128p ps=1.5u w=1.12u l=0.6u
X296 VDD VSS.t591 VDD VDD sg13_lv_pmos ad=0.19p pd=1.38u as=0 ps=0 w=1u l=1u
X297 VDD a_1544_1044# a_1721_1395# VDD sg13_lv_pmos ad=0.1918p pd=1.5u as=0.1596p ps=1.22u w=0.84u l=0.13u
X298 a_4248_1044# a_4157_1313# VDD VDD sg13_lv_pmos ad=0.2128p pd=1.5u as=0.3808p ps=2.92u w=1.12u l=0.13u
X299 a_12471_2470# a_12233_1842# a_12363_1842# VDD sg13_lv_pmos ad=0.2128p pd=1.5u as=0.3808p ps=2.92u w=1.12u l=0.2u
X300 a_17031_1842# a_16793_1842# a_16923_1842# VSS.t406 sg13_lv_nmos ad=0.1406p pd=1.12u as=0.2516p ps=2.16u w=0.74u l=0.2u
X301 VSS.t13 a_1721_331# a_2019_311# VSS.t12 sg13_lv_nmos ad=0.2812p pd=2.24u as=0.1406p ps=1.12u w=0.74u l=0.13u
X302 a_19550_1044# a_21911_1008# a_21835_1044# VDD sg13_lv_pmos ad=0.3808p pd=2.92u as=0.2128p ps=1.5u w=1.12u l=0.13u
X303 a_16108_289# a_26985_519# a_25630_1044# VDD sg13_lv_pmos ad=0.3808p pd=2.92u as=0.3808p ps=2.92u w=1.12u l=0.13u
X304 VSS.t38 a_2297_331# a_2595_311.t1 VSS.t37 sg13_lv_nmos ad=0.2812p pd=2.24u as=0.1406p ps=1.12u w=0.74u l=0.13u
X305 a_18795_1044# a_18585_1044# VSS.t157 VSS.t156 sg13_lv_nmos ad=0.1406p pd=1.12u as=0.1665p ps=1.19u w=0.74u l=0.13u
X306 a_20831_1842# a_20593_1842# a_20723_1842# VSS.t381 sg13_lv_nmos ad=0.1406p pd=1.12u as=0.2516p ps=2.16u w=0.74u l=0.2u
X307 VSS.t257 VDD VSS.t256 VSS.t255 sg13_lv_nmos ad=0.1428p pd=1.52u as=0 ps=0 w=0.42u l=1u
X308 VDD a_22677_1842# a_23145_1044# VDD sg13_lv_pmos ad=0.252p pd=1.57u as=0.3808p ps=2.92u w=1.12u l=0.13u
X309 VSS.t25 a_2595_1047.t5 a_17351_1008# VSS.t24 sg13_lv_nmos ad=0.2516p pd=2.16u as=0.2516p ps=2.16u w=0.74u l=0.13u
X310 a_5393_1842# a_5197_1842# VSS.t106 VSS.t105 sg13_lv_nmos ad=0.2516p pd=2.16u as=0.1406p ps=1.12u w=0.74u l=0.13u
X311 VSS.t467 DELAY_VBIASN.t14 a_17031_1842# VSS.t466 sg13_lv_nmos ad=0.2516p pd=2.16u as=0.1406p ps=1.12u w=0.74u l=0.6u
X312 a_25630_1044# a_3171_1047.t2 a_27048_1044# VSS.t133 sg13_lv_nmos ad=0.2516p pd=2.16u as=0.1406p ps=1.12u w=0.74u l=0.13u
X313 a_9953_1842# a_9757_1842# VDD VDD sg13_lv_pmos ad=0.3808p pd=2.92u as=0.2128p ps=1.5u w=1.12u l=0.13u
X314 VDD a_10843_1842# a_11277_1842# VDD sg13_lv_pmos ad=0.2128p pd=1.5u as=0.3808p ps=2.92u w=1.12u l=0.13u
X315 VSS.t64 a_26803_1842# a_27237_1842# VSS.t508 sg13_lv_nmos ad=0.1406p pd=1.12u as=0.2516p ps=2.16u w=0.74u l=0.13u
X316 a_4350_1044# a_3171_1047.t9 a_5768_1044# VSS.t130 sg13_lv_nmos ad=0.2516p pd=2.16u as=0.1406p ps=1.12u w=0.74u l=0.13u
X317 a_10430_1044# a_12791_1008# a_12715_1044# VDD sg13_lv_pmos ad=0.3808p pd=2.92u as=0.2128p ps=1.5u w=1.12u l=0.13u
X318 a_19311_1842# a_19073_1842# a_19203_1842# VSS.t550 sg13_lv_nmos ad=0.1406p pd=1.12u as=0.2516p ps=2.16u w=0.74u l=0.2u
X319 a_24875_1044# a_24665_1044# VDD VDD sg13_lv_pmos ad=0.2128p pd=1.5u as=0.252p ps=1.57u w=1.12u l=0.13u
X320 VDD a_2595_1047.t3 a_23431_1008# VDD sg13_lv_pmos ad=0.3808p pd=2.92u as=0.3808p ps=2.92u w=1.12u l=0.13u
X321 VDD a_13557_1842# a_14025_1044# VDD sg13_lv_pmos ad=0.252p pd=1.57u as=0.3808p ps=2.92u w=1.12u l=0.13u
X322 a_23111_1842# a_22873_1842# a_23003_1842# VSS.t531 sg13_lv_nmos ad=0.1406p pd=1.12u as=0.2516p ps=2.16u w=0.74u l=0.2u
X323 a_27671_2470# a_27433_1842# a_27563_1842# VDD sg13_lv_pmos ad=0.2128p pd=1.5u as=0.3808p ps=2.92u w=1.12u l=0.2u
X324 VSS.t254 a_17683_1842# a_18117_1842# VSS.t253 sg13_lv_nmos ad=0.1406p pd=1.12u as=0.2516p ps=2.16u w=0.74u l=0.13u
X325 VSS.t314 VDD VSS.t312 VSS.t313 sg13_lv_nmos ad=79.8f pd=0.8u as=0 ps=0 w=0.42u l=1u
X326 a_10713_1842# a_10517_1842# VSS.t363 VSS.t362 sg13_lv_nmos ad=0.2516p pd=2.16u as=0.1406p ps=1.12u w=0.74u l=0.13u
X327 VSS.t529 a_2019_1047.t8 a_7364_1008# VSS.t528 sg13_lv_nmos ad=0.2516p pd=2.16u as=0.2516p ps=2.16u w=0.74u l=0.13u
X328 VSS.t410 a_7803_1842# a_8237_1842# VSS.t417 sg13_lv_nmos ad=0.1406p pd=1.12u as=0.2516p ps=2.16u w=0.74u l=0.13u
X329 VDD DELAY_VBIASP.t15 a_16271_2470# VDD sg13_lv_pmos ad=0.3808p pd=2.92u as=0.2128p ps=1.5u w=1.12u l=0.6u
X330 VSS.t309 VDD VSS.t307 VSS.t308 sg13_lv_nmos ad=79.8f pd=0.8u as=0 ps=0 w=0.42u l=1u
X331 VSS.t282 VDD VSS.t281 VSS.t280 sg13_lv_nmos ad=0.1428p pd=1.52u as=0 ps=0 w=0.42u l=1u
X332 VDD a_26043_1842# a_26477_1842# VDD sg13_lv_pmos ad=0.2128p pd=1.5u as=0.3808p ps=2.92u w=1.12u l=0.13u
X333 a_3543_331# MUX_SEL2 a_3449_331# VSS.t246 sg13_lv_nmos ad=0.1216p pd=1.02u as=0.2176p ps=1.96u w=0.64u l=0.13u
X334 a_22488_1044# a_21917_1842# VSS.t489 VSS.t488 sg13_lv_nmos ad=0.1406p pd=1.12u as=0.2516p ps=2.16u w=0.74u l=0.13u
X335 VDD VSS.t593 VDD VDD sg13_lv_pmos ad=0.19p pd=1.38u as=0 ps=0 w=1u l=1u
X336 a_22590_1044# a_24084_1008# a_24008_1044# VDD sg13_lv_pmos ad=0.3808p pd=2.92u as=0.2128p ps=1.5u w=1.12u l=0.13u
X337 VDD DELAY_VBIASP.t10 a_20071_2470# VDD sg13_lv_pmos ad=0.3808p pd=2.92u as=0.2128p ps=1.5u w=1.12u l=0.6u
X338 a_14751_1842# a_14513_1842# a_14643_1842# VSS.t74 sg13_lv_nmos ad=0.1406p pd=1.12u as=0.2516p ps=2.16u w=0.74u l=0.2u
X339 VSS.t218 a_2873_1395# a_3171_1047.t1 VSS.t217 sg13_lv_nmos ad=0.2812p pd=2.24u as=0.1406p ps=1.12u w=0.74u l=0.13u
X340 VDD VSS.t567 VDD VDD sg13_lv_pmos ad=0.19p pd=1.38u as=0 ps=0 w=1u l=1u
X341 a_25630_1044# a_27991_1008# a_27915_1044# VDD sg13_lv_pmos ad=0.3808p pd=2.92u as=0.2128p ps=1.5u w=1.12u l=0.13u
X342 VSS.t351 VSS.t349 VSS.t347 VSS.t350 sg13_lv_nmos ad=0.1406p pd=1.12u as=0 ps=0 w=0.74u l=0.13u
X343 a_4111_1842# DELAY_IN a_4003_1842# VSS.t250 sg13_lv_nmos ad=0.1406p pd=1.12u as=0.2516p ps=2.16u w=0.74u l=0.2u
X344 a_8671_2470# a_8433_1842# a_8563_1842# VDD sg13_lv_pmos ad=0.2128p pd=1.5u as=0.3808p ps=2.92u w=1.12u l=0.2u
X345 a_17553_1842# a_17357_1842# VDD VDD sg13_lv_pmos ad=0.3808p pd=2.92u as=0.2128p ps=1.5u w=1.12u l=0.13u
X346 VSS.t113 a_1544_1044# a_2391_1395# VSS.t225 sg13_lv_nmos ad=0.1331p pd=1.12u as=0.1216p ps=1.02u w=0.64u l=0.13u
X347 VSS.t239 a_3747_311.t3 a_14825_519# VSS.t238 sg13_lv_nmos ad=0.2516p pd=2.16u as=0.2516p ps=2.16u w=0.74u l=0.13u
X348 VSS.t95 a_1256_289# a_2967_331# VSS.t159 sg13_lv_nmos ad=0.1331p pd=1.12u as=0.1216p ps=1.02u w=0.64u l=0.13u
X349 a_2019_1047.t1 a_1721_1395# VSS.t50 VSS.t49 sg13_lv_nmos ad=0.1406p pd=1.12u as=0.1331p ps=1.12u w=0.74u l=0.13u
X350 a_15964_289# a_15765_463# a_5731_289# VSS.t181 sg13_lv_nmos ad=0.2183p pd=1.33u as=0.2516p ps=2.16u w=0.74u l=0.13u
X351 a_13470_1044# a_2019_1047.t6 a_13368_1044# VSS.t533 sg13_lv_nmos ad=0.2516p pd=2.16u as=0.1406p ps=1.12u w=0.74u l=0.13u
X352 VSS.t206 a_13123_1842# a_13557_1842# VSS.t486 sg13_lv_nmos ad=0.1406p pd=1.12u as=0.2516p ps=2.16u w=0.74u l=0.13u
X353 VDD VSS.t566 VDD VDD sg13_lv_pmos ad=0.34p pd=2.68u as=0 ps=0 w=1u l=1u
X354 VSS.t5 a_3171_1047.t3 a_24084_1008# VSS.t4 sg13_lv_nmos ad=0.2516p pd=2.16u as=0.2516p ps=2.16u w=0.74u l=0.13u
X355 a_25913_1842# a_25717_1842# VSS.t101 VSS.t100 sg13_lv_nmos ad=0.2516p pd=2.16u as=0.1406p ps=1.12u w=0.74u l=0.13u
X356 a_21353_1842# a_21157_1842# VDD VDD sg13_lv_pmos ad=0.3808p pd=2.92u as=0.2128p ps=1.5u w=1.12u l=0.13u
X357 VSS.t317 VDD VSS.t316 VSS.t315 sg13_lv_nmos ad=0.1428p pd=1.52u as=0 ps=0 w=0.42u l=1u
X358 a_2297_331# MUX_SEL2 VDD VDD sg13_lv_pmos ad=0.1596p pd=1.22u as=0.2856p ps=2.36u w=0.84u l=0.13u
X359 VDD a_7043_1842# a_7477_1842# VDD sg13_lv_pmos ad=0.2128p pd=1.5u as=0.3808p ps=2.92u w=1.12u l=0.13u
X360 a_2873_331# MUX_SEL3 VDD VDD sg13_lv_pmos ad=0.1596p pd=1.22u as=0.2856p ps=2.36u w=0.84u l=0.13u
X361 a_8155_1044# a_7945_1044# VDD VDD sg13_lv_pmos ad=0.2128p pd=1.5u as=0.252p ps=1.57u w=1.12u l=0.13u
X362 VSS.t157 a_18117_1842# a_18585_1044# VSS.t382 sg13_lv_nmos ad=0.1665p pd=1.19u as=0.2516p ps=2.16u w=0.74u l=0.13u
X363 a_27048_1044# a_26477_1842# VDD VDD sg13_lv_pmos ad=0.2128p pd=1.5u as=0.3808p ps=2.92u w=1.12u l=0.13u
X364 a_5768_1044# a_5197_1842# VDD VDD sg13_lv_pmos ad=0.2128p pd=1.5u as=0.3808p ps=2.92u w=1.12u l=0.13u
X365 a_13991_2470# a_13753_1842# a_13883_1842# VDD sg13_lv_pmos ad=0.2128p pd=1.5u as=0.3808p ps=2.92u w=1.12u l=0.2u
X366 VSS.t2 a_3171_1047.t6 a_14964_1008# VSS.t1 sg13_lv_nmos ad=0.2516p pd=2.16u as=0.2516p ps=2.16u w=0.74u l=0.13u
X367 VDD a_2019_311# a_17865_519# VDD sg13_lv_pmos ad=0.3808p pd=2.92u as=0.3808p ps=2.92u w=1.12u l=0.13u
X368 DELAY_OUT_LAST a_27997_1842# VSS.t507 VSS.t562 sg13_lv_nmos ad=0.2516p pd=2.16u as=0.1406p ps=1.12u w=0.74u l=0.13u
X369 a_11195_1044# a_10985_1044# VSS.t365 VSS.t546 sg13_lv_nmos ad=0.1406p pd=1.12u as=0.1665p ps=1.19u w=0.74u l=0.13u
X370 VDD a_24197_1842# a_24665_1044# VDD sg13_lv_pmos ad=0.252p pd=1.57u as=0.3808p ps=2.92u w=1.12u l=0.13u
X371 a_6913_1842# a_6717_1842# VSS.t42 VSS.t504 sg13_lv_nmos ad=0.2516p pd=2.16u as=0.1406p ps=1.12u w=0.74u l=0.13u
X372 VSS.t469 DELAY_VBIASN.t12 a_18551_1842# VSS.t468 sg13_lv_nmos ad=0.2516p pd=2.16u as=0.1406p ps=1.12u w=0.74u l=0.6u
X373 a_16510_1044# a_18004_1008# a_17928_1044# VDD sg13_lv_pmos ad=0.3808p pd=2.92u as=0.2128p ps=1.5u w=1.12u l=0.13u
X374 VDD a_12363_1842# a_12797_1842# VDD sg13_lv_pmos ad=0.2128p pd=1.5u as=0.3808p ps=2.92u w=1.12u l=0.13u
X375 VSS.t91 MUX_SEL3 a_3543_331# VSS.t178 sg13_lv_nmos ad=0.1331p pd=1.12u as=0.1216p ps=1.02u w=0.64u l=0.13u
X376 a_22590_1044# a_2595_1047.t3 a_23355_1044# VSS.t29 sg13_lv_nmos ad=0.2516p pd=2.16u as=0.1406p ps=1.12u w=0.74u l=0.13u
X377 VSS.t475 DELAY_VBIASN.t7 a_22351_1842# VSS.t474 sg13_lv_nmos ad=0.2516p pd=2.16u as=0.1406p ps=1.12u w=0.74u l=0.6u
X378 VDD a_3171_1047.t4 a_21044_1008# VDD sg13_lv_pmos ad=0.3808p pd=2.92u as=0.3808p ps=2.92u w=1.12u l=0.13u
X379 VDD VSS.t569 VDD VDD sg13_lv_pmos ad=0.19p pd=1.38u as=0 ps=0 w=1u l=1u
X380 a_16271_2470# a_16033_1842# a_16163_1842# VDD sg13_lv_pmos ad=0.2128p pd=1.5u as=0.3808p ps=2.92u w=1.12u l=0.2u
X381 VDD VSS.t583 VDD VDD sg13_lv_pmos ad=0.19p pd=1.38u as=0 ps=0 w=1u l=1u
X382 a_19833_1842# a_19637_1842# VSS.t161 VSS.t160 sg13_lv_nmos ad=0.2516p pd=2.16u as=0.1406p ps=1.12u w=0.74u l=0.13u
X383 VDD a_2019_311# a_5705_519# VDD sg13_lv_pmos ad=0.3808p pd=2.92u as=0.3808p ps=2.92u w=1.12u l=0.13u
X384 a_20071_2470# a_19833_1842# a_19963_1842# VDD sg13_lv_pmos ad=0.2128p pd=1.5u as=0.3808p ps=2.92u w=1.12u l=0.2u
X385 a_9193_1842# a_8997_1842# VSS.t405 VSS.t404 sg13_lv_nmos ad=0.2516p pd=2.16u as=0.1406p ps=1.12u w=0.74u l=0.13u
X386 a_24631_1842# a_24393_1842# a_24523_1842# VSS.t555 sg13_lv_nmos ad=0.1406p pd=1.12u as=0.2516p ps=2.16u w=0.74u l=0.2u
X387 VDD VSS.t582 VDD VDD sg13_lv_pmos ad=0.34p pd=2.68u as=0 ps=0 w=1u l=1u
X388 VSS.t83 a_2019_1047.t7 a_10404_1008# VSS.t82 sg13_lv_nmos ad=0.2516p pd=2.16u as=0.2516p ps=2.16u w=0.74u l=0.13u
X389 VDD a_14643_1842# a_15077_1842# VDD sg13_lv_pmos ad=0.2128p pd=1.5u as=0.3808p ps=2.92u w=1.12u l=0.13u
X390 VDD a_1544_289# a_2297_331# VDD sg13_lv_pmos ad=0.1918p pd=1.5u as=0.1596p ps=1.22u w=0.84u l=0.13u
X391 a_23633_1842# a_23437_1842# VSS.t209 VSS.t397 sg13_lv_nmos ad=0.2516p pd=2.16u as=0.1406p ps=1.12u w=0.74u l=0.13u
X392 VSS.t312 VDD VSS.t311 VSS.t310 sg13_lv_nmos ad=0.1428p pd=1.52u as=0 ps=0 w=0.42u l=1u
X393 a_2019_311# a_1721_331# VDD VDD sg13_lv_pmos ad=0.2128p pd=1.5u as=0.1918p ps=1.5u w=1.12u l=0.13u
X394 VSS.t408 a_9323_1842# a_9757_1842# VSS.t407 sg13_lv_nmos ad=0.1406p pd=1.12u as=0.2516p ps=2.16u w=0.74u l=0.13u
X395 a_26395_1044# a_26185_1044# VSS.t99 VSS.t120 sg13_lv_nmos ad=0.1406p pd=1.12u as=0.1665p ps=1.19u w=0.74u l=0.13u
X396 VDD DELAY_VBIASP.t13 a_17791_2470# VDD sg13_lv_pmos ad=0.3808p pd=2.92u as=0.2128p ps=1.5u w=1.12u l=0.6u
X397 VSS.t147 a_3747_1047.t3 a_24951_1008# VSS.t146 sg13_lv_nmos ad=0.2516p pd=2.16u as=0.2516p ps=2.16u w=0.74u l=0.13u
X398 VSS.t277 VDD VSS.t276 VSS.t275 sg13_lv_nmos ad=0.1428p pd=1.52u as=0 ps=0 w=0.42u l=1u
X399 VSS.t307 VDD VSS.t306 VSS.t305 sg13_lv_nmos ad=0.1428p pd=1.52u as=0 ps=0 w=0.42u l=1u
X400 a_3747_1047.t0 a_3449_1395# VDD VDD sg13_lv_pmos ad=0.2128p pd=1.5u as=0.1918p ps=1.5u w=1.12u l=0.13u
X401 a_13368_1044# a_12797_1842# VDD VDD sg13_lv_pmos ad=0.2128p pd=1.5u as=0.3808p ps=2.92u w=1.12u l=0.13u
X402 a_24008_1044# a_23437_1842# VSS.t399 VSS.t398 sg13_lv_nmos ad=0.1406p pd=1.12u as=0.2516p ps=2.16u w=0.74u l=0.13u
X403 VDD DELAY_VBIASP.t8 a_21591_2470# VDD sg13_lv_pmos ad=0.3808p pd=2.92u as=0.2128p ps=1.5u w=1.12u l=0.6u
X404 a_15964_289# MUX_SEL4 a_5731_289# VDD sg13_lv_pmos ad=0.3304p pd=1.71u as=0.3808p ps=2.92u w=1.12u l=0.13u
X405 a_4350_1044# a_6711_1008# a_6635_1044# VDD sg13_lv_pmos ad=0.3808p pd=2.92u as=0.2128p ps=1.5u w=1.12u l=0.13u
X406 a_2873_1395# MUX_SEL1 VDD VDD sg13_lv_pmos ad=0.1596p pd=1.22u as=0.2856p ps=2.36u w=0.84u l=0.13u
X407 a_1256_1044# MUX_SEL0 VSS.t493 VSS.t492 sg13_lv_nmos ad=0.2516p pd=2.16u as=0.2516p ps=2.16u w=0.74u l=0.13u
X408 VSS.t274 VDD VSS.t272 VSS.t273 sg13_lv_nmos ad=79.8f pd=0.8u as=0 ps=0 w=0.42u l=1u
X409 a_19550_1044# a_20391_1008# a_20315_1044# VDD sg13_lv_pmos ad=0.3808p pd=2.92u as=0.2128p ps=1.5u w=1.12u l=0.13u
X410 VDD VDD VDD VDD sg13_lv_pmos ad=0.2128p pd=1.5u as=0 ps=0 w=1.12u l=0.2u
X411 a_5631_1842# a_5393_1842# a_5523_1842# VSS.t164 sg13_lv_nmos ad=0.1406p pd=1.12u as=0.2516p ps=2.16u w=0.74u l=0.2u
X412 a_14513_1842# a_14317_1842# VSS.t361 VSS.t396 sg13_lv_nmos ad=0.2516p pd=2.16u as=0.1406p ps=1.12u w=0.74u l=0.13u
X413 VSS.t34 a_2595_311.t2 a_20905_519# VSS.t33 sg13_lv_nmos ad=0.2516p pd=2.16u as=0.2516p ps=2.16u w=0.74u l=0.13u
X414 VDD a_7477_1842# a_7945_1044# VDD sg13_lv_pmos ad=0.252p pd=1.57u as=0.3808p ps=2.92u w=1.12u l=0.13u
X415 a_13470_1044# a_3171_1047.t6 a_14888_1044# VSS.t0 sg13_lv_nmos ad=0.2516p pd=2.16u as=0.1406p ps=1.12u w=0.74u l=0.13u
X416 a_4633_1842# a_4437_1842# VSS.t174 VSS.t173 sg13_lv_nmos ad=0.2516p pd=2.16u as=0.1406p ps=1.12u w=0.74u l=0.13u
X417 a_1256_289# MUX_SEL2 VSS.t244 VSS.t243 sg13_lv_nmos ad=0.2516p pd=2.16u as=0.2516p ps=2.16u w=0.74u l=0.13u
X418 VSS.t212 a_2019_1047.t2 a_25604_1008# VSS.t211 sg13_lv_nmos ad=0.2516p pd=2.16u as=0.2516p ps=2.16u w=0.74u l=0.13u
X419 a_16108_289# MUX_SEL4 a_15964_289# VSS.t102 sg13_lv_nmos ad=0.2516p pd=2.16u as=0.2183p ps=1.33u w=0.74u l=0.13u
X420 a_22873_1842# a_22677_1842# VDD VDD sg13_lv_pmos ad=0.3808p pd=2.92u as=0.2128p ps=1.5u w=1.12u l=0.13u
X421 a_21835_1044# a_21625_1044# VSS.t393 VSS.t548 sg13_lv_nmos ad=0.1406p pd=1.12u as=0.1665p ps=1.19u w=0.74u l=0.13u
X422 VSS.t242 a_2595_1047.t4 a_20391_1008# VSS.t241 sg13_lv_nmos ad=0.2516p pd=2.16u as=0.2516p ps=2.16u w=0.74u l=0.13u
X423 a_9675_1044# a_9465_1044# VDD VDD sg13_lv_pmos ad=0.2128p pd=1.5u as=0.252p ps=1.57u w=1.12u l=0.13u
X424 VSS.t365 a_10517_1842# a_10985_1044# VSS.t364 sg13_lv_nmos ad=0.1665p pd=1.19u as=0.2516p ps=2.16u w=0.74u l=0.13u
X425 VDD a_2595_1047.t8 a_8231_1008# VDD sg13_lv_pmos ad=0.3808p pd=2.92u as=0.3808p ps=2.92u w=1.12u l=0.13u
X426 a_18551_1842# a_18313_1842# a_18443_1842# VSS.t384 sg13_lv_nmos ad=0.1406p pd=1.12u as=0.2516p ps=2.16u w=0.74u l=0.2u
X427 a_22351_1842# a_22113_1842# a_22243_1842# VSS.t496 sg13_lv_nmos ad=0.1406p pd=1.12u as=0.2516p ps=2.16u w=0.74u l=0.2u
X428 VSS.t138 a_3747_1047.t5 a_18871_1008# VSS.t137 sg13_lv_nmos ad=0.2516p pd=2.16u as=0.2516p ps=2.16u w=0.74u l=0.13u
X429 VSS.t190 a_16923_1842# a_17357_1842# VSS.t372 sg13_lv_nmos ad=0.1406p pd=1.12u as=0.2516p ps=2.16u w=0.74u l=0.13u
X430 VDD a_3171_311.t2 a_23945_519# VDD sg13_lv_pmos ad=0.3808p pd=2.92u as=0.3808p ps=2.92u w=1.12u l=0.13u
X431 a_2019_311# a_1721_331# VSS.t11 VSS.t10 sg13_lv_nmos ad=0.1406p pd=1.12u as=0.1331p ps=1.12u w=0.74u l=0.13u
X432 a_25153_1842# a_24957_1842# VDD VDD sg13_lv_pmos ad=0.3808p pd=2.92u as=0.2128p ps=1.5u w=1.12u l=0.13u
X433 a_17928_1044# a_17357_1842# VSS.t188 VSS.t187 sg13_lv_nmos ad=0.1406p pd=1.12u as=0.2516p ps=2.16u w=0.74u l=0.13u
X434 a_12715_1044# a_12505_1044# VSS.t119 VSS.t118 sg13_lv_nmos ad=0.1406p pd=1.12u as=0.1665p ps=1.19u w=0.74u l=0.13u
X435 VDD MUX_SEL4 a_15765_463# VDD sg13_lv_pmos ad=0.3808p pd=2.92u as=0.3808p ps=2.92u w=1.12u l=0.13u
X436 a_19550_1044# a_3171_1047.t4 a_20968_1044# VSS.t542 sg13_lv_nmos ad=0.2516p pd=2.16u as=0.1406p ps=1.12u w=0.74u l=0.13u
X437 VSS.t447 DELAY_VBIASN.t22 a_10951_1842# VSS.t446 sg13_lv_nmos ad=0.2516p pd=2.16u as=0.1406p ps=1.12u w=0.74u l=0.6u
X438 a_19550_1044# a_19524_1008# a_19448_1044# VDD sg13_lv_pmos ad=0.3808p pd=2.92u as=0.2128p ps=1.5u w=1.12u l=0.13u
X439 a_7288_1044# a_6717_1842# VSS.t503 VSS.t502 sg13_lv_nmos ad=0.1406p pd=1.12u as=0.2516p ps=2.16u w=0.74u l=0.13u
X440 VSS.t368 a_20723_1842# a_21157_1842# VSS.t367 sg13_lv_nmos ad=0.1406p pd=1.12u as=0.2516p ps=2.16u w=0.74u l=0.13u
X441 a_1544_289# MUX_SEL3 VSS.t176 VSS.t175 sg13_lv_nmos ad=0.2516p pd=2.16u as=0.2516p ps=2.16u w=0.74u l=0.13u
X442 a_13470_1044# a_14311_1008# a_14235_1044# VDD sg13_lv_pmos ad=0.3808p pd=2.92u as=0.2128p ps=1.5u w=1.12u l=0.13u
X443 a_22590_1044# a_3747_1047.t3 a_24875_1044# VSS.t145 sg13_lv_nmos ad=0.2516p pd=2.16u as=0.1406p ps=1.12u w=0.74u l=0.13u
X444 VSS.t425 DELAY_VBIASN.t5 a_23871_1842# VSS.t424 sg13_lv_nmos ad=0.2516p pd=2.16u as=0.1406p ps=1.12u w=0.74u l=0.6u
X445 VDD a_2019_1047.t3 a_22564_1008# VDD sg13_lv_pmos ad=0.3808p pd=2.92u as=0.3808p ps=2.92u w=1.12u l=0.13u
X446 VSS.t99 a_25717_1842# a_26185_1044# VSS.t98 sg13_lv_nmos ad=0.1665p pd=1.19u as=0.2516p ps=2.16u w=0.74u l=0.13u
X447 a_13231_1842# a_12993_1842# a_13123_1842# VSS.t517 sg13_lv_nmos ad=0.1406p pd=1.12u as=0.2516p ps=2.16u w=0.74u l=0.2u
X448 VSS.t269 VDD VSS.t267 VSS.t268 sg13_lv_nmos ad=79.8f pd=0.8u as=0 ps=0 w=0.42u l=1u
X449 a_17791_2470# a_17553_1842# a_17683_1842# VDD sg13_lv_pmos ad=0.2128p pd=1.5u as=0.3808p ps=2.92u w=1.12u l=0.2u
X450 VSS.t117 a_4437_1842# a_4905_1044# VSS.t172 sg13_lv_nmos ad=0.1665p pd=1.19u as=0.2516p ps=2.16u w=0.74u l=0.13u
X451 VDD VSS.t570 VDD VDD sg13_lv_pmos ad=0.34p pd=2.68u as=0 ps=0 w=1u l=1u
X452 a_12233_1842# a_12037_1842# VSS.t60 VSS.t558 sg13_lv_nmos ad=0.2516p pd=2.16u as=0.1406p ps=1.12u w=0.74u l=0.13u
X453 VSS.t9 a_3449_1395# a_3747_1047.t1 VSS.t8 sg13_lv_nmos ad=0.2812p pd=2.24u as=0.1406p ps=1.12u w=0.74u l=0.13u
X454 VDD VSS.t584 VDD VDD sg13_lv_pmos ad=0.34p pd=2.68u as=0 ps=0 w=1u l=1u
X455 VDD VSS.t579 VDD VDD sg13_lv_pmos ad=0.19p pd=1.38u as=0 ps=0 w=1u l=1u
X456 VSS.t334 VDD VSS.t332 VSS.t333 sg13_lv_nmos ad=79.8f pd=0.8u as=0 ps=0 w=0.42u l=1u
X457 VSS.t129 a_3171_1047.t8 a_8884_1008# VSS.t128 sg13_lv_nmos ad=0.2516p pd=2.16u as=0.2516p ps=2.16u w=0.74u l=0.13u
X458 a_21591_2470# a_21353_1842# a_21483_1842# VDD sg13_lv_pmos ad=0.2128p pd=1.5u as=0.3808p ps=2.92u w=1.12u l=0.2u
X459 VDD a_2873_1395# a_3171_1047.t0 VDD sg13_lv_pmos ad=0.4256p pd=3u as=0.2128p ps=1.5u w=1.12u l=0.13u
X460 a_6153_1842# a_5957_1842# VDD VDD sg13_lv_pmos ad=0.3808p pd=2.92u as=0.2128p ps=1.5u w=1.12u l=0.13u
X461 VDD a_16163_1842# a_16597_1842# VDD sg13_lv_pmos ad=0.2128p pd=1.5u as=0.3808p ps=2.92u w=1.12u l=0.13u
X462 a_3543_1395# MUX_SEL0 a_3449_1395# VSS.t495 sg13_lv_nmos ad=0.1216p pd=1.02u as=0.2176p ps=1.96u w=0.64u l=0.13u
X463 VDD a_1544_1044# a_2297_1395# VDD sg13_lv_pmos ad=0.1918p pd=1.5u as=0.1596p ps=1.22u w=0.84u l=0.13u
X464 VDD DELAY_VBIASP.t23 a_10191_2470# VDD sg13_lv_pmos ad=0.3808p pd=2.92u as=0.2128p ps=1.5u w=1.12u l=0.6u
X465 a_17275_1044# a_17065_1044# VDD VDD sg13_lv_pmos ad=0.2128p pd=1.5u as=0.252p ps=1.57u w=1.12u l=0.13u
X466 a_2019_1047.t0 a_1721_1395# VDD VDD sg13_lv_pmos ad=0.2128p pd=1.5u as=0.1918p ps=1.5u w=1.12u l=0.13u
X467 a_27915_1044# a_27705_1044# VSS.t62 VSS.t219 sg13_lv_nmos ad=0.1406p pd=1.12u as=0.1665p ps=1.19u w=0.74u l=0.13u
X468 VSS.t477 DELAY_VBIASN.t2 a_26151_1842# VSS.t476 sg13_lv_nmos ad=0.2516p pd=2.16u as=0.1406p ps=1.12u w=0.74u l=0.6u
X469 VDD a_3747_1047.t6 a_15831_1008# VDD sg13_lv_pmos ad=0.3808p pd=2.92u as=0.3808p ps=2.92u w=1.12u l=0.13u
X470 VDD a_19963_1842# a_20397_1842# VDD sg13_lv_pmos ad=0.2128p pd=1.5u as=0.3808p ps=2.92u w=1.12u l=0.13u
X471 VSS.t337 VDD VSS.t336 VSS.t335 sg13_lv_nmos ad=0.1428p pd=1.52u as=0 ps=0 w=0.42u l=1u
X472 VSS.t435 DELAY_VBIASN.t30 a_4871_1842# VSS.t434 sg13_lv_nmos ad=0.2516p pd=2.16u as=0.1406p ps=1.12u w=0.74u l=0.6u
X473 a_14888_1044# a_14317_1842# VDD VDD sg13_lv_pmos ad=0.2128p pd=1.5u as=0.3808p ps=2.92u w=1.12u l=0.13u
X474 a_4350_1044# a_4324_1008# a_4248_1044# VDD sg13_lv_pmos ad=0.3808p pd=2.92u as=0.2128p ps=1.5u w=1.12u l=0.13u
X475 a_1256_289# MUX_SEL2 VDD VDD sg13_lv_pmos ad=0.3808p pd=2.92u as=0.3808p ps=2.92u w=1.12u l=0.13u
X476 VSS.t355 VSS.t352 VSS.t354 VSS.t353 sg13_lv_nmos ad=0.2516p pd=2.16u as=0 ps=0 w=0.74u l=0.6u
X477 a_16108_289# a_15765_463# a_15964_289# VDD sg13_lv_pmos ad=0.3808p pd=2.92u as=0.3304p ps=1.71u w=1.12u l=0.13u
X478 a_11473_1842# a_11277_1842# VDD VDD sg13_lv_pmos ad=0.3808p pd=2.92u as=0.2128p ps=1.5u w=1.12u l=0.13u
X479 VDD a_8997_1842# a_9465_1044# VDD sg13_lv_pmos ad=0.252p pd=1.57u as=0.3808p ps=2.92u w=1.12u l=0.13u
X480 a_27433_1842# a_27237_1842# VSS.t64 VSS.t63 sg13_lv_nmos ad=0.2516p pd=2.16u as=0.1406p ps=1.12u w=0.74u l=0.13u
X481 a_2391_331# MUX_SEL2 a_2297_331# VSS.t245 sg13_lv_nmos ad=0.1216p pd=1.02u as=0.2176p ps=1.96u w=0.64u l=0.13u
X482 a_2967_331# MUX_SEL3 a_2873_331# VSS.t177 sg13_lv_nmos ad=0.1216p pd=1.02u as=0.2176p ps=1.96u w=0.64u l=0.13u
X483 VDD a_2019_1047.t5 a_16484_1008# VDD sg13_lv_pmos ad=0.3808p pd=2.92u as=0.3808p ps=2.92u w=1.12u l=0.13u
X484 a_7390_1044# a_2595_1047.t8 a_8155_1044# VSS.t43 sg13_lv_nmos ad=0.2516p pd=2.16u as=0.1406p ps=1.12u w=0.74u l=0.13u
X485 VSS.t443 DELAY_VBIASN.t27 a_7151_1842# VSS.t442 sg13_lv_nmos ad=0.2516p pd=2.16u as=0.1406p ps=1.12u w=0.74u l=0.6u
X486 VDD a_3171_1047.t9 a_5844_1008# VDD sg13_lv_pmos ad=0.3808p pd=2.92u as=0.3808p ps=2.92u w=1.12u l=0.13u
X487 VDD DELAY_VBIASP.t3 a_25391_2470# VDD sg13_lv_pmos ad=0.3808p pd=2.92u as=0.2128p ps=1.5u w=1.12u l=0.6u
X488 VDD a_2595_1047.t7 a_11271_1008# VDD sg13_lv_pmos ad=0.3808p pd=2.92u as=0.3808p ps=2.92u w=1.12u l=0.13u
X489 VDD VSS.t587 VDD VDD sg13_lv_pmos ad=0.19p pd=1.38u as=0 ps=0 w=1u l=1u
X490 VSS.t119 a_12037_1842# a_12505_1044# VSS.t559 sg13_lv_nmos ad=0.1665p pd=1.19u as=0.2516p ps=2.16u w=0.74u l=0.13u
X491 VDD a_3747_1047.t8 a_9751_1008# VDD sg13_lv_pmos ad=0.3808p pd=2.92u as=0.3808p ps=2.92u w=1.12u l=0.13u
X492 a_9431_1842# a_9193_1842# a_9323_1842# VSS.t167 sg13_lv_nmos ad=0.1406p pd=1.12u as=0.2516p ps=2.16u w=0.74u l=0.2u
X493 a_18313_1842# a_18117_1842# VSS.t254 VSS.t383 sg13_lv_nmos ad=0.2516p pd=2.16u as=0.1406p ps=1.12u w=0.74u l=0.13u
X494 MUX_OUT a_16851_309# VSS.t77 VSS.t76 sg13_lv_nmos ad=0.1406p pd=1.12u as=0.1371p ps=1.12u w=0.74u l=0.13u
X495 VSS.t329 VDD VSS.t327 VSS.t328 sg13_lv_nmos ad=79.8f pd=0.8u as=0 ps=0 w=0.42u l=1u
X496 a_23871_1842# a_23633_1842# a_23763_1842# VSS.t75 sg13_lv_nmos ad=0.1406p pd=1.12u as=0.2516p ps=2.16u w=0.74u l=0.2u
X497 a_8433_1842# a_8237_1842# VSS.t410 VSS.t409 sg13_lv_nmos ad=0.2516p pd=2.16u as=0.1406p ps=1.12u w=0.74u l=0.13u
X498 VSS.t68 a_18443_1842# a_18877_1842# VSS.t207 sg13_lv_nmos ad=0.1406p pd=1.12u as=0.2516p ps=2.16u w=0.74u l=0.13u
X499 VSS.t294 VDD VSS.t292 VSS.t293 sg13_lv_nmos ad=79.8f pd=0.8u as=0 ps=0 w=0.42u l=1u
X500 a_22113_1842# a_21917_1842# VSS.t17 VSS.t487 sg13_lv_nmos ad=0.2516p pd=2.16u as=0.1406p ps=1.12u w=0.74u l=0.13u
X501 a_1544_289# MUX_SEL3 VDD VDD sg13_lv_pmos ad=0.3808p pd=2.92u as=0.3808p ps=2.92u w=1.12u l=0.13u
X502 a_26673_1842# a_26477_1842# VDD VDD sg13_lv_pmos ad=0.3808p pd=2.92u as=0.2128p ps=1.5u w=1.12u l=0.13u
X503 a_10328_1044# a_9757_1842# VSS.t510 VSS.t509 sg13_lv_nmos ad=0.1406p pd=1.12u as=0.2516p ps=2.16u w=0.74u l=0.13u
X504 VSS.t297 VDD VSS.t296 VSS.t295 sg13_lv_nmos ad=0.1428p pd=1.52u as=0 ps=0 w=0.42u l=1u
X505 a_22590_1044# a_2019_1047.t3 a_22488_1044# VSS.t536 sg13_lv_nmos ad=0.2516p pd=2.16u as=0.1406p ps=1.12u w=0.74u l=0.13u
X506 VSS.t423 DELAY_VBIASN.t20 a_12471_1842# VSS.t422 sg13_lv_nmos ad=0.2516p pd=2.16u as=0.1406p ps=1.12u w=0.74u l=0.6u
X507 a_8808_1044# a_8237_1842# VSS.t412 VSS.t411 sg13_lv_nmos ad=0.1406p pd=1.12u as=0.2516p ps=2.16u w=0.74u l=0.13u
X508 VSS.t201 a_22243_1842# a_22677_1842# VSS.t202 sg13_lv_nmos ad=0.1406p pd=1.12u as=0.2516p ps=2.16u w=0.74u l=0.13u
X509 VDD DELAY_VBIASP.t28 a_6391_2470# VDD sg13_lv_pmos ad=0.3808p pd=2.92u as=0.2128p ps=1.5u w=1.12u l=0.6u
X510 a_13470_1044# a_15831_1008# a_15755_1044# VDD sg13_lv_pmos ad=0.3808p pd=2.92u as=0.2128p ps=1.5u w=1.12u l=0.13u
X511 a_1544_1044# MUX_SEL1 VDD VDD sg13_lv_pmos ad=0.3808p pd=2.92u as=0.3808p ps=2.92u w=1.12u l=0.13u
X512 VDD DELAY_VBIASP.t9 a_20831_2470# VDD sg13_lv_pmos ad=0.3808p pd=2.92u as=0.2128p ps=1.5u w=1.12u l=0.6u
X513 VDD a_2595_1047.t2 a_26471_1008# VDD sg13_lv_pmos ad=0.3808p pd=2.92u as=0.3808p ps=2.92u w=1.12u l=0.13u
X514 a_4350_1044# a_5191_1008# a_5115_1044# VDD sg13_lv_pmos ad=0.3808p pd=2.92u as=0.2128p ps=1.5u w=1.12u l=0.13u
X515 VDD a_16597_1842# a_17065_1044# VDD sg13_lv_pmos ad=0.252p pd=1.57u as=0.3808p ps=2.92u w=1.12u l=0.13u
X516 VSS.t62 a_27237_1842# a_27705_1044# VSS.t61 sg13_lv_nmos ad=0.1665p pd=1.19u as=0.2516p ps=2.16u w=0.74u l=0.13u
X517 a_10191_2470# a_9953_1842# a_10083_1842# VDD sg13_lv_pmos ad=0.2128p pd=1.5u as=0.3808p ps=2.92u w=1.12u l=0.2u
X518 a_2595_1047.t1 a_2297_1395# VSS.t113 VSS.t112 sg13_lv_nmos ad=0.1406p pd=1.12u as=0.1331p ps=1.12u w=0.74u l=0.13u
X519 a_26151_1842# a_25913_1842# a_26043_1842# VSS.t552 sg13_lv_nmos ad=0.1406p pd=1.12u as=0.2516p ps=2.16u w=0.74u l=0.2u
X520 VSS.t378 a_2019_311# a_17865_519# VSS.t377 sg13_lv_nmos ad=0.2516p pd=2.16u as=0.2516p ps=2.16u w=0.74u l=0.13u
X521 VSS.t36 a_1544_289# a_2391_331# VSS.t560 sg13_lv_nmos ad=0.1331p pd=1.12u as=0.1216p ps=1.02u w=0.64u l=0.13u
X522 a_4871_1842# a_4633_1842# a_4763_1842# VSS.t421 sg13_lv_nmos ad=0.1406p pd=1.12u as=0.2516p ps=2.16u w=0.74u l=0.2u
X523 a_13753_1842# a_13557_1842# VSS.t206 VSS.t205 sg13_lv_nmos ad=0.2516p pd=2.16u as=0.1406p ps=1.12u w=0.74u l=0.13u
X524 a_1815_1395# a_1256_1044# a_1721_1395# VSS.t151 sg13_lv_nmos ad=0.1216p pd=1.02u as=0.2176p ps=1.96u w=0.64u l=0.13u
X525 a_7673_1842# a_7477_1842# VDD VDD sg13_lv_pmos ad=0.3808p pd=2.92u as=0.2128p ps=1.5u w=1.12u l=0.13u
X526 VDD VSS.t580 VDD VDD sg13_lv_pmos ad=0.34p pd=2.68u as=0 ps=0 w=1u l=1u
X527 a_1721_331# a_1256_289# VDD VDD sg13_lv_pmos ad=0.1596p pd=1.22u as=0.2856p ps=2.36u w=0.84u l=0.13u
X528 VSS.t197 a_24523_1842# a_24957_1842# VSS.t379 sg13_lv_nmos ad=0.1406p pd=1.12u as=0.2516p ps=2.16u w=0.74u l=0.13u
X529 a_6635_1044# a_6425_1044# VSS.t155 VSS.t154 sg13_lv_nmos ad=0.1406p pd=1.12u as=0.1665p ps=1.19u w=0.74u l=0.13u
X530 VSS.t86 a_2595_1047.t9 a_5191_1008# VSS.t85 sg13_lv_nmos ad=0.2516p pd=2.16u as=0.2516p ps=2.16u w=0.74u l=0.13u
X531 a_20315_1044# a_20105_1044# VSS.t163 VSS.t549 sg13_lv_nmos ad=0.1406p pd=1.12u as=0.1665p ps=1.19u w=0.74u l=0.13u
X532 VDD DELAY_VBIASP.t21 a_11711_2470# VDD sg13_lv_pmos ad=0.3808p pd=2.92u as=0.2128p ps=1.5u w=1.12u l=0.6u
X533 a_18795_1044# a_18585_1044# VDD VDD sg13_lv_pmos ad=0.2128p pd=1.5u as=0.252p ps=1.57u w=1.12u l=0.13u
X534 a_25528_1044# a_24957_1842# VSS.t195 VSS.t194 sg13_lv_nmos ad=0.1406p pd=1.12u as=0.2516p ps=2.16u w=0.74u l=0.13u
X535 VSS.t473 DELAY_VBIASN.t0 a_27671_1842# VSS.t472 sg13_lv_nmos ad=0.2516p pd=2.16u as=0.1406p ps=1.12u w=0.74u l=0.6u
X536 a_5731_289# a_3747_311.t3 a_13470_1044# VSS.t237 sg13_lv_nmos ad=0.2516p pd=2.16u as=0.2516p ps=2.16u w=0.74u l=0.13u
X537 a_25630_1044# a_27124_1008# a_27048_1044# VDD sg13_lv_pmos ad=0.3808p pd=2.92u as=0.2128p ps=1.5u w=1.12u l=0.13u
X538 VDD a_2595_1047.t5 a_17351_1008# VDD sg13_lv_pmos ad=0.3808p pd=2.92u as=0.3808p ps=2.92u w=1.12u l=0.13u
X539 VDD a_21483_1842# a_21917_1842# VDD sg13_lv_pmos ad=0.2128p pd=1.5u as=0.3808p ps=2.92u w=1.12u l=0.13u
X540 a_4350_1044# a_5844_1008# a_5768_1044# VDD sg13_lv_pmos ad=0.3808p pd=2.92u as=0.2128p ps=1.5u w=1.12u l=0.13u
X541 VSS.t79 a_16851_309# MUX_OUT VSS.t78 sg13_lv_nmos ad=0.2516p pd=2.16u as=0.1406p ps=1.12u w=0.74u l=0.13u
X542 VSS.t375 a_2019_311# a_5705_519# VSS.t374 sg13_lv_nmos ad=0.2516p pd=2.16u as=0.2516p ps=2.16u w=0.74u l=0.13u
X543 VDD a_1544_289# a_1721_331# VDD sg13_lv_pmos ad=0.1918p pd=1.5u as=0.1596p ps=1.22u w=0.84u l=0.13u
X544 a_7151_1842# a_6913_1842# a_7043_1842# VSS.t55 sg13_lv_nmos ad=0.1406p pd=1.12u as=0.2516p ps=2.16u w=0.74u l=0.2u
X545 a_16033_1842# a_15837_1842# VSS.t54 VSS.t500 sg13_lv_nmos ad=0.2516p pd=2.16u as=0.1406p ps=1.12u w=0.74u l=0.13u
X546 MUX_OUT a_16851_309# VDD VDD sg13_lv_pmos ad=0.2128p pd=1.5u as=0.2086p ps=1.5u w=1.12u l=0.13u
X547 a_25391_2470# a_25153_1842# a_25283_1842# VDD sg13_lv_pmos ad=0.2128p pd=1.5u as=0.3808p ps=2.92u w=1.12u l=0.2u
X548 VDD VSS.t592 VDD VDD sg13_lv_pmos ad=0.34p pd=2.68u as=0 ps=0 w=1u l=1u
X549 a_12993_1842# a_12797_1842# VDD VDD sg13_lv_pmos ad=0.3808p pd=2.92u as=0.2128p ps=1.5u w=1.12u l=0.13u
X550 a_16408_1044# a_15837_1842# VSS.t499 VSS.t498 sg13_lv_nmos ad=0.1406p pd=1.12u as=0.2516p ps=2.16u w=0.74u l=0.13u
X551 VSS.t171 a_5523_1842# a_5957_1842# VSS.t359 sg13_lv_nmos ad=0.1406p pd=1.12u as=0.2516p ps=2.16u w=0.74u l=0.13u
X552 VDD DELAY_VBIASP.t18 a_13991_2470# VDD sg13_lv_pmos ad=0.3808p pd=2.92u as=0.2128p ps=1.5u w=1.12u l=0.6u
X553 a_5731_289# a_2019_311# a_4350_1044# VSS.t373 sg13_lv_nmos ad=0.2516p pd=2.16u as=0.2516p ps=2.16u w=0.74u l=0.13u
X554 a_7390_1044# a_3747_1047.t8 a_9675_1044# VSS.t228 sg13_lv_nmos ad=0.2516p pd=2.16u as=0.1406p ps=1.12u w=0.74u l=0.13u
X555 VDD a_23763_1842# a_24197_1842# VDD sg13_lv_pmos ad=0.2128p pd=1.5u as=0.3808p ps=2.92u w=1.12u l=0.13u
X556 VSS.t433 DELAY_VBIASN.t25 a_8671_1842# VSS.t432 sg13_lv_nmos ad=0.2516p pd=2.16u as=0.1406p ps=1.12u w=0.74u l=0.6u
X557 VDD a_2019_1047.t8 a_7364_1008# VDD sg13_lv_pmos ad=0.3808p pd=2.92u as=0.3808p ps=2.92u w=1.12u l=0.13u
X558 VDD DELAY_VBIASP.t1 a_26911_2470# VDD sg13_lv_pmos ad=0.3808p pd=2.92u as=0.2128p ps=1.5u w=1.12u l=0.6u
X559 VDD VSS.t563 VDD VDD sg13_lv_pmos ad=0.19p pd=1.38u as=0 ps=0 w=1u l=1u
X560 a_12471_1842# a_12233_1842# a_12363_1842# VSS.t14 sg13_lv_nmos ad=0.1406p pd=1.12u as=0.2516p ps=2.16u w=0.74u l=0.2u
X561 a_22488_1044# a_21917_1842# VDD VDD sg13_lv_pmos ad=0.2128p pd=1.5u as=0.3808p ps=2.92u w=1.12u l=0.13u
X562 VDD a_2595_311.t3 a_8745_519# VDD sg13_lv_pmos ad=0.3808p pd=2.92u as=0.3808p ps=2.92u w=1.12u l=0.13u
X563 VSS.t126 a_3171_1047.t5 a_18004_1008# VSS.t125 sg13_lv_nmos ad=0.2516p pd=2.16u as=0.2516p ps=2.16u w=0.74u l=0.13u
X564 a_6391_2470# a_6153_1842# a_6283_1842# VDD sg13_lv_pmos ad=0.2128p pd=1.5u as=0.3808p ps=2.92u w=1.12u l=0.2u
X565 a_15273_1842# a_15077_1842# VDD VDD sg13_lv_pmos ad=0.3808p pd=2.92u as=0.2128p ps=1.5u w=1.12u l=0.13u
X566 a_14235_1044# a_14025_1044# VSS.t204 VSS.t226 sg13_lv_nmos ad=0.1406p pd=1.12u as=0.1665p ps=1.19u w=0.74u l=0.13u
X567 VSS.t215 a_3747_1047.t7 a_12791_1008# VSS.t214 sg13_lv_nmos ad=0.2516p pd=2.16u as=0.2516p ps=2.16u w=0.74u l=0.13u
X568 a_9953_1842# a_9757_1842# VSS.t408 VSS.t511 sg13_lv_nmos ad=0.2516p pd=2.16u as=0.1406p ps=1.12u w=0.74u l=0.13u
X569 VSS.t513 a_10843_1842# a_11277_1842# VSS.t522 sg13_lv_nmos ad=0.1406p pd=1.12u as=0.2516p ps=2.16u w=0.74u l=0.13u
X570 VSS.t327 VDD VSS.t326 VSS.t325 sg13_lv_nmos ad=0.1428p pd=1.52u as=0 ps=0 w=0.42u l=1u
X571 VDD a_15403_1842# a_15837_1842# VDD sg13_lv_pmos ad=0.2128p pd=1.5u as=0.3808p ps=2.92u w=1.12u l=0.13u
X572 VSS.t292 VDD VSS.t291 VSS.t290 sg13_lv_nmos ad=0.1428p pd=1.52u as=0 ps=0 w=0.42u l=1u
X573 a_11848_1044# a_11277_1842# VSS.t515 VSS.t514 sg13_lv_nmos ad=0.1406p pd=1.12u as=0.2516p ps=2.16u w=0.74u l=0.13u
X574 VDD a_4763_1842# a_5197_1842# VDD sg13_lv_pmos ad=0.2128p pd=1.5u as=0.3808p ps=2.92u w=1.12u l=0.13u
X575 VSS.t304 VDD VSS.t302 VSS.t303 sg13_lv_nmos ad=79.8f pd=0.8u as=0 ps=0 w=0.42u l=1u
X576 a_13470_1044# a_13444_1008# a_13368_1044# VDD sg13_lv_pmos ad=0.3808p pd=2.92u as=0.2128p ps=1.5u w=1.12u l=0.13u
X577 VDD a_3449_1395# a_3747_1047.t0 VDD sg13_lv_pmos ad=0.4256p pd=3u as=0.2128p ps=1.5u w=1.12u l=0.13u
X578 VDD a_3171_1047.t3 a_24084_1008# VDD sg13_lv_pmos ad=0.3808p pd=2.92u as=0.3808p ps=2.92u w=1.12u l=0.13u
X579 a_3449_1395# MUX_SEL0 VDD VDD sg13_lv_pmos ad=0.1596p pd=1.22u as=0.2856p ps=2.36u w=0.84u l=0.13u
X580 VDD DELAY_VBIASP.t26 a_7911_2470# VDD sg13_lv_pmos ad=0.3808p pd=2.92u as=0.2128p ps=1.5u w=1.12u l=0.6u
X581 VDD VSS.t595 VDD VDD sg13_lv_pmos ad=0.19p pd=1.38u as=0 ps=0 w=1u l=1u
X582 VDD VSS.t594 VDD VDD sg13_lv_pmos ad=0.34p pd=2.68u as=0 ps=0 w=1u l=1u
X583 VDD a_16851_309# MUX_OUT VDD sg13_lv_pmos ad=0.7336p pd=3.55u as=0.2128p ps=1.5u w=1.12u l=0.13u
X584 VSS.t123 a_3171_311.t2 a_23945_519# VSS.t122 sg13_lv_nmos ad=0.2516p pd=2.16u as=0.2516p ps=2.16u w=0.74u l=0.13u
X585 VDD a_18117_1842# a_18585_1044# VDD sg13_lv_pmos ad=0.252p pd=1.57u as=0.3808p ps=2.92u w=1.12u l=0.13u
X586 VSS.t163 a_19637_1842# a_20105_1044# VSS.t162 sg13_lv_nmos ad=0.1665p pd=1.19u as=0.2516p ps=2.16u w=0.74u l=0.13u
X587 a_11711_2470# a_11473_1842# a_11603_1842# VDD sg13_lv_pmos ad=0.2128p pd=1.5u as=0.3808p ps=2.92u w=1.12u l=0.2u
X588 a_27671_1842# a_27433_1842# a_27563_1842# VSS.t366 sg13_lv_nmos ad=0.1406p pd=1.12u as=0.2516p ps=2.16u w=0.74u l=0.2u
X589 VSS.t104 MUX_SEL4 a_15765_463# VSS.t103 sg13_lv_nmos ad=0.2516p pd=2.16u as=0.2516p ps=2.16u w=0.74u l=0.13u
X590 a_5731_289# a_14825_519# a_13470_1044# VDD sg13_lv_pmos ad=0.3808p pd=2.92u as=0.3808p ps=2.92u w=1.12u l=0.13u
X591 a_16510_1044# a_2595_1047.t5 a_17275_1044# VSS.t23 sg13_lv_nmos ad=0.2516p pd=2.16u as=0.1406p ps=1.12u w=0.74u l=0.13u
X592 VSS.t465 DELAY_VBIASN.t15 a_16271_1842# VSS.t464 sg13_lv_nmos ad=0.2516p pd=2.16u as=0.1406p ps=1.12u w=0.74u l=0.6u
X593 VDD VSS.t568 VDD VDD sg13_lv_pmos ad=0.34p pd=2.68u as=0 ps=0 w=1u l=1u
X594 VDD a_3171_1047.t6 a_14964_1008# VDD sg13_lv_pmos ad=0.3808p pd=2.92u as=0.3808p ps=2.92u w=1.12u l=0.13u
X595 VDD a_10083_1842# a_10517_1842# VDD sg13_lv_pmos ad=0.2128p pd=1.5u as=0.3808p ps=2.92u w=1.12u l=0.13u
X596 VSS.t150 a_3747_1047.t2 a_27991_1008# VSS.t149 sg13_lv_nmos ad=0.2516p pd=2.16u as=0.2516p ps=2.16u w=0.74u l=0.13u
X597 VSS.t186 a_26043_1842# a_26477_1842# VSS.t556 sg13_lv_nmos ad=0.1406p pd=1.12u as=0.2516p ps=2.16u w=0.74u l=0.13u
X598 a_11195_1044# a_10985_1044# VDD VDD sg13_lv_pmos ad=0.2128p pd=1.5u as=0.252p ps=1.57u w=1.12u l=0.13u
X599 VSS.t111 a_3747_1047.t9 a_6711_1008# VSS.t110 sg13_lv_nmos ad=0.2516p pd=2.16u as=0.2516p ps=2.16u w=0.74u l=0.13u
X600 a_16108_289# a_2595_311.t2 a_19550_1044# VSS.t32 sg13_lv_nmos ad=0.2516p pd=2.16u as=0.2516p ps=2.16u w=0.74u l=0.13u
X601 VSS.t471 DELAY_VBIASN.t10 a_20071_1842# VSS.t470 sg13_lv_nmos ad=0.2516p pd=2.16u as=0.1406p ps=1.12u w=0.74u l=0.6u
X602 VDD DELAY_VBIASP.t4 a_24631_2470# VDD sg13_lv_pmos ad=0.3808p pd=2.92u as=0.2128p ps=1.5u w=1.12u l=0.6u
X603 a_22590_1044# a_23431_1008# a_23355_1044# VDD sg13_lv_pmos ad=0.3808p pd=2.92u as=0.2128p ps=1.5u w=1.12u l=0.13u
X604 VSS.t284 VDD VSS.t282 VSS.t283 sg13_lv_nmos ad=79.8f pd=0.8u as=0 ps=0 w=0.42u l=1u
X605 a_8671_1842# a_8433_1842# a_8563_1842# VSS.t530 sg13_lv_nmos ad=0.1406p pd=1.12u as=0.2516p ps=2.16u w=0.74u l=0.2u
X606 a_17553_1842# a_17357_1842# VSS.t190 VSS.t189 sg13_lv_nmos ad=0.2516p pd=2.16u as=0.1406p ps=1.12u w=0.74u l=0.13u
X607 a_5731_289# a_5705_519# a_4350_1044# VDD sg13_lv_pmos ad=0.3808p pd=2.92u as=0.3808p ps=2.92u w=1.12u l=0.13u
X608 VDD VDD VDD VDD sg13_lv_pmos ad=0.3808p pd=2.92u as=0 ps=0 w=1.12u l=0.13u
X609 a_26911_2470# a_26673_1842# a_26803_1842# VDD sg13_lv_pmos ad=0.2128p pd=1.5u as=0.3808p ps=2.92u w=1.12u l=0.2u
X610 a_7390_1044# a_2019_1047.t8 a_7288_1044# VSS.t527 sg13_lv_nmos ad=0.2516p pd=2.16u as=0.1406p ps=1.12u w=0.74u l=0.13u
X611 a_21353_1842# a_21157_1842# VSS.t368 VSS.t391 sg13_lv_nmos ad=0.2516p pd=2.16u as=0.1406p ps=1.12u w=0.74u l=0.13u
X612 VSS.t166 a_7043_1842# a_7477_1842# VSS.t165 sg13_lv_nmos ad=0.1406p pd=1.12u as=0.2516p ps=2.16u w=0.74u l=0.13u
X613 VDD DELAY_VBIASP.t16 a_15511_2470# VDD sg13_lv_pmos ad=0.3808p pd=2.92u as=0.2128p ps=1.5u w=1.12u l=0.6u
X614 VDD a_2019_1047.t7 a_10404_1008# VDD sg13_lv_pmos ad=0.3808p pd=2.92u as=0.3808p ps=2.92u w=1.12u l=0.13u
X615 VDD a_25283_1842# a_25717_1842# VDD sg13_lv_pmos ad=0.2128p pd=1.5u as=0.3808p ps=2.92u w=1.12u l=0.13u
X616 VDD DELAY_VBIASP.t29 a_5631_2470# VDD sg13_lv_pmos ad=0.3808p pd=2.92u as=0.2128p ps=1.5u w=1.12u l=0.6u
X617 a_26395_1044# a_26185_1044# VDD VDD sg13_lv_pmos ad=0.2128p pd=1.5u as=0.252p ps=1.57u w=1.12u l=0.13u
X618 VDD a_3747_1047.t3 a_24951_1008# VDD sg13_lv_pmos ad=0.3808p pd=2.92u as=0.3808p ps=2.92u w=1.12u l=0.13u
X619 VDD VSS.t571 VDD VDD sg13_lv_pmos ad=0.19p pd=1.38u as=0 ps=0 w=1u l=1u
X620 a_13991_1842# a_13753_1842# a_13883_1842# VSS.t497 sg13_lv_nmos ad=0.1406p pd=1.12u as=0.2516p ps=2.16u w=0.74u l=0.2u
X621 a_24008_1044# a_23437_1842# VDD VDD sg13_lv_pmos ad=0.2128p pd=1.5u as=0.3808p ps=2.92u w=1.12u l=0.13u
X622 VDD VSS.t585 VDD VDD sg13_lv_pmos ad=0.19p pd=1.38u as=0 ps=0 w=1u l=1u
X623 VSS.t541 a_2019_1047.t4 a_19524_1008# VSS.t540 sg13_lv_nmos ad=0.2516p pd=2.16u as=0.2516p ps=2.16u w=0.74u l=0.13u
X624 a_7911_2470# a_7673_1842# a_7803_1842# VDD sg13_lv_pmos ad=0.2128p pd=1.5u as=0.3808p ps=2.92u w=1.12u l=0.2u
X625 a_16793_1842# a_16597_1842# VDD VDD sg13_lv_pmos ad=0.3808p pd=2.92u as=0.2128p ps=1.5u w=1.12u l=0.13u
X626 VSS.t7 MUX_SEL1 a_3543_1395# VSS.t521 sg13_lv_nmos ad=0.1331p pd=1.12u as=0.1216p ps=1.02u w=0.64u l=0.13u
X627 a_15755_1044# a_15545_1044# VSS.t416 VSS.t545 sg13_lv_nmos ad=0.1406p pd=1.12u as=0.1665p ps=1.19u w=0.74u l=0.13u
X628 a_2595_1047.t0 a_2297_1395# VDD VDD sg13_lv_pmos ad=0.2128p pd=1.5u as=0.1918p ps=1.5u w=1.12u l=0.13u
X629 VSS.t28 a_2595_1047.t6 a_14311_1008# VSS.t27 sg13_lv_nmos ad=0.2516p pd=2.16u as=0.2516p ps=2.16u w=0.74u l=0.13u
X630 VSS.t371 a_12363_1842# a_12797_1842# VSS.t370 sg13_lv_nmos ad=0.1406p pd=1.12u as=0.2516p ps=2.16u w=0.74u l=0.13u
X631 a_5115_1044# a_4905_1044# VSS.t117 VSS.t116 sg13_lv_nmos ad=0.1406p pd=1.12u as=0.1665p ps=1.19u w=0.74u l=0.13u
X632 a_1256_1044# MUX_SEL0 VDD VDD sg13_lv_pmos ad=0.3808p pd=2.92u as=0.3808p ps=2.92u w=1.12u l=0.13u
X633 VDD a_27563_1842# a_27997_1842# VDD sg13_lv_pmos ad=0.2128p pd=1.5u as=0.3808p ps=2.92u w=1.12u l=0.13u
X634 a_20593_1842# a_20397_1842# VDD VDD sg13_lv_pmos ad=0.3808p pd=2.92u as=0.2128p ps=1.5u w=1.12u l=0.13u
X635 a_1721_1395# a_1256_1044# VDD VDD sg13_lv_pmos ad=0.1596p pd=1.22u as=0.2856p ps=2.36u w=0.84u l=0.13u
X636 VDD a_6283_1842# a_6717_1842# VDD sg13_lv_pmos ad=0.2128p pd=1.5u as=0.3808p ps=2.92u w=1.12u l=0.13u
X637 a_13470_1044# a_14964_1008# a_14888_1044# VDD sg13_lv_pmos ad=0.3808p pd=2.92u as=0.2128p ps=1.5u w=1.12u l=0.13u
X638 VSS.t302 VDD VSS.t301 VSS.t300 sg13_lv_nmos ad=0.1428p pd=1.52u as=0 ps=0 w=0.42u l=1u
X639 VDD a_2019_1047.t2 a_25604_1008# VDD sg13_lv_pmos ad=0.3808p pd=2.92u as=0.3808p ps=2.92u w=1.12u l=0.13u
X640 a_16271_1842# a_16033_1842# a_16163_1842# VSS.t551 sg13_lv_nmos ad=0.1406p pd=1.12u as=0.2516p ps=2.16u w=0.74u l=0.2u
X641 a_21835_1044# a_21625_1044# VDD VDD sg13_lv_pmos ad=0.2128p pd=1.5u as=0.252p ps=1.57u w=1.12u l=0.13u
X642 VDD VSS.t596 VDD VDD sg13_lv_pmos ad=0.34p pd=2.68u as=0 ps=0 w=1u l=1u
X643 VDD a_2595_1047.t4 a_20391_1008# VDD sg13_lv_pmos ad=0.3808p pd=2.92u as=0.3808p ps=2.92u w=1.12u l=0.13u
X644 a_19073_1842# a_18877_1842# VDD VDD sg13_lv_pmos ad=0.3808p pd=2.92u as=0.2128p ps=1.5u w=1.12u l=0.13u
X645 VDD a_10517_1842# a_10985_1044# VDD sg13_lv_pmos ad=0.252p pd=1.57u as=0.3808p ps=2.92u w=1.12u l=0.13u
X646 VSS.t393 a_21157_1842# a_21625_1044# VSS.t392 sg13_lv_nmos ad=0.1665p pd=1.19u as=0.2516p ps=2.16u w=0.74u l=0.13u
X647 a_20071_1842# a_19833_1842# a_19963_1842# VSS.t15 sg13_lv_nmos ad=0.1406p pd=1.12u as=0.2516p ps=2.16u w=0.74u l=0.2u
X648 VSS.t40 a_14643_1842# a_15077_1842# VSS.t39 sg13_lv_nmos ad=0.1406p pd=1.12u as=0.2516p ps=2.16u w=0.74u l=0.13u
X649 a_1815_331# a_1256_289# a_1721_331# VSS.t158 sg13_lv_nmos ad=0.1216p pd=1.02u as=0.2176p ps=1.96u w=0.64u l=0.13u
X650 VDD a_19203_1842# a_19637_1842# VDD sg13_lv_pmos ad=0.2128p pd=1.5u as=0.3808p ps=2.92u w=1.12u l=0.13u
X651 VSS.t236 a_2019_1047.t9 a_4324_1008# VSS.t235 sg13_lv_nmos ad=0.2516p pd=2.16u as=0.2516p ps=2.16u w=0.74u l=0.13u
X652 a_16108_289# a_20905_519# a_19550_1044# VDD sg13_lv_pmos ad=0.3808p pd=2.92u as=0.3808p ps=2.92u w=1.12u l=0.13u
X653 a_16510_1044# a_3747_1047.t5 a_18795_1044# VSS.t136 sg13_lv_nmos ad=0.2516p pd=2.16u as=0.1406p ps=1.12u w=0.74u l=0.13u
X654 VDD a_8563_1842# a_8997_1842# VDD sg13_lv_pmos ad=0.2128p pd=1.5u as=0.3808p ps=2.92u w=1.12u l=0.13u
X655 VDD DELAY_VBIASP.t19 a_13231_2470# VDD sg13_lv_pmos ad=0.3808p pd=2.92u as=0.2128p ps=1.5u w=1.12u l=0.6u
X656 VSS.t451 DELAY_VBIASN.t13 a_17791_1842# VSS.t450 sg13_lv_nmos ad=0.2516p pd=2.16u as=0.1406p ps=1.12u w=0.74u l=0.6u
X657 VSS.t272 VDD VSS.t271 VSS.t270 sg13_lv_nmos ad=0.1428p pd=1.52u as=0 ps=0 w=0.42u l=1u
X658 VDD a_3747_1047.t5 a_18871_1008# VDD sg13_lv_pmos ad=0.3808p pd=2.92u as=0.3808p ps=2.92u w=1.12u l=0.13u
X659 VDD a_23003_1842# a_23437_1842# VDD sg13_lv_pmos ad=0.2128p pd=1.5u as=0.3808p ps=2.92u w=1.12u l=0.13u
X660 a_12715_1044# a_12505_1044# VDD VDD sg13_lv_pmos ad=0.2128p pd=1.5u as=0.252p ps=1.57u w=1.12u l=0.13u
X661 a_19550_1044# a_21044_1008# a_20968_1044# VDD sg13_lv_pmos ad=0.3808p pd=2.92u as=0.2128p ps=1.5u w=1.12u l=0.13u
X662 a_17928_1044# a_17357_1842# VDD VDD sg13_lv_pmos ad=0.2128p pd=1.5u as=0.3808p ps=2.92u w=1.12u l=0.13u
X663 VSS.t431 DELAY_VBIASN.t8 a_21591_1842# VSS.t430 sg13_lv_nmos ad=0.2516p pd=2.16u as=0.1406p ps=1.12u w=0.74u l=0.6u
X664 VSS.t11 a_1544_289# a_1815_331# VSS.t561 sg13_lv_nmos ad=0.1331p pd=1.12u as=0.1216p ps=1.02u w=0.64u l=0.13u
X665 a_7288_1044# a_6717_1842# VDD VDD sg13_lv_pmos ad=0.2128p pd=1.5u as=0.3808p ps=2.92u w=1.12u l=0.13u
X666 a_15511_2470# a_15273_1842# a_15403_1842# VDD sg13_lv_pmos ad=0.2128p pd=1.5u as=0.3808p ps=2.92u w=1.12u l=0.2u
X667 VSS.t354 VSS.t356 VSS.t358 VSS.t357 sg13_lv_nmos ad=0.1406p pd=1.12u as=0 ps=0 w=0.74u l=0.2u
X668 a_22590_1044# a_24951_1008# a_24875_1044# VDD sg13_lv_pmos ad=0.3808p pd=2.92u as=0.2128p ps=1.5u w=1.12u l=0.13u
X669 VSS.t344 VDD VSS.t342 VSS.t343 sg13_lv_nmos ad=79.8f pd=0.8u as=0 ps=0 w=0.42u l=1u
X670 a_10430_1044# a_2019_1047.t7 a_10328_1044# VSS.t81 sg13_lv_nmos ad=0.2516p pd=2.16u as=0.1406p ps=1.12u w=0.74u l=0.13u
X671 VDD a_25717_1842# a_26185_1044# VDD sg13_lv_pmos ad=0.252p pd=1.57u as=0.3808p ps=2.92u w=1.12u l=0.13u
X672 VDD a_13883_1842# a_14317_1842# VDD sg13_lv_pmos ad=0.2128p pd=1.5u as=0.3808p ps=2.92u w=1.12u l=0.13u
X673 VDD a_4437_1842# a_4905_1044# VDD sg13_lv_pmos ad=0.252p pd=1.57u as=0.3808p ps=2.92u w=1.12u l=0.13u
X674 a_4157_1313# DELAY_IN VSS.t252 VSS.t251 sg13_lv_nmos ad=0.2516p pd=2.16u as=0.2553p ps=2.17u w=0.74u l=0.13u
X675 a_7390_1044# a_3171_1047.t8 a_8808_1044# VSS.t127 sg13_lv_nmos ad=0.2516p pd=2.16u as=0.1406p ps=1.12u w=0.74u l=0.13u
X676 a_22873_1842# a_22677_1842# VSS.t201 VSS.t200 sg13_lv_nmos ad=0.2516p pd=2.16u as=0.1406p ps=1.12u w=0.74u l=0.13u
X677 VDD a_3171_1047.t8 a_8884_1008# VDD sg13_lv_pmos ad=0.3808p pd=2.92u as=0.3808p ps=2.92u w=1.12u l=0.13u
C0 DELAY_VBIASP a_27997_1842# 0.04001f
C1 VDD DELAY_OUT_LAST 0.46312f
C2 a_21917_1842# a_22113_1842# 0.76914f
C3 a_16108_289# a_16510_1044# 0.56108f
C4 a_6283_1842# a_6391_1842# 0.01163f
C5 a_5197_1842# a_4763_1842# 0.6972f
C6 a_1256_1044# MUX_SEL0 0.3314f
C7 a_17683_1842# DELAY_VBIASP 0.06627f
C8 a_4350_1044# a_5191_1008# 0.28268f
C9 a_9953_1842# DELAY_VBIASP 0.11222f
C10 DELAY_VBIASN a_24393_1842# 0.0961f
C11 VDD a_27671_2470# 0.01806f
C12 a_15511_1842# a_15403_1842# 0.01163f
C13 a_12505_1044# a_10430_1044# 0.03208f
C14 VDD a_13444_1008# 0.28633f
C15 a_4763_1842# DELAY_VBIASN 0.07254f
C16 a_16108_289# a_23945_519# 0.2906f
C17 VDD a_1544_289# 0.39113f
C18 a_10843_1842# a_10951_2470# 0.01697f
C19 DELAY_VBIASP a_25283_1842# 0.06627f
C20 a_8433_1842# VDD 0.49417f
C21 a_15273_1842# VDD 0.49285f
C22 a_20391_1008# a_20397_1842# 0.02349f
C23 a_16510_1044# a_18795_1044# 0.39036f
C24 a_15755_1044# VDD 0.15389f
C25 a_11277_1842# a_11924_1008# 0.02312f
C26 a_9757_1842# a_10404_1008# 0.02011f
C27 a_5731_289# a_5705_519# 0.28954f
C28 a_8237_1842# VDD 0.86909f
C29 a_19550_1044# a_19963_1842# 0.01012f
C30 MUX_SEL1 a_3449_1395# 0.29404f
C31 VDD a_19963_1842# 0.4973f
C32 a_25630_1044# a_26395_1044# 0.39037f
C33 a_7390_1044# a_8155_1044# 0.39037f
C34 MUX_SEL3 a_2297_331# 0.01595f
C35 MUX_SEL4 a_1721_331# 0.05813f
C36 MUX_SEL2 a_2873_331# 0.01422f
C37 MUX_OUT a_1544_289# 0.69943f
C38 a_22590_1044# a_23437_1842# 0.08038f
C39 a_10430_1044# a_12791_1008# 0.26208f
C40 a_4324_1008# a_4157_1313# 0.02463f
C41 a_4350_1044# a_4905_1044# 0.03209f
C42 a_12797_1842# a_12993_1842# 0.76914f
C43 a_22873_1842# a_23003_1842# 0.70845f
C44 a_22590_1044# a_24197_1842# 0.05231f
C45 a_20105_1044# a_20315_1044# 0.09424f
C46 a_23437_1842# a_24197_1842# 0.03319f
C47 VDD a_16163_1842# 0.4973f
C48 a_4350_1044# a_2019_311# 0.02042f
C49 a_18117_1842# a_17683_1842# 0.6972f
C50 DELAY_VBIASN a_4157_1313# 0.01202f
C51 a_20105_1044# a_19550_1044# 0.03209f
C52 DELAY_VBIASN a_9323_1842# 0.07254f
C53 a_8563_1842# a_8671_2470# 0.01697f
C54 a_20105_1044# VDD 0.30409f
C55 DELAY_VBIASP a_15403_1842# 0.06627f
C56 a_27124_1008# a_26477_1842# 0.02312f
C57 a_16271_2470# VDD 0.01806f
C58 a_7390_1044# VDD 0.8686f
C59 a_25630_1044# VDD 0.89531f
C60 DELAY_VBIASN a_21917_1842# 0.09992f
C61 a_22488_1044# VDD 0.17274f
C62 VDD a_22873_1842# 0.49294f
C63 a_12797_1842# VDD 0.87771f
C64 a_5957_1842# a_6717_1842# 0.02912f
C65 DELAY_VBIASN a_14513_1842# 0.0961f
C66 a_13470_1044# a_15403_1842# 0.01012f
C67 a_23145_1044# a_23355_1044# 0.09424f
C68 a_4248_1044# VDD 0.17587f
C69 a_16851_309# VDD 0.51536f
C70 a_9757_1842# a_9323_1842# 0.6972f
C71 a_16510_1044# a_2019_311# 0.03139f
C72 a_8563_1842# DELAY_VBIASP 0.06627f
C73 a_25630_1044# a_25717_1842# 0.1088f
C74 DELAY_VBIASN a_7477_1842# 0.08375f
C75 a_19637_1842# a_19550_1044# 0.1088f
C76 a_12505_1044# a_12715_1044# 0.09424f
C77 a_19637_1842# VDD 0.86707f
C78 a_23431_1008# a_22590_1044# 0.28268f
C79 a_10843_1842# VDD 0.4973f
C80 a_23431_1008# a_23437_1842# 0.02349f
C81 a_7390_1044# a_9675_1044# 0.39036f
C82 a_22351_1842# a_22243_1842# 0.01163f
C83 a_13470_1044# a_14311_1008# 0.28268f
C84 a_18313_1842# a_18443_1842# 0.70845f
C85 a_12037_1842# a_10430_1044# 0.05231f
C86 DELAY_VBIASP a_21157_1842# 0.04141f
C87 a_1256_289# a_2297_331# 0.04261f
C88 a_1544_289# a_1721_331# 0.36963f
C89 a_10517_1842# a_10713_1842# 0.73897f
C90 a_15273_1842# a_15837_1842# 0.0114f
C91 MUX_OUT a_16851_309# 0.45865f
C92 a_18871_1008# VDD 0.2822f
C93 a_27237_1842# a_27433_1842# 0.77122f
C94 VDD a_27237_1842# 0.85969f
C95 a_8433_1842# a_8997_1842# 0.0114f
C96 a_26911_1842# a_26803_1842# 0.01163f
C97 a_11271_1008# VDD 0.28336f
C98 DELAY_VBIASP a_17357_1842# 0.0414f
C99 a_15755_1044# a_15831_1008# 0.01194f
C100 a_21353_1842# a_21917_1842# 0.0114f
C101 a_5731_289# a_15765_463# 0.23301f
C102 a_8237_1842# a_8997_1842# 0.03319f
C103 VDD a_26911_2470# 0.01806f
C104 a_6717_1842# DELAY_VBIASP 0.0414f
C105 a_12715_1044# a_12791_1008# 0.01194f
C106 a_10517_1842# a_10404_1008# 0.05157f
C107 VDD a_24523_1842# 0.4973f
C108 a_14317_1842# a_15077_1842# 0.03319f
C109 MUX_SEL3 VDD 0.4053f
C110 a_14888_1044# a_14317_1842# 0.10863f
C111 a_14025_1044# a_13557_1842# 0.19203f
C112 a_23355_1044# VDD 0.15389f
C113 a_25391_1842# a_25283_1842# 0.01163f
C114 a_15837_1842# a_16163_1842# 0.01427f
C115 DELAY_VBIASN a_22113_1842# 0.0961f
C116 a_5957_1842# VDD 0.85848f
C117 a_5768_1044# VDD 0.17499f
C118 DELAY_VBIASN a_12037_1842# 0.09156f
C119 a_20397_1842# a_21157_1842# 0.03319f
C120 a_10328_1044# a_10404_1008# 0.01176f
C121 a_1721_1395# VDD 0.4533f
C122 DELAY_VBIASP a_23003_1842# 0.06627f
C123 a_24957_1842# a_25283_1842# 0.01427f
C124 a_12993_1842# DELAY_VBIASP 0.11222f
C125 a_5731_289# a_10430_1044# 0.41176f
C126 a_13753_1842# VDD 0.49294f
C127 MUX_SEL3 MUX_OUT 0.79533f
C128 VDD a_8671_2470# 0.01806f
C129 a_6913_1842# a_7477_1842# 0.0114f
C130 a_23871_1842# a_23763_1842# 0.01163f
C131 a_4633_1842# a_4437_1842# 0.73897f
C132 a_4350_1044# a_4437_1842# 0.1088f
C133 a_13123_1842# a_13231_2470# 0.01697f
C134 a_20831_2470# a_20723_1842# 0.01697f
C135 DELAY_VBIASN a_18877_1842# 0.09992f
C136 DELAY_VBIASN a_10083_1842# 0.07254f
C137 a_16597_1842# a_17357_1842# 0.01669f
C138 a_5957_1842# a_6153_1842# 0.77122f
C139 a_18117_1842# a_17357_1842# 0.03319f
C140 a_7390_1044# a_8997_1842# 0.05231f
C141 a_15545_1044# VDD 0.29918f
C142 DELAY_VBIASN a_26477_1842# 0.10224f
C143 a_6425_1044# VDD 0.29722f
C144 DELAY_VBIASN a_10430_1044# 0.02115f
C145 a_11603_1842# a_11711_2470# 0.01697f
C146 a_1544_1044# a_2297_1395# 0.28651f
C147 DELAY_VBIASP a_27433_1842# 0.11222f
C148 a_15964_289# a_16510_1044# 0.05416f
C149 VDD DELAY_VBIASP 13.3418f
C150 a_4633_1842# a_4763_1842# 0.70845f
C151 a_4350_1044# a_5115_1044# 0.39037f
C152 a_4763_1842# a_4350_1044# 0.01012f
C153 a_10083_1842# a_9757_1842# 0.01427f
C154 DELAY_VBIASN a_23763_1842# 0.07254f
C155 a_18443_1842# a_16510_1044# 0.01012f
C156 a_14751_2470# VDD 0.01806f
C157 a_10985_1044# a_10430_1044# 0.03209f
C158 VDD a_13470_1044# 0.87936f
C159 a_27048_1044# a_27124_1008# 0.01176f
C160 a_7288_1044# a_6717_1842# 0.10864f
C161 a_5197_1842# DELAY_VBIASN 0.09974f
C162 a_8808_1044# a_8884_1008# 0.01176f
C163 DELAY_VBIASP a_25717_1842# 0.0414f
C164 a_16108_289# a_20905_519# 0.2906f
C165 VDD a_1256_289# 0.40292f
C166 a_14643_1842# VDD 0.49671f
C167 a_7803_1842# VDD 0.4973f
C168 a_16510_1044# a_18004_1008# 0.28279f
C169 a_6635_1044# a_6425_1044# 0.09424f
C170 a_17275_1044# a_17351_1008# 0.01194f
C171 a_14964_1008# VDD 0.28225f
C172 a_6153_1842# DELAY_VBIASP 0.11222f
C173 a_7673_1842# VDD 0.49294f
C174 a_9323_1842# a_9431_1842# 0.01163f
C175 a_19550_1044# a_20397_1842# 0.08038f
C176 MUX_SEL0 a_3449_1395# 0.10753f
C177 VDD a_20397_1842# 0.86909f
C178 a_25630_1044# a_25604_1008# 0.277f
C179 a_7390_1044# a_7364_1008# 0.277f
C180 a_22488_1044# a_22590_1044# 0.37183f
C181 MUX_SEL4 a_1544_289# 0.47529f
C182 MUX_SEL2 a_2297_331# 0.10655f
C183 MUX_OUT a_1256_289# 0.1134f
C184 a_22873_1842# a_23437_1842# 0.0114f
C185 a_10430_1044# a_12715_1044# 0.39036f
C186 a_4350_1044# a_4157_1313# 0.04624f
C187 a_12797_1842# a_12363_1842# 0.6972f
C188 a_18117_1842# VDD 0.85848f
C189 VDD a_16597_1842# 0.86876f
C190 a_4350_1044# a_5705_519# 0.02005f
C191 a_27991_1008# VDD 0.28201f
C192 a_18551_2470# a_18443_1842# 0.01697f
C193 a_20968_1044# a_21044_1008# 0.01176f
C194 DELAY_VBIASN a_9757_1842# 0.09992f
C195 a_27048_1044# a_26477_1842# 0.10863f
C196 a_21911_1008# a_19550_1044# 0.26208f
C197 a_14025_1044# a_14311_1008# 0.01885f
C198 a_7288_1044# VDD 0.17274f
C199 a_21911_1008# VDD 0.2822f
C200 VDD a_22243_1842# 0.49737f
C201 DELAY_VBIASN a_21353_1842# 0.0961f
C202 a_12233_1842# VDD 0.49285f
C203 DELAY_VBIASN a_13883_1842# 0.07254f
C204 a_15831_1008# a_15545_1044# 0.01885f
C205 a_19637_1842# a_19203_1842# 0.69698f
C206 a_16108_289# a_19550_1044# 0.58202f
C207 DELAY_VBIASN a_17553_1842# 0.0961f
C208 a_2297_331# a_2019_311# 0.04011f
C209 a_16108_289# VDD 1.25759f
C210 a_8997_1842# DELAY_VBIASP 0.04141f
C211 a_9193_1842# a_9323_1842# 0.70845f
C212 a_15837_1842# DELAY_VBIASP 0.0414f
C213 DELAY_VBIASN a_6913_1842# 0.0961f
C214 a_22590_1044# a_24523_1842# 0.01012f
C215 MUX_SEL4 a_7390_1044# 0.34655f
C216 a_16510_1044# a_17275_1044# 0.39037f
C217 MUX_SEL4 a_12797_1842# 0.01829f
C218 a_19073_1842# VDD 0.49426f
C219 DELAY_VBIASP a_21483_1842# 0.06627f
C220 a_23355_1044# a_22590_1044# 0.39037f
C221 a_11277_1842# VDD 0.86909f
C222 a_20071_1842# a_19963_1842# 0.01163f
C223 a_27997_1842# a_27563_1842# 0.69646f
C224 a_13470_1044# a_14235_1044# 0.39037f
C225 a_18313_1842# a_18877_1842# 0.0114f
C226 a_13883_1842# a_13991_1842# 0.01163f
C227 DELAY_VBIASP a_20593_1842# 0.11222f
C228 a_15837_1842# a_13470_1044# 0.02479f
C229 a_10517_1842# a_10083_1842# 0.69698f
C230 a_1256_289# a_1721_331# 0.13421f
C231 a_22351_2470# a_22243_1842# 0.01697f
C232 a_4003_1842# VDD 0.61559f
C233 a_27237_1842# a_26803_1842# 0.6972f
C234 MUX_OUT a_16108_289# 0.24265f
C235 a_15831_1008# a_13470_1044# 0.26208f
C236 a_18795_1044# VDD 0.15406f
C237 VDD a_26673_1842# 0.49417f
C238 a_11195_1044# VDD 0.15389f
C239 DELAY_VBIASP a_16793_1842# 0.11222f
C240 DELAY_VBIASN a_13123_1842# 0.07254f
C241 a_5731_289# a_14825_519# 0.28056f
C242 a_26803_1842# a_26911_2470# 0.01697f
C243 a_8237_1842# a_8433_1842# 0.76914f
C244 VDD a_26151_2470# 0.01806f
C245 a_10517_1842# a_10430_1044# 0.1088f
C246 VDD a_24957_1842# 0.87825f
C247 a_14317_1842# a_14513_1842# 0.76914f
C248 DELAY_VBIASP a_25913_1842# 0.11222f
C249 MUX_SEL2 VDD 0.50938f
C250 a_22564_1008# VDD 0.28633f
C251 a_15837_1842# a_16597_1842# 0.06198f
C252 a_24875_1044# a_24951_1008# 0.01194f
C253 a_5393_1842# VDD 0.49417f
C254 a_5191_1008# VDD 0.28565f
C255 a_25391_2470# a_25283_1842# 0.01697f
C256 a_20397_1842# a_20593_1842# 0.76914f
C257 a_10328_1044# a_10430_1044# 0.37183f
C258 a_1544_1044# VDD 0.45079f
C259 a_24957_1842# a_25717_1842# 0.06198f
C260 DELAY_VBIASP a_23437_1842# 0.0414f
C261 a_12363_1842# DELAY_VBIASP 0.06627f
C262 DELAY_VBIASP a_24197_1842# 0.04141f
C263 MUX_SEL3 MUX_SEL4 0.75489f
C264 a_7803_1842# a_7911_1842# 0.01163f
C265 VDD a_7911_2470# 0.01806f
C266 MUX_SEL2 MUX_OUT 0.08497f
C267 a_6717_1842# a_7043_1842# 0.01427f
C268 DELAY_VBIASN a_18313_1842# 0.0961f
C269 a_23355_1044# a_23431_1008# 0.01194f
C270 DELAY_VBIASN a_10517_1842# 0.08375f
C271 a_23871_2470# a_23763_1842# 0.01697f
C272 a_16597_1842# a_16793_1842# 0.73897f
C273 a_19203_1842# a_19311_1842# 0.01163f
C274 a_21591_1842# a_21483_1842# 0.01163f
C275 a_5957_1842# a_5523_1842# 0.6972f
C276 a_12797_1842# a_13444_1008# 0.02011f
C277 a_5768_1044# a_5844_1008# 0.01176f
C278 a_1544_1044# MUX_OUT 0.04258f
C279 a_2297_1395# MUX_SEL1 0.01995f
C280 a_5957_1842# a_5844_1008# 0.02055f
C281 a_19203_1842# DELAY_VBIASP 0.06627f
C282 a_4003_1842# a_4111_2470# 0.01697f
C283 a_14025_1044# VDD 0.30409f
C284 a_11473_1842# DELAY_VBIASP 0.11222f
C285 a_5731_289# a_4350_1044# 0.41099f
C286 a_4905_1044# VDD 0.30126f
C287 a_7390_1044# a_8237_1842# 0.08038f
C288 a_10985_1044# a_10517_1842# 0.19203f
C289 VDD a_2019_311# 1.43004f
C290 a_1256_1044# a_2297_1395# 0.04619f
C291 VDD DELAY_IN 1.33375f
C292 DELAY_VBIASP a_26803_1842# 0.06627f
C293 a_17683_1842# a_17791_1842# 0.01163f
C294 a_10843_1842# a_10951_1842# 0.01163f
C295 a_4633_1842# a_5197_1842# 0.0114f
C296 a_12037_1842# a_11924_1008# 0.02055f
C297 a_4350_1044# a_4324_1008# 0.277f
C298 a_5197_1842# a_4350_1044# 0.08038f
C299 a_10517_1842# a_9757_1842# 0.06198f
C300 a_18877_1842# a_16510_1044# 0.02479f
C301 a_16271_2470# a_16163_1842# 0.01697f
C302 a_13991_2470# VDD 0.01806f
C303 VDD a_13368_1044# 0.17274f
C304 a_4763_1842# a_4871_2470# 0.01697f
C305 MUX_OUT a_2019_311# 8.45486f
C306 DELAY_VBIASP a_25153_1842# 0.11222f
C307 a_4633_1842# DELAY_VBIASN 0.0961f
C308 DELAY_VBIASN a_4350_1044# 0.02115f
C309 a_15077_1842# VDD 0.85963f
C310 a_16510_1044# a_17928_1044# 0.38994f
C311 a_14888_1044# VDD 0.17499f
C312 a_21625_1044# a_21911_1008# 0.01885f
C313 a_5523_1842# DELAY_VBIASP 0.06627f
C314 a_23145_1044# a_22677_1842# 0.19203f
C315 a_9757_1842# a_10328_1044# 0.10864f
C316 DELAY_VBIASN a_19833_1842# 0.0961f
C317 a_7043_1842# VDD 0.49723f
C318 MUX_SEL4 a_13470_1044# 0.256f
C319 a_7288_1044# a_7364_1008# 0.01176f
C320 MUX_SEL2 a_1721_331# 0.01315f
C321 MUX_SEL4 a_1256_289# 0.65005f
C322 MUX_SEL3 a_1544_289# 0.15976f
C323 a_10430_1044# a_11924_1008# 0.28279f
C324 a_12233_1842# a_12363_1842# 0.70845f
C325 a_18004_1008# a_17357_1842# 0.02312f
C326 a_20105_1044# a_19637_1842# 0.19203f
C327 VDD a_16033_1842# 0.49413f
C328 a_16108_289# a_22590_1044# 0.58202f
C329 a_27915_1044# VDD 0.15389f
C330 a_20831_2470# VDD 0.01806f
C331 DELAY_VBIASN a_9193_1842# 0.0961f
C332 a_24665_1044# a_24951_1008# 0.01885f
C333 DELAY_VBIASN a_16510_1044# 0.02115f
C334 a_16108_289# a_17865_519# 0.29564f
C335 DELAY_VBIASP DELAY_OUT_LAST 0.21225f
C336 VDD a_21591_2470# 0.01806f
C337 a_26471_1008# a_26477_1842# 0.02349f
C338 a_25630_1044# a_27237_1842# 0.05253f
C339 a_21835_1044# a_19550_1044# 0.39036f
C340 a_14025_1044# a_14235_1044# 0.09424f
C341 DELAY_VBIASN a_20723_1842# 0.07254f
C342 a_21835_1044# VDD 0.15406f
C343 VDD a_22677_1842# 0.86707f
C344 a_11603_1842# VDD 0.49671f
C345 a_15755_1044# a_15545_1044# 0.09424f
C346 DELAY_VBIASN a_14317_1842# 0.09974f
C347 a_19073_1842# a_19203_1842# 0.70845f
C348 a_18585_1044# a_16510_1044# 0.03208f
C349 a_27671_1842# a_27563_1842# 0.01163f
C350 a_11277_1842# a_11473_1842# 0.76914f
C351 DELAY_VBIASN a_16923_1842# 0.07254f
C352 a_1721_331# a_2019_311# 0.18452f
C353 a_15964_289# VDD 0.31312f
C354 a_9193_1842# a_9757_1842# 0.0114f
C355 a_8433_1842# DELAY_VBIASP 0.11222f
C356 a_15273_1842# DELAY_VBIASP 0.11222f
C357 DELAY_VBIASN a_6283_1842# 0.07254f
C358 a_25604_1008# a_24957_1842# 0.02011f
C359 a_22590_1044# a_24957_1842# 0.02479f
C360 a_6283_1842# a_6391_2470# 0.01697f
C361 a_23633_1842# a_23763_1842# 0.70845f
C362 a_18877_1842# a_19524_1008# 0.02011f
C363 a_16510_1044# a_16484_1008# 0.277f
C364 a_24197_1842# a_24957_1842# 0.02912f
C365 a_18443_1842# VDD 0.4973f
C366 a_22564_1008# a_22590_1044# 0.277f
C367 a_10713_1842# VDD 0.49294f
C368 a_8237_1842# DELAY_VBIASP 0.0414f
C369 a_27433_1842# a_27563_1842# 0.70845f
C370 VDD a_27563_1842# 0.49811f
C371 a_13470_1044# a_13444_1008# 0.277f
C372 a_11277_1842# a_11848_1044# 0.10863f
C373 a_17065_1044# a_16597_1842# 0.19203f
C374 DELAY_VBIASP a_19963_1842# 0.06627f
C375 a_9953_1842# a_10083_1842# 0.70845f
C376 MUX_SEL4 a_16108_289# 0.1283f
C377 a_1256_289# a_1544_289# 1.25711f
C378 a_4437_1842# VDD 0.86998f
C379 MUX_OUT a_15964_289# 0.01307f
C380 a_7945_1044# a_7477_1842# 0.19203f
C381 a_18004_1008# VDD 0.28225f
C382 a_15077_1842# a_15837_1842# 0.02912f
C383 a_26673_1842# a_26803_1842# 0.70845f
C384 a_15755_1044# a_13470_1044# 0.39036f
C385 VDD a_26043_1842# 0.4973f
C386 a_17031_1842# a_16923_1842# 0.01163f
C387 a_25528_1044# VDD 0.17274f
C388 a_11785_519# a_10430_1044# 0.02058f
C389 DELAY_VBIASN a_23633_1842# 0.0961f
C390 DELAY_VBIASP a_16163_1842# 0.06627f
C391 a_10404_1008# VDD 0.28633f
C392 DELAY_VBIASN a_13557_1842# 0.08375f
C393 a_21157_1842# a_21917_1842# 0.02912f
C394 a_8237_1842# a_7803_1842# 0.6972f
C395 a_5731_289# a_11785_519# 0.28056f
C396 VDD a_25391_2470# 0.01806f
C397 a_8745_519# VDD 0.29292f
C398 VDD a_24393_1842# 0.49285f
C399 a_14317_1842# a_13883_1842# 0.6972f
C400 MUX_SEL1 VDD 0.50267f
C401 a_7673_1842# a_8237_1842# 0.0114f
C402 a_15837_1842# a_16033_1842# 0.76914f
C403 a_4763_1842# VDD 0.4973f
C404 a_5115_1044# VDD 0.15389f
C405 a_20397_1842# a_19963_1842# 0.6972f
C406 a_13123_1842# a_13231_1842# 0.01163f
C407 a_9431_2470# VDD 0.01806f
C408 a_25630_1044# DELAY_VBIASP 0.01522f
C409 a_1256_1044# VDD 0.475f
C410 a_12797_1842# DELAY_VBIASP 0.0414f
C411 DELAY_VBIASP a_22873_1842# 0.11222f
C412 a_24957_1842# a_25153_1842# 0.76914f
C413 DELAY_VBIASN a_27997_1842# 0.04176f
C414 MUX_SEL1 MUX_OUT 0.09357f
C415 VDD a_7151_2470# 0.01806f
C416 MUX_SEL2 MUX_SEL4 0.01978f
C417 a_6717_1842# a_7477_1842# 0.06198f
C418 a_17865_519# a_2019_311# 0.13959f
C419 DELAY_VBIASN a_17683_1842# 0.07254f
C420 DELAY_VBIASN a_9953_1842# 0.0961f
C421 a_11603_1842# a_11711_1842# 0.01163f
C422 a_16597_1842# a_16163_1842# 0.69698f
C423 a_5393_1842# a_5523_1842# 0.70845f
C424 a_1544_1044# MUX_SEL4 0.03407f
C425 a_7390_1044# a_7803_1842# 0.01012f
C426 a_2297_1395# MUX_SEL0 0.10655f
C427 a_1256_1044# MUX_OUT 0.02466f
C428 a_19637_1842# DELAY_VBIASP 0.0414f
C429 a_21591_2470# a_21483_1842# 0.01697f
C430 a_10843_1842# DELAY_VBIASP 0.06627f
C431 a_12505_1044# VDD 0.29722f
C432 DELAY_VBIASN a_25283_1842# 0.07254f
C433 a_4157_1313# VDD 0.48935f
C434 a_15964_289# a_15837_1842# 0.02f
C435 VDD a_5705_519# 0.29556f
C436 DELAY_VBIASP a_27237_1842# 0.06189f
C437 a_21044_1008# a_21157_1842# 0.02055f
C438 a_9323_1842# VDD 0.4973f
C439 a_17275_1044# VDD 0.15389f
C440 a_26185_1044# a_26471_1008# 0.01885f
C441 a_9953_1842# a_9757_1842# 0.76914f
C442 a_13231_2470# VDD 0.01806f
C443 a_19550_1044# a_21917_1842# 0.02479f
C444 VDD a_21917_1842# 0.87825f
C445 a_25630_1044# a_27991_1008# 0.26208f
C446 VDD a_12791_1008# 0.2822f
C447 MUX_SEL4 a_2019_311# 0.90276f
C448 DELAY_VBIASP a_24523_1842# 0.06627f
C449 a_19637_1842# a_20397_1842# 0.01669f
C450 a_5957_1842# a_6425_1044# 0.2079f
C451 MUX_SEL4 DELAY_IN 0.0663f
C452 a_14513_1842# VDD 0.49417f
C453 a_16510_1044# a_17351_1008# 0.28268f
C454 a_13557_1842# a_13123_1842# 0.69698f
C455 a_21625_1044# a_21835_1044# 0.09424f
C456 a_5957_1842# DELAY_VBIASP 0.04141f
C457 a_9757_1842# a_9751_1008# 0.02354f
C458 a_7477_1842# VDD 0.86707f
C459 a_17683_1842# a_17553_1842# 0.70845f
C460 MUX_SEL1 a_2873_1395# 0.13092f
C461 DELAY_VBIASN a_15403_1842# 0.07254f
C462 MUX_SEL3 a_1256_289# 1.41161f
C463 a_7288_1044# a_7390_1044# 0.37183f
C464 MUX_SEL2 a_1544_289# 0.07405f
C465 a_27705_1044# VDD 0.29918f
C466 a_13753_1842# DELAY_VBIASP 0.11222f
C467 a_22590_1044# a_22677_1842# 0.1088f
C468 a_22677_1842# a_23437_1842# 0.01669f
C469 a_12233_1842# a_12797_1842# 0.0114f
C470 a_17928_1044# a_17357_1842# 0.10863f
C471 a_1256_1044# a_2873_1395# 0.28892f
C472 a_16108_289# a_25630_1044# 0.55833f
C473 a_6711_1008# a_4350_1044# 0.26208f
C474 a_27124_1008# VDD 0.28225f
C475 a_20071_2470# VDD 0.01806f
C476 a_8884_1008# VDD 0.28225f
C477 a_25913_1842# a_26043_1842# 0.70845f
C478 DELAY_VBIASN a_8563_1842# 0.07254f
C479 a_24665_1044# a_24875_1044# 0.09424f
C480 a_11603_1842# a_11473_1842# 0.70845f
C481 a_16108_289# a_16851_309# 0.06181f
C482 a_15511_2470# a_15403_1842# 0.01697f
C483 a_15545_1044# a_13470_1044# 0.03208f
C484 a_21044_1008# a_19550_1044# 0.28279f
C485 a_21044_1008# VDD 0.28225f
C486 DELAY_VBIASN a_21157_1842# 0.09156f
C487 VDD a_22113_1842# 0.49426f
C488 a_25604_1008# a_25528_1044# 0.01176f
C489 a_12037_1842# VDD 0.85848f
C490 a_4350_1044# a_6283_1842# 0.01012f
C491 a_19073_1842# a_19637_1842# 0.0114f
C492 a_11277_1842# a_10843_1842# 0.6972f
C493 DELAY_VBIASN a_17357_1842# 0.09974f
C494 a_1544_289# a_2019_311# 0.01747f
C495 a_5523_1842# a_5631_1842# 0.01163f
C496 a_15765_463# VDD 0.35368f
C497 a_14643_1842# DELAY_VBIASP 0.06627f
C498 a_7803_1842# DELAY_VBIASP 0.06627f
C499 DELAY_VBIASN a_6717_1842# 0.09992f
C500 a_16408_1044# a_16484_1008# 0.01176f
C501 a_18877_1842# VDD 0.87825f
C502 a_24197_1842# a_24393_1842# 0.77122f
C503 a_22564_1008# a_22488_1044# 0.01176f
C504 a_10083_1842# VDD 0.49727f
C505 a_14643_1842# a_14751_2470# 0.01697f
C506 a_7673_1842# DELAY_VBIASP 0.11222f
C507 a_13368_1044# a_13444_1008# 0.01176f
C508 a_11277_1842# a_11271_1008# 0.02349f
C509 DELAY_VBIASP a_20397_1842# 0.0414f
C510 a_9953_1842# a_10517_1842# 0.0114f
C511 a_18795_1044# a_18871_1008# 0.01194f
C512 MUX_SEL4 a_15964_289# 0.5544f
C513 a_17928_1044# VDD 0.17499f
C514 a_14964_1008# a_13470_1044# 0.28279f
C515 a_15077_1842# a_15273_1842# 0.77122f
C516 a_26673_1842# a_27237_1842# 0.0114f
C517 VDD a_26477_1842# 0.86909f
C518 a_21917_1842# a_21483_1842# 0.6972f
C519 a_24951_1008# VDD 0.2822f
C520 a_18117_1842# DELAY_VBIASP 0.04141f
C521 DELAY_VBIASP a_16597_1842# 0.0414f
C522 DELAY_VBIASN a_23003_1842# 0.07254f
C523 DELAY_VBIASN a_12993_1842# 0.0961f
C524 a_10430_1044# VDD 0.88416f
C525 a_16510_1044# a_16923_1842# 0.01012f
C526 a_21157_1842# a_21353_1842# 0.77122f
C527 a_11195_1044# a_11271_1008# 0.01194f
C528 a_7673_1842# a_7803_1842# 0.70845f
C529 a_5731_289# VDD 0.6143f
C530 VDD a_24631_2470# 0.01806f
C531 VDD a_23763_1842# 0.49671f
C532 a_26477_1842# a_25717_1842# 0.01669f
C533 MUX_SEL0 VDD 0.56365f
C534 a_5197_1842# VDD 0.86909f
C535 a_4324_1008# VDD 0.28597f
C536 a_8745_519# MUX_SEL4 0.04472f
C537 a_5731_289# MUX_OUT 1.04829f
C538 a_17357_1842# a_17553_1842# 0.76914f
C539 a_8884_1008# a_8997_1842# 0.02055f
C540 DELAY_VBIASP a_22243_1842# 0.06627f
C541 a_12233_1842# DELAY_VBIASP 0.11222f
C542 a_24957_1842# a_24523_1842# 0.6972f
C543 DELAY_VBIASN a_27433_1842# 0.0961f
C544 DELAY_VBIASN a_19550_1044# 0.02115f
C545 MUX_SEL2 MUX_SEL3 3.21891f
C546 MUX_SEL1 MUX_SEL4 0.03574f
C547 DELAY_VBIASN VDD 0.9333f
C548 VDD a_6391_2470# 0.01806f
C549 a_6717_1842# a_6913_1842# 0.76914f
C550 a_16851_309# a_2019_311# 0.01299f
C551 a_7043_1842# a_7151_1842# 0.01163f
C552 a_16033_1842# a_16163_1842# 0.70845f
C553 a_12797_1842# a_13368_1044# 0.10864f
C554 a_5393_1842# a_5957_1842# 0.0114f
C555 a_1256_1044# MUX_SEL4 0.04908f
C556 a_19073_1842# DELAY_VBIASP 0.11222f
C557 a_13557_1842# a_14317_1842# 0.01669f
C558 a_11277_1842# DELAY_VBIASP 0.0414f
C559 a_10985_1044# VDD 0.30409f
C560 DELAY_VBIASN a_25717_1842# 0.08411f
C561 a_18585_1044# VDD 0.29722f
C562 a_7364_1008# a_7477_1842# 0.05157f
C563 a_3449_1395# VDD 0.46731f
C564 a_6153_1842# DELAY_VBIASN 0.0961f
C565 a_4003_1842# DELAY_VBIASP 0.05992f
C566 a_1544_1044# a_1721_1395# 0.38063f
C567 VDD a_3449_331# 0.46596f
C568 a_9757_1842# VDD 0.87771f
C569 DELAY_VBIASP a_26673_1842# 0.11222f
C570 a_26185_1044# a_26395_1044# 0.09424f
C571 a_16484_1008# VDD 0.28597f
C572 a_27671_2470# a_27563_1842# 0.01697f
C573 a_15511_2470# VDD 0.01806f
C574 a_12471_2470# VDD 0.01806f
C575 VDD a_21353_1842# 0.49285f
C576 a_9465_1044# a_9751_1008# 0.01885f
C577 MUX_SEL4 a_4157_1313# 0.08229f
C578 VDD a_12715_1044# 0.15406f
C579 a_25630_1044# a_27915_1044# 0.39036f
C580 MUX_SEL4 a_5705_519# 0.03556f
C581 DELAY_VBIASP a_24957_1842# 0.0414f
C582 MUX_SEL3 a_2019_311# 0.06209f
C583 a_13883_1842# VDD 0.4973f
C584 a_10083_1842# a_10191_2470# 0.01697f
C585 a_26985_519# VDD 0.29292f
C586 a_12993_1842# a_13123_1842# 0.70845f
C587 VDD a_17553_1842# 0.49417f
C588 a_5393_1842# DELAY_VBIASP 0.11222f
C589 a_6913_1842# VDD 0.49426f
C590 MUX_SEL0 a_2873_1395# 0.01504f
C591 a_26185_1044# VDD 0.30409f
C592 MUX_SEL2 a_1256_289# 0.33134f
C593 a_22677_1842# a_22873_1842# 0.73897f
C594 a_17351_1008# a_17357_1842# 0.02349f
C595 a_27048_1044# VDD 0.17499f
C596 a_19311_2470# VDD 0.01806f
C597 a_8808_1044# VDD 0.17499f
C598 a_13123_1842# VDD 0.49727f
C599 a_26185_1044# a_25717_1842# 0.19203f
C600 a_25913_1842# a_26477_1842# 0.0114f
C601 a_17275_1044# a_17065_1044# 0.09424f
C602 DELAY_VBIASN a_15837_1842# 0.09992f
C603 DELAY_VBIASN a_8997_1842# 0.09156f
C604 a_7803_1842# a_7911_2470# 0.01697f
C605 a_12037_1842# a_11473_1842# 0.0114f
C606 a_25630_1044# a_27563_1842# 0.01024f
C607 DELAY_VBIASN a_21483_1842# 0.07254f
C608 a_15964_289# a_16851_309# 0.16757f
C609 DELAY_IN DELAY_VBIASP 0.07719f
C610 a_20968_1044# a_19550_1044# 0.38994f
C611 a_25630_1044# a_26043_1842# 0.01012f
C612 a_14025_1044# a_13470_1044# 0.03209f
C613 a_20968_1044# VDD 0.17499f
C614 DELAY_VBIASN a_20593_1842# 0.0961f
C615 a_25630_1044# a_25528_1044# 0.37183f
C616 a_24951_1008# a_22590_1044# 0.26208f
C617 a_15545_1044# a_15077_1842# 0.2079f
C618 a_4350_1044# a_6717_1842# 0.02479f
C619 a_12363_1842# a_10430_1044# 0.01012f
C620 a_18877_1842# a_19203_1842# 0.01427f
C621 a_23111_1842# a_23003_1842# 0.01163f
C622 a_10713_1842# a_10843_1842# 0.70845f
C623 DELAY_VBIASN a_16793_1842# 0.0961f
C624 a_8745_519# a_7390_1044# 0.01756f
C625 a_1256_289# a_2019_311# 0.02904f
C626 a_14825_519# VDD 0.29292f
C627 a_8997_1842# a_9757_1842# 0.02912f
C628 a_15077_1842# DELAY_VBIASP 0.04141f
C629 a_16484_1008# a_15837_1842# 0.02011f
C630 a_23437_1842# a_23763_1842# 0.01427f
C631 a_16408_1044# a_16510_1044# 0.37183f
C632 a_18877_1842# a_19448_1044# 0.10864f
C633 a_24197_1842# a_23763_1842# 0.6972f
C634 a_18313_1842# VDD 0.49285f
C635 a_10517_1842# VDD 0.86707f
C636 a_7043_1842# DELAY_VBIASP 0.06627f
C637 DELAY_VBIASN a_25913_1842# 0.0961f
C638 a_13368_1044# a_13470_1044# 0.37183f
C639 a_14317_1842# a_14311_1008# 0.02349f
C640 a_15077_1842# a_13470_1044# 0.05231f
C641 a_16108_289# a_24957_1842# 0.0157f
C642 MUX_SEL4 a_15765_463# 0.65508f
C643 a_15077_1842# a_14643_1842# 0.6972f
C644 a_26477_1842# a_26803_1842# 0.01427f
C645 a_14888_1044# a_13470_1044# 0.38994f
C646 a_17351_1008# VDD 0.28565f
C647 a_21353_1842# a_21483_1842# 0.70845f
C648 a_14964_1008# a_15077_1842# 0.02055f
C649 a_24875_1044# VDD 0.15406f
C650 a_26151_1842# a_26043_1842# 0.01163f
C651 DELAY_VBIASN a_22590_1044# 0.02115f
C652 DELAY_VBIASN a_12363_1842# 0.07254f
C653 DELAY_VBIASP a_16033_1842# 0.11222f
C654 a_14888_1044# a_14964_1008# 0.01176f
C655 DELAY_VBIASN a_23437_1842# 0.09974f
C656 a_10328_1044# VDD 0.17274f
C657 a_16510_1044# a_17357_1842# 0.08038f
C658 DELAY_VBIASN a_24197_1842# 0.09156f
C659 a_21157_1842# a_20723_1842# 0.6972f
C660 VDD a_23871_2470# 0.01806f
C661 a_10430_1044# a_11848_1044# 0.38994f
C662 a_6711_1008# a_6717_1842# 0.02354f
C663 a_7477_1842# a_8237_1842# 0.01669f
C664 a_8231_1008# a_7945_1044# 0.01885f
C665 a_24631_1842# a_24523_1842# 0.01163f
C666 MUX_SEL4 a_10430_1044# 0.24983f
C667 DELAY_VBIASN a_19203_1842# 0.07254f
C668 a_4633_1842# VDD 0.49285f
C669 a_4350_1044# VDD 0.87635f
C670 DELAY_VBIASN a_11473_1842# 0.0961f
C671 a_5731_289# MUX_SEL4 4.60702f
C672 a_17357_1842# a_16923_1842# 0.6972f
C673 a_7390_1044# a_9323_1842# 0.01012f
C674 VDD a_19833_1842# 0.49294f
C675 DELAY_VBIASP a_22677_1842# 0.0414f
C676 a_11603_1842# DELAY_VBIASP 0.06627f
C677 a_24393_1842# a_24523_1842# 0.70845f
C678 DELAY_VBIASN a_26803_1842# 0.07254f
C679 a_6717_1842# a_6283_1842# 0.6972f
C680 VDD a_5631_2470# 0.01806f
C681 a_4248_1044# a_4157_1313# 0.11672f
C682 a_8884_1008# a_8237_1842# 0.02312f
C683 a_12363_1842# a_12471_2470# 0.01697f
C684 a_16108_289# a_2019_311# 0.33889f
C685 a_22488_1044# a_21917_1842# 0.10864f
C686 a_20071_2470# a_19963_1842# 0.01697f
C687 a_12797_1842# a_12791_1008# 0.02354f
C688 a_16033_1842# a_16597_1842# 0.0114f
C689 a_5197_1842# a_5844_1008# 0.02312f
C690 a_5197_1842# a_5523_1842# 0.01427f
C691 a_4350_1044# a_6635_1044# 0.39036f
C692 a_18443_1842# DELAY_VBIASP 0.06627f
C693 a_10713_1842# DELAY_VBIASP 0.11222f
C694 a_9465_1044# VDD 0.29722f
C695 DELAY_VBIASN a_25153_1842# 0.0961f
C696 DELAY_VBIASP a_27563_1842# 0.06629f
C697 a_7390_1044# a_7477_1842# 0.1088f
C698 a_27915_1044# a_27991_1008# 0.01194f
C699 a_4437_1842# DELAY_VBIASP 0.0414f
C700 a_5523_1842# DELAY_VBIASN 0.07254f
C701 a_4003_1842# DELAY_IN 0.54998f
C702 VDD a_2873_331# 0.46491f
C703 a_1256_1044# a_1721_1395# 0.13421f
C704 DELAY_VBIASP a_26043_1842# 0.06627f
C705 a_9193_1842# VDD 0.49285f
C706 a_27705_1044# a_25630_1044# 0.03208f
C707 a_16510_1044# VDD 0.8795f
C708 a_6711_1008# VDD 0.2822f
C709 a_11711_2470# VDD 0.01806f
C710 VDD a_20723_1842# 0.49671f
C711 a_9465_1044# a_9675_1044# 0.09424f
C712 a_25630_1044# a_27124_1008# 0.28279f
C713 a_26395_1044# a_26471_1008# 0.01194f
C714 VDD a_11924_1008# 0.28225f
C715 DELAY_VBIASP a_24393_1842# 0.11222f
C716 a_8155_1044# a_8231_1008# 0.01194f
C717 a_7390_1044# a_8884_1008# 0.28279f
C718 MUX_SEL4 a_3449_331# 0.05166f
C719 a_14317_1842# VDD 0.86909f
C720 MUX_SEL4 a_9757_1842# 0.01829f
C721 a_23945_519# VDD 0.29292f
C722 a_12993_1842# a_13557_1842# 0.0114f
C723 a_5191_1008# a_4905_1044# 0.01885f
C724 VDD a_16923_1842# 0.4973f
C725 a_4763_1842# DELAY_VBIASP 0.06627f
C726 a_6283_1842# VDD 0.4973f
C727 a_6711_1008# a_6635_1044# 0.01194f
C728 a_17683_1842# a_17357_1842# 0.01427f
C729 a_27705_1044# a_27237_1842# 0.2079f
C730 a_24665_1044# VDD 0.29722f
C731 a_19311_2470# a_19203_1842# 0.01697f
C732 a_21835_1044# a_21911_1008# 0.01194f
C733 DELAY_VBIASN DELAY_OUT_LAST 0.04786f
C734 a_22677_1842# a_22243_1842# 0.69698f
C735 a_12037_1842# a_12797_1842# 0.02912f
C736 a_18117_1842# a_18004_1008# 0.02055f
C737 a_27124_1008# a_27237_1842# 0.02055f
C738 a_26471_1008# VDD 0.28336f
C739 a_18551_2470# VDD 0.01806f
C740 a_8231_1008# VDD 0.28336f
C741 VDD a_23633_1842# 0.49417f
C742 a_13557_1842# VDD 0.86707f
C743 a_6153_1842# a_6283_1842# 0.70845f
C744 a_20315_1044# a_20391_1008# 0.01194f
C745 DELAY_VBIASN a_15273_1842# 0.0961f
C746 a_17791_2470# a_17683_1842# 0.01697f
C747 DELAY_VBIASN a_8433_1842# 0.0961f
C748 a_11603_1842# a_11277_1842# 0.01427f
C749 a_15964_289# a_16108_289# 0.42202f
C750 a_9323_1842# DELAY_VBIASP 0.06627f
C751 DELAY_VBIASN a_8237_1842# 0.09974f
C752 a_20391_1008# a_19550_1044# 0.28268f
C753 a_25630_1044# a_26477_1842# 0.08038f
C754 a_20391_1008# VDD 0.28336f
C755 DELAY_VBIASN a_19963_1842# 0.07254f
C756 a_24875_1044# a_22590_1044# 0.39036f
C757 a_9465_1044# a_8997_1842# 0.2079f
C758 a_20831_1842# a_20723_1842# 0.01163f
C759 a_18877_1842# a_19637_1842# 0.06198f
C760 a_12797_1842# a_10430_1044# 0.02479f
C761 a_14643_1842# a_14751_1842# 0.01163f
C762 DELAY_VBIASP a_21917_1842# 0.0414f
C763 a_5731_289# a_7390_1044# 0.41331f
C764 a_10713_1842# a_11277_1842# 0.0114f
C765 DELAY_VBIASN a_16163_1842# 0.07254f
C766 a_19550_1044# a_19524_1008# 0.277f
C767 a_23111_2470# a_23003_1842# 0.01697f
C768 a_11785_519# VDD 0.29292f
C769 a_27433_1842# a_27997_1842# 0.0114f
C770 VDD a_27997_1842# 0.76025f
C771 a_19524_1008# VDD 0.28633f
C772 a_8997_1842# a_9193_1842# 0.77122f
C773 a_14513_1842# DELAY_VBIASP 0.11222f
C774 a_18877_1842# a_18871_1008# 0.02354f
C775 a_17683_1842# VDD 0.49671f
C776 a_9953_1842# VDD 0.49426f
C777 a_22564_1008# a_22677_1842# 0.05157f
C778 a_7477_1842# DELAY_VBIASP 0.0414f
C779 a_10843_1842# a_10430_1044# 0.01012f
C780 a_4437_1842# a_4003_1842# 0.69698f
C781 VDD a_25283_1842# 0.49737f
C782 MUX_SEL4 a_14825_519# 0.03307f
C783 a_14513_1842# a_14643_1842# 0.70845f
C784 a_26477_1842# a_27237_1842# 0.03319f
C785 a_24084_1008# VDD 0.28225f
C786 DELAY_VBIASN a_25630_1044# 0.02756f
C787 DELAY_VBIASN a_7390_1044# 0.02115f
C788 a_4248_1044# a_4324_1008# 0.01176f
C789 a_9751_1008# VDD 0.2822f
C790 DELAY_VBIASN a_22873_1842# 0.0961f
C791 DELAY_VBIASN a_12797_1842# 0.09992f
C792 a_20593_1842# a_20723_1842# 0.70845f
C793 VDD a_23111_2470# 0.01806f
C794 a_10430_1044# a_11271_1008# 0.28268f
C795 a_26043_1842# a_26151_2470# 0.01697f
C796 a_2297_1395# VDD 0.46536f
C797 a_25717_1842# a_25283_1842# 0.69698f
C798 a_8563_1842# a_8671_1842# 0.01163f
C799 a_7477_1842# a_7673_1842# 0.73897f
C800 a_8155_1044# a_7945_1044# 0.09424f
C801 a_25528_1044# a_24957_1842# 0.10864f
C802 a_24008_1044# a_24084_1008# 0.01176f
C803 DELAY_VBIASN a_19637_1842# 0.08375f
C804 DELAY_VBIASN a_10843_1842# 0.07254f
C805 a_24631_2470# a_24523_1842# 0.01697f
C806 a_9675_1044# a_9751_1008# 0.01194f
C807 a_16793_1842# a_16923_1842# 0.70845f
C808 a_7390_1044# a_9757_1842# 0.02479f
C809 DELAY_VBIASP a_22113_1842# 0.11222f
C810 a_12037_1842# DELAY_VBIASP 0.04141f
C811 a_24393_1842# a_24957_1842# 0.0114f
C812 DELAY_VBIASN a_27237_1842# 0.09456f
C813 VDD a_4871_2470# 0.01806f
C814 a_8808_1044# a_8237_1842# 0.10863f
C815 VDD a_15403_1842# 0.4973f
C816 a_15964_289# a_2019_311# 0.02413f
C817 MUX_SEL4 a_4350_1044# 0.31434f
C818 a_21911_1008# a_21917_1842# 0.02354f
C819 a_21917_1842# a_22243_1842# 0.01427f
C820 a_18443_1842# a_18551_1842# 0.01163f
C821 a_17865_519# a_16510_1044# 0.02165f
C822 a_27705_1044# a_27991_1008# 0.01885f
C823 a_5197_1842# a_5957_1842# 0.03319f
C824 a_25630_1044# a_26985_519# 0.02165f
C825 a_5197_1842# a_5768_1044# 0.10863f
C826 a_5115_1044# a_5191_1008# 0.01194f
C827 a_22590_1044# a_23945_519# 0.02165f
C828 a_4350_1044# a_5844_1008# 0.28279f
C829 a_1544_1044# MUX_SEL1 0.1672f
C830 a_1721_1395# MUX_SEL0 0.01315f
C831 a_17065_1044# a_17351_1008# 0.01885f
C832 a_18877_1842# DELAY_VBIASP 0.0414f
C833 a_18585_1044# a_18871_1008# 0.01885f
C834 a_10083_1842# DELAY_VBIASP 0.06627f
C835 a_7945_1044# VDD 0.30409f
C836 DELAY_VBIASN a_24523_1842# 0.07254f
C837 a_17031_2470# a_16923_1842# 0.01697f
C838 a_4905_1044# a_4437_1842# 0.19203f
C839 a_16108_289# a_21917_1842# 0.0157f
C840 a_10985_1044# a_11271_1008# 0.01885f
C841 VDD a_14311_1008# 0.28336f
C842 a_5957_1842# DELAY_VBIASN 0.09156f
C843 a_4437_1842# DELAY_IN 0.05007f
C844 a_5523_1842# a_5631_2470# 0.01697f
C845 a_1256_1044# a_1544_1044# 1.26509f
C846 VDD a_2297_331# 0.46496f
C847 a_21044_1008# a_20397_1842# 0.02312f
C848 a_8563_1842# VDD 0.49671f
C849 DELAY_VBIASP a_26477_1842# 0.04144f
C850 a_10083_1842# a_10191_1842# 0.01163f
C851 a_24665_1044# a_22590_1044# 0.03208f
C852 a_16408_1044# VDD 0.17274f
C853 a_26185_1044# a_25630_1044# 0.03209f
C854 a_24665_1044# a_24197_1842# 0.2079f
C855 DELAY_VBIASN a_13753_1842# 0.0961f
C856 a_10951_2470# VDD 0.01806f
C857 a_19550_1044# a_21157_1842# 0.05231f
C858 VDD a_21157_1842# 0.85848f
C859 a_25630_1044# a_27048_1044# 0.38994f
C860 DELAY_VBIASP a_23763_1842# 0.06627f
C861 MUX_SEL3 a_3449_331# 0.28429f
C862 MUX_SEL4 a_2873_331# 0.04916f
C863 MUX_OUT a_2297_331# 0.01179f
C864 a_7390_1044# a_8808_1044# 0.38994f
C865 a_19550_1044# a_20905_519# 0.02165f
C866 MUX_SEL1 DELAY_IN 0.01858f
C867 a_20905_519# VDD 0.29292f
C868 a_11848_1044# a_11924_1008# 0.01176f
C869 a_23437_1842# a_23633_1842# 0.76914f
C870 a_12797_1842# a_13123_1842# 0.01427f
C871 a_5115_1044# a_4905_1044# 0.09424f
C872 a_23633_1842# a_24197_1842# 0.0114f
C873 VDD a_17357_1842# 0.86909f
C874 a_5731_289# a_13470_1044# 0.41365f
C875 a_5197_1842# DELAY_VBIASP 0.0414f
C876 a_6717_1842# VDD 0.87726f
C877 a_18117_1842# a_18877_1842# 0.02912f
C878 a_22564_1008# a_21917_1842# 0.02011f
C879 a_23145_1044# VDD 0.30409f
C880 DELAY_VBIASN DELAY_VBIASP 3.50557f
C881 a_22113_1842# a_22243_1842# 0.70845f
C882 a_12037_1842# a_12233_1842# 0.77122f
C883 a_26395_1044# VDD 0.15389f
C884 a_17791_2470# VDD 0.01806f
C885 a_8155_1044# VDD 0.15389f
C886 VDD a_23003_1842# 0.4973f
C887 DELAY_VBIASN a_13470_1044# 0.02115f
C888 a_12993_1842# VDD 0.49426f
C889 a_6153_1842# a_6717_1842# 0.0114f
C890 a_16510_1044# a_17065_1044# 0.03209f
C891 a_13753_1842# a_13883_1842# 0.70845f
C892 DELAY_VBIASN a_14643_1842# 0.07254f
C893 DELAY_VBIASN a_7803_1842# 0.07254f
C894 a_4157_1313# a_2019_311# 0.01018f
C895 a_4157_1313# DELAY_IN 0.50642f
C896 a_12037_1842# a_11277_1842# 0.03319f
C897 a_15765_463# a_16108_289# 0.42004f
C898 a_15837_1842# a_15403_1842# 0.6972f
C899 a_5705_519# a_2019_311# 0.13872f
C900 a_9757_1842# DELAY_VBIASP 0.0414f
C901 a_19833_1842# a_19963_1842# 0.70845f
C902 DELAY_VBIASN a_7673_1842# 0.0961f
C903 a_7043_1842# a_7151_2470# 0.01697f
C904 a_20315_1044# a_19550_1044# 0.39037f
C905 a_16108_289# a_18877_1842# 0.0157f
C906 a_20315_1044# VDD 0.15389f
C907 DELAY_VBIASN a_20397_1842# 0.09974f
C908 a_24084_1008# a_22590_1044# 0.28279f
C909 a_24084_1008# a_23437_1842# 0.02312f
C910 a_14235_1044# a_14311_1008# 0.01194f
C911 a_24084_1008# a_24197_1842# 0.02055f
C912 a_18877_1842# a_19073_1842# 0.76914f
C913 DELAY_VBIASP a_21353_1842# 0.11222f
C914 DELAY_VBIASN a_18117_1842# 0.09156f
C915 DELAY_VBIASN a_16597_1842# 0.08375f
C916 a_19448_1044# a_19524_1008# 0.01176f
C917 VDD a_27433_1842# 0.49285f
C918 a_19550_1044# VDD 0.89766f
C919 a_8997_1842# a_8563_1842# 0.6972f
C920 a_13883_1842# DELAY_VBIASP 0.06627f
C921 a_16408_1044# a_15837_1842# 0.10864f
C922 DELAY_VBIASP a_17553_1842# 0.11222f
C923 a_5731_289# a_16108_289# 0.01334f
C924 a_6913_1842# DELAY_VBIASP 0.11222f
C925 a_11277_1842# a_10430_1044# 0.08038f
C926 a_13883_1842# a_13470_1044# 0.01012f
C927 a_18585_1044# a_18117_1842# 0.2079f
C928 MUX_SEL4 a_11785_519# 0.03255f
C929 VDD a_25717_1842# 0.86707f
C930 a_26477_1842# a_26673_1842# 0.76914f
C931 a_14513_1842# a_15077_1842# 0.0114f
C932 MUX_OUT VDD 0.35871f
C933 a_16271_1842# a_16163_1842# 0.01163f
C934 a_24008_1044# VDD 0.17499f
C935 a_9675_1044# VDD 0.15406f
C936 a_4248_1044# a_4350_1044# 0.37183f
C937 DELAY_VBIASN a_12233_1842# 0.0961f
C938 a_6153_1842# VDD 0.49285f
C939 a_6635_1044# VDD 0.15406f
C940 DELAY_VBIASN a_22243_1842# 0.07254f
C941 a_20593_1842# a_21157_1842# 0.0114f
C942 a_16484_1008# a_16597_1842# 0.05157f
C943 VDD a_22351_2470# 0.01806f
C944 a_10430_1044# a_11195_1044# 0.39037f
C945 a_25153_1842# a_25283_1842# 0.70845f
C946 a_13123_1842# DELAY_VBIASP 0.06627f
C947 a_19637_1842# a_19833_1842# 0.73897f
C948 a_24951_1008# a_24957_1842# 0.02354f
C949 a_7477_1842# a_7043_1842# 0.69698f
C950 a_7390_1044# a_9465_1044# 0.03208f
C951 DELAY_VBIASN a_19073_1842# 0.0961f
C952 DELAY_VBIASN a_11277_1842# 0.09974f
C953 a_16793_1842# a_17357_1842# 0.0114f
C954 a_12363_1842# a_12471_1842# 0.01163f
C955 a_18117_1842# a_17553_1842# 0.0114f
C956 a_13557_1842# a_13444_1008# 0.05157f
C957 a_21625_1044# a_21157_1842# 0.2079f
C958 DELAY_VBIASN a_4003_1842# 0.06486f
C959 DELAY_VBIASN a_26673_1842# 0.0961f
C960 MUX_SEL0 MUX_SEL2 0.01204f
C961 VDD a_4111_2470# 0.01866f
C962 a_8231_1008# a_8237_1842# 0.02349f
C963 a_15765_463# a_2019_311# 0.05969f
C964 DELAY_OUT_LAST a_27997_1842# 0.70955f
C965 a_21917_1842# a_22677_1842# 0.06198f
C966 a_16851_309# a_16510_1044# 0.02131f
C967 a_27705_1044# a_27915_1044# 0.09424f
C968 a_5197_1842# a_5393_1842# 0.76914f
C969 a_5957_1842# a_4350_1044# 0.05231f
C970 a_5197_1842# a_5191_1008# 0.02349f
C971 a_1544_1044# MUX_SEL0 0.07603f
C972 a_1256_1044# MUX_SEL1 1.44243f
C973 a_4350_1044# a_5768_1044# 0.38994f
C974 a_18313_1842# DELAY_VBIASP 0.11222f
C975 a_10517_1842# DELAY_VBIASP 0.0414f
C976 a_18585_1044# a_18795_1044# 0.09424f
C977 DELAY_VBIASN a_24957_1842# 0.09992f
C978 a_4157_1313# a_4437_1842# 0.01771f
C979 a_10985_1044# a_11195_1044# 0.09424f
C980 a_14825_519# a_13470_1044# 0.02058f
C981 a_2873_1395# VDD 0.46517f
C982 VDD a_14235_1044# 0.15389f
C983 a_7364_1008# a_6717_1842# 0.02011f
C984 a_5393_1842# DELAY_VBIASN 0.0961f
C985 a_16108_289# a_26985_519# 0.2906f
C986 VDD a_1721_331# 0.45259f
C987 a_20968_1044# a_20397_1842# 0.10863f
C988 a_15837_1842# VDD 0.87963f
C989 a_8997_1842# VDD 0.85848f
C990 a_16510_1044# a_18871_1008# 0.26208f
C991 a_23145_1044# a_22590_1044# 0.03209f
C992 a_15831_1008# VDD 0.2816f
C993 a_19550_1044# a_21483_1842# 0.01012f
C994 VDD a_21483_1842# 0.4973f
C995 a_5731_289# a_2019_311# 1.15781f
C996 a_10191_2470# VDD 0.01806f
C997 VDD a_20593_1842# 0.49417f
C998 a_25630_1044# a_26471_1008# 0.28268f
C999 a_7390_1044# a_8231_1008# 0.28268f
C1000 MUX_SEL4 a_2297_331# 0.04338f
C1001 MUX_SEL3 a_2873_331# 0.12606f
C1002 MUX_SEL2 a_3449_331# 0.10741f
C1003 MUX_SEL0 DELAY_IN 0.14089f
C1004 a_22590_1044# a_23003_1842# 0.01012f
C1005 a_23437_1842# a_23003_1842# 0.6972f
C1006 a_4350_1044# a_6425_1044# 0.03208f
C1007 a_12797_1842# a_13557_1842# 0.06198f
C1008 a_20105_1044# a_20391_1008# 0.01885f
C1009 VDD a_16793_1842# 0.49277f
C1010 a_4633_1842# DELAY_VBIASP 0.11222f
C1011 a_9323_1842# a_9431_2470# 0.01697f
C1012 a_18117_1842# a_18313_1842# 0.77122f
C1013 DELAY_VBIASP a_19833_1842# 0.11222f
C1014 a_21625_1044# a_19550_1044# 0.03208f
C1015 VDD a_25913_1842# 0.49294f
C1016 a_21625_1044# VDD 0.29722f
C1017 DELAY_VBIASN DELAY_IN 0.07156f
C1018 a_22113_1842# a_22677_1842# 0.0114f
C1019 a_12037_1842# a_11603_1842# 0.6972f
C1020 MUX_SEL4 a_6717_1842# 0.0195f
C1021 a_25604_1008# VDD 0.28633f
C1022 a_17031_2470# VDD 0.01806f
C1023 a_7364_1008# VDD 0.28633f
C1024 a_22590_1044# VDD 0.89557f
C1025 a_12363_1842# VDD 0.4973f
C1026 VDD a_23437_1842# 0.86909f
C1027 a_25913_1842# a_25717_1842# 0.73897f
C1028 VDD a_24197_1842# 0.85848f
C1029 a_4003_1842# a_4111_1842# 0.01163f
C1030 DELAY_VBIASN a_15077_1842# 0.09156f
C1031 a_13753_1842# a_14317_1842# 0.0114f
C1032 a_23145_1044# a_23431_1008# 0.01885f
C1033 a_3449_1395# DELAY_IN 0.01058f
C1034 a_15273_1842# a_15403_1842# 0.70845f
C1035 a_15765_463# a_15964_289# 0.061f
C1036 a_3449_331# a_2019_311# 0.01176f
C1037 a_17865_519# VDD 0.29444f
C1038 a_6711_1008# a_6425_1044# 0.01885f
C1039 DELAY_IN a_3449_331# 0.01017f
C1040 a_19833_1842# a_20397_1842# 0.0114f
C1041 a_9193_1842# DELAY_VBIASP 0.11222f
C1042 a_25604_1008# a_25717_1842# 0.05157f
C1043 DELAY_VBIASN a_7043_1842# 0.07254f
C1044 a_12505_1044# a_12791_1008# 0.01885f
C1045 a_19637_1842# a_19524_1008# 0.05157f
C1046 a_19203_1842# VDD 0.49737f
C1047 a_11473_1842# VDD 0.49417f
C1048 a_24008_1044# a_22590_1044# 0.38994f
C1049 a_24008_1044# a_23437_1842# 0.10863f
C1050 a_7390_1044# a_9751_1008# 0.26208f
C1051 a_18877_1842# a_18443_1842# 0.6972f
C1052 DELAY_VBIASP a_20723_1842# 0.06627f
C1053 DELAY_VBIASN a_16033_1842# 0.0961f
C1054 a_1256_289# a_2873_331# 0.27926f
C1055 a_1544_289# a_2297_331# 0.27303f
C1056 a_10517_1842# a_11277_1842# 0.01669f
C1057 a_19448_1044# a_19550_1044# 0.37183f
C1058 a_4763_1842# a_4871_1842# 0.01163f
C1059 VDD a_26803_1842# 0.49671f
C1060 a_19448_1044# VDD 0.17274f
C1061 a_8433_1842# a_8563_1842# 0.70845f
C1062 a_14317_1842# DELAY_VBIASP 0.0414f
C1063 a_15831_1008# a_15837_1842# 0.02354f
C1064 DELAY_VBIASP a_16923_1842# 0.06627f
C1065 a_11848_1044# VDD 0.17499f
C1066 a_13557_1842# a_13753_1842# 0.73897f
C1067 a_5731_289# a_15964_289# 0.2778f
C1068 a_13883_1842# a_13991_2470# 0.01697f
C1069 a_6283_1842# DELAY_VBIASP 0.06627f
C1070 a_8237_1842# a_8563_1842# 0.01427f
C1071 a_14317_1842# a_13470_1044# 0.08038f
C1072 VDD a_25153_1842# 0.49426f
C1073 a_17928_1044# a_18004_1008# 0.01176f
C1074 a_14317_1842# a_14643_1842# 0.01427f
C1075 a_26477_1842# a_26043_1842# 0.6972f
C1076 MUX_SEL4 VDD 2.63176f
C1077 a_14964_1008# a_14317_1842# 0.02312f
C1078 a_23431_1008# VDD 0.28336f
C1079 a_5523_1842# VDD 0.49671f
C1080 DELAY_VBIASN a_11603_1842# 0.07254f
C1081 DELAY_VBIASN a_22677_1842# 0.08375f
C1082 a_5844_1008# VDD 0.28225f
C1083 a_20397_1842# a_20723_1842# 0.01427f
C1084 a_18117_1842# a_16510_1044# 0.05231f
C1085 a_16510_1044# a_16597_1842# 0.1088f
C1086 a_10430_1044# a_10404_1008# 0.277f
C1087 a_13557_1842# DELAY_VBIASP 0.0414f
C1088 a_25153_1842# a_25717_1842# 0.0114f
C1089 DELAY_VBIASP a_23633_1842# 0.11222f
C1090 MUX_SEL4 MUX_OUT 0.91933f
C1091 a_6913_1842# a_7043_1842# 0.70845f
C1092 a_7390_1044# a_7945_1044# 0.03209f
C1093 a_5731_289# a_8745_519# 0.28635f
C1094 a_5197_1842# a_4437_1842# 0.01669f
C1095 a_12505_1044# a_12037_1842# 0.2079f
C1096 a_4324_1008# a_4437_1842# 0.05157f
C1097 DELAY_VBIASN a_18443_1842# 0.07254f
C1098 DELAY_VBIASN a_10713_1842# 0.0961f
C1099 a_13557_1842# a_13470_1044# 0.1088f
C1100 DELAY_VBIASN a_27563_1842# 0.07259f
C1101 a_17065_1044# VDD 0.30218f
C1102 DELAY_VBIASN a_4437_1842# 0.08375f
C1103 MUX_SEL0 MUX_SEL1 3.14917f
C1104 DELAY_VBIASN a_26043_1842# 0.07254f
R0 DELAY_VBIASN.n1 DELAY_VBIASN.t31 34.3755
R1 DELAY_VBIASN.n1 DELAY_VBIASN.t30 33.0005
R2 DELAY_VBIASN.n2 DELAY_VBIASN.t29 33.0005
R3 DELAY_VBIASN.n3 DELAY_VBIASN.t28 33.0005
R4 DELAY_VBIASN.n4 DELAY_VBIASN.t27 33.0005
R5 DELAY_VBIASN.n5 DELAY_VBIASN.t26 33.0005
R6 DELAY_VBIASN.n6 DELAY_VBIASN.t25 33.0005
R7 DELAY_VBIASN.n7 DELAY_VBIASN.t24 33.0005
R8 DELAY_VBIASN.n8 DELAY_VBIASN.t23 33.0005
R9 DELAY_VBIASN.n9 DELAY_VBIASN.t22 33.0005
R10 DELAY_VBIASN.n10 DELAY_VBIASN.t21 33.0005
R11 DELAY_VBIASN.n11 DELAY_VBIASN.t20 33.0005
R12 DELAY_VBIASN.n12 DELAY_VBIASN.t19 33.0005
R13 DELAY_VBIASN.n13 DELAY_VBIASN.t18 33.0005
R14 DELAY_VBIASN.n14 DELAY_VBIASN.t17 33.0005
R15 DELAY_VBIASN.n15 DELAY_VBIASN.t16 33.0005
R16 DELAY_VBIASN.n16 DELAY_VBIASN.t15 33.0005
R17 DELAY_VBIASN.n17 DELAY_VBIASN.t14 33.0005
R18 DELAY_VBIASN.n18 DELAY_VBIASN.t13 33.0005
R19 DELAY_VBIASN.n19 DELAY_VBIASN.t12 33.0005
R20 DELAY_VBIASN.n20 DELAY_VBIASN.t11 33.0005
R21 DELAY_VBIASN.n21 DELAY_VBIASN.t10 33.0005
R22 DELAY_VBIASN.n22 DELAY_VBIASN.t9 33.0005
R23 DELAY_VBIASN.n23 DELAY_VBIASN.t8 33.0005
R24 DELAY_VBIASN.n24 DELAY_VBIASN.t7 33.0005
R25 DELAY_VBIASN.n25 DELAY_VBIASN.t6 33.0005
R26 DELAY_VBIASN.n26 DELAY_VBIASN.t5 33.0005
R27 DELAY_VBIASN.n27 DELAY_VBIASN.t4 33.0005
R28 DELAY_VBIASN.n28 DELAY_VBIASN.t3 33.0005
R29 DELAY_VBIASN.n29 DELAY_VBIASN.t2 33.0005
R30 DELAY_VBIASN.n30 DELAY_VBIASN.t1 33.0005
R31 DELAY_VBIASN.n0 DELAY_VBIASN.t0 33.0005
R32 DELAY_VBIASN DELAY_VBIASN.n0 1.55517
R33 DELAY_VBIASN.n0 DELAY_VBIASN.n30 1.3755
R34 DELAY_VBIASN.n30 DELAY_VBIASN.n29 1.3755
R35 DELAY_VBIASN.n29 DELAY_VBIASN.n28 1.3755
R36 DELAY_VBIASN.n28 DELAY_VBIASN.n27 1.3755
R37 DELAY_VBIASN.n27 DELAY_VBIASN.n26 1.3755
R38 DELAY_VBIASN.n26 DELAY_VBIASN.n25 1.3755
R39 DELAY_VBIASN.n25 DELAY_VBIASN.n24 1.3755
R40 DELAY_VBIASN.n24 DELAY_VBIASN.n23 1.3755
R41 DELAY_VBIASN.n23 DELAY_VBIASN.n22 1.3755
R42 DELAY_VBIASN.n22 DELAY_VBIASN.n21 1.3755
R43 DELAY_VBIASN.n21 DELAY_VBIASN.n20 1.3755
R44 DELAY_VBIASN.n20 DELAY_VBIASN.n19 1.3755
R45 DELAY_VBIASN.n19 DELAY_VBIASN.n18 1.3755
R46 DELAY_VBIASN.n18 DELAY_VBIASN.n17 1.3755
R47 DELAY_VBIASN.n17 DELAY_VBIASN.n16 1.3755
R48 DELAY_VBIASN.n16 DELAY_VBIASN.n15 1.3755
R49 DELAY_VBIASN.n15 DELAY_VBIASN.n14 1.3755
R50 DELAY_VBIASN.n14 DELAY_VBIASN.n13 1.3755
R51 DELAY_VBIASN.n13 DELAY_VBIASN.n12 1.3755
R52 DELAY_VBIASN.n12 DELAY_VBIASN.n11 1.3755
R53 DELAY_VBIASN.n11 DELAY_VBIASN.n10 1.3755
R54 DELAY_VBIASN.n10 DELAY_VBIASN.n9 1.3755
R55 DELAY_VBIASN.n9 DELAY_VBIASN.n8 1.3755
R56 DELAY_VBIASN.n8 DELAY_VBIASN.n7 1.3755
R57 DELAY_VBIASN.n7 DELAY_VBIASN.n6 1.3755
R58 DELAY_VBIASN.n6 DELAY_VBIASN.n5 1.3755
R59 DELAY_VBIASN.n5 DELAY_VBIASN.n4 1.3755
R60 DELAY_VBIASN.n4 DELAY_VBIASN.n3 1.3755
R61 DELAY_VBIASN.n3 DELAY_VBIASN.n2 1.3755
R62 DELAY_VBIASN.n2 DELAY_VBIASN.n1 1.3755
R63 DELAY_VBIASP.n1 DELAY_VBIASP.t31 34.3685
R64 DELAY_VBIASP.n1 DELAY_VBIASP.t30 33.0005
R65 DELAY_VBIASP.n2 DELAY_VBIASP.t29 33.0005
R66 DELAY_VBIASP.n3 DELAY_VBIASP.t28 33.0005
R67 DELAY_VBIASP.n4 DELAY_VBIASP.t27 33.0005
R68 DELAY_VBIASP.n5 DELAY_VBIASP.t26 33.0005
R69 DELAY_VBIASP.n6 DELAY_VBIASP.t25 33.0005
R70 DELAY_VBIASP.n7 DELAY_VBIASP.t24 33.0005
R71 DELAY_VBIASP.n8 DELAY_VBIASP.t23 33.0005
R72 DELAY_VBIASP.n9 DELAY_VBIASP.t22 33.0005
R73 DELAY_VBIASP.n10 DELAY_VBIASP.t21 33.0005
R74 DELAY_VBIASP.n11 DELAY_VBIASP.t20 33.0005
R75 DELAY_VBIASP.n12 DELAY_VBIASP.t19 33.0005
R76 DELAY_VBIASP.n13 DELAY_VBIASP.t18 33.0005
R77 DELAY_VBIASP.n14 DELAY_VBIASP.t17 33.0005
R78 DELAY_VBIASP.n15 DELAY_VBIASP.t16 33.0005
R79 DELAY_VBIASP.n16 DELAY_VBIASP.t15 33.0005
R80 DELAY_VBIASP.n17 DELAY_VBIASP.t14 33.0005
R81 DELAY_VBIASP.n18 DELAY_VBIASP.t13 33.0005
R82 DELAY_VBIASP.n19 DELAY_VBIASP.t12 33.0005
R83 DELAY_VBIASP.n20 DELAY_VBIASP.t11 33.0005
R84 DELAY_VBIASP.n21 DELAY_VBIASP.t10 33.0005
R85 DELAY_VBIASP.n22 DELAY_VBIASP.t9 33.0005
R86 DELAY_VBIASP.n23 DELAY_VBIASP.t8 33.0005
R87 DELAY_VBIASP.n24 DELAY_VBIASP.t7 33.0005
R88 DELAY_VBIASP.n25 DELAY_VBIASP.t6 33.0005
R89 DELAY_VBIASP.n26 DELAY_VBIASP.t5 33.0005
R90 DELAY_VBIASP.n27 DELAY_VBIASP.t4 33.0005
R91 DELAY_VBIASP.n28 DELAY_VBIASP.t3 33.0005
R92 DELAY_VBIASP.n29 DELAY_VBIASP.t2 33.0005
R93 DELAY_VBIASP.n30 DELAY_VBIASP.t1 33.0005
R94 DELAY_VBIASP.n0 DELAY_VBIASP.t0 33.0005
R95 DELAY_VBIASP DELAY_VBIASP.n0 1.70586
R96 DELAY_VBIASP.n0 DELAY_VBIASP.n30 1.36852
R97 DELAY_VBIASP.n30 DELAY_VBIASP.n29 1.36852
R98 DELAY_VBIASP.n29 DELAY_VBIASP.n28 1.36852
R99 DELAY_VBIASP.n28 DELAY_VBIASP.n27 1.36852
R100 DELAY_VBIASP.n27 DELAY_VBIASP.n26 1.36852
R101 DELAY_VBIASP.n26 DELAY_VBIASP.n25 1.36852
R102 DELAY_VBIASP.n25 DELAY_VBIASP.n24 1.36852
R103 DELAY_VBIASP.n24 DELAY_VBIASP.n23 1.36852
R104 DELAY_VBIASP.n23 DELAY_VBIASP.n22 1.36852
R105 DELAY_VBIASP.n22 DELAY_VBIASP.n21 1.36852
R106 DELAY_VBIASP.n21 DELAY_VBIASP.n20 1.36852
R107 DELAY_VBIASP.n20 DELAY_VBIASP.n19 1.36852
R108 DELAY_VBIASP.n19 DELAY_VBIASP.n18 1.36852
R109 DELAY_VBIASP.n18 DELAY_VBIASP.n17 1.36852
R110 DELAY_VBIASP.n17 DELAY_VBIASP.n16 1.36852
R111 DELAY_VBIASP.n16 DELAY_VBIASP.n15 1.36852
R112 DELAY_VBIASP.n15 DELAY_VBIASP.n14 1.36852
R113 DELAY_VBIASP.n14 DELAY_VBIASP.n13 1.36852
R114 DELAY_VBIASP.n13 DELAY_VBIASP.n12 1.36852
R115 DELAY_VBIASP.n12 DELAY_VBIASP.n11 1.36852
R116 DELAY_VBIASP.n11 DELAY_VBIASP.n10 1.36852
R117 DELAY_VBIASP.n10 DELAY_VBIASP.n9 1.36852
R118 DELAY_VBIASP.n9 DELAY_VBIASP.n8 1.36852
R119 DELAY_VBIASP.n8 DELAY_VBIASP.n7 1.36852
R120 DELAY_VBIASP.n7 DELAY_VBIASP.n6 1.36852
R121 DELAY_VBIASP.n6 DELAY_VBIASP.n5 1.36852
R122 DELAY_VBIASP.n5 DELAY_VBIASP.n4 1.36852
R123 DELAY_VBIASP.n4 DELAY_VBIASP.n3 1.36852
R124 DELAY_VBIASP.n3 DELAY_VBIASP.n2 1.36852
R125 DELAY_VBIASP.n2 DELAY_VBIASP.n1 1.36852
R126 VSS.n4 VSS.n374 7907.02
R127 VSS.n4 VSS.t260 58.3211
R128 VSS.t288 VSS.n4 101.74
R129 VSS.t232 VSS.n4 116.469
R130 VSS.t96 VSS.n2 25.6732
R131 VSS.n4 VSS.n15 0.547872
R132 VSS.n4 VSS.t313 97.2306
R133 VSS.t295 VSS.n4 49.8619
R134 VSS.t280 VSS.n4 49.8619
R135 VSS.n4 VSS.t268 97.2306
R136 VSS.n8 VSS.t178 409.723
R137 VSS.t181 VSS.n4 21.009
R138 VSS.n9 VSS.t12 59.6836
R139 VSS.t561 VSS.n425 357.007
R140 VSS.t560 VSS.n10 343.118
R141 VSS.n4 VSS.t175 97.2225
R142 VSS.n4 VSS.t298 97.2306
R143 VSS.n4 VSS.t328 97.2306
R144 VSS.n4 VSS.t343 97.2306
R145 VSS.t76 VSS.n14 332.017
R146 VSS.n4 VSS.t258 101.74
R147 VSS.n4 VSS.t318 101.743
R148 VSS.n426 VSS.t94 299.425
R149 VSS.t315 VSS.n4 105.684
R150 VSS.t330 VSS.n4 105.688
R151 VSS.t121 VSS.n4 110.547
R152 VSS.t32 VSS.n4 110.547
R153 VSS.t376 VSS.n4 110.547
R154 VSS.t237 VSS.n4 110.546
R155 VSS.t231 VSS.n4 110.547
R156 VSS.n4 VSS.t70 116.469
R157 VSS.t373 VSS.n4 110.547
R158 VSS.n426 VSS.t159 287.909
R159 VSS.n4 VSS.t251 114.148
R160 VSS.t246 VSS.n8 105.523
R161 VSS.n13 VSS.t90 332.017
R162 VSS.n14 VSS.t78 106.362
R163 VSS.n4 VSS.t374 116.469
R164 VSS.t377 VSS.n4 116.468
R165 VSS.t33 VSS.n4 116.469
R166 VSS.t37 VSS.n12 107.335
R167 VSS.t250 VSS.n87 252.375
R168 VSS.t167 VSS.n79 252.375
R169 VSS.n85 VSS.t421 252.375
R170 VSS.t516 VSS.n83 252.375
R171 VSS.t505 VSS.n81 252.375
R172 VSS.n27 VSS.t380 252.375
R173 VSS.t14 VSS.n76 252.375
R174 VSS.n33 VSS.t497 252.375
R175 VSS.n36 VSS.t402 252.375
R176 VSS.t406 VSS.n74 252.375
R177 VSS.n43 VSS.t384 252.375
R178 VSS.t15 VSS.n71 252.375
R179 VSS.t168 VSS.n69 252.375
R180 VSS.t531 VSS.n67 252.375
R181 VSS.t555 VSS.n64 252.375
R182 VSS.t552 VSS.n63 252.375
R183 VSS.n57 VSS.t366 252.375
R184 VSS.t164 VSS.n84 252.117
R185 VSS.n70 VSS.t381 252.117
R186 VSS.n61 VSS.t182 252.117
R187 VSS.n21 VSS.t55 252.115
R188 VSS.n24 VSS.t530 252.115
R189 VSS.t532 VSS.n98 252.115
R190 VSS.t387 VSS.n97 252.115
R191 VSS.n30 VSS.t517 252.115
R192 VSS.t74 VSS.n95 252.115
R193 VSS.n38 VSS.t551 252.115
R194 VSS.n41 VSS.t553 252.115
R195 VSS.n44 VSS.t550 252.115
R196 VSS.t496 VSS.n91 252.115
R197 VSS.n52 VSS.t75 252.115
R198 VSS.n54 VSS.t554 252.115
R199 VSS.t428 VSS.n236 250.837
R200 VSS.t434 VSS.n238 250.837
R201 VSS.t440 VSS.n244 250.837
R202 VSS.t426 VSS.n246 250.837
R203 VSS.t442 VSS.n252 250.837
R204 VSS.t438 VSS.n254 250.837
R205 VSS.t432 VSS.n260 250.837
R206 VSS.t444 VSS.n262 250.837
R207 VSS.t436 VSS.n268 250.837
R208 VSS.t446 VSS.n270 250.837
R209 VSS.t448 VSS.n276 250.837
R210 VSS.t422 VSS.n278 250.837
R211 VSS.t458 VSS.n284 250.837
R212 VSS.t460 VSS.n286 250.837
R213 VSS.t454 VSS.n292 250.837
R214 VSS.t462 VSS.n294 250.837
R215 VSS.t464 VSS.n300 250.837
R216 VSS.t466 VSS.n302 250.837
R217 VSS.t450 VSS.n308 250.837
R218 VSS.t468 VSS.n310 250.837
R219 VSS.t456 VSS.n316 250.837
R220 VSS.t470 VSS.n318 250.837
R221 VSS.t452 VSS.n324 250.837
R222 VSS.t430 VSS.n326 250.837
R223 VSS.t474 VSS.n332 250.837
R224 VSS.t478 VSS.n334 250.837
R225 VSS.t424 VSS.n340 250.837
R226 VSS.t482 VSS.n342 250.837
R227 VSS.t480 VSS.n348 250.837
R228 VSS.t476 VSS.n350 250.837
R229 VSS.t484 VSS.n356 250.837
R230 VSS.t472 VSS.n358 250.837
R231 VSS.n4 VSS.t278 117.531
R232 VSS.n4 VSS.t323 117.531
R233 VSS.n807 VSS.t105 234.114
R234 VSS.n790 VSS.t504 234.114
R235 VSS.n773 VSS.t409 234.114
R236 VSS.n756 VSS.t511 234.114
R237 VSS.n739 VSS.t512 234.114
R238 VSS.n722 VSS.t390 234.114
R239 VSS.n705 VSS.t396 234.114
R240 VSS.n688 VSS.t500 234.114
R241 VSS.n671 VSS.t189 234.114
R242 VSS.n654 VSS.t67 234.114
R243 VSS.n637 VSS.t418 234.114
R244 VSS.n620 VSS.t487 234.114
R245 VSS.n603 VSS.t397 234.114
R246 VSS.n586 VSS.t196 234.114
R247 VSS.n569 VSS.t185 234.114
R248 VSS.n552 VSS.t562 234.114
R249 VSS.t10 VSS.n425 230.327
R250 VSS.t308 VSS.n4 117.528
R251 VSS.t243 VSS.n4 117.216
R252 VSS.t502 VSS.n82 225.361
R253 VSS.t411 VSS.n80 225.361
R254 VSS.t187 VSS.n73 225.361
R255 VSS.t398 VSS.n66 225.361
R256 VSS.n18 VSS.t525 225.359
R257 VSS.n19 VSS.t107 225.359
R258 VSS.n26 VSS.t509 225.359
R259 VSS.t514 VSS.n96 225.359
R260 VSS.n31 VSS.t388 225.359
R261 VSS.t394 VSS.n94 225.359
R262 VSS.t498 VSS.n93 225.359
R263 VSS.n45 VSS.t65 225.359
R264 VSS.t419 VSS.n92 225.359
R265 VSS.n49 VSS.t488 225.359
R266 VSS.n55 VSS.t194 225.359
R267 VSS.t183 VSS.n90 225.359
R268 VSS.n4 VSS.t238 116.469
R269 VSS.n4 VSS.t192 116.469
R270 VSS.t130 VSS.n99 211.982
R271 VSS.n22 VSS.t527 211.982
R272 VSS.n25 VSS.t127 211.982
R273 VSS.n29 VSS.t139 211.982
R274 VSS.n32 VSS.t533 211.982
R275 VSS.n35 VSS.t0 211.982
R276 VSS.n39 VSS.t87 211.982
R277 VSS.n42 VSS.t124 211.982
R278 VSS.n46 VSS.t539 211.982
R279 VSS.n48 VSS.t542 211.982
R280 VSS.n50 VSS.t536 211.982
R281 VSS.n56 VSS.t210 211.982
R282 VSS.n86 VSS.t234 211.982
R283 VSS.n77 VSS.t81 211.982
R284 VSS.n65 VSS.t3 211.982
R285 VSS.n60 VSS.t133 211.982
R286 VSS.n9 VSS.t10 221.012
R287 VSS.n10 VSS.t245 107.931
R288 VSS.t35 VSS.n12 398.622
R289 VSS.t403 VSS.n78 195.26
R290 VSS.t559 VSS.n75 195.26
R291 VSS.t382 VSS.n72 195.26
R292 VSS.t392 VSS.n68 195.26
R293 VSS.t98 VSS.n62 195.26
R294 VSS.t172 VSS.n100 195.26
R295 VSS.n20 VSS.t169 195.26
R296 VSS.n23 VSS.t248 195.26
R297 VSS.n28 VSS.t364 195.26
R298 VSS.n34 VSS.t203 195.26
R299 VSS.n37 VSS.t415 195.26
R300 VSS.n40 VSS.t56 195.26
R301 VSS.n47 VSS.t162 195.26
R302 VSS.n51 VSS.t198 195.26
R303 VSS.n53 VSS.t523 195.26
R304 VSS.n58 VSS.t61 195.26
R305 VSS.n14 VSS.n4 6.82739
R306 VSS.n13 VSS.t92 106.362
R307 VSS.n813 VSS.t116 187.292
R308 VSS.n796 VSS.t154 187.292
R309 VSS.n779 VSS.t547 187.292
R310 VSS.n762 VSS.t72 187.292
R311 VSS.n745 VSS.t546 187.292
R312 VSS.n728 VSS.t118 187.292
R313 VSS.n711 VSS.t226 187.292
R314 VSS.n694 VSS.t545 187.292
R315 VSS.n677 VSS.t227 187.292
R316 VSS.n660 VSS.t156 187.292
R317 VSS.n643 VSS.t549 187.292
R318 VSS.n626 VSS.t548 187.292
R319 VSS.n609 VSS.t220 187.292
R320 VSS.n592 VSS.t179 187.292
R321 VSS.n575 VSS.t120 187.292
R322 VSS.n558 VSS.t219 187.292
R323 VSS.n4 VSS.t69 110.547
R324 VSS.t191 VSS.n4 110.546
R325 VSS.t85 VSS.n242 173.913
R326 VSS.t110 VSS.n250 173.913
R327 VSS.t44 VSS.n258 173.913
R328 VSS.n266 VSS.t229 173.913
R329 VSS.n274 VSS.t47 173.913
R330 VSS.t214 VSS.n282 173.913
R331 VSS.n290 VSS.t27 173.913
R332 VSS.t143 VSS.n298 173.913
R333 VSS.t24 VSS.n306 173.913
R334 VSS.t137 VSS.n314 173.913
R335 VSS.t241 VSS.n322 173.913
R336 VSS.n330 VSS.t222 173.913
R337 VSS.t30 VSS.n338 173.913
R338 VSS.t146 VSS.n346 173.913
R339 VSS.t21 VSS.n354 173.913
R340 VSS.t149 VSS.n362 173.913
R341 VSS.n374 VSS.n365 173.913
R342 VSS.t235 VSS.t173 163.881
R343 VSS.t131 VSS.t170 163.881
R344 VSS.t528 VSS.t247 163.881
R345 VSS.t128 VSS.t404 163.881
R346 VSS.t82 VSS.t362 163.881
R347 VSS.t140 VSS.t558 163.881
R348 VSS.t534 VSS.t205 163.881
R349 VSS.t1 VSS.t414 163.881
R350 VSS.t88 VSS.t58 163.881
R351 VSS.t125 VSS.t383 163.881
R352 VSS.t540 VSS.t160 163.881
R353 VSS.t543 VSS.t391 163.881
R354 VSS.t537 VSS.t200 163.881
R355 VSS.t4 VSS.t524 163.881
R356 VSS.t211 VSS.t100 163.881
R357 VSS.t134 VSS.t63 163.881
R358 VSS.n4 VSS.t255 105.689
R359 VSS.n4 VSS.t270 105.688
R360 VSS.n4 VSS.t285 105.688
R361 VSS.n4 VSS.t300 105.688
R362 VSS.t333 VSS.n4 101.74
R363 VSS.t520 VSS.n104 157.062
R364 VSS.t495 VSS.n103 156.429
R365 VSS.t501 VSS.n86 155.126
R366 VSS.t491 VSS.n77 155.126
R367 VSS.t400 VSS.n65 155.126
R368 VSS.t508 VSS.n60 155.126
R369 VSS.t359 VSS.n99 155.125
R370 VSS.n22 VSS.t165 155.125
R371 VSS.n25 VSS.t557 155.125
R372 VSS.n29 VSS.t59 155.125
R373 VSS.n32 VSS.t486 155.125
R374 VSS.n35 VSS.t39 155.125
R375 VSS.n39 VSS.t18 155.125
R376 VSS.n42 VSS.t253 155.125
R377 VSS.n46 VSS.t413 155.125
R378 VSS.n48 VSS.t367 155.125
R379 VSS.n50 VSS.t202 155.125
R380 VSS.n56 VSS.t369 155.125
R381 VSS.n835 VSS.t8 153.846
R382 VSS.n813 VSS.t84 153.846
R383 VSS.n796 VSS.t109 153.846
R384 VSS.n779 VSS.t43 153.846
R385 VSS.n762 VSS.t228 153.846
R386 VSS.n745 VSS.t46 153.846
R387 VSS.n728 VSS.t213 153.846
R388 VSS.n711 VSS.t26 153.846
R389 VSS.n694 VSS.t142 153.846
R390 VSS.n677 VSS.t23 153.846
R391 VSS.n660 VSS.t136 153.846
R392 VSS.n643 VSS.t240 153.846
R393 VSS.n626 VSS.t221 153.846
R394 VSS.n609 VSS.t29 153.846
R395 VSS.n592 VSS.t145 153.846
R396 VSS.n575 VSS.t20 153.846
R397 VSS.n558 VSS.t148 153.846
R398 VSS.t217 VSS.n103 153.327
R399 VSS.t521 VSS.n102 153.236
R400 VSS.t159 VSS.n11 165.508
R401 VSS.t490 VSS.n241 147.157
R402 VSS.t41 VSS.n249 147.157
R403 VSS.t417 VSS.n257 147.157
R404 VSS.t407 VSS.n265 147.157
R405 VSS.t522 VSS.n273 147.157
R406 VSS.t370 VSS.n281 147.157
R407 VSS.t360 VSS.n289 147.157
R408 VSS.t53 VSS.n297 147.157
R409 VSS.t372 VSS.n305 147.157
R410 VSS.t207 VSS.n313 147.157
R411 VSS.t385 VSS.n321 147.157
R412 VSS.t16 VSS.n329 147.157
R413 VSS.t208 VSS.n337 147.157
R414 VSS.t379 VSS.n345 147.157
R415 VSS.t556 VSS.n353 147.157
R416 VSS.t506 VSS.n361 147.157
R417 VSS.t357 VSS.n89 145.093
R418 VSS.t353 VSS.n89 138.404
R419 VSS.t283 VSS.n4 97.2306
R420 VSS.n17 VSS.t151 134.661
R421 VSS.n59 VSS.t353 131.974
R422 VSS.n1 VSS.t90 130.939
R423 VSS.n15 VSS.t76 131.005
R424 VSS.n845 VSS.t112 126.945
R425 VSS.n846 VSS.t51 123.212
R426 VSS.n102 VSS.t495 120.691
R427 VSS.n3 VSS.t560 119.422
R428 VSS.t518 VSS.n17 117.858
R429 VSS.n365 VSS.t357 117.058
R430 VSS.t224 VSS.n127 115.745
R431 VSS.t225 VSS.n128 108.276
R432 VSS.n815 VSS.t501 107.023
R433 VSS.n807 VSS.t490 107.023
R434 VSS.n798 VSS.t359 107.023
R435 VSS.n790 VSS.t41 107.023
R436 VSS.t165 VSS.n781 107.023
R437 VSS.n773 VSS.t417 107.023
R438 VSS.t557 VSS.n764 107.023
R439 VSS.n756 VSS.t407 107.023
R440 VSS.n747 VSS.t491 107.023
R441 VSS.n739 VSS.t522 107.023
R442 VSS.t59 VSS.n730 107.023
R443 VSS.n722 VSS.t370 107.023
R444 VSS.t486 VSS.n713 107.023
R445 VSS.n705 VSS.t360 107.023
R446 VSS.t39 VSS.n696 107.023
R447 VSS.n688 VSS.t53 107.023
R448 VSS.t18 VSS.n679 107.023
R449 VSS.n671 VSS.t372 107.023
R450 VSS.t253 VSS.n662 107.023
R451 VSS.n654 VSS.t207 107.023
R452 VSS.t413 VSS.n645 107.023
R453 VSS.n637 VSS.t385 107.023
R454 VSS.t367 VSS.n628 107.023
R455 VSS.n620 VSS.t16 107.023
R456 VSS.t202 VSS.n611 107.023
R457 VSS.n603 VSS.t208 107.023
R458 VSS.n594 VSS.t400 107.023
R459 VSS.n586 VSS.t379 107.023
R460 VSS.t369 VSS.n577 107.023
R461 VSS.n569 VSS.t556 107.023
R462 VSS.n560 VSS.t508 107.023
R463 VSS.n552 VSS.t506 107.023
R464 VSS.n835 VSS.t346 100.335
R465 VSS.t84 VSS.n241 100.335
R466 VSS.t109 VSS.n249 100.335
R467 VSS.t43 VSS.n257 100.335
R468 VSS.t228 VSS.n265 100.335
R469 VSS.t46 VSS.n273 100.335
R470 VSS.t213 VSS.n281 100.335
R471 VSS.t26 VSS.n289 100.335
R472 VSS.t142 VSS.n297 100.335
R473 VSS.t23 VSS.n305 100.335
R474 VSS.t136 VSS.n313 100.335
R475 VSS.t240 VSS.n321 100.335
R476 VSS.t221 VSS.n329 100.335
R477 VSS.t29 VSS.n337 100.335
R478 VSS.t145 VSS.n345 100.335
R479 VSS.t20 VSS.n353 100.335
R480 VSS.t148 VSS.n361 100.335
R481 VSS.n844 VSS.t216 97.0758
R482 VSS.n0 VSS.t561 96.5008
R483 VSS.t114 VSS.n104 93.5889
R484 VSS.n844 VSS.t152 93.3421
R485 VSS.n59 VSS.t149 88.4945
R486 VSS.t229 VSS.n98 88.2366
R487 VSS.t47 VSS.n97 88.2366
R488 VSS.t27 VSS.n95 88.2366
R489 VSS.t222 VSS.n91 88.2366
R490 VSS.n21 VSS.t110 88.2366
R491 VSS.n24 VSS.t44 88.2366
R492 VSS.n30 VSS.t214 88.2366
R493 VSS.n38 VSS.t143 88.2366
R494 VSS.n41 VSS.t24 88.2366
R495 VSS.n44 VSS.t137 88.2366
R496 VSS.n52 VSS.t30 88.2366
R497 VSS.n54 VSS.t146 88.2366
R498 VSS.n84 VSS.t85 88.2359
R499 VSS.n70 VSS.t241 88.2359
R500 VSS.n61 VSS.t21 88.2359
R501 VSS.n16 VSS.t492 88.133
R502 VSS.t346 VSS.t6 86.957
R503 VSS.t8 VSS.t350 86.957
R504 VSS.t158 VSS.n0 69.4495
R505 VSS.t492 VSS.n7 82.7875
R506 VSS.n128 VSS.t494 82.1411
R507 VSS.t494 VSS.n105 75.0671
R508 VSS.t6 VSS.n88 74.8587
R509 VSS.t49 VSS.n127 74.6738
R510 VSS.n9 VSS.n4 2.67074
R511 VSS.n815 VSS.t235 70.2346
R512 VSS.n798 VSS.t131 70.2346
R513 VSS.n781 VSS.t528 70.2346
R514 VSS.n764 VSS.t128 70.2346
R515 VSS.n747 VSS.t82 70.2346
R516 VSS.n730 VSS.t140 70.2346
R517 VSS.n713 VSS.t534 70.2346
R518 VSS.n696 VSS.t1 70.2346
R519 VSS.n679 VSS.t88 70.2346
R520 VSS.n662 VSS.t125 70.2346
R521 VSS.n645 VSS.t540 70.2346
R522 VSS.n628 VSS.t543 70.2346
R523 VSS.n611 VSS.t537 70.2346
R524 VSS.n594 VSS.t4 70.2346
R525 VSS.n577 VSS.t211 70.2346
R526 VSS.n560 VSS.t134 70.2346
R527 VSS.n4 VSS.t263 117.531
R528 VSS.n4 VSS.t293 117.529
R529 VSS.t305 VSS.n4 58.3253
R530 VSS.n4 VSS.t338 117.525
R531 VSS.n846 VSS.t49 67.2065
R532 VSS.n814 VSS.t172 66.8901
R533 VSS.t116 VSS.n238 66.8901
R534 VSS.t169 VSS.n797 66.8901
R535 VSS.t154 VSS.n246 66.8901
R536 VSS.t248 VSS.n780 66.8901
R537 VSS.t547 VSS.n254 66.8901
R538 VSS.n763 VSS.t403 66.8901
R539 VSS.t72 VSS.n262 66.8901
R540 VSS.t364 VSS.n746 66.8901
R541 VSS.t546 VSS.n270 66.8901
R542 VSS.n729 VSS.t559 66.8901
R543 VSS.t118 VSS.n278 66.8901
R544 VSS.t203 VSS.n712 66.8901
R545 VSS.t226 VSS.n286 66.8901
R546 VSS.t415 VSS.n695 66.8901
R547 VSS.t545 VSS.n294 66.8901
R548 VSS.t56 VSS.n678 66.8901
R549 VSS.t227 VSS.n302 66.8901
R550 VSS.n661 VSS.t382 66.8901
R551 VSS.t156 VSS.n310 66.8901
R552 VSS.t162 VSS.n644 66.8901
R553 VSS.t549 VSS.n318 66.8901
R554 VSS.n627 VSS.t392 66.8901
R555 VSS.t548 VSS.n326 66.8901
R556 VSS.t198 VSS.n610 66.8901
R557 VSS.t220 VSS.n334 66.8901
R558 VSS.t523 VSS.n593 66.8901
R559 VSS.t179 VSS.n342 66.8901
R560 VSS.n576 VSS.t98 66.8901
R561 VSS.t120 VSS.n350 66.8901
R562 VSS.t61 VSS.n559 66.8901
R563 VSS.t219 VSS.n358 66.8901
R564 VSS.n845 VSS.t114 63.4728
R565 VSS.t152 VSS.n130 62.2523
R566 VSS.t35 VSS.n3 61.8407
R567 VSS.t216 VSS.n843 58.5186
R568 VSS.t102 VSS.n4 49.7663
R569 VSS.n4 VSS.t265 49.8619
R570 VSS.n4 VSS.t310 49.8619
R571 VSS.n4 VSS.t325 49.8619
R572 VSS.t340 VSS.n4 49.8619
R573 VSS.n16 VSS.t518 54.532
R574 VSS.t178 VSS.n1 50.3244
R575 VSS.t80 VSS.n15 44.8755
R576 VSS.t234 VSS.n236 50.1677
R577 VSS.n244 VSS.t130 50.1677
R578 VSS.t527 VSS.n252 50.1677
R579 VSS.t127 VSS.n260 50.1677
R580 VSS.t81 VSS.n268 50.1677
R581 VSS.t139 VSS.n276 50.1677
R582 VSS.t533 VSS.n284 50.1677
R583 VSS.t0 VSS.n292 50.1677
R584 VSS.t87 VSS.n300 50.1677
R585 VSS.t124 VSS.n308 50.1677
R586 VSS.t539 VSS.n316 50.1677
R587 VSS.t542 VSS.n324 50.1677
R588 VSS.t536 VSS.n332 50.1677
R589 VSS.t3 VSS.n340 50.1677
R590 VSS.t210 VSS.n348 50.1677
R591 VSS.t133 VSS.n356 50.1677
R592 VSS.n129 VSS.t225 47.3176
R593 VSS.n847 VSS.t224 39.8503
R594 VSS.t525 VSS.n822 36.7898
R595 VSS.t107 VSS.n806 36.7898
R596 VSS.n789 VSS.t502 36.7898
R597 VSS.n772 VSS.t411 36.7898
R598 VSS.t509 VSS.n755 36.7898
R599 VSS.n738 VSS.t514 36.7898
R600 VSS.t388 VSS.n721 36.7898
R601 VSS.n704 VSS.t394 36.7898
R602 VSS.n687 VSS.t498 36.7898
R603 VSS.n670 VSS.t187 36.7898
R604 VSS.t65 VSS.n653 36.7898
R605 VSS.n636 VSS.t419 36.7898
R606 VSS.t488 VSS.n619 36.7898
R607 VSS.n602 VSS.t398 36.7898
R608 VSS.t194 VSS.n585 36.7898
R609 VSS.n568 VSS.t183 36.7898
R610 VSS.t151 VSS.n847 36.1166
R611 VSS.t51 VSS.n105 33.9948
R612 VSS.t112 VSS.n129 28.6493
R613 VSS.t173 VSS.n85 28.2938
R614 VSS.t170 VSS.n83 28.2938
R615 VSS.t247 VSS.n81 28.2938
R616 VSS.t362 VSS.n27 28.2938
R617 VSS.t558 VSS.n76 28.2938
R618 VSS.t205 VSS.n33 28.2938
R619 VSS.t414 VSS.n36 28.2938
R620 VSS.t58 VSS.n74 28.2938
R621 VSS.t383 VSS.n43 28.2938
R622 VSS.t160 VSS.n71 28.2938
R623 VSS.t391 VSS.n69 28.2938
R624 VSS.t200 VSS.n67 28.2938
R625 VSS.t524 VSS.n64 28.2938
R626 VSS.t100 VSS.n63 28.2938
R627 VSS.t63 VSS.n57 28.2938
R628 VSS.t404 VSS.n79 28.2928
R629 VSS.n88 VSS.t521 28.0352
R630 VSS.t94 VSS.n2 154.007
R631 VSS.t103 VSS.n4 21.1052
R632 VSS.t350 VSS.n87 21.6039
R633 VSS.t105 VSS.n242 20.0674
R634 VSS.t504 VSS.n250 20.0674
R635 VSS.t409 VSS.n258 20.0674
R636 VSS.t511 VSS.n266 20.0674
R637 VSS.t512 VSS.n274 20.0674
R638 VSS.t390 VSS.n282 20.0674
R639 VSS.t396 VSS.n290 20.0674
R640 VSS.t500 VSS.n298 20.0674
R641 VSS.t189 VSS.n306 20.0674
R642 VSS.t67 VSS.n314 20.0674
R643 VSS.t418 VSS.n322 20.0674
R644 VSS.t487 VSS.n330 20.0674
R645 VSS.t397 VSS.n338 20.0674
R646 VSS.t196 VSS.n346 20.0674
R647 VSS.t185 VSS.n354 20.0674
R648 VSS.t562 VSS.n362 20.0674
R649 VSS.t421 VSS.n100 18.0025
R650 VSS.n96 VSS.t387 18.0025
R651 VSS.n94 VSS.t74 18.0025
R652 VSS.t551 VSS.n93 18.0025
R653 VSS.t381 VSS.n92 18.0025
R654 VSS.t182 VSS.n90 18.0025
R655 VSS.n18 VSS.t250 18.0025
R656 VSS.n19 VSS.t164 18.0025
R657 VSS.n20 VSS.t516 18.0025
R658 VSS.n23 VSS.t505 18.0025
R659 VSS.n26 VSS.t532 18.0025
R660 VSS.t380 VSS.n28 18.0025
R661 VSS.t517 VSS.n31 18.0025
R662 VSS.t497 VSS.n34 18.0025
R663 VSS.t402 VSS.n37 18.0025
R664 VSS.n40 VSS.t406 18.0025
R665 VSS.t550 VSS.n45 18.0025
R666 VSS.n47 VSS.t15 18.0025
R667 VSS.n49 VSS.t496 18.0025
R668 VSS.n51 VSS.t531 18.0025
R669 VSS.n53 VSS.t555 18.0025
R670 VSS.t554 VSS.n55 18.0025
R671 VSS.t366 VSS.n58 18.0025
R672 VSS.t55 VSS.n82 18.0017
R673 VSS.t530 VSS.n80 18.0017
R674 VSS.n78 VSS.t167 18.0017
R675 VSS.n75 VSS.t14 18.0017
R676 VSS.t553 VSS.n73 18.0017
R677 VSS.t384 VSS.n72 18.0017
R678 VSS.n68 VSS.t168 18.0017
R679 VSS.t75 VSS.n66 18.0017
R680 VSS.n62 VSS.t552 18.0017
R681 VSS.n843 VSS.t217 17.4483
R682 VSS.n861 VSS.t153 17.3368
R683 VSS.n857 VSS.t113 17.3368
R684 VSS.n853 VSS.t50 17.3368
R685 VSS.n433 VSS.t11 17.3368
R686 VSS.n437 VSS.t36 17.3368
R687 VSS.n441 VSS.t95 17.3368
R688 VSS.n445 VSS.t91 17.3368
R689 VSS.n840 VSS.t7 17.3368
R690 VSS.n495 VSS.t77 17.2607
R691 VSS.n424 VSS.t257 17.2313
R692 VSS.n453 VSS.t262 17.2313
R693 VSS.n457 VSS.t267 17.2313
R694 VSS.n416 VSS.t272 17.2313
R695 VSS.n468 VSS.t277 17.2313
R696 VSS.n472 VSS.t282 17.2313
R697 VSS.n408 VSS.t287 17.2313
R698 VSS.n483 VSS.t292 17.2313
R699 VSS.n487 VSS.t297 17.2313
R700 VSS.n400 VSS.t302 17.2313
R701 VSS.n506 VSS.t307 17.2313
R702 VSS.n510 VSS.t312 17.2313
R703 VSS.n392 VSS.t317 17.2313
R704 VSS.n521 VSS.t322 17.2313
R705 VSS.n525 VSS.t327 17.2313
R706 VSS.n384 VSS.t332 17.2313
R707 VSS.n536 VSS.t337 17.2313
R708 VSS.n540 VSS.t342 17.2313
R709 VSS.n848 VSS.n106 17.0005
R710 VSS.n106 VSS.n127 17.0005
R711 VSS.n106 VSS.n846 17.0005
R712 VSS.n106 VSS.n128 17.0005
R713 VSS.n106 VSS.n845 17.0005
R714 VSS.n106 VSS.n844 17.0005
R715 VSS.n106 VSS.n842 17.0005
R716 VSS.n106 VSS.n235 17.0005
R717 VSS.n106 VSS.n240 17.0005
R718 VSS.n106 VSS.n248 17.0005
R719 VSS.n106 VSS.n256 17.0005
R720 VSS.n106 VSS.n264 17.0005
R721 VSS.n106 VSS.n272 17.0005
R722 VSS.n106 VSS.n280 17.0005
R723 VSS.n106 VSS.n288 17.0005
R724 VSS.n106 VSS.n296 17.0005
R725 VSS.n106 VSS.n304 17.0005
R726 VSS.n106 VSS.n312 17.0005
R727 VSS.n106 VSS.n320 17.0005
R728 VSS.n106 VSS.n328 17.0005
R729 VSS.n106 VSS.n336 17.0005
R730 VSS.n106 VSS.n344 17.0005
R731 VSS.n106 VSS.n352 17.0005
R732 VSS.n106 VSS.n360 17.0005
R733 VSS.n106 VSS.n363 17.0005
R734 VSS.n106 VSS.n551 17.0005
R735 VSS.n106 VSS.n364 17.0005
R736 VSS.n106 VSS.n546 17.0005
R737 VSS.n106 VSS.n366 17.0005
R738 VSS.n106 VSS.n233 17.0005
R739 VSS.n106 VSS.n132 17.0005
R740 VSS.n4 VSS.n121 5.65652
R741 VSS.n4 VSS.n118 5.65652
R742 VSS.n4 VSS.n115 5.65652
R743 VSS.n4 VSS.n13 6.82737
R744 VSS.n4 VSS.n8 9.73657
R745 VSS.n4 VSS.n426 17.0005
R746 VSS.n4 VSS.n11 0.592458
R747 VSS.n4 VSS.n12 9.32125
R748 VSS.n4 VSS.n10 7.24297
R749 VSS.n4 VSS.n425 17.0005
R750 VSS.n428 VSS.n4 17.0005
R751 VSS.n427 VSS.t256 17.0005
R752 VSS.n423 VSS.t259 17.0005
R753 VSS.n451 VSS.t261 17.0005
R754 VSS.n420 VSS.t264 17.0005
R755 VSS.n419 VSS.t266 17.0005
R756 VSS.n418 VSS.t269 17.0005
R757 VSS.n417 VSS.t271 17.0005
R758 VSS.n415 VSS.t274 17.0005
R759 VSS.n466 VSS.t276 17.0005
R760 VSS.n412 VSS.t279 17.0005
R761 VSS.n411 VSS.t281 17.0005
R762 VSS.n410 VSS.t284 17.0005
R763 VSS.n409 VSS.t286 17.0005
R764 VSS.n407 VSS.t289 17.0005
R765 VSS.n481 VSS.t291 17.0005
R766 VSS.n404 VSS.t294 17.0005
R767 VSS.n403 VSS.t296 17.0005
R768 VSS.n402 VSS.t299 17.0005
R769 VSS.n401 VSS.t301 17.0005
R770 VSS.n399 VSS.t304 17.0005
R771 VSS.n504 VSS.t306 17.0005
R772 VSS.n396 VSS.t309 17.0005
R773 VSS.n395 VSS.t311 17.0005
R774 VSS.n394 VSS.t314 17.0005
R775 VSS.n393 VSS.t316 17.0005
R776 VSS.n391 VSS.t319 17.0005
R777 VSS.n519 VSS.t321 17.0005
R778 VSS.n388 VSS.t324 17.0005
R779 VSS.n387 VSS.t326 17.0005
R780 VSS.n386 VSS.t329 17.0005
R781 VSS.n385 VSS.t331 17.0005
R782 VSS.n383 VSS.t334 17.0005
R783 VSS.n534 VSS.t336 17.0005
R784 VSS.n380 VSS.t339 17.0005
R785 VSS.n379 VSS.t341 17.0005
R786 VSS.n376 VSS.t344 17.0005
R787 VSS.n11 VSS.t177 15.2265
R788 VSS.n107 VSS.n374 88.4718
R789 VSS.n423 VSS.t597 15.3099
R790 VSS.n420 VSS.t595 15.3099
R791 VSS.n418 VSS.t593 15.3099
R792 VSS.n415 VSS.t591 15.3099
R793 VSS.n412 VSS.t589 15.3099
R794 VSS.n410 VSS.t587 15.3099
R795 VSS.n407 VSS.t585 15.3099
R796 VSS.n404 VSS.t583 15.3099
R797 VSS.n402 VSS.t581 15.3099
R798 VSS.n399 VSS.t579 15.3099
R799 VSS.n396 VSS.t577 15.3099
R800 VSS.n394 VSS.t575 15.3099
R801 VSS.n391 VSS.t573 15.3099
R802 VSS.n388 VSS.t571 15.3099
R803 VSS.n386 VSS.t569 15.3099
R804 VSS.n383 VSS.t567 15.3099
R805 VSS.n380 VSS.t565 15.3099
R806 VSS.n376 VSS.t563 15.3099
R807 VSS.n427 VSS.t598 15.2696
R808 VSS.n451 VSS.t596 15.2696
R809 VSS.n419 VSS.t594 15.2696
R810 VSS.n417 VSS.t592 15.2696
R811 VSS.n466 VSS.t590 15.2696
R812 VSS.n411 VSS.t588 15.2696
R813 VSS.n409 VSS.t586 15.2696
R814 VSS.n481 VSS.t584 15.2696
R815 VSS.n403 VSS.t582 15.2696
R816 VSS.n401 VSS.t580 15.2696
R817 VSS.n504 VSS.t578 15.2696
R818 VSS.n395 VSS.t576 15.2696
R819 VSS.n393 VSS.t574 15.2696
R820 VSS.n519 VSS.t572 15.2696
R821 VSS.n387 VSS.t570 15.2696
R822 VSS.n385 VSS.t568 15.2696
R823 VSS.n534 VSS.t566 15.2696
R824 VSS.n379 VSS.t564 15.2696
R825 VSS.n547 VSS.t352 15.1276
R826 VSS.n369 VSS.t356 15.0005
R827 VSS.n828 VSS.t349 15.0005
R828 VSS.n837 VSS.t345 15.0005
R829 VSS.n130 VSS.t520 13.7147
R830 VSS.n168 VSS.t507 8.85039
R831 VSS.n170 VSS.t64 8.85039
R832 VSS.n172 VSS.t186 8.85039
R833 VSS.n174 VSS.t101 8.85039
R834 VSS.n176 VSS.t197 8.85039
R835 VSS.n178 VSS.t401 8.85039
R836 VSS.n180 VSS.t209 8.85039
R837 VSS.n182 VSS.t201 8.85039
R838 VSS.n184 VSS.t17 8.85039
R839 VSS.n186 VSS.t368 8.85039
R840 VSS.n188 VSS.t386 8.85039
R841 VSS.n190 VSS.t161 8.85039
R842 VSS.n192 VSS.t68 8.85039
R843 VSS.n194 VSS.t254 8.85039
R844 VSS.n196 VSS.t190 8.85039
R845 VSS.n198 VSS.t19 8.85039
R846 VSS.n200 VSS.t54 8.85039
R847 VSS.n202 VSS.t40 8.85039
R848 VSS.n204 VSS.t361 8.85039
R849 VSS.n206 VSS.t206 8.85039
R850 VSS.n208 VSS.t371 8.85039
R851 VSS.n210 VSS.t60 8.85039
R852 VSS.n212 VSS.t513 8.85039
R853 VSS.n214 VSS.t363 8.85039
R854 VSS.n216 VSS.t408 8.85039
R855 VSS.n218 VSS.t405 8.85039
R856 VSS.n220 VSS.t410 8.85039
R857 VSS.n222 VSS.t166 8.85039
R858 VSS.n224 VSS.t42 8.85039
R859 VSS.n226 VSS.t171 8.85039
R860 VSS.n228 VSS.t106 8.85039
R861 VSS.n230 VSS.t174 8.85039
R862 VSS.n863 VSS.t218 8.80385
R863 VSS.n859 VSS.t115 8.80385
R864 VSS.n855 VSS.t52 8.80385
R865 VSS.n832 VSS.t9 8.80385
R866 VSS.n435 VSS.t13 8.80285
R867 VSS.n439 VSS.t38 8.80285
R868 VSS.n443 VSS.t97 8.80285
R869 VSS.n447 VSS.t93 8.80285
R870 VSS.n553 VSS.t150 8.77423
R871 VSS.n359 VSS.t62 8.77423
R872 VSS.n561 VSS.t135 8.77423
R873 VSS.n566 VSS.t184 8.77423
R874 VSS.n570 VSS.t22 8.77423
R875 VSS.n351 VSS.t99 8.77423
R876 VSS.n578 VSS.t212 8.77423
R877 VSS.n583 VSS.t195 8.77423
R878 VSS.n587 VSS.t147 8.77423
R879 VSS.n343 VSS.t180 8.77423
R880 VSS.n595 VSS.t5 8.77423
R881 VSS.n600 VSS.t399 8.77423
R882 VSS.n604 VSS.t31 8.77423
R883 VSS.n335 VSS.t199 8.77423
R884 VSS.n612 VSS.t538 8.77423
R885 VSS.n617 VSS.t489 8.77423
R886 VSS.n621 VSS.t223 8.77423
R887 VSS.n327 VSS.t393 8.77423
R888 VSS.n629 VSS.t544 8.77423
R889 VSS.n634 VSS.t420 8.77423
R890 VSS.n638 VSS.t242 8.77423
R891 VSS.n319 VSS.t163 8.77423
R892 VSS.n646 VSS.t541 8.77423
R893 VSS.n651 VSS.t66 8.77423
R894 VSS.n655 VSS.t138 8.77423
R895 VSS.n311 VSS.t157 8.77423
R896 VSS.n663 VSS.t126 8.77423
R897 VSS.n668 VSS.t188 8.77423
R898 VSS.n672 VSS.t25 8.77423
R899 VSS.n303 VSS.t57 8.77423
R900 VSS.n680 VSS.t89 8.77423
R901 VSS.n685 VSS.t499 8.77423
R902 VSS.n689 VSS.t144 8.77423
R903 VSS.n295 VSS.t416 8.77423
R904 VSS.n697 VSS.t2 8.77423
R905 VSS.n702 VSS.t395 8.77423
R906 VSS.n706 VSS.t28 8.77423
R907 VSS.n287 VSS.t204 8.77423
R908 VSS.n714 VSS.t535 8.77423
R909 VSS.n719 VSS.t389 8.77423
R910 VSS.n723 VSS.t215 8.77423
R911 VSS.n279 VSS.t119 8.77423
R912 VSS.n731 VSS.t141 8.77423
R913 VSS.n736 VSS.t515 8.77423
R914 VSS.n740 VSS.t48 8.77423
R915 VSS.n271 VSS.t365 8.77423
R916 VSS.n748 VSS.t83 8.77423
R917 VSS.n753 VSS.t510 8.77423
R918 VSS.n757 VSS.t230 8.77423
R919 VSS.n263 VSS.t73 8.77423
R920 VSS.n765 VSS.t129 8.77423
R921 VSS.n770 VSS.t412 8.77423
R922 VSS.n774 VSS.t45 8.77423
R923 VSS.n255 VSS.t249 8.77423
R924 VSS.n782 VSS.t529 8.77423
R925 VSS.n787 VSS.t503 8.77423
R926 VSS.n791 VSS.t111 8.77423
R927 VSS.n247 VSS.t155 8.77423
R928 VSS.n799 VSS.t132 8.77423
R929 VSS.n804 VSS.t108 8.77423
R930 VSS.n808 VSS.t86 8.77423
R931 VSS.n239 VSS.t117 8.77423
R932 VSS.n816 VSS.t236 8.77423
R933 VSS.n823 VSS.t526 8.77423
R934 VSS.n6 VSS.t375 8.82841
R935 VSS.n461 VSS.t71 8.77323
R936 VSS.n476 VSS.t233 8.77323
R937 VSS.n491 VSS.t239 8.77323
R938 VSS.n493 VSS.t104 8.77323
R939 VSS.n499 VSS.t378 8.77323
R940 VSS.n514 VSS.t34 8.77323
R941 VSS.n529 VSS.t123 8.77323
R942 VSS.n373 VSS.t193 8.77323
R943 VSS.n5 VSS.t252 8.79211
R944 VSS.n497 VSS.t79 8.76678
R945 VSS.n851 VSS.t519 8.75731
R946 VSS.n849 VSS.t493 8.75731
R947 VSS.n429 VSS.t244 8.75631
R948 VSS.n431 VSS.t176 8.75631
R949 VSS.n107 VSS.n106 0.00101512
R950 VSS.n539 VSS.n125 0.0435295
R951 VSS.n124 VSS.n4 5.65652
R952 VSS.n123 VSS.n531 0.0633111
R953 VSS.n122 VSS.n4 4.22409
R954 VSS.n518 VSS.n121 0.0180497
R955 VSS.n120 VSS.n516 0.0633111
R956 VSS.n119 VSS.n4 4.22409
R957 VSS.n503 VSS.n118 0.0180497
R958 VSS.n117 VSS.n501 0.0633111
R959 VSS.n486 VSS.n116 0.0435295
R960 VSS.n480 VSS.n115 0.0180497
R961 VSS.n114 VSS.n478 0.0633111
R962 VSS.n113 VSS.n4 4.22409
R963 VSS.n112 VSS.n4 5.65652
R964 VSS.n111 VSS.n463 0.0633111
R965 VSS.n456 VSS.n110 0.0435295
R966 VSS.n109 VSS.n4 5.65652
R967 VSS.n108 VSS.n448 0.0633111
R968 VSS.n106 VSS.n835 8.5005
R969 VSS.n106 VSS.n822 8.5005
R970 VSS.n106 VSS.n236 8.5005
R971 VSS.n106 VSS.n815 8.5005
R972 VSS.n106 VSS.n814 8.5005
R973 VSS.n106 VSS.n238 8.5005
R974 VSS.n106 VSS.n813 8.5005
R975 VSS.n106 VSS.n241 8.5005
R976 VSS.n106 VSS.n807 8.5005
R977 VSS.n106 VSS.n242 8.5005
R978 VSS.n106 VSS.n806 8.5005
R979 VSS.n106 VSS.n244 8.5005
R980 VSS.n106 VSS.n798 8.5005
R981 VSS.n106 VSS.n797 8.5005
R982 VSS.n106 VSS.n246 8.5005
R983 VSS.n106 VSS.n796 8.5005
R984 VSS.n106 VSS.n249 8.5005
R985 VSS.n106 VSS.n790 8.5005
R986 VSS.n106 VSS.n250 8.5005
R987 VSS.n106 VSS.n789 8.5005
R988 VSS.n106 VSS.n252 8.5005
R989 VSS.n106 VSS.n781 8.5005
R990 VSS.n106 VSS.n780 8.5005
R991 VSS.n106 VSS.n254 8.5005
R992 VSS.n106 VSS.n779 8.5005
R993 VSS.n106 VSS.n257 8.5005
R994 VSS.n106 VSS.n773 8.5005
R995 VSS.n106 VSS.n258 8.5005
R996 VSS.n106 VSS.n772 8.5005
R997 VSS.n106 VSS.n260 8.5005
R998 VSS.n106 VSS.n764 8.5005
R999 VSS.n106 VSS.n763 8.5005
R1000 VSS.n106 VSS.n262 8.5005
R1001 VSS.n106 VSS.n762 8.5005
R1002 VSS.n106 VSS.n265 8.5005
R1003 VSS.n106 VSS.n756 8.5005
R1004 VSS.n106 VSS.n266 8.5005
R1005 VSS.n106 VSS.n755 8.5005
R1006 VSS.n106 VSS.n268 8.5005
R1007 VSS.n106 VSS.n747 8.5005
R1008 VSS.n106 VSS.n746 8.5005
R1009 VSS.n106 VSS.n270 8.5005
R1010 VSS.n106 VSS.n745 8.5005
R1011 VSS.n106 VSS.n273 8.5005
R1012 VSS.n106 VSS.n739 8.5005
R1013 VSS.n106 VSS.n274 8.5005
R1014 VSS.n106 VSS.n738 8.5005
R1015 VSS.n106 VSS.n276 8.5005
R1016 VSS.n106 VSS.n730 8.5005
R1017 VSS.n106 VSS.n729 8.5005
R1018 VSS.n106 VSS.n278 8.5005
R1019 VSS.n106 VSS.n728 8.5005
R1020 VSS.n106 VSS.n281 8.5005
R1021 VSS.n106 VSS.n722 8.5005
R1022 VSS.n106 VSS.n282 8.5005
R1023 VSS.n106 VSS.n721 8.5005
R1024 VSS.n106 VSS.n284 8.5005
R1025 VSS.n106 VSS.n713 8.5005
R1026 VSS.n106 VSS.n712 8.5005
R1027 VSS.n106 VSS.n286 8.5005
R1028 VSS.n106 VSS.n711 8.5005
R1029 VSS.n106 VSS.n289 8.5005
R1030 VSS.n106 VSS.n705 8.5005
R1031 VSS.n106 VSS.n290 8.5005
R1032 VSS.n106 VSS.n704 8.5005
R1033 VSS.n106 VSS.n292 8.5005
R1034 VSS.n106 VSS.n696 8.5005
R1035 VSS.n106 VSS.n695 8.5005
R1036 VSS.n106 VSS.n294 8.5005
R1037 VSS.n106 VSS.n694 8.5005
R1038 VSS.n106 VSS.n297 8.5005
R1039 VSS.n106 VSS.n688 8.5005
R1040 VSS.n106 VSS.n298 8.5005
R1041 VSS.n106 VSS.n687 8.5005
R1042 VSS.n106 VSS.n300 8.5005
R1043 VSS.n106 VSS.n679 8.5005
R1044 VSS.n106 VSS.n678 8.5005
R1045 VSS.n106 VSS.n302 8.5005
R1046 VSS.n106 VSS.n677 8.5005
R1047 VSS.n106 VSS.n305 8.5005
R1048 VSS.n106 VSS.n671 8.5005
R1049 VSS.n106 VSS.n306 8.5005
R1050 VSS.n106 VSS.n670 8.5005
R1051 VSS.n106 VSS.n308 8.5005
R1052 VSS.n106 VSS.n662 8.5005
R1053 VSS.n106 VSS.n661 8.5005
R1054 VSS.n106 VSS.n310 8.5005
R1055 VSS.n106 VSS.n660 8.5005
R1056 VSS.n106 VSS.n313 8.5005
R1057 VSS.n106 VSS.n654 8.5005
R1058 VSS.n106 VSS.n314 8.5005
R1059 VSS.n106 VSS.n653 8.5005
R1060 VSS.n106 VSS.n316 8.5005
R1061 VSS.n106 VSS.n645 8.5005
R1062 VSS.n106 VSS.n644 8.5005
R1063 VSS.n106 VSS.n318 8.5005
R1064 VSS.n106 VSS.n643 8.5005
R1065 VSS.n106 VSS.n321 8.5005
R1066 VSS.n106 VSS.n637 8.5005
R1067 VSS.n106 VSS.n322 8.5005
R1068 VSS.n106 VSS.n636 8.5005
R1069 VSS.n106 VSS.n324 8.5005
R1070 VSS.n106 VSS.n628 8.5005
R1071 VSS.n106 VSS.n627 8.5005
R1072 VSS.n106 VSS.n326 8.5005
R1073 VSS.n106 VSS.n626 8.5005
R1074 VSS.n106 VSS.n329 8.5005
R1075 VSS.n106 VSS.n620 8.5005
R1076 VSS.n106 VSS.n330 8.5005
R1077 VSS.n106 VSS.n619 8.5005
R1078 VSS.n106 VSS.n332 8.5005
R1079 VSS.n106 VSS.n611 8.5005
R1080 VSS.n106 VSS.n610 8.5005
R1081 VSS.n106 VSS.n334 8.5005
R1082 VSS.n106 VSS.n609 8.5005
R1083 VSS.n106 VSS.n337 8.5005
R1084 VSS.n106 VSS.n603 8.5005
R1085 VSS.n106 VSS.n338 8.5005
R1086 VSS.n106 VSS.n602 8.5005
R1087 VSS.n106 VSS.n340 8.5005
R1088 VSS.n106 VSS.n594 8.5005
R1089 VSS.n106 VSS.n593 8.5005
R1090 VSS.n106 VSS.n342 8.5005
R1091 VSS.n106 VSS.n592 8.5005
R1092 VSS.n106 VSS.n345 8.5005
R1093 VSS.n106 VSS.n586 8.5005
R1094 VSS.n106 VSS.n346 8.5005
R1095 VSS.n106 VSS.n585 8.5005
R1096 VSS.n106 VSS.n348 8.5005
R1097 VSS.n106 VSS.n577 8.5005
R1098 VSS.n106 VSS.n576 8.5005
R1099 VSS.n106 VSS.n350 8.5005
R1100 VSS.n106 VSS.n575 8.5005
R1101 VSS.n106 VSS.n353 8.5005
R1102 VSS.n106 VSS.n569 8.5005
R1103 VSS.n106 VSS.n354 8.5005
R1104 VSS.n106 VSS.n568 8.5005
R1105 VSS.n106 VSS.n356 8.5005
R1106 VSS.n106 VSS.n560 8.5005
R1107 VSS.n106 VSS.n559 8.5005
R1108 VSS.n106 VSS.n358 8.5005
R1109 VSS.n106 VSS.n558 8.5005
R1110 VSS.n106 VSS.n361 8.5005
R1111 VSS.n106 VSS.n552 8.5005
R1112 VSS.n106 VSS.n362 8.5005
R1113 VSS.n106 VSS.n365 8.5005
R1114 VSS.n538 VSS.n4 8.49319
R1115 VSS.n523 VSS.n4 8.49319
R1116 VSS.n508 VSS.n4 8.49319
R1117 VSS.n485 VSS.n4 8.49319
R1118 VSS.n470 VSS.n4 8.49319
R1119 VSS.n455 VSS.n4 8.49319
R1120 VSS.n862 VSS.n106 8.47732
R1121 VSS.n106 VSS.n234 8.47732
R1122 VSS.n106 VSS.n821 8.47732
R1123 VSS.n106 VSS.n805 8.47732
R1124 VSS.n106 VSS.n788 8.47732
R1125 VSS.n106 VSS.n771 8.47732
R1126 VSS.n106 VSS.n754 8.47732
R1127 VSS.n106 VSS.n737 8.47732
R1128 VSS.n106 VSS.n720 8.47732
R1129 VSS.n106 VSS.n703 8.47732
R1130 VSS.n106 VSS.n686 8.47732
R1131 VSS.n106 VSS.n669 8.47732
R1132 VSS.n106 VSS.n652 8.47732
R1133 VSS.n106 VSS.n635 8.47732
R1134 VSS.n106 VSS.n618 8.47732
R1135 VSS.n106 VSS.n601 8.47732
R1136 VSS.n106 VSS.n584 8.47732
R1137 VSS.n106 VSS.n567 8.47732
R1138 VSS.n106 VSS.n131 8.47732
R1139 VSS.n106 VSS.n167 8.47732
R1140 VSS.n106 VSS.n166 8.47732
R1141 VSS.n4 VSS.n125 4.22409
R1142 VSS.n532 VSS.n4 8.47732
R1143 VSS.n4 VSS.n123 4.21421
R1144 VSS.n525 VSS.n122 0.176279
R1145 VSS.n517 VSS.n4 8.47732
R1146 VSS.n4 VSS.n120 4.21421
R1147 VSS.n510 VSS.n119 0.176279
R1148 VSS.n502 VSS.n4 8.47732
R1149 VSS.n4 VSS.n117 4.21421
R1150 VSS.n116 VSS.n4 4.22409
R1151 VSS.n479 VSS.n4 8.47732
R1152 VSS.n4 VSS.n114 4.21421
R1153 VSS.n472 VSS.n113 0.176279
R1154 VSS.n464 VSS.n4 8.47732
R1155 VSS.n4 VSS.n111 4.21421
R1156 VSS.n110 VSS.n4 4.22409
R1157 VSS.n449 VSS.n4 8.47732
R1158 VSS.n4 VSS.n108 4.21421
R1159 VSS.n442 VSS.n4 8.47732
R1160 VSS.n368 VSS.t358 8.46888
R1161 VSS.n544 VSS.t354 8.46888
R1162 VSS.n549 VSS.t355 8.46631
R1163 VSS.n555 VSS.t473 8.46631
R1164 VSS.n564 VSS.t485 8.46631
R1165 VSS.n572 VSS.t477 8.46631
R1166 VSS.n581 VSS.t481 8.46631
R1167 VSS.n589 VSS.t483 8.46631
R1168 VSS.n598 VSS.t425 8.46631
R1169 VSS.n606 VSS.t479 8.46631
R1170 VSS.n615 VSS.t475 8.46631
R1171 VSS.n623 VSS.t431 8.46631
R1172 VSS.n632 VSS.t453 8.46631
R1173 VSS.n640 VSS.t471 8.46631
R1174 VSS.n649 VSS.t457 8.46631
R1175 VSS.n657 VSS.t469 8.46631
R1176 VSS.n666 VSS.t451 8.46631
R1177 VSS.n674 VSS.t467 8.46631
R1178 VSS.n683 VSS.t465 8.46631
R1179 VSS.n691 VSS.t463 8.46631
R1180 VSS.n700 VSS.t455 8.46631
R1181 VSS.n708 VSS.t461 8.46631
R1182 VSS.n717 VSS.t459 8.46631
R1183 VSS.n725 VSS.t423 8.46631
R1184 VSS.n734 VSS.t449 8.46631
R1185 VSS.n742 VSS.t447 8.46631
R1186 VSS.n751 VSS.t437 8.46631
R1187 VSS.n759 VSS.t445 8.46631
R1188 VSS.n768 VSS.t433 8.46631
R1189 VSS.n776 VSS.t439 8.46631
R1190 VSS.n785 VSS.t443 8.46631
R1191 VSS.n793 VSS.t427 8.46631
R1192 VSS.n802 VSS.t441 8.46631
R1193 VSS.n810 VSS.t435 8.46631
R1194 VSS.n819 VSS.t429 8.46631
R1195 VSS.n830 VSS.t351 8.46519
R1196 VSS.n825 VSS.t347 8.46519
R1197 VSS.n838 VSS.t348 8.46519
R1198 VSS.n865 VSS.n126 6.99673
R1199 VSS.n106 VSS.n372 5.63777
R1200 VSS.n854 VSS.n106 5.62581
R1201 VSS.n858 VSS.n106 5.62581
R1202 VSS.n864 VSS.n106 5.62581
R1203 VSS.n106 VSS.n817 5.62581
R1204 VSS.n106 VSS.n243 5.62581
R1205 VSS.n106 VSS.n800 5.62581
R1206 VSS.n106 VSS.n251 5.62581
R1207 VSS.n106 VSS.n783 5.62581
R1208 VSS.n106 VSS.n259 5.62581
R1209 VSS.n106 VSS.n766 5.62581
R1210 VSS.n106 VSS.n267 5.62581
R1211 VSS.n106 VSS.n749 5.62581
R1212 VSS.n106 VSS.n275 5.62581
R1213 VSS.n106 VSS.n732 5.62581
R1214 VSS.n106 VSS.n283 5.62581
R1215 VSS.n106 VSS.n715 5.62581
R1216 VSS.n106 VSS.n291 5.62581
R1217 VSS.n106 VSS.n698 5.62581
R1218 VSS.n106 VSS.n299 5.62581
R1219 VSS.n106 VSS.n681 5.62581
R1220 VSS.n106 VSS.n307 5.62581
R1221 VSS.n106 VSS.n664 5.62581
R1222 VSS.n106 VSS.n315 5.62581
R1223 VSS.n106 VSS.n647 5.62581
R1224 VSS.n106 VSS.n323 5.62581
R1225 VSS.n106 VSS.n630 5.62581
R1226 VSS.n106 VSS.n331 5.62581
R1227 VSS.n106 VSS.n613 5.62581
R1228 VSS.n106 VSS.n339 5.62581
R1229 VSS.n106 VSS.n596 5.62581
R1230 VSS.n106 VSS.n347 5.62581
R1231 VSS.n106 VSS.n579 5.62581
R1232 VSS.n106 VSS.n355 5.62581
R1233 VSS.n106 VSS.n562 5.62581
R1234 VSS.n106 VSS.n231 5.62581
R1235 VSS.n106 VSS.n229 5.62581
R1236 VSS.n106 VSS.n227 5.62581
R1237 VSS.n106 VSS.n225 5.62581
R1238 VSS.n106 VSS.n223 5.62581
R1239 VSS.n106 VSS.n221 5.62581
R1240 VSS.n106 VSS.n219 5.62581
R1241 VSS.n106 VSS.n217 5.62581
R1242 VSS.n106 VSS.n215 5.62581
R1243 VSS.n106 VSS.n213 5.62581
R1244 VSS.n106 VSS.n211 5.62581
R1245 VSS.n106 VSS.n209 5.62581
R1246 VSS.n106 VSS.n207 5.62581
R1247 VSS.n106 VSS.n205 5.62581
R1248 VSS.n106 VSS.n203 5.62581
R1249 VSS.n106 VSS.n201 5.62581
R1250 VSS.n106 VSS.n199 5.62581
R1251 VSS.n106 VSS.n197 5.62581
R1252 VSS.n106 VSS.n195 5.62581
R1253 VSS.n106 VSS.n193 5.62581
R1254 VSS.n106 VSS.n191 5.62581
R1255 VSS.n106 VSS.n189 5.62581
R1256 VSS.n106 VSS.n187 5.62581
R1257 VSS.n106 VSS.n185 5.62581
R1258 VSS.n106 VSS.n183 5.62581
R1259 VSS.n106 VSS.n181 5.62581
R1260 VSS.n106 VSS.n179 5.62581
R1261 VSS.n106 VSS.n177 5.62581
R1262 VSS.n106 VSS.n175 5.62581
R1263 VSS.n106 VSS.n173 5.62581
R1264 VSS.n106 VSS.n171 5.62581
R1265 VSS.n106 VSS.n169 5.62581
R1266 VSS.n106 VSS.n164 5.62581
R1267 VSS.n4 VSS.n378 5.62581
R1268 VSS.n4 VSS.n382 5.62581
R1269 VSS.n526 VSS.n4 5.62581
R1270 VSS.n4 VSS.n390 5.62581
R1271 VSS.n511 VSS.n4 5.62581
R1272 VSS.n4 VSS.n398 5.62581
R1273 VSS.n496 VSS.n4 5.62581
R1274 VSS.n488 VSS.n4 5.62581
R1275 VSS.n4 VSS.n406 5.62581
R1276 VSS.n473 VSS.n4 5.62581
R1277 VSS.n4 VSS.n414 5.62581
R1278 VSS.n458 VSS.n4 5.62581
R1279 VSS.n4 VSS.n422 5.62581
R1280 VSS.n5 VSS.n4 0.761893
R1281 VSS.n446 VSS.n4 5.62581
R1282 VSS.n438 VSS.n4 5.62581
R1283 VSS.n434 VSS.n4 5.62581
R1284 VSS.n428 VSS.n126 4.28471
R1285 VSS.n4 VSS.n537 4.21914
R1286 VSS.n4 VSS.n522 4.21914
R1287 VSS.n4 VSS.n507 4.21914
R1288 VSS.n4 VSS.n484 4.21914
R1289 VSS.n4 VSS.n469 4.21914
R1290 VSS.n4 VSS.n454 4.21914
R1291 VSS.n106 VSS.n165 4.20662
R1292 VSS.n850 VSS.n106 4.19244
R1293 VSS.n106 VSS.n834 4.19244
R1294 VSS.n430 VSS.n4 4.19244
R1295 VSS VSS.n126 3.80469
R1296 VSS.n822 VSS.t428 3.34498
R1297 VSS.n814 VSS.t434 3.34498
R1298 VSS.n806 VSS.t440 3.34498
R1299 VSS.n797 VSS.t426 3.34498
R1300 VSS.n789 VSS.t442 3.34498
R1301 VSS.n780 VSS.t438 3.34498
R1302 VSS.n772 VSS.t432 3.34498
R1303 VSS.n763 VSS.t444 3.34498
R1304 VSS.n755 VSS.t436 3.34498
R1305 VSS.n746 VSS.t446 3.34498
R1306 VSS.n738 VSS.t448 3.34498
R1307 VSS.n729 VSS.t422 3.34498
R1308 VSS.n721 VSS.t458 3.34498
R1309 VSS.n712 VSS.t460 3.34498
R1310 VSS.n704 VSS.t454 3.34498
R1311 VSS.n695 VSS.t462 3.34498
R1312 VSS.n687 VSS.t464 3.34498
R1313 VSS.n678 VSS.t466 3.34498
R1314 VSS.n670 VSS.t450 3.34498
R1315 VSS.n661 VSS.t468 3.34498
R1316 VSS.n653 VSS.t456 3.34498
R1317 VSS.n644 VSS.t470 3.34498
R1318 VSS.n636 VSS.t452 3.34498
R1319 VSS.n627 VSS.t430 3.34498
R1320 VSS.n619 VSS.t474 3.34498
R1321 VSS.n610 VSS.t478 3.34498
R1322 VSS.n602 VSS.t424 3.34498
R1323 VSS.n593 VSS.t482 3.34498
R1324 VSS.n585 VSS.t480 3.34498
R1325 VSS.n576 VSS.t476 3.34498
R1326 VSS.n568 VSS.t484 3.34498
R1327 VSS.n559 VSS.t472 3.34498
R1328 VSS.n856 VSS.n106 3.3265
R1329 VSS.n860 VSS.n106 3.3265
R1330 VSS.n106 VSS.n812 3.3265
R1331 VSS.n106 VSS.n795 3.3265
R1332 VSS.n106 VSS.n778 3.3265
R1333 VSS.n106 VSS.n761 3.3265
R1334 VSS.n106 VSS.n744 3.3265
R1335 VSS.n106 VSS.n727 3.3265
R1336 VSS.n106 VSS.n710 3.3265
R1337 VSS.n106 VSS.n693 3.3265
R1338 VSS.n106 VSS.n676 3.3265
R1339 VSS.n106 VSS.n659 3.3265
R1340 VSS.n106 VSS.n642 3.3265
R1341 VSS.n106 VSS.n625 3.3265
R1342 VSS.n106 VSS.n608 3.3265
R1343 VSS.n106 VSS.n591 3.3265
R1344 VSS.n106 VSS.n574 3.3265
R1345 VSS.n106 VSS.n557 3.3265
R1346 VSS.n530 VSS.n4 3.3265
R1347 VSS.n515 VSS.n4 3.3265
R1348 VSS.n500 VSS.n4 3.3265
R1349 VSS.n477 VSS.n4 3.3265
R1350 VSS.n462 VSS.n4 3.3265
R1351 VSS.n6 VSS.n4 0.665344
R1352 VSS.n444 VSS.n4 3.3265
R1353 VSS.n440 VSS.n4 3.3265
R1354 VSS.n436 VSS.n4 3.3265
R1355 VSS.n841 VSS 3.16675
R1356 VSS.n542 VSS.n541 3.01826
R1357 VSS.n106 VSS.n101 2.83376
R1358 VSS.n852 VSS.n106 2.74446
R1359 VSS.n106 VSS.n237 2.74446
R1360 VSS.n106 VSS.n245 2.74446
R1361 VSS.n106 VSS.n253 2.74446
R1362 VSS.n106 VSS.n261 2.74446
R1363 VSS.n106 VSS.n269 2.74446
R1364 VSS.n106 VSS.n277 2.74446
R1365 VSS.n106 VSS.n285 2.74446
R1366 VSS.n106 VSS.n293 2.74446
R1367 VSS.n106 VSS.n301 2.74446
R1368 VSS.n106 VSS.n309 2.74446
R1369 VSS.n106 VSS.n317 2.74446
R1370 VSS.n106 VSS.n325 2.74446
R1371 VSS.n106 VSS.n333 2.74446
R1372 VSS.n106 VSS.n341 2.74446
R1373 VSS.n106 VSS.n349 2.74446
R1374 VSS.n106 VSS.n357 2.74446
R1375 VSS.n106 VSS.n232 2.74446
R1376 VSS.n432 VSS.n4 2.74446
R1377 VSS.n106 VSS.n133 2.32483
R1378 VSS.n106 VSS.n134 2.32483
R1379 VSS.n106 VSS.n135 2.32483
R1380 VSS.n106 VSS.n136 2.32483
R1381 VSS.n106 VSS.n137 2.32483
R1382 VSS.n106 VSS.n138 2.32483
R1383 VSS.n106 VSS.n139 2.32483
R1384 VSS.n106 VSS.n140 2.32483
R1385 VSS.n106 VSS.n141 2.32483
R1386 VSS.n106 VSS.n142 2.32483
R1387 VSS.n106 VSS.n143 2.32483
R1388 VSS.n106 VSS.n144 2.32483
R1389 VSS.n106 VSS.n145 2.32483
R1390 VSS.n106 VSS.n146 2.32483
R1391 VSS.n106 VSS.n147 2.32483
R1392 VSS.n106 VSS.n148 2.32483
R1393 VSS.n106 VSS.n149 2.32483
R1394 VSS.n106 VSS.n150 2.32483
R1395 VSS.n106 VSS.n151 2.32483
R1396 VSS.n106 VSS.n152 2.32483
R1397 VSS.n106 VSS.n153 2.32483
R1398 VSS.n106 VSS.n154 2.32483
R1399 VSS.n106 VSS.n155 2.32483
R1400 VSS.n106 VSS.n156 2.32483
R1401 VSS.n106 VSS.n157 2.32483
R1402 VSS.n106 VSS.n158 2.32483
R1403 VSS.n106 VSS.n159 2.32483
R1404 VSS.n106 VSS.n160 2.32483
R1405 VSS.n106 VSS.n161 2.32483
R1406 VSS.n106 VSS.n162 2.32483
R1407 VSS.n106 VSS.n163 2.32483
R1408 VSS.n494 VSS.n4 2.00687
R1409 VSS.n106 VSS.n7 1.64417
R1410 VSS.n106 VSS.n847 1.64417
R1411 VSS.n106 VSS.n129 1.64417
R1412 VSS.n106 VSS.n130 1.64417
R1413 VSS.n106 VSS.n843 1.64417
R1414 VSS.n4 VSS.n375 1.56144
R1415 VSS.n528 VSS.n4 1.56144
R1416 VSS.n513 VSS.n4 1.56144
R1417 VSS.n490 VSS.n4 1.56144
R1418 VSS.n475 VSS.n4 1.56144
R1419 VSS.n460 VSS.n4 1.56144
R1420 VSS.n498 VSS.n4 1.12565
R1421 VSS.n541 VSS.n4 0.92982
R1422 VSS.n492 VSS.n4 0.849178
R1423 VSS.n492 VSS.n491 0.728316
R1424 VSS.n493 VSS.n492 0.69965
R1425 VSS.n541 VSS.n373 0.69304
R1426 VSS.n4 VSS.n1 0.613782
R1427 VSS.n4 VSS.n2 0.577899
R1428 VSS.n4 VSS.n3 0.613782
R1429 VSS.n4 VSS.n7 4666.38
R1430 VSS.n498 VSS.n497 0.603496
R1431 VSS.n106 VSS.n102 0.556705
R1432 VSS.n499 VSS.n498 0.540438
R1433 VSS VSS.n865 0.48296
R1434 VSS.n550 VSS.n549 0.419816
R1435 VSS.n556 VSS.n555 0.419816
R1436 VSS.n565 VSS.n564 0.419816
R1437 VSS.n573 VSS.n572 0.419816
R1438 VSS.n582 VSS.n581 0.419816
R1439 VSS.n590 VSS.n589 0.419816
R1440 VSS.n599 VSS.n598 0.419816
R1441 VSS.n607 VSS.n606 0.419816
R1442 VSS.n616 VSS.n615 0.419816
R1443 VSS.n624 VSS.n623 0.419816
R1444 VSS.n633 VSS.n632 0.419816
R1445 VSS.n641 VSS.n640 0.419816
R1446 VSS.n650 VSS.n649 0.419816
R1447 VSS.n658 VSS.n657 0.419816
R1448 VSS.n667 VSS.n666 0.419816
R1449 VSS.n675 VSS.n674 0.419816
R1450 VSS.n684 VSS.n683 0.419816
R1451 VSS.n692 VSS.n691 0.419816
R1452 VSS.n701 VSS.n700 0.419816
R1453 VSS.n709 VSS.n708 0.419816
R1454 VSS.n718 VSS.n717 0.419816
R1455 VSS.n726 VSS.n725 0.419816
R1456 VSS.n735 VSS.n734 0.419816
R1457 VSS.n743 VSS.n742 0.419816
R1458 VSS.n752 VSS.n751 0.419816
R1459 VSS.n760 VSS.n759 0.419816
R1460 VSS.n769 VSS.n768 0.419816
R1461 VSS.n777 VSS.n776 0.419816
R1462 VSS.n786 VSS.n785 0.419816
R1463 VSS.n794 VSS.n793 0.419816
R1464 VSS.n803 VSS.n802 0.419816
R1465 VSS.n811 VSS.n810 0.419816
R1466 VSS.n820 VSS.n819 0.419816
R1467 VSS.n461 VSS.n460 0.413418
R1468 VSS.n476 VSS.n475 0.413418
R1469 VSS.n491 VSS.n490 0.413418
R1470 VSS.n514 VSS.n513 0.413418
R1471 VSS.n529 VSS.n528 0.413418
R1472 VSS.n375 VSS.n373 0.413418
R1473 VSS.n830 VSS.n829 0.385697
R1474 VSS.n825 VSS.n824 0.385697
R1475 VSS.n549 VSS.n548 0.383459
R1476 VSS.n555 VSS.n554 0.383459
R1477 VSS.n564 VSS.n563 0.383459
R1478 VSS.n572 VSS.n571 0.383459
R1479 VSS.n581 VSS.n580 0.383459
R1480 VSS.n589 VSS.n588 0.383459
R1481 VSS.n598 VSS.n597 0.383459
R1482 VSS.n606 VSS.n605 0.383459
R1483 VSS.n615 VSS.n614 0.383459
R1484 VSS.n623 VSS.n622 0.383459
R1485 VSS.n632 VSS.n631 0.383459
R1486 VSS.n640 VSS.n639 0.383459
R1487 VSS.n649 VSS.n648 0.383459
R1488 VSS.n657 VSS.n656 0.383459
R1489 VSS.n666 VSS.n665 0.383459
R1490 VSS.n674 VSS.n673 0.383459
R1491 VSS.n683 VSS.n682 0.383459
R1492 VSS.n691 VSS.n690 0.383459
R1493 VSS.n700 VSS.n699 0.383459
R1494 VSS.n708 VSS.n707 0.383459
R1495 VSS.n717 VSS.n716 0.383459
R1496 VSS.n725 VSS.n724 0.383459
R1497 VSS.n734 VSS.n733 0.383459
R1498 VSS.n742 VSS.n741 0.383459
R1499 VSS.n751 VSS.n750 0.383459
R1500 VSS.n759 VSS.n758 0.383459
R1501 VSS.n768 VSS.n767 0.383459
R1502 VSS.n776 VSS.n775 0.383459
R1503 VSS.n785 VSS.n784 0.383459
R1504 VSS.n793 VSS.n792 0.383459
R1505 VSS.n802 VSS.n801 0.383459
R1506 VSS.n810 VSS.n809 0.383459
R1507 VSS.n819 VSS.n818 0.383459
R1508 VSS.n495 VSS.n494 0.380519
R1509 VSS.n839 VSS.n838 0.379351
R1510 VSS.n545 VSS.n544 0.37817
R1511 VSS.n494 VSS.n493 0.359515
R1512 VSS.n230 VSS.n133 0.351341
R1513 VSS.n228 VSS.n134 0.351341
R1514 VSS.n226 VSS.n135 0.351341
R1515 VSS.n224 VSS.n136 0.351341
R1516 VSS.n222 VSS.n137 0.351341
R1517 VSS.n220 VSS.n138 0.351341
R1518 VSS.n218 VSS.n139 0.351341
R1519 VSS.n216 VSS.n140 0.351341
R1520 VSS.n214 VSS.n141 0.351341
R1521 VSS.n212 VSS.n142 0.351341
R1522 VSS.n210 VSS.n143 0.351341
R1523 VSS.n208 VSS.n144 0.351341
R1524 VSS.n206 VSS.n145 0.351341
R1525 VSS.n204 VSS.n146 0.351341
R1526 VSS.n202 VSS.n147 0.351341
R1527 VSS.n200 VSS.n148 0.351341
R1528 VSS.n198 VSS.n149 0.351341
R1529 VSS.n196 VSS.n150 0.351341
R1530 VSS.n194 VSS.n151 0.351341
R1531 VSS.n192 VSS.n152 0.351341
R1532 VSS.n190 VSS.n153 0.351341
R1533 VSS.n188 VSS.n154 0.351341
R1534 VSS.n186 VSS.n155 0.351341
R1535 VSS.n184 VSS.n156 0.351341
R1536 VSS.n182 VSS.n157 0.351341
R1537 VSS.n180 VSS.n158 0.351341
R1538 VSS.n178 VSS.n159 0.351341
R1539 VSS.n176 VSS.n160 0.351341
R1540 VSS.n174 VSS.n161 0.351341
R1541 VSS.n172 VSS.n162 0.351341
R1542 VSS.n170 VSS.n163 0.351341
R1543 VSS.n368 VSS.n367 0.345929
R1544 VSS.n544 VSS.n543 0.345929
R1545 VSS.n377 VSS.n375 0.340858
R1546 VSS.n528 VSS.n527 0.340858
R1547 VSS.n513 VSS.n512 0.340858
R1548 VSS.n490 VSS.n489 0.340858
R1549 VSS.n475 VSS.n474 0.340858
R1550 VSS.n460 VSS.n459 0.340858
R1551 VSS.n853 VSS.n852 0.318018
R1552 VSS.n433 VSS.n432 0.316299
R1553 VSS.n809 VSS.n133 0.311066
R1554 VSS.n801 VSS.n134 0.311066
R1555 VSS.n792 VSS.n135 0.311066
R1556 VSS.n784 VSS.n136 0.311066
R1557 VSS.n775 VSS.n137 0.311066
R1558 VSS.n767 VSS.n138 0.311066
R1559 VSS.n758 VSS.n139 0.311066
R1560 VSS.n750 VSS.n140 0.311066
R1561 VSS.n741 VSS.n141 0.311066
R1562 VSS.n733 VSS.n142 0.311066
R1563 VSS.n724 VSS.n143 0.311066
R1564 VSS.n716 VSS.n144 0.311066
R1565 VSS.n707 VSS.n145 0.311066
R1566 VSS.n699 VSS.n146 0.311066
R1567 VSS.n690 VSS.n147 0.311066
R1568 VSS.n682 VSS.n148 0.311066
R1569 VSS.n673 VSS.n149 0.311066
R1570 VSS.n665 VSS.n150 0.311066
R1571 VSS.n656 VSS.n151 0.311066
R1572 VSS.n648 VSS.n152 0.311066
R1573 VSS.n639 VSS.n153 0.311066
R1574 VSS.n631 VSS.n154 0.311066
R1575 VSS.n622 VSS.n155 0.311066
R1576 VSS.n614 VSS.n156 0.311066
R1577 VSS.n605 VSS.n157 0.311066
R1578 VSS.n597 VSS.n158 0.311066
R1579 VSS.n588 VSS.n159 0.311066
R1580 VSS.n580 VSS.n160 0.311066
R1581 VSS.n571 VSS.n161 0.311066
R1582 VSS.n563 VSS.n162 0.311066
R1583 VSS.n554 VSS.n163 0.311066
R1584 VSS.n239 VSS.n237 0.284268
R1585 VSS.n247 VSS.n245 0.284268
R1586 VSS.n255 VSS.n253 0.284268
R1587 VSS.n263 VSS.n261 0.284268
R1588 VSS.n271 VSS.n269 0.284268
R1589 VSS.n279 VSS.n277 0.284268
R1590 VSS.n287 VSS.n285 0.284268
R1591 VSS.n295 VSS.n293 0.284268
R1592 VSS.n303 VSS.n301 0.284268
R1593 VSS.n311 VSS.n309 0.284268
R1594 VSS.n319 VSS.n317 0.284268
R1595 VSS.n327 VSS.n325 0.284268
R1596 VSS.n335 VSS.n333 0.284268
R1597 VSS.n343 VSS.n341 0.284268
R1598 VSS.n351 VSS.n349 0.284268
R1599 VSS.n359 VSS.n357 0.284268
R1600 VSS.n838 VSS.n837 0.279928
R1601 VSS.n432 VSS.n431 0.274268
R1602 VSS.n440 VSS.n439 0.274227
R1603 VSS.n448 VSS.n6 0.440892
R1604 VSS.n462 VSS.n461 0.274227
R1605 VSS.n477 VSS.n476 0.274227
R1606 VSS.n500 VSS.n499 0.274227
R1607 VSS.n515 VSS.n514 0.274227
R1608 VSS.n530 VSS.n529 0.274227
R1609 VSS.n860 VSS.n859 0.272997
R1610 VSS.n852 VSS.n851 0.272549
R1611 VSS.n829 VSS.n232 0.271299
R1612 VSS.n106 VSS.n88 0.267794
R1613 VSS.n106 VSS.n18 0.267794
R1614 VSS.n106 VSS.n86 0.267794
R1615 VSS.n106 VSS.n84 0.267794
R1616 VSS.n106 VSS.n19 0.267794
R1617 VSS.n106 VSS.n20 0.267794
R1618 VSS.n106 VSS.n21 0.267794
R1619 VSS.n106 VSS.n82 0.267794
R1620 VSS.n106 VSS.n22 0.267794
R1621 VSS.n106 VSS.n23 0.267794
R1622 VSS.n106 VSS.n24 0.267794
R1623 VSS.n106 VSS.n80 0.267794
R1624 VSS.n106 VSS.n25 0.267794
R1625 VSS.n106 VSS.n78 0.267794
R1626 VSS.n106 VSS.n26 0.267794
R1627 VSS.n106 VSS.n77 0.267794
R1628 VSS.n106 VSS.n28 0.267794
R1629 VSS.n106 VSS.n29 0.267794
R1630 VSS.n106 VSS.n75 0.267794
R1631 VSS.n106 VSS.n30 0.267794
R1632 VSS.n106 VSS.n31 0.267794
R1633 VSS.n106 VSS.n32 0.267794
R1634 VSS.n106 VSS.n34 0.267794
R1635 VSS.n106 VSS.n35 0.267794
R1636 VSS.n106 VSS.n37 0.267794
R1637 VSS.n106 VSS.n38 0.267794
R1638 VSS.n106 VSS.n39 0.267794
R1639 VSS.n106 VSS.n40 0.267794
R1640 VSS.n106 VSS.n41 0.267794
R1641 VSS.n106 VSS.n73 0.267794
R1642 VSS.n106 VSS.n42 0.267794
R1643 VSS.n106 VSS.n72 0.267794
R1644 VSS.n106 VSS.n44 0.267794
R1645 VSS.n106 VSS.n45 0.267794
R1646 VSS.n106 VSS.n46 0.267794
R1647 VSS.n106 VSS.n47 0.267794
R1648 VSS.n106 VSS.n70 0.267794
R1649 VSS.n106 VSS.n48 0.267794
R1650 VSS.n106 VSS.n68 0.267794
R1651 VSS.n106 VSS.n49 0.267794
R1652 VSS.n106 VSS.n50 0.267794
R1653 VSS.n106 VSS.n51 0.267794
R1654 VSS.n106 VSS.n52 0.267794
R1655 VSS.n106 VSS.n66 0.267794
R1656 VSS.n106 VSS.n65 0.267794
R1657 VSS.n106 VSS.n53 0.267794
R1658 VSS.n106 VSS.n54 0.267794
R1659 VSS.n106 VSS.n55 0.267794
R1660 VSS.n106 VSS.n56 0.267794
R1661 VSS.n106 VSS.n62 0.267794
R1662 VSS.n106 VSS.n61 0.267794
R1663 VSS.n106 VSS.n60 0.267794
R1664 VSS.n106 VSS.n58 0.267794
R1665 VSS.n106 VSS.n100 0.267794
R1666 VSS.n106 VSS.n99 0.267794
R1667 VSS.n106 VSS.n98 0.267794
R1668 VSS.n106 VSS.n97 0.267794
R1669 VSS.n106 VSS.n96 0.267794
R1670 VSS.n106 VSS.n95 0.267794
R1671 VSS.n106 VSS.n94 0.267794
R1672 VSS.n106 VSS.n93 0.267794
R1673 VSS.n106 VSS.n92 0.267794
R1674 VSS.n106 VSS.n91 0.267794
R1675 VSS.n106 VSS.n90 0.267794
R1676 VSS.n106 VSS.n89 0.267794
R1677 VSS.n818 VSS.n232 0.265518
R1678 VSS.n371 VSS.n165 0.259448
R1679 VSS.n369 VSS.n368 0.251101
R1680 VSS.n445 VSS.n444 0.245497
R1681 VSS.n812 VSS.n811 0.244247
R1682 VSS.n795 VSS.n794 0.244247
R1683 VSS.n778 VSS.n777 0.244247
R1684 VSS.n761 VSS.n760 0.244247
R1685 VSS.n744 VSS.n743 0.244247
R1686 VSS.n727 VSS.n726 0.244247
R1687 VSS.n710 VSS.n709 0.244247
R1688 VSS.n693 VSS.n692 0.244247
R1689 VSS.n676 VSS.n675 0.244247
R1690 VSS.n659 VSS.n658 0.244247
R1691 VSS.n642 VSS.n641 0.244247
R1692 VSS.n625 VSS.n624 0.244247
R1693 VSS.n608 VSS.n607 0.244247
R1694 VSS.n591 VSS.n590 0.244247
R1695 VSS.n574 VSS.n573 0.244247
R1696 VSS.n557 VSS.n556 0.244247
R1697 VSS.n816 VSS.n237 0.240049
R1698 VSS.n799 VSS.n245 0.240049
R1699 VSS.n782 VSS.n253 0.240049
R1700 VSS.n765 VSS.n261 0.240049
R1701 VSS.n748 VSS.n269 0.240049
R1702 VSS.n731 VSS.n277 0.240049
R1703 VSS.n714 VSS.n285 0.240049
R1704 VSS.n697 VSS.n293 0.240049
R1705 VSS.n680 VSS.n301 0.240049
R1706 VSS.n663 VSS.n309 0.240049
R1707 VSS.n646 VSS.n317 0.240049
R1708 VSS.n629 VSS.n325 0.240049
R1709 VSS.n612 VSS.n333 0.240049
R1710 VSS.n595 VSS.n341 0.240049
R1711 VSS.n578 VSS.n349 0.240049
R1712 VSS.n561 VSS.n357 0.240049
R1713 VSS.n463 VSS.n462 0.237997
R1714 VSS.n478 VSS.n477 0.237997
R1715 VSS.n501 VSS.n500 0.237997
R1716 VSS.n516 VSS.n515 0.237997
R1717 VSS.n531 VSS.n530 0.237997
R1718 VSS.n436 VSS.n435 0.234227
R1719 VSS.n856 VSS.n855 0.232997
R1720 VSS.n857 VSS.n856 0.231727
R1721 VSS.n437 VSS.n436 0.230497
R1722 VSS.n812 VSS.n808 0.224227
R1723 VSS.n795 VSS.n791 0.224227
R1724 VSS.n778 VSS.n774 0.224227
R1725 VSS.n761 VSS.n757 0.224227
R1726 VSS.n744 VSS.n740 0.224227
R1727 VSS.n727 VSS.n723 0.224227
R1728 VSS.n710 VSS.n706 0.224227
R1729 VSS.n693 VSS.n689 0.224227
R1730 VSS.n676 VSS.n672 0.224227
R1731 VSS.n659 VSS.n655 0.224227
R1732 VSS.n642 VSS.n638 0.224227
R1733 VSS.n625 VSS.n621 0.224227
R1734 VSS.n608 VSS.n604 0.224227
R1735 VSS.n591 VSS.n587 0.224227
R1736 VSS.n574 VSS.n570 0.224227
R1737 VSS.n557 VSS.n553 0.224227
R1738 VSS.n444 VSS.n443 0.219227
R1739 VSS.n831 VSS.n830 0.21012
R1740 VSS.n827 VSS.n825 0.21012
R1741 VSS.n372 VSS.n371 0.206787
R1742 VSS.n851 VSS.n850 0.201058
R1743 VSS.n431 VSS.n430 0.200293
R1744 VSS.n861 VSS.n860 0.191727
R1745 VSS.n441 VSS.n440 0.190497
R1746 VSS.n817 VSS.n816 0.186138
R1747 VSS.n800 VSS.n799 0.186138
R1748 VSS.n783 VSS.n782 0.186138
R1749 VSS.n766 VSS.n765 0.186138
R1750 VSS.n749 VSS.n748 0.186138
R1751 VSS.n732 VSS.n731 0.186138
R1752 VSS.n715 VSS.n714 0.186138
R1753 VSS.n698 VSS.n697 0.186138
R1754 VSS.n681 VSS.n680 0.186138
R1755 VSS.n664 VSS.n663 0.186138
R1756 VSS.n647 VSS.n646 0.186138
R1757 VSS.n630 VSS.n629 0.186138
R1758 VSS.n613 VSS.n612 0.186138
R1759 VSS.n596 VSS.n595 0.186138
R1760 VSS.n579 VSS.n578 0.186138
R1761 VSS.n562 VSS.n561 0.186138
R1762 VSS.n834 VSS.n833 0.179043
R1763 VSS.n367 VSS.n165 0.177116
R1764 VSS.n865 VSS.n864 0.167388
R1765 VSS.n168 VSS.n164 0.16705
R1766 VSS.n454 VSS.n453 0.166269
R1767 VSS.n469 VSS.n468 0.166269
R1768 VSS.n484 VSS.n483 0.166269
R1769 VSS.n507 VSS.n506 0.166269
R1770 VSS.n522 VSS.n521 0.166269
R1771 VSS.n537 VSS.n536 0.166269
R1772 VSS.n5 VSS.n447 0.318488
R1773 VSS.n818 VSS.n231 0.16205
R1774 VSS.n809 VSS.n229 0.16205
R1775 VSS.n801 VSS.n227 0.16205
R1776 VSS.n792 VSS.n225 0.16205
R1777 VSS.n784 VSS.n223 0.16205
R1778 VSS.n775 VSS.n221 0.16205
R1779 VSS.n767 VSS.n219 0.16205
R1780 VSS.n758 VSS.n217 0.16205
R1781 VSS.n750 VSS.n215 0.16205
R1782 VSS.n741 VSS.n213 0.16205
R1783 VSS.n733 VSS.n211 0.16205
R1784 VSS.n724 VSS.n209 0.16205
R1785 VSS.n716 VSS.n207 0.16205
R1786 VSS.n707 VSS.n205 0.16205
R1787 VSS.n699 VSS.n203 0.16205
R1788 VSS.n690 VSS.n201 0.16205
R1789 VSS.n682 VSS.n199 0.16205
R1790 VSS.n673 VSS.n197 0.16205
R1791 VSS.n665 VSS.n195 0.16205
R1792 VSS.n656 VSS.n193 0.16205
R1793 VSS.n648 VSS.n191 0.16205
R1794 VSS.n639 VSS.n189 0.16205
R1795 VSS.n631 VSS.n187 0.16205
R1796 VSS.n622 VSS.n185 0.16205
R1797 VSS.n614 VSS.n183 0.16205
R1798 VSS.n605 VSS.n181 0.16205
R1799 VSS.n597 VSS.n179 0.16205
R1800 VSS.n588 VSS.n177 0.16205
R1801 VSS.n580 VSS.n175 0.16205
R1802 VSS.n571 VSS.n173 0.16205
R1803 VSS.n563 VSS.n171 0.16205
R1804 VSS.n554 VSS.n169 0.16205
R1805 VSS.n106 VSS.n17 0.16137
R1806 VSS.n106 VSS.n104 0.16137
R1807 VSS.n106 VSS.n103 0.16137
R1808 VSS.n834 VSS.n823 0.161058
R1809 VSS.n430 VSS.n429 0.161058
R1810 VSS.n850 VSS.n849 0.160293
R1811 VSS.n808 VSS.n243 0.15705
R1812 VSS.n791 VSS.n251 0.15705
R1813 VSS.n774 VSS.n259 0.15705
R1814 VSS.n757 VSS.n267 0.15705
R1815 VSS.n740 VSS.n275 0.15705
R1816 VSS.n723 VSS.n283 0.15705
R1817 VSS.n706 VSS.n291 0.15705
R1818 VSS.n689 VSS.n299 0.15705
R1819 VSS.n672 VSS.n307 0.15705
R1820 VSS.n655 VSS.n315 0.15705
R1821 VSS.n638 VSS.n323 0.15705
R1822 VSS.n621 VSS.n331 0.15705
R1823 VSS.n604 VSS.n339 0.15705
R1824 VSS.n587 VSS.n347 0.15705
R1825 VSS.n570 VSS.n355 0.15705
R1826 VSS.n450 VSS.n423 0.155582
R1827 VSS.n421 VSS.n420 0.155582
R1828 VSS.n459 VSS.n418 0.155582
R1829 VSS.n465 VSS.n415 0.155582
R1830 VSS.n413 VSS.n412 0.155582
R1831 VSS.n474 VSS.n410 0.155582
R1832 VSS.n480 VSS.n407 0.155582
R1833 VSS.n405 VSS.n404 0.155582
R1834 VSS.n489 VSS.n402 0.155582
R1835 VSS.n503 VSS.n399 0.155582
R1836 VSS.n397 VSS.n396 0.155582
R1837 VSS.n512 VSS.n394 0.155582
R1838 VSS.n518 VSS.n391 0.155582
R1839 VSS.n389 VSS.n388 0.155582
R1840 VSS.n527 VSS.n386 0.155582
R1841 VSS.n533 VSS.n383 0.155582
R1842 VSS.n381 VSS.n380 0.155582
R1843 VSS.n377 VSS.n376 0.155582
R1844 VSS.n820 VSS.n817 0.1508
R1845 VSS.n803 VSS.n800 0.1508
R1846 VSS.n786 VSS.n783 0.1508
R1847 VSS.n769 VSS.n766 0.1508
R1848 VSS.n752 VSS.n749 0.1508
R1849 VSS.n735 VSS.n732 0.1508
R1850 VSS.n718 VSS.n715 0.1508
R1851 VSS.n701 VSS.n698 0.1508
R1852 VSS.n684 VSS.n681 0.1508
R1853 VSS.n667 VSS.n664 0.1508
R1854 VSS.n650 VSS.n647 0.1508
R1855 VSS.n633 VSS.n630 0.1508
R1856 VSS.n616 VSS.n613 0.1508
R1857 VSS.n599 VSS.n596 0.1508
R1858 VSS.n582 VSS.n579 0.1508
R1859 VSS.n565 VSS.n562 0.1508
R1860 VSS.n438 VSS.n437 0.149888
R1861 VSS.n858 VSS.n857 0.14955
R1862 VSS.n448 VSS.n427 0.149476
R1863 VSS.n452 VSS.n451 0.149476
R1864 VSS.n456 VSS.n419 0.149476
R1865 VSS.n463 VSS.n417 0.149476
R1866 VSS.n467 VSS.n466 0.149476
R1867 VSS.n471 VSS.n411 0.149476
R1868 VSS.n478 VSS.n409 0.149476
R1869 VSS.n482 VSS.n481 0.149476
R1870 VSS.n486 VSS.n403 0.149476
R1871 VSS.n501 VSS.n401 0.149476
R1872 VSS.n505 VSS.n504 0.149476
R1873 VSS.n509 VSS.n395 0.149476
R1874 VSS.n516 VSS.n393 0.149476
R1875 VSS.n520 VSS.n519 0.149476
R1876 VSS.n524 VSS.n387 0.149476
R1877 VSS.n531 VSS.n385 0.149476
R1878 VSS.n535 VSS.n534 0.149476
R1879 VSS.n539 VSS.n379 0.149476
R1880 VSS.n837 VSS.n836 0.148577
R1881 VSS.n855 VSS.n854 0.147388
R1882 VSS.n435 VSS.n434 0.14705
R1883 VSS.n862 VSS.n861 0.142118
R1884 VSS.n442 VSS.n441 0.142118
R1885 VSS.n372 VSS.n370 0.141022
R1886 VSS.n446 VSS.n445 0.134888
R1887 VSS.n496 VSS.n495 0.134888
R1888 VSS.n450 VSS.n449 0.129618
R1889 VSS.n465 VSS.n464 0.129618
R1890 VSS.n480 VSS.n479 0.129618
R1891 VSS.n503 VSS.n502 0.129618
R1892 VSS.n518 VSS.n517 0.129618
R1893 VSS.n533 VSS.n532 0.129618
R1894 VSS.n370 VSS.n369 0.127569
R1895 VSS.n453 VSS.n422 0.126138
R1896 VSS.n468 VSS.n414 0.126138
R1897 VSS.n483 VSS.n406 0.126138
R1898 VSS.n506 VSS.n398 0.126138
R1899 VSS.n521 VSS.n390 0.126138
R1900 VSS.n536 VSS.n382 0.126138
R1901 VSS.n823 VSS.n821 0.125868
R1902 VSS.n805 VSS.n804 0.125868
R1903 VSS.n788 VSS.n787 0.125868
R1904 VSS.n771 VSS.n770 0.125868
R1905 VSS.n754 VSS.n753 0.125868
R1906 VSS.n737 VSS.n736 0.125868
R1907 VSS.n720 VSS.n719 0.125868
R1908 VSS.n703 VSS.n702 0.125868
R1909 VSS.n686 VSS.n685 0.125868
R1910 VSS.n669 VSS.n668 0.125868
R1911 VSS.n652 VSS.n651 0.125868
R1912 VSS.n635 VSS.n634 0.125868
R1913 VSS.n618 VSS.n617 0.125868
R1914 VSS.n601 VSS.n600 0.125868
R1915 VSS.n584 VSS.n583 0.125868
R1916 VSS.n567 VSS.n566 0.125868
R1917 VSS.n108 VSS.n424 0.156005
R1918 VSS.n111 VSS.n416 0.156005
R1919 VSS.n114 VSS.n408 0.156005
R1920 VSS.n117 VSS.n400 0.156005
R1921 VSS.n120 VSS.n392 0.156005
R1922 VSS.n123 VSS.n384 0.156005
R1923 VSS.n548 VSS.n167 0.124618
R1924 VSS.n864 VSS.n863 0.12455
R1925 VSS.n543 VSS.n167 0.122118
R1926 VSS.n447 VSS.n446 0.12205
R1927 VSS.n459 VSS.n458 0.12205
R1928 VSS.n474 VSS.n473 0.12205
R1929 VSS.n489 VSS.n488 0.12205
R1930 VSS.n497 VSS.n496 0.12205
R1931 VSS.n512 VSS.n511 0.12205
R1932 VSS.n527 VSS.n526 0.12205
R1933 VSS.n378 VSS.n377 0.12205
R1934 VSS.n231 VSS.n230 0.119888
R1935 VSS.n229 VSS.n228 0.119888
R1936 VSS.n227 VSS.n226 0.119888
R1937 VSS.n225 VSS.n224 0.119888
R1938 VSS.n223 VSS.n222 0.119888
R1939 VSS.n221 VSS.n220 0.119888
R1940 VSS.n219 VSS.n218 0.119888
R1941 VSS.n217 VSS.n216 0.119888
R1942 VSS.n215 VSS.n214 0.119888
R1943 VSS.n213 VSS.n212 0.119888
R1944 VSS.n211 VSS.n210 0.119888
R1945 VSS.n209 VSS.n208 0.119888
R1946 VSS.n207 VSS.n206 0.119888
R1947 VSS.n205 VSS.n204 0.119888
R1948 VSS.n203 VSS.n202 0.119888
R1949 VSS.n201 VSS.n200 0.119888
R1950 VSS.n199 VSS.n198 0.119888
R1951 VSS.n197 VSS.n196 0.119888
R1952 VSS.n195 VSS.n194 0.119888
R1953 VSS.n193 VSS.n192 0.119888
R1954 VSS.n191 VSS.n190 0.119888
R1955 VSS.n189 VSS.n188 0.119888
R1956 VSS.n187 VSS.n186 0.119888
R1957 VSS.n185 VSS.n184 0.119888
R1958 VSS.n183 VSS.n182 0.119888
R1959 VSS.n181 VSS.n180 0.119888
R1960 VSS.n179 VSS.n178 0.119888
R1961 VSS.n177 VSS.n176 0.119888
R1962 VSS.n175 VSS.n174 0.119888
R1963 VSS.n173 VSS.n172 0.119888
R1964 VSS.n171 VSS.n170 0.119888
R1965 VSS.n169 VSS.n168 0.119888
R1966 VSS.n548 VSS.n164 0.114888
R1967 VSS.n863 VSS.n862 0.114618
R1968 VSS.n443 VSS.n442 0.114618
R1969 VSS.n804 VSS.n243 0.113638
R1970 VSS.n787 VSS.n251 0.113638
R1971 VSS.n770 VSS.n259 0.113638
R1972 VSS.n753 VSS.n267 0.113638
R1973 VSS.n736 VSS.n275 0.113638
R1974 VSS.n719 VSS.n283 0.113638
R1975 VSS.n702 VSS.n291 0.113638
R1976 VSS.n685 VSS.n299 0.113638
R1977 VSS.n668 VSS.n307 0.113638
R1978 VSS.n651 VSS.n315 0.113638
R1979 VSS.n634 VSS.n323 0.113638
R1980 VSS.n617 VSS.n331 0.113638
R1981 VSS.n600 VSS.n339 0.113638
R1982 VSS.n583 VSS.n347 0.113638
R1983 VSS.n566 VSS.n355 0.113638
R1984 VSS.n434 VSS.n433 0.109888
R1985 VSS.n854 VSS.n853 0.10955
R1986 VSS.n859 VSS.n858 0.107388
R1987 VSS.n439 VSS.n438 0.10705
R1988 VSS.n458 VSS.n457 0.106138
R1989 VSS.n473 VSS.n472 0.106138
R1990 VSS.n488 VSS.n487 0.106138
R1991 VSS.n511 VSS.n510 0.106138
R1992 VSS.n526 VSS.n525 0.106138
R1993 VSS.n540 VSS.n378 0.106138
R1994 VSS.n456 VSS.n455 0.105361
R1995 VSS.n471 VSS.n470 0.105361
R1996 VSS.n486 VSS.n485 0.105361
R1997 VSS.n509 VSS.n508 0.105361
R1998 VSS.n524 VSS.n523 0.105361
R1999 VSS.n539 VSS.n538 0.105361
R2000 VSS.n422 VSS.n421 0.10205
R2001 VSS.n414 VSS.n413 0.10205
R2002 VSS.n406 VSS.n405 0.10205
R2003 VSS.n398 VSS.n397 0.10205
R2004 VSS.n390 VSS.n389 0.10205
R2005 VSS.n382 VSS.n381 0.10205
R2006 VSS.n449 VSS.n424 0.0983676
R2007 VSS.n464 VSS.n416 0.0983676
R2008 VSS.n479 VSS.n408 0.0983676
R2009 VSS.n502 VSS.n400 0.0983676
R2010 VSS.n517 VSS.n392 0.0983676
R2011 VSS.n532 VSS.n384 0.0983676
R2012 VSS.n828 VSS.n827 0.094
R2013 VSS.n831 VSS.n828 0.094
R2014 VSS.n836 VSS.n233 0.08925
R2015 VSS.n821 VSS.n820 0.0883676
R2016 VSS.n805 VSS.n803 0.0883676
R2017 VSS.n788 VSS.n786 0.0883676
R2018 VSS.n771 VSS.n769 0.0883676
R2019 VSS.n754 VSS.n752 0.0883676
R2020 VSS.n737 VSS.n735 0.0883676
R2021 VSS.n720 VSS.n718 0.0883676
R2022 VSS.n703 VSS.n701 0.0883676
R2023 VSS.n686 VSS.n684 0.0883676
R2024 VSS.n669 VSS.n667 0.0883676
R2025 VSS.n652 VSS.n650 0.0883676
R2026 VSS.n635 VSS.n633 0.0883676
R2027 VSS.n618 VSS.n616 0.0883676
R2028 VSS.n601 VSS.n599 0.0883676
R2029 VSS.n584 VSS.n582 0.0883676
R2030 VSS.n567 VSS.n565 0.0883676
R2031 VSS.n551 VSS.n550 0.088
R2032 VSS.n457 VSS.n110 0.176279
R2033 VSS.n113 VSS.n471 0.0435295
R2034 VSS.n487 VSS.n116 0.176279
R2035 VSS.n119 VSS.n509 0.0435295
R2036 VSS.n122 VSS.n524 0.0435295
R2037 VSS.n540 VSS.n125 0.176279
R2038 VSS.n827 VSS.n826 0.0851154
R2039 VSS.n833 VSS.n831 0.0851154
R2040 VSS.n546 VSS.n542 0.0805
R2041 VSS.n849 VSS.n848 0.078
R2042 VSS.n429 VSS.n428 0.078
R2043 VSS.n367 VSS.n166 0.0771176
R2044 VSS.n826 VSS.n234 0.0746176
R2045 VSS.n824 VSS.n131 0.0746176
R2046 VSS.n545 VSS.n364 0.07425
R2047 VSS.n543 VSS.n166 0.0696176
R2048 VSS.n826 VSS.n235 0.06925
R2049 VSS.n824 VSS.n132 0.06925
R2050 VSS.n452 VSS.n109 0.103847
R2051 VSS.n467 VSS.n112 0.103847
R2052 VSS.n482 VSS.n115 0.103847
R2053 VSS.n505 VSS.n118 0.103847
R2054 VSS.n520 VSS.n121 0.103847
R2055 VSS.n535 VSS.n124 0.103847
R2056 VSS.n553 VSS.n363 0.06175
R2057 VSS.n829 VSS.n132 0.05925
R2058 VSS.n842 VSS.n840 0.05675
R2059 VSS.n839 VSS.n234 0.0546176
R2060 VSS.n836 VSS.n131 0.0546176
R2061 VSS.n537 VSS.n535 0.0543074
R2062 VSS.n522 VSS.n520 0.0543074
R2063 VSS.n507 VSS.n505 0.0543074
R2064 VSS.n484 VSS.n482 0.0543074
R2065 VSS.n469 VSS.n467 0.0543074
R2066 VSS.n454 VSS.n452 0.0543074
R2067 VSS.n109 VSS.n450 0.0180497
R2068 VSS.n112 VSS.n465 0.0180497
R2069 VSS.n124 VSS.n533 0.0180497
R2070 VSS.n547 VSS.n364 0.04925
R2071 VSS.n240 VSS.n239 0.048
R2072 VSS.n248 VSS.n247 0.048
R2073 VSS.n256 VSS.n255 0.048
R2074 VSS.n264 VSS.n263 0.048
R2075 VSS.n272 VSS.n271 0.048
R2076 VSS.n280 VSS.n279 0.048
R2077 VSS.n288 VSS.n287 0.048
R2078 VSS.n296 VSS.n295 0.048
R2079 VSS.n304 VSS.n303 0.048
R2080 VSS.n312 VSS.n311 0.048
R2081 VSS.n320 VSS.n319 0.048
R2082 VSS.n328 VSS.n327 0.048
R2083 VSS.n336 VSS.n335 0.048
R2084 VSS.n344 VSS.n343 0.048
R2085 VSS.n352 VSS.n351 0.048
R2086 VSS.n360 VSS.n359 0.048
R2087 VSS.n551 VSS.n547 0.04675
R2088 VSS.n811 VSS.n240 0.0405
R2089 VSS.n794 VSS.n248 0.0405
R2090 VSS.n777 VSS.n256 0.0405
R2091 VSS.n760 VSS.n264 0.0405
R2092 VSS.n743 VSS.n272 0.0405
R2093 VSS.n726 VSS.n280 0.0405
R2094 VSS.n709 VSS.n288 0.0405
R2095 VSS.n692 VSS.n296 0.0405
R2096 VSS.n675 VSS.n304 0.0405
R2097 VSS.n658 VSS.n312 0.0405
R2098 VSS.n641 VSS.n320 0.0405
R2099 VSS.n624 VSS.n328 0.0405
R2100 VSS.n607 VSS.n336 0.0405
R2101 VSS.n590 VSS.n344 0.0405
R2102 VSS.n573 VSS.n352 0.0405
R2103 VSS.n556 VSS.n360 0.0405
R2104 VSS.n848 VSS 0.038
R2105 VSS.n840 VSS.n839 0.033
R2106 VSS.n833 VSS.n832 0.033
R2107 VSS.n370 VSS.n366 0.02925
R2108 VSS.n832 VSS.n235 0.02675
R2109 VSS.t122 VSS.n4 116.468
R2110 VSS.n546 VSS.n545 0.02175
R2111 VSS.n106 VSS.n16 0.0166972
R2112 VSS.n106 VSS.n105 0.0166972
R2113 VSS.n538 VSS.n381 0.0166107
R2114 VSS.n523 VSS.n389 0.0166107
R2115 VSS.n508 VSS.n397 0.0166107
R2116 VSS.n485 VSS.n405 0.0166107
R2117 VSS.n470 VSS.n413 0.0166107
R2118 VSS.n455 VSS.n421 0.0166107
R2119 VSS.n542 VSS.n366 0.0155
R2120 VSS.n841 VSS.n101 0.0112403
R2121 VSS.n865 VSS.n101 0.0095322
R2122 VSS.n106 VSS.n87 0.00938635
R2123 VSS.n106 VSS.n79 0.00938635
R2124 VSS.n106 VSS.n85 0.00937856
R2125 VSS.n106 VSS.n81 0.00937856
R2126 VSS.n106 VSS.n27 0.00937856
R2127 VSS.n106 VSS.n76 0.00937856
R2128 VSS.n106 VSS.n33 0.00937856
R2129 VSS.n106 VSS.n36 0.00937856
R2130 VSS.n106 VSS.n74 0.00937856
R2131 VSS.n106 VSS.n43 0.00937856
R2132 VSS.n106 VSS.n67 0.00937856
R2133 VSS.n106 VSS.n64 0.00937856
R2134 VSS.n106 VSS.n57 0.00937856
R2135 VSS.n106 VSS.n59 0.00937856
R2136 VSS.n106 VSS.n83 0.00937856
R2137 VSS.n106 VSS.n71 0.00937856
R2138 VSS.n106 VSS.n69 0.00937856
R2139 VSS.n106 VSS.n63 0.00937856
R2140 VSS.n550 VSS.n363 0.008
R2141 VSS.n842 VSS.n841 0.00675
R2142 VSS.n841 VSS.n233 0.00675
R2143 VSS.n4 VSS.t335 58.3181
R2144 VSS.n4 VSS.t303 101.74
R2145 VSS.n4 VSS.t290 58.3216
R2146 VSS.n4 VSS.t275 58.3211
R2147 VSS.n371 VSS.n107 8.47947
R2148 VSS.n4 VSS.t273 101.74
R2149 VSS.n4 VSS.t320 58.3203
R2150 VSS.n4 VSS.n0 1.42341
R2151 a_3747_311.n0 a_3747_311.t2 52.0388
R2152 a_3747_311.t1 a_3747_311.n0 35.4491
R2153 a_3747_311.n0 a_3747_311.t3 33.5891
R2154 a_3747_311.t0 a_3747_311.t1 5.61942
R2155 a_3171_311.n0 a_3171_311.t2 51.8377
R2156 a_3171_311.n0 a_3171_311.t3 33.3881
R2157 a_3171_311.t1 a_3171_311.n0 31.8923
R2158 a_3171_311.t0 a_3171_311.t1 5.61777
R2159 a_2595_311.n0 a_2595_311.t2 51.6367
R2160 a_2595_311.n0 a_2595_311.t3 33.187
R2161 a_2595_311.t1 a_2595_311.n0 27.993
R2162 a_2595_311.t0 a_2595_311.t1 5.73018
R2163 a_3747_1047.n0 a_3747_1047.t2 38.0081
R2164 a_3747_1047.n0 a_3747_1047.t3 33.3957
R2165 a_3747_1047.n1 a_3747_1047.t4 33.3957
R2166 a_3747_1047.n2 a_3747_1047.t5 33.3957
R2167 a_3747_1047.n3 a_3747_1047.t6 33.3957
R2168 a_3747_1047.n4 a_3747_1047.t7 33.3957
R2169 a_3747_1047.n5 a_3747_1047.t8 33.3957
R2170 a_3747_1047.n6 a_3747_1047.t9 33.3957
R2171 a_3747_1047.t1 a_3747_1047.n6 23.2419
R2172 a_3747_1047.t0 a_3747_1047.t1 5.61942
R2173 a_3747_1047.n6 a_3747_1047.n5 4.61291
R2174 a_3747_1047.n5 a_3747_1047.n4 4.61291
R2175 a_3747_1047.n4 a_3747_1047.n3 4.61291
R2176 a_3747_1047.n3 a_3747_1047.n2 4.61291
R2177 a_3747_1047.n2 a_3747_1047.n1 4.61291
R2178 a_3747_1047.n1 a_3747_1047.n0 4.61291
R2179 a_3171_1047.n0 a_3171_1047.t2 37.8054
R2180 a_3171_1047.n0 a_3171_1047.t3 33.193
R2181 a_3171_1047.n1 a_3171_1047.t4 33.193
R2182 a_3171_1047.n2 a_3171_1047.t5 33.193
R2183 a_3171_1047.n3 a_3171_1047.t6 33.193
R2184 a_3171_1047.n4 a_3171_1047.t7 33.193
R2185 a_3171_1047.n5 a_3171_1047.t8 33.193
R2186 a_3171_1047.n6 a_3171_1047.t9 33.193
R2187 a_3171_1047.t1 a_3171_1047.n6 23.0313
R2188 a_3171_1047.t0 a_3171_1047.t1 5.61777
R2189 a_3171_1047.n6 a_3171_1047.n5 4.61291
R2190 a_3171_1047.n5 a_3171_1047.n4 4.61291
R2191 a_3171_1047.n4 a_3171_1047.n3 4.61291
R2192 a_3171_1047.n3 a_3171_1047.n2 4.61291
R2193 a_3171_1047.n2 a_3171_1047.n1 4.61291
R2194 a_3171_1047.n1 a_3171_1047.n0 4.61291
R2195 a_2595_1047.n0 a_2595_1047.t2 37.7691
R2196 a_2595_1047.n0 a_2595_1047.t3 33.1567
R2197 a_2595_1047.n1 a_2595_1047.t4 33.1567
R2198 a_2595_1047.n2 a_2595_1047.t5 33.1567
R2199 a_2595_1047.n3 a_2595_1047.t6 33.1567
R2200 a_2595_1047.n4 a_2595_1047.t7 33.1567
R2201 a_2595_1047.n5 a_2595_1047.t8 33.1567
R2202 a_2595_1047.n6 a_2595_1047.t9 33.1567
R2203 a_2595_1047.t1 a_2595_1047.n6 22.7941
R2204 a_2595_1047.t0 a_2595_1047.t1 5.65522
R2205 a_2595_1047.n6 a_2595_1047.n5 4.61291
R2206 a_2595_1047.n5 a_2595_1047.n4 4.61291
R2207 a_2595_1047.n4 a_2595_1047.n3 4.61291
R2208 a_2595_1047.n3 a_2595_1047.n2 4.61291
R2209 a_2595_1047.n2 a_2595_1047.n1 4.61291
R2210 a_2595_1047.n1 a_2595_1047.n0 4.61291
R2211 a_2019_1047.n0 a_2019_1047.t2 37.9701
R2212 a_2019_1047.n0 a_2019_1047.t3 33.3577
R2213 a_2019_1047.n1 a_2019_1047.t4 33.3577
R2214 a_2019_1047.n2 a_2019_1047.t5 33.3577
R2215 a_2019_1047.n3 a_2019_1047.t6 33.3577
R2216 a_2019_1047.n4 a_2019_1047.t7 33.3577
R2217 a_2019_1047.n5 a_2019_1047.t8 33.3577
R2218 a_2019_1047.t1 a_2019_1047.t9 22.5945
R2219 a_2019_1047.t0 a_2019_1047.t1 5.62052
R2220 a_2019_1047.t9 a_2019_1047.n5 4.61291
R2221 a_2019_1047.n5 a_2019_1047.n4 4.61291
R2222 a_2019_1047.n4 a_2019_1047.n3 4.61291
R2223 a_2019_1047.n3 a_2019_1047.n2 4.61291
R2224 a_2019_1047.n2 a_2019_1047.n1 4.61291
R2225 a_2019_1047.n1 a_2019_1047.n0 4.61291
C1105 MUX_OUT VSS 3.24058f
C1106 MUX_SEL4 VSS 1.60778f
C1107 MUX_SEL3 VSS 0.90686f
C1108 MUX_SEL2 VSS 1.81137f
C1109 MUX_SEL1 VSS 0.95076f
C1110 MUX_SEL0 VSS 1.55166f
C1111 DELAY_VBIASN VSS 12.41106f
C1112 DELAY_OUT_LAST VSS 0.39284f
C1113 DELAY_VBIASP VSS 4.13999f
C1114 DELAY_IN VSS 1.91954f
C1115 VDD VSS 46.2831f
C1116 a_26985_519# VSS 0.17928f ; **FLOATING
C1117 a_23945_519# VSS 0.17928f ; **FLOATING
C1118 a_20905_519# VSS 0.17928f ; **FLOATING
C1119 a_17865_519# VSS 0.17593f ; **FLOATING
C1120 a_16851_309# VSS 0.38699f ; **FLOATING
C1121 a_16108_289# VSS 3.85084f ; **FLOATING
C1122 a_15964_289# VSS 0.17613f ; **FLOATING
C1123 a_15765_463# VSS 0.36132f ; **FLOATING
C1124 a_14825_519# VSS 0.17928f ; **FLOATING
C1125 a_11785_519# VSS 0.17928f ; **FLOATING
C1126 a_8745_519# VSS 0.17928f ; **FLOATING
C1127 a_5731_289# VSS 3.39133f ; **FLOATING
C1128 a_2019_311# VSS 1.61601f ; **FLOATING
C1129 a_5705_519# VSS 0.17638f ; **FLOATING
C1130 a_3449_331# VSS 0.18478f ; **FLOATING
C1131 a_2873_331# VSS 0.18321f ; **FLOATING
C1132 a_2297_331# VSS 0.18321f ; **FLOATING
C1133 a_1721_331# VSS 0.17001f ; **FLOATING
C1134 a_1544_289# VSS 0.30014f ; **FLOATING
C1135 a_1256_289# VSS 0.84266f ; **FLOATING
C1136 a_27991_1008# VSS 0.18706f ; **FLOATING
C1137 a_27915_1044# VSS 0.10926f ; **FLOATING
C1138 a_27124_1008# VSS 0.17878f ; **FLOATING
C1139 a_27048_1044# VSS 0.12122f ; **FLOATING
C1140 a_26471_1008# VSS 0.18175f ; **FLOATING
C1141 a_26395_1044# VSS 0.11073f ; **FLOATING
C1142 a_25604_1008# VSS 0.18087f ; **FLOATING
C1143 a_25630_1044# VSS 0.34158f ; **FLOATING
C1144 a_25528_1044# VSS 0.12433f ; **FLOATING
C1145 a_24951_1008# VSS 0.18335f ; **FLOATING
C1146 a_24875_1044# VSS 0.11016f ; **FLOATING
C1147 a_24084_1008# VSS 0.17878f ; **FLOATING
C1148 a_24008_1044# VSS 0.12122f ; **FLOATING
C1149 a_23431_1008# VSS 0.18175f ; **FLOATING
C1150 a_23355_1044# VSS 0.11073f ; **FLOATING
C1151 a_22564_1008# VSS 0.18087f ; **FLOATING
C1152 a_22590_1044# VSS 0.33314f ; **FLOATING
C1153 a_22488_1044# VSS 0.12433f ; **FLOATING
C1154 a_21911_1008# VSS 0.18335f ; **FLOATING
C1155 a_21835_1044# VSS 0.11016f ; **FLOATING
C1156 a_21044_1008# VSS 0.17878f ; **FLOATING
C1157 a_20968_1044# VSS 0.12122f ; **FLOATING
C1158 a_20391_1008# VSS 0.18175f ; **FLOATING
C1159 a_20315_1044# VSS 0.11073f ; **FLOATING
C1160 a_19524_1008# VSS 0.18087f ; **FLOATING
C1161 a_19550_1044# VSS 0.33563f ; **FLOATING
C1162 a_19448_1044# VSS 0.12433f ; **FLOATING
C1163 a_18871_1008# VSS 0.18335f ; **FLOATING
C1164 a_18795_1044# VSS 0.11016f ; **FLOATING
C1165 a_18004_1008# VSS 0.17878f ; **FLOATING
C1166 a_17928_1044# VSS 0.12122f ; **FLOATING
C1167 a_17351_1008# VSS 0.18022f ; **FLOATING
C1168 a_17275_1044# VSS 0.10926f ; **FLOATING
C1169 a_16484_1008# VSS 0.18023f ; **FLOATING
C1170 a_16510_1044# VSS 0.28935f ; **FLOATING
C1171 a_16408_1044# VSS 0.1229f ; **FLOATING
C1172 a_15831_1008# VSS 0.17846f ; **FLOATING
C1173 a_15755_1044# VSS 0.10926f ; **FLOATING
C1174 a_14964_1008# VSS 0.17878f ; **FLOATING
C1175 a_14888_1044# VSS 0.12122f ; **FLOATING
C1176 a_14311_1008# VSS 0.18175f ; **FLOATING
C1177 a_14235_1044# VSS 0.11073f ; **FLOATING
C1178 a_13444_1008# VSS 0.18087f ; **FLOATING
C1179 a_13470_1044# VSS 0.30333f ; **FLOATING
C1180 a_13368_1044# VSS 0.12433f ; **FLOATING
C1181 a_12791_1008# VSS 0.18335f ; **FLOATING
C1182 a_12715_1044# VSS 0.11016f ; **FLOATING
C1183 a_11924_1008# VSS 0.17878f ; **FLOATING
C1184 a_11848_1044# VSS 0.12122f ; **FLOATING
C1185 a_11271_1008# VSS 0.18175f ; **FLOATING
C1186 a_11195_1044# VSS 0.11073f ; **FLOATING
C1187 a_10404_1008# VSS 0.18087f ; **FLOATING
C1188 a_10430_1044# VSS 0.31665f ; **FLOATING
C1189 a_10328_1044# VSS 0.12433f ; **FLOATING
C1190 a_9751_1008# VSS 0.18335f ; **FLOATING
C1191 a_9675_1044# VSS 0.11016f ; **FLOATING
C1192 a_8884_1008# VSS 0.17878f ; **FLOATING
C1193 a_8808_1044# VSS 0.12122f ; **FLOATING
C1194 a_8231_1008# VSS 0.18175f ; **FLOATING
C1195 a_8155_1044# VSS 0.11073f ; **FLOATING
C1196 a_7364_1008# VSS 0.18087f ; **FLOATING
C1197 a_7390_1044# VSS 0.31357f ; **FLOATING
C1198 a_7288_1044# VSS 0.12433f ; **FLOATING
C1199 a_6711_1008# VSS 0.18335f ; **FLOATING
C1200 a_6635_1044# VSS 0.11016f ; **FLOATING
C1201 a_5844_1008# VSS 0.17878f ; **FLOATING
C1202 a_5768_1044# VSS 0.12122f ; **FLOATING
C1203 a_5191_1008# VSS 0.18022f ; **FLOATING
C1204 a_5115_1044# VSS 0.10926f ; **FLOATING
C1205 a_4324_1008# VSS 0.18023f ; **FLOATING
C1206 a_4350_1044# VSS 0.26655f ; **FLOATING
C1207 a_4248_1044# VSS 0.12443f ; **FLOATING
C1208 a_27705_1044# VSS 0.25296f ; **FLOATING
C1209 a_26185_1044# VSS 0.23475f ; **FLOATING
C1210 a_24665_1044# VSS 0.25432f ; **FLOATING
C1211 a_23145_1044# VSS 0.23475f ; **FLOATING
C1212 a_21625_1044# VSS 0.25432f ; **FLOATING
C1213 a_20105_1044# VSS 0.23475f ; **FLOATING
C1214 a_18585_1044# VSS 0.25432f ; **FLOATING
C1215 a_17065_1044# VSS 0.23385f ; **FLOATING
C1216 a_15545_1044# VSS 0.25296f ; **FLOATING
C1217 a_14025_1044# VSS 0.23475f ; **FLOATING
C1218 a_12505_1044# VSS 0.25432f ; **FLOATING
C1219 a_10985_1044# VSS 0.23475f ; **FLOATING
C1220 a_9465_1044# VSS 0.25432f ; **FLOATING
C1221 a_7945_1044# VSS 0.23475f ; **FLOATING
C1222 a_6425_1044# VSS 0.25432f ; **FLOATING
C1223 a_4905_1044# VSS 0.23549f ; **FLOATING
C1224 a_4157_1313# VSS 0.32875f ; **FLOATING
C1225 a_3449_1395# VSS 0.18629f ; **FLOATING
C1226 a_2873_1395# VSS 0.18349f ; **FLOATING
C1227 a_2297_1395# VSS 0.18349f ; **FLOATING
C1228 a_1721_1395# VSS 0.17029f ; **FLOATING
C1229 a_1544_1044# VSS 0.29829f ; **FLOATING
C1230 a_1256_1044# VSS 0.82978f ; **FLOATING
C1231 a_27671_1842# VSS 0.01336f ; **FLOATING
C1232 a_26911_1842# VSS 0.01336f ; **FLOATING
C1233 a_26151_1842# VSS 0.01336f ; **FLOATING
C1234 a_25391_1842# VSS 0.01336f ; **FLOATING
C1235 a_24631_1842# VSS 0.01336f ; **FLOATING
C1236 a_23871_1842# VSS 0.01336f ; **FLOATING
C1237 a_23111_1842# VSS 0.01336f ; **FLOATING
C1238 a_22351_1842# VSS 0.01336f ; **FLOATING
C1239 a_21591_1842# VSS 0.01336f ; **FLOATING
C1240 a_20831_1842# VSS 0.01336f ; **FLOATING
C1241 a_20071_1842# VSS 0.01336f ; **FLOATING
C1242 a_19311_1842# VSS 0.01336f ; **FLOATING
C1243 a_18551_1842# VSS 0.01336f ; **FLOATING
C1244 a_17791_1842# VSS 0.01336f ; **FLOATING
C1245 a_17031_1842# VSS 0.01336f ; **FLOATING
C1246 a_16271_1842# VSS 0.01336f ; **FLOATING
C1247 a_15511_1842# VSS 0.01336f ; **FLOATING
C1248 a_14751_1842# VSS 0.01336f ; **FLOATING
C1249 a_13991_1842# VSS 0.01336f ; **FLOATING
C1250 a_13231_1842# VSS 0.01336f ; **FLOATING
C1251 a_12471_1842# VSS 0.01336f ; **FLOATING
C1252 a_11711_1842# VSS 0.01336f ; **FLOATING
C1253 a_10951_1842# VSS 0.01336f ; **FLOATING
C1254 a_10191_1842# VSS 0.01336f ; **FLOATING
C1255 a_9431_1842# VSS 0.01336f ; **FLOATING
C1256 a_8671_1842# VSS 0.01336f ; **FLOATING
C1257 a_7911_1842# VSS 0.01336f ; **FLOATING
C1258 a_7151_1842# VSS 0.01336f ; **FLOATING
C1259 a_6391_1842# VSS 0.01336f ; **FLOATING
C1260 a_5631_1842# VSS 0.01336f ; **FLOATING
C1261 a_4871_1842# VSS 0.01336f ; **FLOATING
C1262 a_4111_1842# VSS 0.0139f ; **FLOATING
C1263 a_27563_1842# VSS 0.51284f ; **FLOATING
C1264 a_27997_1842# VSS 0.6533f ; **FLOATING
C1265 a_27433_1842# VSS 0.45843f ; **FLOATING
C1266 a_26803_1842# VSS 0.50902f ; **FLOATING
C1267 a_27237_1842# VSS 0.93747f ; **FLOATING
C1268 a_26673_1842# VSS 0.45994f ; **FLOATING
C1269 a_26043_1842# VSS 0.51137f ; **FLOATING
C1270 a_26477_1842# VSS 0.96549f ; **FLOATING
C1271 a_25913_1842# VSS 0.46292f ; **FLOATING
C1272 a_25283_1842# VSS 0.50906f ; **FLOATING
C1273 a_25717_1842# VSS 0.87619f ; **FLOATING
C1274 a_25153_1842# VSS 0.45997f ; **FLOATING
C1275 a_24523_1842# VSS 0.51043f ; **FLOATING
C1276 a_24957_1842# VSS 0.97121f ; **FLOATING
C1277 a_24393_1842# VSS 0.45843f ; **FLOATING
C1278 a_23763_1842# VSS 0.50902f ; **FLOATING
C1279 a_24197_1842# VSS 0.93322f ; **FLOATING
C1280 a_23633_1842# VSS 0.45994f ; **FLOATING
C1281 a_23003_1842# VSS 0.51137f ; **FLOATING
C1282 a_23437_1842# VSS 0.96549f ; **FLOATING
C1283 a_22873_1842# VSS 0.46292f ; **FLOATING
C1284 a_22243_1842# VSS 0.50906f ; **FLOATING
C1285 a_22677_1842# VSS 0.87619f ; **FLOATING
C1286 a_22113_1842# VSS 0.45997f ; **FLOATING
C1287 a_21483_1842# VSS 0.51043f ; **FLOATING
C1288 a_21917_1842# VSS 0.97121f ; **FLOATING
C1289 a_21353_1842# VSS 0.45843f ; **FLOATING
C1290 a_20723_1842# VSS 0.50902f ; **FLOATING
C1291 a_21157_1842# VSS 0.93322f ; **FLOATING
C1292 a_20593_1842# VSS 0.45994f ; **FLOATING
C1293 a_19963_1842# VSS 0.51137f ; **FLOATING
C1294 a_20397_1842# VSS 0.96549f ; **FLOATING
C1295 a_19833_1842# VSS 0.46292f ; **FLOATING
C1296 a_19203_1842# VSS 0.50906f ; **FLOATING
C1297 a_19637_1842# VSS 0.87619f ; **FLOATING
C1298 a_19073_1842# VSS 0.45997f ; **FLOATING
C1299 a_18443_1842# VSS 0.51043f ; **FLOATING
C1300 a_18877_1842# VSS 0.97121f ; **FLOATING
C1301 a_18313_1842# VSS 0.45843f ; **FLOATING
C1302 a_17683_1842# VSS 0.50902f ; **FLOATING
C1303 a_18117_1842# VSS 0.93322f ; **FLOATING
C1304 a_17553_1842# VSS 0.45994f ; **FLOATING
C1305 a_16923_1842# VSS 0.51133f ; **FLOATING
C1306 a_17357_1842# VSS 0.96549f ; **FLOATING
C1307 a_16793_1842# VSS 0.46262f ; **FLOATING
C1308 a_16163_1842# VSS 0.50902f ; **FLOATING
C1309 a_16597_1842# VSS 0.87137f ; **FLOATING
C1310 a_16033_1842# VSS 0.45859f ; **FLOATING
C1311 a_15403_1842# VSS 0.51041f ; **FLOATING
C1312 a_15837_1842# VSS 0.9618f ; **FLOATING
C1313 a_15273_1842# VSS 0.45843f ; **FLOATING
C1314 a_14643_1842# VSS 0.50902f ; **FLOATING
C1315 a_15077_1842# VSS 0.93209f ; **FLOATING
C1316 a_14513_1842# VSS 0.45994f ; **FLOATING
C1317 a_13883_1842# VSS 0.51137f ; **FLOATING
C1318 a_14317_1842# VSS 0.96549f ; **FLOATING
C1319 a_13753_1842# VSS 0.46292f ; **FLOATING
C1320 a_13123_1842# VSS 0.50904f ; **FLOATING
C1321 a_13557_1842# VSS 0.87619f ; **FLOATING
C1322 a_12993_1842# VSS 0.45997f ; **FLOATING
C1323 a_12363_1842# VSS 0.51043f ; **FLOATING
C1324 a_12797_1842# VSS 0.96954f ; **FLOATING
C1325 a_12233_1842# VSS 0.45843f ; **FLOATING
C1326 a_11603_1842# VSS 0.50902f ; **FLOATING
C1327 a_12037_1842# VSS 0.93322f ; **FLOATING
C1328 a_11473_1842# VSS 0.45994f ; **FLOATING
C1329 a_10843_1842# VSS 0.51137f ; **FLOATING
C1330 a_11277_1842# VSS 0.96549f ; **FLOATING
C1331 a_10713_1842# VSS 0.46292f ; **FLOATING
C1332 a_10083_1842# VSS 0.50904f ; **FLOATING
C1333 a_10517_1842# VSS 0.87619f ; **FLOATING
C1334 a_9953_1842# VSS 0.45997f ; **FLOATING
C1335 a_9323_1842# VSS 0.51043f ; **FLOATING
C1336 a_9757_1842# VSS 0.96954f ; **FLOATING
C1337 a_9193_1842# VSS 0.45843f ; **FLOATING
C1338 a_8563_1842# VSS 0.50902f ; **FLOATING
C1339 a_8997_1842# VSS 0.93322f ; **FLOATING
C1340 a_8433_1842# VSS 0.45994f ; **FLOATING
C1341 a_7803_1842# VSS 0.51137f ; **FLOATING
C1342 a_8237_1842# VSS 0.96549f ; **FLOATING
C1343 a_7673_1842# VSS 0.46292f ; **FLOATING
C1344 a_7043_1842# VSS 0.50904f ; **FLOATING
C1345 a_7477_1842# VSS 0.87619f ; **FLOATING
C1346 a_6913_1842# VSS 0.45997f ; **FLOATING
C1347 a_6283_1842# VSS 0.51043f ; **FLOATING
C1348 a_6717_1842# VSS 0.96895f ; **FLOATING
C1349 a_6153_1842# VSS 0.45843f ; **FLOATING
C1350 a_5523_1842# VSS 0.50902f ; **FLOATING
C1351 a_5957_1842# VSS 0.93322f ; **FLOATING
C1352 a_5393_1842# VSS 0.45994f ; **FLOATING
C1353 a_4763_1842# VSS 0.51133f ; **FLOATING
C1354 a_5197_1842# VSS 0.96549f ; **FLOATING
C1355 a_4633_1842# VSS 0.4629f ; **FLOATING
C1356 a_4003_1842# VSS 0.58899f ; **FLOATING
C1357 a_4437_1842# VSS 0.87666f ; **FLOATING
C1358 a_2019_1047.t2 VSS 0.93017f ; **FLOATING
C1359 a_2019_1047.t3 VSS 0.70616f ; **FLOATING
C1360 a_2019_1047.n0 VSS 5.0083f ; **FLOATING
C1361 a_2019_1047.t4 VSS 0.70616f ; **FLOATING
C1362 a_2019_1047.n1 VSS 3.38825f ; **FLOATING
C1363 a_2019_1047.t5 VSS 0.70616f ; **FLOATING
C1364 a_2019_1047.n2 VSS 3.38825f ; **FLOATING
C1365 a_2019_1047.t6 VSS 0.70616f ; **FLOATING
C1366 a_2019_1047.n3 VSS 3.38825f ; **FLOATING
C1367 a_2019_1047.t7 VSS 0.70616f ; **FLOATING
C1368 a_2019_1047.n4 VSS 3.38825f ; **FLOATING
C1369 a_2019_1047.t8 VSS 0.70616f ; **FLOATING
C1370 a_2019_1047.n5 VSS 3.38825f ; **FLOATING
C1371 a_2019_1047.t9 VSS 5.45426f ; **FLOATING
C1372 a_2019_1047.t1 VSS 1.07246f ; **FLOATING
C1373 a_2019_1047.t0 VSS 0.30482f ; **FLOATING
C1374 a_2595_1047.t2 VSS 1.36702f ; **FLOATING
C1375 a_2595_1047.t3 VSS 1.02093f ; **FLOATING
C1376 a_2595_1047.n0 VSS 7.7612f ; **FLOATING
C1377 a_2595_1047.t4 VSS 1.02093f ; **FLOATING
C1378 a_2595_1047.n1 VSS 5.27337f ; **FLOATING
C1379 a_2595_1047.t5 VSS 1.02093f ; **FLOATING
C1380 a_2595_1047.n2 VSS 5.27337f ; **FLOATING
C1381 a_2595_1047.t6 VSS 1.02093f ; **FLOATING
C1382 a_2595_1047.n3 VSS 5.27337f ; **FLOATING
C1383 a_2595_1047.t7 VSS 1.02093f ; **FLOATING
C1384 a_2595_1047.n4 VSS 5.27337f ; **FLOATING
C1385 a_2595_1047.t8 VSS 1.02093f ; **FLOATING
C1386 a_2595_1047.n5 VSS 5.27337f ; **FLOATING
C1387 a_2595_1047.t9 VSS 1.02093f ; **FLOATING
C1388 a_2595_1047.n6 VSS 7.58543f ; **FLOATING
C1389 a_2595_1047.t1 VSS 1.75118f ; **FLOATING
C1390 a_2595_1047.t0 VSS 0.48227f ; **FLOATING
C1391 a_3171_1047.t2 VSS 1.38442f ; **FLOATING
C1392 a_3171_1047.t3 VSS 1.03733f ; **FLOATING
C1393 a_3171_1047.n0 VSS 7.77854f ; **FLOATING
C1394 a_3171_1047.t4 VSS 1.03733f ; **FLOATING
C1395 a_3171_1047.n1 VSS 5.28082f ; **FLOATING
C1396 a_3171_1047.t5 VSS 1.03733f ; **FLOATING
C1397 a_3171_1047.n2 VSS 5.28082f ; **FLOATING
C1398 a_3171_1047.t6 VSS 1.03733f ; **FLOATING
C1399 a_3171_1047.n3 VSS 5.28082f ; **FLOATING
C1400 a_3171_1047.t7 VSS 1.03733f ; **FLOATING
C1401 a_3171_1047.n4 VSS 5.28082f ; **FLOATING
C1402 a_3171_1047.t8 VSS 1.03733f ; **FLOATING
C1403 a_3171_1047.n5 VSS 5.28082f ; **FLOATING
C1404 a_3171_1047.t9 VSS 1.03733f ; **FLOATING
C1405 a_3171_1047.n6 VSS 7.68345f ; **FLOATING
C1406 a_3171_1047.t1 VSS 1.77026f ; **FLOATING
C1407 a_3171_1047.t0 VSS 0.48084f ; **FLOATING
C1408 a_3747_1047.t2 VSS 0.96886f ; **FLOATING
C1409 a_3747_1047.t3 VSS 0.73761f ; **FLOATING
C1410 a_3747_1047.n0 VSS 5.16753f ; **FLOATING
C1411 a_3747_1047.t4 VSS 0.73761f ; **FLOATING
C1412 a_3747_1047.n1 VSS 3.49318f ; **FLOATING
C1413 a_3747_1047.t5 VSS 0.73761f ; **FLOATING
C1414 a_3747_1047.n2 VSS 3.49318f ; **FLOATING
C1415 a_3747_1047.t6 VSS 0.73761f ; **FLOATING
C1416 a_3747_1047.n3 VSS 3.49318f ; **FLOATING
C1417 a_3747_1047.t7 VSS 0.73761f ; **FLOATING
C1418 a_3747_1047.n4 VSS 3.49318f ; **FLOATING
C1419 a_3747_1047.t8 VSS 0.73761f ; **FLOATING
C1420 a_3747_1047.n5 VSS 3.49318f ; **FLOATING
C1421 a_3747_1047.t9 VSS 0.73761f ; **FLOATING
C1422 a_3747_1047.n6 VSS 5.18696f ; **FLOATING
C1423 a_3747_1047.t1 VSS 1.18537f ; **FLOATING
C1424 a_3747_1047.t0 VSS 0.31338f ; **FLOATING
C1425 a_2595_311.t1 VSS 3.27037f ; **FLOATING
C1426 a_2595_311.t2 VSS 5.04145f ; **FLOATING
C1427 a_2595_311.t3 VSS 1.20632f ; **FLOATING
C1428 a_2595_311.n0 VSS 26.8668f ; **FLOATING
C1429 a_2595_311.t0 VSS 0.49572f ; **FLOATING
C1430 a_3171_311.t2 VSS 5.05009f ; **FLOATING
C1431 a_3171_311.t3 VSS 1.21149f ; **FLOATING
C1432 a_3171_311.n0 VSS 29.8499f ; **FLOATING
C1433 a_3171_311.t1 VSS 4.61154f ; **FLOATING
C1434 a_3171_311.t0 VSS 0.4973f ; **FLOATING
C1435 a_3747_311.t2 VSS 3.09203f ; **FLOATING
C1436 a_3747_311.t3 VSS 0.74422f ; **FLOATING
C1437 a_3747_311.n0 VSS 19.8885f ; **FLOATING
C1438 a_3747_311.t1 VSS 3.68893f ; **FLOATING
C1439 a_3747_311.t0 VSS 0.30537f ; **FLOATING
C1440 DELAY_VBIASP.n0 VSS 0.14465f ; **FLOATING
C1441 DELAY_VBIASP.t31 VSS 0.37042f ; **FLOATING
C1442 DELAY_VBIASP.t30 VSS 0.36213f ; **FLOATING
C1443 DELAY_VBIASP.n1 VSS 0.64895f ; **FLOATING
C1444 DELAY_VBIASP.t29 VSS 0.36213f ; **FLOATING
C1445 DELAY_VBIASP.n2 VSS 0.44908f ; **FLOATING
C1446 DELAY_VBIASP.t28 VSS 0.36213f ; **FLOATING
C1447 DELAY_VBIASP.n3 VSS 0.44908f ; **FLOATING
C1448 DELAY_VBIASP.t27 VSS 0.36213f ; **FLOATING
C1449 DELAY_VBIASP.n4 VSS 0.44908f ; **FLOATING
C1450 DELAY_VBIASP.t26 VSS 0.36213f ; **FLOATING
C1451 DELAY_VBIASP.n5 VSS 0.44908f ; **FLOATING
C1452 DELAY_VBIASP.t25 VSS 0.36213f ; **FLOATING
C1453 DELAY_VBIASP.n6 VSS 0.44908f ; **FLOATING
C1454 DELAY_VBIASP.t24 VSS 0.36213f ; **FLOATING
C1455 DELAY_VBIASP.n7 VSS 0.44908f ; **FLOATING
C1456 DELAY_VBIASP.t23 VSS 0.36213f ; **FLOATING
C1457 DELAY_VBIASP.n8 VSS 0.44908f ; **FLOATING
C1458 DELAY_VBIASP.t22 VSS 0.36213f ; **FLOATING
C1459 DELAY_VBIASP.n9 VSS 0.44908f ; **FLOATING
C1460 DELAY_VBIASP.t21 VSS 0.36213f ; **FLOATING
C1461 DELAY_VBIASP.n10 VSS 0.44908f ; **FLOATING
C1462 DELAY_VBIASP.t20 VSS 0.36213f ; **FLOATING
C1463 DELAY_VBIASP.n11 VSS 0.44908f ; **FLOATING
C1464 DELAY_VBIASP.t19 VSS 0.36213f ; **FLOATING
C1465 DELAY_VBIASP.n12 VSS 0.44908f ; **FLOATING
C1466 DELAY_VBIASP.t18 VSS 0.36213f ; **FLOATING
C1467 DELAY_VBIASP.n13 VSS 0.44908f ; **FLOATING
C1468 DELAY_VBIASP.t17 VSS 0.36213f ; **FLOATING
C1469 DELAY_VBIASP.n14 VSS 0.44908f ; **FLOATING
C1470 DELAY_VBIASP.t16 VSS 0.36213f ; **FLOATING
C1471 DELAY_VBIASP.n15 VSS 0.44908f ; **FLOATING
C1472 DELAY_VBIASP.t15 VSS 0.36213f ; **FLOATING
C1473 DELAY_VBIASP.n16 VSS 0.44908f ; **FLOATING
C1474 DELAY_VBIASP.t14 VSS 0.36213f ; **FLOATING
C1475 DELAY_VBIASP.n17 VSS 0.44908f ; **FLOATING
C1476 DELAY_VBIASP.t13 VSS 0.36213f ; **FLOATING
C1477 DELAY_VBIASP.n18 VSS 0.44908f ; **FLOATING
C1478 DELAY_VBIASP.t12 VSS 0.36213f ; **FLOATING
C1479 DELAY_VBIASP.n19 VSS 0.44908f ; **FLOATING
C1480 DELAY_VBIASP.t11 VSS 0.36213f ; **FLOATING
C1481 DELAY_VBIASP.n20 VSS 0.44908f ; **FLOATING
C1482 DELAY_VBIASP.t10 VSS 0.36213f ; **FLOATING
C1483 DELAY_VBIASP.n21 VSS 0.44908f ; **FLOATING
C1484 DELAY_VBIASP.t9 VSS 0.36213f ; **FLOATING
C1485 DELAY_VBIASP.n22 VSS 0.44908f ; **FLOATING
C1486 DELAY_VBIASP.t8 VSS 0.36213f ; **FLOATING
C1487 DELAY_VBIASP.n23 VSS 0.44908f ; **FLOATING
C1488 DELAY_VBIASP.t7 VSS 0.36213f ; **FLOATING
C1489 DELAY_VBIASP.n24 VSS 0.44908f ; **FLOATING
C1490 DELAY_VBIASP.t6 VSS 0.36213f ; **FLOATING
C1491 DELAY_VBIASP.n25 VSS 0.44908f ; **FLOATING
C1492 DELAY_VBIASP.t5 VSS 0.36213f ; **FLOATING
C1493 DELAY_VBIASP.n26 VSS 0.44908f ; **FLOATING
C1494 DELAY_VBIASP.t4 VSS 0.36213f ; **FLOATING
C1495 DELAY_VBIASP.n27 VSS 0.44908f ; **FLOATING
C1496 DELAY_VBIASP.t3 VSS 0.36213f ; **FLOATING
C1497 DELAY_VBIASP.n28 VSS 0.44908f ; **FLOATING
C1498 DELAY_VBIASP.t2 VSS 0.36213f ; **FLOATING
C1499 DELAY_VBIASP.n29 VSS 0.44908f ; **FLOATING
C1500 DELAY_VBIASP.t1 VSS 0.36213f ; **FLOATING
C1501 DELAY_VBIASP.n30 VSS 0.44908f ; **FLOATING
C1502 DELAY_VBIASP.t0 VSS 0.36213f ; **FLOATING
C1503 DELAY_VBIASN.n0 VSS 0.37703f ; **FLOATING
C1504 DELAY_VBIASN.t31 VSS 0.22492f ; **FLOATING
C1505 DELAY_VBIASN.t30 VSS 0.21832f ; **FLOATING
C1506 DELAY_VBIASN.n1 VSS 0.51667f ; **FLOATING
C1507 DELAY_VBIASN.t29 VSS 0.21832f ; **FLOATING
C1508 DELAY_VBIASN.n2 VSS 0.35838f ; **FLOATING
C1509 DELAY_VBIASN.t28 VSS 0.21832f ; **FLOATING
C1510 DELAY_VBIASN.n3 VSS 0.35838f ; **FLOATING
C1511 DELAY_VBIASN.t27 VSS 0.21832f ; **FLOATING
C1512 DELAY_VBIASN.n4 VSS 0.35838f ; **FLOATING
C1513 DELAY_VBIASN.t26 VSS 0.21832f ; **FLOATING
C1514 DELAY_VBIASN.n5 VSS 0.35838f ; **FLOATING
C1515 DELAY_VBIASN.t25 VSS 0.21832f ; **FLOATING
C1516 DELAY_VBIASN.n6 VSS 0.35838f ; **FLOATING
C1517 DELAY_VBIASN.t24 VSS 0.21832f ; **FLOATING
C1518 DELAY_VBIASN.n7 VSS 0.35838f ; **FLOATING
C1519 DELAY_VBIASN.t23 VSS 0.21832f ; **FLOATING
C1520 DELAY_VBIASN.n8 VSS 0.35838f ; **FLOATING
C1521 DELAY_VBIASN.t22 VSS 0.21832f ; **FLOATING
C1522 DELAY_VBIASN.n9 VSS 0.35838f ; **FLOATING
C1523 DELAY_VBIASN.t21 VSS 0.21832f ; **FLOATING
C1524 DELAY_VBIASN.n10 VSS 0.35838f ; **FLOATING
C1525 DELAY_VBIASN.t20 VSS 0.21832f ; **FLOATING
C1526 DELAY_VBIASN.n11 VSS 0.35838f ; **FLOATING
C1527 DELAY_VBIASN.t19 VSS 0.21832f ; **FLOATING
C1528 DELAY_VBIASN.n12 VSS 0.35838f ; **FLOATING
C1529 DELAY_VBIASN.t18 VSS 0.21832f ; **FLOATING
C1530 DELAY_VBIASN.n13 VSS 0.35838f ; **FLOATING
C1531 DELAY_VBIASN.t17 VSS 0.21832f ; **FLOATING
C1532 DELAY_VBIASN.n14 VSS 0.35838f ; **FLOATING
C1533 DELAY_VBIASN.t16 VSS 0.21832f ; **FLOATING
C1534 DELAY_VBIASN.n15 VSS 0.35838f ; **FLOATING
C1535 DELAY_VBIASN.t15 VSS 0.21832f ; **FLOATING
C1536 DELAY_VBIASN.n16 VSS 0.35838f ; **FLOATING
C1537 DELAY_VBIASN.t14 VSS 0.21832f ; **FLOATING
C1538 DELAY_VBIASN.n17 VSS 0.35838f ; **FLOATING
C1539 DELAY_VBIASN.t13 VSS 0.21832f ; **FLOATING
C1540 DELAY_VBIASN.n18 VSS 0.35838f ; **FLOATING
C1541 DELAY_VBIASN.t12 VSS 0.21832f ; **FLOATING
C1542 DELAY_VBIASN.n19 VSS 0.35838f ; **FLOATING
C1543 DELAY_VBIASN.t11 VSS 0.21832f ; **FLOATING
C1544 DELAY_VBIASN.n20 VSS 0.35838f ; **FLOATING
C1545 DELAY_VBIASN.t10 VSS 0.21832f ; **FLOATING
C1546 DELAY_VBIASN.n21 VSS 0.35838f ; **FLOATING
C1547 DELAY_VBIASN.t9 VSS 0.21832f ; **FLOATING
C1548 DELAY_VBIASN.n22 VSS 0.35838f ; **FLOATING
C1549 DELAY_VBIASN.t8 VSS 0.21832f ; **FLOATING
C1550 DELAY_VBIASN.n23 VSS 0.35838f ; **FLOATING
C1551 DELAY_VBIASN.t7 VSS 0.21832f ; **FLOATING
C1552 DELAY_VBIASN.n24 VSS 0.35838f ; **FLOATING
C1553 DELAY_VBIASN.t6 VSS 0.21832f ; **FLOATING
C1554 DELAY_VBIASN.n25 VSS 0.35838f ; **FLOATING
C1555 DELAY_VBIASN.t5 VSS 0.21832f ; **FLOATING
C1556 DELAY_VBIASN.n26 VSS 0.35838f ; **FLOATING
C1557 DELAY_VBIASN.t4 VSS 0.21832f ; **FLOATING
C1558 DELAY_VBIASN.n27 VSS 0.35838f ; **FLOATING
C1559 DELAY_VBIASN.t3 VSS 0.21832f ; **FLOATING
C1560 DELAY_VBIASN.n28 VSS 0.35838f ; **FLOATING
C1561 DELAY_VBIASN.t2 VSS 0.21832f ; **FLOATING
C1562 DELAY_VBIASN.n29 VSS 0.35838f ; **FLOATING
C1563 DELAY_VBIASN.t1 VSS 0.21832f ; **FLOATING
C1564 DELAY_VBIASN.n30 VSS 0.35838f ; **FLOATING
C1565 DELAY_VBIASN.t0 VSS 0.21832f ; **FLOATING
.ends
