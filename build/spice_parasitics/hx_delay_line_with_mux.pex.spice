* NGSPICE file created from hx_delay_line_with_mux.ext - technology: ihp-sg13g2

.subckt hx_delay_line_with_mux VSS VDD DELAY_OUT_LAST DELAY_IN MUX_SEL0 MUX_SEL1 MUX_OUT
+ MUX_SEL4 MUX_SEL2 MUX_SEL3 DELAY_VBIASN DELAY_VBIASP
X0 VDD a_4003_1842# a_4437_1842# VDD sg13_lv_pmos ad=0.2128p pd=1.5u as=0.3808p ps=2.92u w=1.12u l=0.13u
X1 VSS.t219 a_15077_1842# a_15545_1044# VSS.t504 sg13_lv_nmos ad=0.1665p pd=1.19u as=0.2516p ps=2.16u w=0.74u l=0.13u
X2 a_27915_1044# a_27705_1044# VDD VDD sg13_lv_pmos ad=0.2128p pd=1.5u as=0.252p ps=1.57u w=1.12u l=0.13u
X3 VSS.t285 VDD VSS.t283 VSS.t284 sg13_lv_nmos ad=79.8f pd=0.8u as=0 ps=0 w=0.42u l=1u
X4 a_10951_2470# a_10713_1842# a_10843_1842# VDD sg13_lv_pmos ad=0.2128p pd=1.5u as=0.3808p ps=2.92u w=1.12u l=0.2u
X5 VSS.t11 a_3171_1047.t7 a_11924_1008# VSS.t10 sg13_lv_nmos ad=0.2516p pd=2.16u as=0.2516p ps=2.16u w=0.74u l=0.13u
X6 VDD VSS.t572 VDD VDD sg13_lv_pmos ad=0.34p pd=2.68u as=0.30484n ps=1.54979m w=1u l=1u
X7 VSS.t35 a_1256_1044# a_2967_1395# VSS.t34 sg13_lv_nmos ad=0.1331p pd=1.12u as=0.1216p ps=1.02u w=0.64u l=0.13u
X8 VSS.t288 VDD VSS.t287 VSS.t286 sg13_lv_nmos ad=0.1428p pd=1.52u as=0 ps=0 w=0.42u l=1u
X9 a_25153_1842# a_24957_1842# VSS.t529 VSS.t528 sg13_lv_nmos ad=0.2516p pd=2.16u as=0.1406p ps=1.12u w=0.74u l=0.13u
X10 VDD VSS.t586 VDD VDD sg13_lv_pmos ad=0.34p pd=2.68u as=0 ps=0 w=1u l=1u
X11 a_25630_1044# a_2019_1047.t2 a_25528_1044# VSS.t122 sg13_lv_nmos ad=0.2516p pd=2.16u as=0.1406p ps=1.12u w=0.74u l=0.13u
X12 VDD DELAY_VBIASP.t11 a_19311_2470# VDD sg13_lv_pmos ad=0.3808p pd=2.92u as=0.2128p ps=1.5u w=1.12u l=0.6u
X13 a_16108_289# a_2019_311# a_16510_1044# VSS.t174 sg13_lv_nmos ad=0.2516p pd=2.16u as=0.2516p ps=2.16u w=0.74u l=0.13u
X14 VDD DELAY_VBIASP.t24 a_9431_2470# VDD sg13_lv_pmos ad=0.3808p pd=2.92u as=0.2128p ps=1.5u w=1.12u l=0.6u
X15 VSS.t353 VDD VSS.t352 VSS.t351 sg13_lv_nmos ad=0.1428p pd=1.52u as=0 ps=0 w=0.42u l=1u
X16 VDD DELAY_VBIASP.t6 a_23111_2470# VDD sg13_lv_pmos ad=0.3808p pd=2.92u as=0.2128p ps=1.5u w=1.12u l=0.6u
X17 a_7390_1044# a_8231_1008# a_8155_1044# VDD sg13_lv_pmos ad=0.3808p pd=2.92u as=0.2128p ps=1.5u w=1.12u l=0.13u
X18 VSS.t21 a_2595_311.t3 a_8745_519# VSS.t20 sg13_lv_nmos ad=0.2516p pd=2.16u as=0.2516p ps=2.16u w=0.74u l=0.13u
X19 a_17791_1842# a_17553_1842# a_17683_1842# VSS.t192 sg13_lv_nmos ad=0.1406p pd=1.12u as=0.2516p ps=2.16u w=0.74u l=0.2u
X20 VDD a_12037_1842# a_12505_1044# VDD sg13_lv_pmos ad=0.252p pd=1.57u as=0.3808p ps=2.92u w=1.12u l=0.13u
X21 a_16510_1044# a_2019_1047.t5 a_16408_1044# VSS.t94 sg13_lv_nmos ad=0.2516p pd=2.16u as=0.1406p ps=1.12u w=0.74u l=0.13u
X22 a_21591_1842# a_21353_1842# a_21483_1842# VSS.t556 sg13_lv_nmos ad=0.1406p pd=1.12u as=0.2516p ps=2.16u w=0.74u l=0.2u
X23 a_6153_1842# a_5957_1842# VSS.t390 VSS.t389 sg13_lv_nmos ad=0.2516p pd=2.16u as=0.1406p ps=1.12u w=0.74u l=0.13u
X24 VSS.t194 a_16163_1842# a_16597_1842# VSS.t193 sg13_lv_nmos ad=0.1406p pd=1.12u as=0.2516p ps=2.16u w=0.74u l=0.13u
X25 VSS.t99 a_3171_1047.t2 a_27124_1008# VSS.t98 sg13_lv_nmos ad=0.2516p pd=2.16u as=0.2516p ps=2.16u w=0.74u l=0.13u
X26 VDD a_11603_1842# a_12037_1842# VDD sg13_lv_pmos ad=0.2128p pd=1.5u as=0.3808p ps=2.92u w=1.12u l=0.13u
X27 VDD a_3171_311.t3 a_11785_519# VDD sg13_lv_pmos ad=0.3808p pd=2.92u as=0.3808p ps=2.92u w=1.12u l=0.13u
X28 a_24393_1842# a_24197_1842# VDD VDD sg13_lv_pmos ad=0.3808p pd=2.92u as=0.2128p ps=1.5u w=1.12u l=0.13u
X29 a_5731_289# a_2595_311.t3 a_7390_1044# VSS.t19 sg13_lv_nmos ad=0.2516p pd=2.16u as=0.2516p ps=2.16u w=0.74u l=0.13u
X30 a_10430_1044# a_2595_1047.t7 a_11195_1044# VSS.t38 sg13_lv_nmos ad=0.2516p pd=2.16u as=0.1406p ps=1.12u w=0.74u l=0.13u
X31 a_23355_1044# a_23145_1044# VSS.t414 VSS.t543 sg13_lv_nmos ad=0.1406p pd=1.12u as=0.1665p ps=1.19u w=0.74u l=0.13u
X32 VDD DELAY_VBIASP.t17 a_14751_2470# VDD sg13_lv_pmos ad=0.3808p pd=2.92u as=0.2128p ps=1.5u w=1.12u l=0.6u
X33 VSS.t444 DELAY_VBIASN.t23 a_10191_1842# VSS.t443 sg13_lv_nmos ad=0.2516p pd=2.16u as=0.1406p ps=1.12u w=0.74u l=0.6u
X34 VSS.t212 a_3747_1047.t4 a_21911_1008# VSS.t211 sg13_lv_nmos ad=0.2516p pd=2.16u as=0.2516p ps=2.16u w=0.74u l=0.13u
X35 VSS.t200 a_19963_1842# a_20397_1842# VSS.t415 sg13_lv_nmos ad=0.1406p pd=1.12u as=0.2516p ps=2.16u w=0.74u l=0.13u
X36 VDD DELAY_VBIASP.t31 a_4111_2470# VDD sg13_lv_pmos ad=0.3808p pd=2.92u as=0.2128p ps=1.5u w=1.12u l=0.6u
X37 a_10328_1044# a_9757_1842# VDD VDD sg13_lv_pmos ad=0.2128p pd=1.5u as=0.3808p ps=2.92u w=1.12u l=0.13u
X38 a_20968_1044# a_20397_1842# VSS.t198 VSS.t197 sg13_lv_nmos ad=0.1406p pd=1.12u as=0.2516p ps=2.16u w=0.74u l=0.13u
X39 a_22590_1044# a_22564_1008# a_22488_1044# VDD sg13_lv_pmos ad=0.3808p pd=2.92u as=0.2128p ps=1.5u w=1.12u l=0.13u
X40 VDD VSS.t589 VDD VDD sg13_lv_pmos ad=0.19p pd=1.38u as=0 ps=0 w=1u l=1u
X41 a_8808_1044# a_8237_1842# VDD VDD sg13_lv_pmos ad=0.2128p pd=1.5u as=0.3808p ps=2.92u w=1.12u l=0.13u
X42 a_4157_1313# DELAY_IN VDD VDD sg13_lv_pmos ad=0.3808p pd=2.92u as=0.3808p ps=2.92u w=1.12u l=0.13u
X43 a_17031_2470# a_16793_1842# a_16923_1842# VDD sg13_lv_pmos ad=0.2128p pd=1.5u as=0.3808p ps=2.92u w=1.12u l=0.2u
X44 a_11473_1842# a_11277_1842# VSS.t272 VSS.t421 sg13_lv_nmos ad=0.2516p pd=2.16u as=0.1406p ps=1.12u w=0.74u l=0.13u
X45 VSS.t345 VDD VSS.t343 VSS.t344 sg13_lv_nmos ad=79.8f pd=0.8u as=0 ps=0 w=0.42u l=1u
X46 a_19448_1044# a_18877_1842# VSS.t52 VSS.t51 sg13_lv_nmos ad=0.1406p pd=1.12u as=0.2516p ps=2.16u w=0.74u l=0.13u
X47 a_10430_1044# a_3171_1047.t7 a_11848_1044# VSS.t9 sg13_lv_nmos ad=0.2516p pd=2.16u as=0.1406p ps=1.12u w=0.74u l=0.13u
X48 a_20831_2470# a_20593_1842# a_20723_1842# VDD sg13_lv_pmos ad=0.2128p pd=1.5u as=0.3808p ps=2.92u w=1.12u l=0.2u
X49 VSS.t310 VDD VSS.t308 VSS.t309 sg13_lv_nmos ad=79.8f pd=0.8u as=0 ps=0 w=0.42u l=1u
X50 VDD a_27237_1842# a_27705_1044# VDD sg13_lv_pmos ad=0.252p pd=1.57u as=0.3808p ps=2.92u w=1.12u l=0.13u
X51 a_5393_1842# a_5197_1842# VDD VDD sg13_lv_pmos ad=0.3808p pd=2.92u as=0.2128p ps=1.5u w=1.12u l=0.13u
X52 VDD DELAY_VBIASP.t14 a_17031_2470# VDD sg13_lv_pmos ad=0.3808p pd=2.92u as=0.2128p ps=1.5u w=1.12u l=0.6u
X53 VDD a_26803_1842# a_27237_1842# VDD sg13_lv_pmos ad=0.2128p pd=1.5u as=0.3808p ps=2.92u w=1.12u l=0.13u
X54 VDD MUX_SEL1 a_3449_1395# VDD sg13_lv_pmos ad=0.1918p pd=1.5u as=0.1596p ps=1.22u w=0.84u l=0.13u
X55 a_25630_1044# a_2595_1047.t2 a_26395_1044# VSS.t100 sg13_lv_nmos ad=0.2516p pd=2.16u as=0.1406p ps=1.12u w=0.74u l=0.13u
X56 VSS.t448 DELAY_VBIASN.t3 a_25391_1842# VSS.t447 sg13_lv_nmos ad=0.2516p pd=2.16u as=0.1406p ps=1.12u w=0.74u l=0.6u
X57 a_6635_1044# a_6425_1044# VDD VDD sg13_lv_pmos ad=0.2128p pd=1.5u as=0.252p ps=1.57u w=1.12u l=0.13u
X58 a_20315_1044# a_20105_1044# VDD VDD sg13_lv_pmos ad=0.2128p pd=1.5u as=0.252p ps=1.57u w=1.12u l=0.13u
X59 VDD a_2595_1047.t9 a_5191_1008# VDD sg13_lv_pmos ad=0.3808p pd=2.92u as=0.3808p ps=2.92u w=1.12u l=0.13u
X60 a_19311_2470# a_19073_1842# a_19203_1842# VDD sg13_lv_pmos ad=0.2128p pd=1.5u as=0.3808p ps=2.92u w=1.12u l=0.2u
X61 VSS.t32 a_1721_1395# a_2019_1047.t1 VSS.t31 sg13_lv_nmos ad=0.2812p pd=2.24u as=0.1406p ps=1.12u w=0.74u l=0.13u
X62 a_25528_1044# a_24957_1842# VDD VDD sg13_lv_pmos ad=0.2128p pd=1.5u as=0.3808p ps=2.92u w=1.12u l=0.13u
X63 VSS.t141 a_5957_1842# a_6425_1044# VSS.t388 sg13_lv_nmos ad=0.1665p pd=1.19u as=0.2516p ps=2.16u w=0.74u l=0.13u
X64 VSS.t244 a_2019_1047.t6 a_13444_1008# VSS.t243 sg13_lv_nmos ad=0.2516p pd=2.16u as=0.2516p ps=2.16u w=0.74u l=0.13u
X65 a_23111_2470# a_22873_1842# a_23003_1842# VDD sg13_lv_pmos ad=0.2128p pd=1.5u as=0.3808p ps=2.92u w=1.12u l=0.2u
X66 VSS.t283 VDD VSS.t282 VSS.t281 sg13_lv_nmos ad=0.1428p pd=1.52u as=0 ps=0 w=0.42u l=1u
X67 VSS.t93 a_15964_289# a_16851_309# VSS.t92 sg13_lv_nmos ad=0.1371p pd=1.12u as=0.2176p ps=1.96u w=0.64u l=0.13u
X68 a_10713_1842# a_10517_1842# VDD VDD sg13_lv_pmos ad=0.3808p pd=2.92u as=0.2128p ps=1.5u w=1.12u l=0.13u
X69 VDD a_17683_1842# a_18117_1842# VDD sg13_lv_pmos ad=0.2128p pd=1.5u as=0.3808p ps=2.92u w=1.12u l=0.13u
X70 a_16108_289# a_17865_519# a_16510_1044# VDD sg13_lv_pmos ad=0.3808p pd=2.92u as=0.3808p ps=2.92u w=1.12u l=0.13u
X71 a_26673_1842# a_26477_1842# VSS.t109 VSS.t108 sg13_lv_nmos ad=0.2516p pd=2.16u as=0.1406p ps=1.12u w=0.74u l=0.13u
X72 VDD a_7803_1842# a_8237_1842# VDD sg13_lv_pmos ad=0.2128p pd=1.5u as=0.3808p ps=2.92u w=1.12u l=0.13u
X73 a_4248_1044# a_4157_1313# VSS.t214 VSS.t213 sg13_lv_nmos ad=0.1406p pd=1.12u as=0.2516p ps=2.16u w=0.74u l=0.13u
X74 a_16108_289# a_3171_311.t2 a_22590_1044# VSS.t248 sg13_lv_nmos ad=0.2516p pd=2.16u as=0.2516p ps=2.16u w=0.74u l=0.13u
X75 VSS.t460 DELAY_VBIASN.t28 a_6391_1842# VSS.t459 sg13_lv_nmos ad=0.2516p pd=2.16u as=0.1406p ps=1.12u w=0.74u l=0.6u
X76 a_16408_1044# a_15837_1842# VDD VDD sg13_lv_pmos ad=0.2128p pd=1.5u as=0.3808p ps=2.92u w=1.12u l=0.13u
X77 a_19550_1044# a_3747_1047.t4 a_21835_1044# VSS.t210 sg13_lv_nmos ad=0.2516p pd=2.16u as=0.1406p ps=1.12u w=0.74u l=0.13u
X78 VSS.t482 DELAY_VBIASN.t9 a_20831_1842# VSS.t481 sg13_lv_nmos ad=0.2516p pd=2.16u as=0.1406p ps=1.12u w=0.74u l=0.6u
X79 a_3171_311.t0 a_2873_331# VDD VDD sg13_lv_pmos ad=0.2128p pd=1.5u as=0.1918p ps=1.5u w=1.12u l=0.13u
X80 a_3747_311.t0 a_3449_331# VDD VDD sg13_lv_pmos ad=0.2128p pd=1.5u as=0.1918p ps=1.5u w=1.12u l=0.13u
X81 a_7390_1044# a_9751_1008# a_9675_1044# VDD sg13_lv_pmos ad=0.3808p pd=2.92u as=0.2128p ps=1.5u w=1.12u l=0.13u
X82 a_10191_1842# a_9953_1842# a_10083_1842# VSS.t411 sg13_lv_nmos ad=0.1406p pd=1.12u as=0.2516p ps=2.16u w=0.74u l=0.2u
X83 VSS.t414 a_22677_1842# a_23145_1044# VSS.t413 sg13_lv_nmos ad=0.1665p pd=1.19u as=0.2516p ps=2.16u w=0.74u l=0.13u
X84 a_14751_2470# a_14513_1842# a_14643_1842# VDD sg13_lv_pmos ad=0.2128p pd=1.5u as=0.3808p ps=2.92u w=1.12u l=0.2u
X85 a_5731_289# a_8745_519# a_7390_1044# VDD sg13_lv_pmos ad=0.3808p pd=2.92u as=0.3808p ps=2.92u w=1.12u l=0.13u
X86 VDD VDD VDD VDD sg13_lv_pmos ad=0.2128p pd=1.5u as=0 ps=0 w=1.12u l=0.13u
X87 a_4111_2470# DELAY_IN a_4003_1842# VDD sg13_lv_pmos ad=0.2128p pd=1.5u as=0.3808p ps=2.92u w=1.12u l=0.2u
X88 a_7673_1842# a_7477_1842# VSS.t508 VSS.t507 sg13_lv_nmos ad=0.2516p pd=2.16u as=0.1406p ps=1.12u w=0.74u l=0.13u
X89 VDD a_3171_1047.t5 a_18004_1008# VDD sg13_lv_pmos ad=0.3808p pd=2.92u as=0.3808p ps=2.92u w=1.12u l=0.13u
X90 VDD a_13123_1842# a_13557_1842# VDD sg13_lv_pmos ad=0.2128p pd=1.5u as=0.3808p ps=2.92u w=1.12u l=0.13u
X91 VDD a_3747_311.t2 a_26985_519# VDD sg13_lv_pmos ad=0.3808p pd=2.92u as=0.3808p ps=2.92u w=1.12u l=0.13u
X92 a_25913_1842# a_25717_1842# VDD VDD sg13_lv_pmos ad=0.3808p pd=2.92u as=0.2128p ps=1.5u w=1.12u l=0.13u
X93 a_10430_1044# a_3747_1047.t7 a_12715_1044# VSS.t137 sg13_lv_nmos ad=0.2516p pd=2.16u as=0.1406p ps=1.12u w=0.74u l=0.13u
X94 a_14235_1044# a_14025_1044# VDD VDD sg13_lv_pmos ad=0.2128p pd=1.5u as=0.252p ps=1.57u w=1.12u l=0.13u
X95 a_24875_1044# a_24665_1044# VSS.t143 VSS.t142 sg13_lv_nmos ad=0.1406p pd=1.12u as=0.1665p ps=1.19u w=0.74u l=0.13u
X96 VSS.t474 DELAY_VBIASN.t21 a_11711_1842# VSS.t473 sg13_lv_nmos ad=0.2516p pd=2.16u as=0.1406p ps=1.12u w=0.74u l=0.6u
X97 VDD a_3747_1047.t7 a_12791_1008# VDD sg13_lv_pmos ad=0.3808p pd=2.92u as=0.3808p ps=2.92u w=1.12u l=0.13u
X98 VSS.t549 a_2595_1047.t3 a_23431_1008# VSS.t548 sg13_lv_nmos ad=0.2516p pd=2.16u as=0.2516p ps=2.16u w=0.74u l=0.13u
X99 VSS.t386 a_21483_1842# a_21917_1842# VSS.t385 sg13_lv_nmos ad=0.1406p pd=1.12u as=0.2516p ps=2.16u w=0.74u l=0.13u
X100 VSS.t119 a_13557_1842# a_14025_1044# VSS.t394 sg13_lv_nmos ad=0.1665p pd=1.19u as=0.2516p ps=2.16u w=0.74u l=0.13u
X101 a_11848_1044# a_11277_1842# VDD VDD sg13_lv_pmos ad=0.2128p pd=1.5u as=0.3808p ps=2.92u w=1.12u l=0.13u
X102 VDD VSS.t565 VDD VDD sg13_lv_pmos ad=0.19p pd=1.38u as=0 ps=0 w=1u l=1u
X103 a_25391_1842# a_25153_1842# a_25283_1842# VSS.t195 sg13_lv_nmos ad=0.1406p pd=1.12u as=0.2516p ps=2.16u w=0.74u l=0.2u
X104 a_12993_1842# a_12797_1842# VSS.t189 VSS.t188 sg13_lv_nmos ad=0.2516p pd=2.16u as=0.1406p ps=1.12u w=0.74u l=0.13u
X105 DELAY_OUT_LAST a_27997_1842# VDD VDD sg13_lv_pmos ad=0.3808p pd=2.92u as=0.2128p ps=1.5u w=1.12u l=0.13u
X106 VDD VSS.t564 VDD VDD sg13_lv_pmos ad=0.34p pd=2.68u as=0 ps=0 w=1u l=1u
X107 VDD a_19637_1842# a_20105_1044# VDD sg13_lv_pmos ad=0.252p pd=1.57u as=0.3808p ps=2.92u w=1.12u l=0.13u
X108 VSS.t478 DELAY_VBIASN.t18 a_13991_1842# VSS.t477 sg13_lv_nmos ad=0.2516p pd=2.16u as=0.1406p ps=1.12u w=0.74u l=0.6u
X109 VSS.t343 VDD VSS.t342 VSS.t341 sg13_lv_nmos ad=0.1428p pd=1.52u as=0 ps=0 w=0.42u l=1u
X110 a_22590_1044# a_3171_1047.t3 a_24008_1044# VSS.t3 sg13_lv_nmos ad=0.2516p pd=2.16u as=0.1406p ps=1.12u w=0.74u l=0.13u
X111 a_6913_1842# a_6717_1842# VDD VDD sg13_lv_pmos ad=0.3808p pd=2.92u as=0.2128p ps=1.5u w=1.12u l=0.13u
X112 VDD DELAY_VBIASP.t12 a_18551_2470# VDD sg13_lv_pmos ad=0.3808p pd=2.92u as=0.2128p ps=1.5u w=1.12u l=0.6u
X113 VSS.t114 a_23763_1842# a_24197_1842# VSS.t113 sg13_lv_nmos ad=0.1406p pd=1.12u as=0.2516p ps=2.16u w=0.74u l=0.13u
X114 VSS.t308 VDD VSS.t307 VSS.t306 sg13_lv_nmos ad=0.1428p pd=1.52u as=0 ps=0 w=0.42u l=1u
X115 VDD a_1256_1044# a_2873_1395# VDD sg13_lv_pmos ad=0.1918p pd=1.5u as=0.1596p ps=1.22u w=0.84u l=0.13u
X116 a_3171_311.t1 a_2873_331# VSS.t47 VSS.t168 sg13_lv_nmos ad=0.1406p pd=1.12u as=0.1331p ps=1.12u w=0.74u l=0.13u
X117 VDD a_2873_331# a_3171_311.t0 VDD sg13_lv_pmos ad=0.4256p pd=3u as=0.2128p ps=1.5u w=1.12u l=0.13u
X118 a_16510_1044# a_17351_1008# a_17275_1044# VDD sg13_lv_pmos ad=0.3808p pd=2.92u as=0.2128p ps=1.5u w=1.12u l=0.13u
X119 a_25630_1044# a_3747_1047.t2 a_27915_1044# VSS.t134 sg13_lv_nmos ad=0.2516p pd=2.16u as=0.1406p ps=1.12u w=0.74u l=0.13u
X120 VSS.t452 DELAY_VBIASN.t1 a_26911_1842# VSS.t451 sg13_lv_nmos ad=0.2516p pd=2.16u as=0.1406p ps=1.12u w=0.74u l=0.6u
X121 a_3747_311.t1 a_3449_331# VSS.t66 VSS.t65 sg13_lv_nmos ad=0.1406p pd=1.12u as=0.1331p ps=1.12u w=0.74u l=0.13u
X122 VDD a_3449_331# a_3747_311.t0 VDD sg13_lv_pmos ad=0.4256p pd=3u as=0.2128p ps=1.5u w=1.12u l=0.13u
X123 VDD DELAY_VBIASP.t7 a_22351_2470# VDD sg13_lv_pmos ad=0.3808p pd=2.92u as=0.2128p ps=1.5u w=1.12u l=0.6u
X124 VDD a_3747_1047.t2 a_27991_1008# VDD sg13_lv_pmos ad=0.3808p pd=2.92u as=0.3808p ps=2.92u w=1.12u l=0.13u
X125 VDD VSS.t597 VDD VDD sg13_lv_pmos ad=0.19p pd=1.38u as=0 ps=0 w=1u l=1u
X126 VDD a_3747_1047.t9 a_6711_1008# VDD sg13_lv_pmos ad=0.3808p pd=2.92u as=0.3808p ps=2.92u w=1.12u l=0.13u
X127 a_6391_1842# a_6153_1842# a_6283_1842# VSS.t501 sg13_lv_nmos ad=0.1406p pd=1.12u as=0.2516p ps=2.16u w=0.74u l=0.2u
X128 a_15273_1842# a_15077_1842# VSS.t425 VSS.t503 sg13_lv_nmos ad=0.2516p pd=2.16u as=0.1406p ps=1.12u w=0.74u l=0.13u
X129 a_19833_1842# a_19637_1842# VDD VDD sg13_lv_pmos ad=0.3808p pd=2.92u as=0.2128p ps=1.5u w=1.12u l=0.13u
X130 a_16108_289# a_23945_519# a_22590_1044# VDD sg13_lv_pmos ad=0.3808p pd=2.92u as=0.3808p ps=2.92u w=1.12u l=0.13u
X131 a_9193_1842# a_8997_1842# VDD VDD sg13_lv_pmos ad=0.3808p pd=2.92u as=0.2128p ps=1.5u w=1.12u l=0.13u
X132 a_24631_2470# a_24393_1842# a_24523_1842# VDD sg13_lv_pmos ad=0.2128p pd=1.5u as=0.3808p ps=2.92u w=1.12u l=0.2u
X133 VSS.t60 a_15403_1842# a_15837_1842# VSS.t107 sg13_lv_nmos ad=0.1406p pd=1.12u as=0.2516p ps=2.16u w=0.74u l=0.13u
X134 a_8155_1044# a_7945_1044# VSS.t64 VSS.t63 sg13_lv_nmos ad=0.1406p pd=1.12u as=0.1665p ps=1.19u w=0.74u l=0.13u
X135 a_23633_1842# a_23437_1842# VDD VDD sg13_lv_pmos ad=0.3808p pd=2.92u as=0.2128p ps=1.5u w=1.12u l=0.13u
X136 VSS.t264 a_4763_1842# a_5197_1842# VSS.t275 sg13_lv_nmos ad=0.1406p pd=1.12u as=0.2516p ps=2.16u w=0.74u l=0.13u
X137 a_27048_1044# a_26477_1842# VSS.t111 VSS.t110 sg13_lv_nmos ad=0.1406p pd=1.12u as=0.2516p ps=2.16u w=0.74u l=0.13u
X138 VDD a_9323_1842# a_9757_1842# VDD sg13_lv_pmos ad=0.2128p pd=1.5u as=0.3808p ps=2.92u w=1.12u l=0.13u
X139 a_5768_1044# a_5197_1842# VSS.t266 VSS.t265 sg13_lv_nmos ad=0.1406p pd=1.12u as=0.2516p ps=2.16u w=0.74u l=0.13u
X140 a_7390_1044# a_7364_1008# a_7288_1044# VDD sg13_lv_pmos ad=0.3808p pd=2.92u as=0.2128p ps=1.5u w=1.12u l=0.13u
X141 VSS.t468 DELAY_VBIASN.t26 a_7911_1842# VSS.t467 sg13_lv_nmos ad=0.2516p pd=2.16u as=0.1406p ps=1.12u w=0.74u l=0.6u
X142 VDD VSS.t581 VDD VDD sg13_lv_pmos ad=0.19p pd=1.38u as=0 ps=0 w=1u l=1u
X143 a_11711_1842# a_11473_1842# a_11603_1842# VSS.t160 sg13_lv_nmos ad=0.1406p pd=1.12u as=0.2516p ps=2.16u w=0.74u l=0.2u
X144 VSS.t143 a_24197_1842# a_24665_1044# VSS.t201 sg13_lv_nmos ad=0.1665p pd=1.19u as=0.2516p ps=2.16u w=0.74u l=0.13u
X145 a_16510_1044# a_3171_1047.t5 a_17928_1044# VSS.t70 sg13_lv_nmos ad=0.2516p pd=2.16u as=0.1406p ps=1.12u w=0.74u l=0.13u
X146 VSS.t300 VDD VSS.t298 VSS.t299 sg13_lv_nmos ad=79.8f pd=0.8u as=0 ps=0 w=0.42u l=1u
X147 a_5631_2470# a_5393_1842# a_5523_1842# VDD sg13_lv_pmos ad=0.2128p pd=1.5u as=0.3808p ps=2.92u w=1.12u l=0.2u
X148 a_14513_1842# a_14317_1842# VDD VDD sg13_lv_pmos ad=0.3808p pd=2.92u as=0.2128p ps=1.5u w=1.12u l=0.13u
X149 a_4633_1842# a_4437_1842# VDD VDD sg13_lv_pmos ad=0.3808p pd=2.92u as=0.2128p ps=1.5u w=1.12u l=0.13u
X150 VSS.t393 a_10083_1842# a_10517_1842# VSS.t420 sg13_lv_nmos ad=0.1406p pd=1.12u as=0.2516p ps=2.16u w=0.74u l=0.13u
X151 VDD a_2019_1047.t4 a_19524_1008# VDD sg13_lv_pmos ad=0.3808p pd=2.92u as=0.3808p ps=2.92u w=1.12u l=0.13u
X152 VSS.t18 a_3171_1047.t4 a_21044_1008# VSS.t17 sg13_lv_nmos ad=0.2516p pd=2.16u as=0.2516p ps=2.16u w=0.74u l=0.13u
X153 VSS.t170 a_2873_331# a_3171_311.t1 VSS.t169 sg13_lv_nmos ad=0.2812p pd=2.24u as=0.1406p ps=1.12u w=0.74u l=0.13u
X154 VSS.t68 a_3449_331# a_3747_311.t1 VSS.t67 sg13_lv_nmos ad=0.2812p pd=2.24u as=0.1406p ps=1.12u w=0.74u l=0.13u
X155 a_15755_1044# a_15545_1044# VDD VDD sg13_lv_pmos ad=0.2128p pd=1.5u as=0.252p ps=1.57u w=1.12u l=0.13u
X156 VDD a_2595_1047.t6 a_14311_1008# VDD sg13_lv_pmos ad=0.3808p pd=2.92u as=0.3808p ps=2.92u w=1.12u l=0.13u
X157 VSS.t498 DELAY_VBIASN.t4 a_24631_1842# VSS.t497 sg13_lv_nmos ad=0.2516p pd=2.16u as=0.1406p ps=1.12u w=0.74u l=0.6u
X158 a_5115_1044# a_4905_1044# VDD VDD sg13_lv_pmos ad=0.2128p pd=1.5u as=0.252p ps=1.57u w=1.12u l=0.13u
X159 a_18551_2470# a_18313_1842# a_18443_1842# VDD sg13_lv_pmos ad=0.2128p pd=1.5u as=0.3808p ps=2.92u w=1.12u l=0.2u
X160 VDD VSS.t573 VDD VDD sg13_lv_pmos ad=0.19p pd=1.38u as=0 ps=0 w=1u l=1u
X161 a_3171_1047.t1 a_2873_1395# VSS.t35 VSS.t215 sg13_lv_nmos ad=0.1406p pd=1.12u as=0.1331p ps=1.12u w=0.74u l=0.13u
X162 VSS.t28 a_2297_1395# a_2595_1047.t1 VSS.t27 sg13_lv_nmos ad=0.2812p pd=2.24u as=0.1406p ps=1.12u w=0.74u l=0.13u
X163 a_22351_2470# a_22113_1842# a_22243_1842# VDD sg13_lv_pmos ad=0.2128p pd=1.5u as=0.3808p ps=2.92u w=1.12u l=0.2u
X164 VSS.t370 VSS.t367 VSS.t369 VSS.t368 sg13_lv_nmos ad=0.2516p pd=2.16u as=0 ps=0 w=0.74u l=0.13u
X165 a_26911_1842# a_26673_1842# a_26803_1842# VSS.t69 sg13_lv_nmos ad=0.1406p pd=1.12u as=0.2516p ps=2.16u w=0.74u l=0.2u
X166 VSS.t238 a_3171_311.t3 a_11785_519# VSS.t237 sg13_lv_nmos ad=0.2516p pd=2.16u as=0.2516p ps=2.16u w=0.74u l=0.13u
X167 VDD a_1721_1395# a_2019_1047.t0 VDD sg13_lv_pmos ad=0.4256p pd=3u as=0.2128p ps=1.5u w=1.12u l=0.13u
X168 VDD a_16923_1842# a_17357_1842# VDD sg13_lv_pmos ad=0.2128p pd=1.5u as=0.3808p ps=2.92u w=1.12u l=0.13u
X169 a_2391_1395# MUX_SEL0 a_2297_1395# VSS.t516 sg13_lv_nmos ad=0.1216p pd=1.02u as=0.2176p ps=1.96u w=0.64u l=0.13u
X170 VSS.t30 a_1544_1044# a_1815_1395# VSS.t542 sg13_lv_nmos ad=0.1331p pd=1.12u as=0.1216p ps=1.02u w=0.64u l=0.13u
X171 a_13368_1044# a_12797_1842# VSS.t191 VSS.t190 sg13_lv_nmos ad=0.1406p pd=1.12u as=0.2516p ps=2.16u w=0.74u l=0.13u
X172 a_5731_289# a_3171_311.t3 a_10430_1044# VSS.t236 sg13_lv_nmos ad=0.2516p pd=2.16u as=0.2516p ps=2.16u w=0.74u l=0.13u
X173 VDD a_21157_1842# a_21625_1044# VDD sg13_lv_pmos ad=0.252p pd=1.57u as=0.3808p ps=2.92u w=1.12u l=0.13u
X174 VDD DELAY_VBIASP.t22 a_10951_2470# VDD sg13_lv_pmos ad=0.3808p pd=2.92u as=0.2128p ps=1.5u w=1.12u l=0.6u
X175 VSS.t480 DELAY_VBIASN.t16 a_15511_1842# VSS.t479 sg13_lv_nmos ad=0.2516p pd=2.16u as=0.1406p ps=1.12u w=0.74u l=0.6u
X176 VDD a_20723_1842# a_21157_1842# VDD sg13_lv_pmos ad=0.2128p pd=1.5u as=0.3808p ps=2.92u w=1.12u l=0.13u
X177 VSS.t13 a_25283_1842# a_25717_1842# VSS.t12 sg13_lv_nmos ad=0.1406p pd=1.12u as=0.2516p ps=2.16u w=0.74u l=0.13u
X178 a_4350_1044# a_3747_1047.t9 a_6635_1044# VSS.t115 sg13_lv_nmos ad=0.2516p pd=2.16u as=0.1406p ps=1.12u w=0.74u l=0.13u
X179 VSS.t442 DELAY_VBIASN.t29 a_5631_1842# VSS.t441 sg13_lv_nmos ad=0.2516p pd=2.16u as=0.1406p ps=1.12u w=0.74u l=0.6u
X180 VDD a_2019_1047.t9 a_4324_1008# VDD sg13_lv_pmos ad=0.3808p pd=2.92u as=0.3808p ps=2.92u w=1.12u l=0.13u
X181 a_16510_1044# a_18871_1008# a_18795_1044# VDD sg13_lv_pmos ad=0.3808p pd=2.92u as=0.2128p ps=1.5u w=1.12u l=0.13u
X182 a_19550_1044# a_2595_1047.t4 a_20315_1044# VSS.t22 sg13_lv_nmos ad=0.2516p pd=2.16u as=0.1406p ps=1.12u w=0.74u l=0.13u
X183 VDD DELAY_VBIASP.t5 a_23871_2470# VDD sg13_lv_pmos ad=0.3808p pd=2.92u as=0.2128p ps=1.5u w=1.12u l=0.6u
X184 VSS.t64 a_7477_1842# a_7945_1044# VSS.t506 sg13_lv_nmos ad=0.1665p pd=1.19u as=0.2516p ps=2.16u w=0.74u l=0.13u
X185 a_13231_2470# a_12993_1842# a_13123_1842# VDD sg13_lv_pmos ad=0.2128p pd=1.5u as=0.3808p ps=2.92u w=1.12u l=0.2u
X186 VDD VSS.t598 VDD VDD sg13_lv_pmos ad=0.34p pd=2.68u as=0 ps=0 w=1u l=1u
X187 a_12233_1842# a_12037_1842# VDD VDD sg13_lv_pmos ad=0.3808p pd=2.92u as=0.2128p ps=1.5u w=1.12u l=0.13u
X188 a_7911_1842# a_7673_1842# a_7803_1842# VSS.t401 sg13_lv_nmos ad=0.1406p pd=1.12u as=0.2516p ps=2.16u w=0.74u l=0.2u
X189 a_16793_1842# a_16597_1842# VSS.t194 VSS.t435 sg13_lv_nmos ad=0.2516p pd=2.16u as=0.1406p ps=1.12u w=0.74u l=0.13u
X190 VDD a_3747_311.t3 a_14825_519# VDD sg13_lv_pmos ad=0.3808p pd=2.92u as=0.3808p ps=2.92u w=1.12u l=0.13u
X191 VSS.t62 a_27563_1842# a_27997_1842# VSS.t560 sg13_lv_nmos ad=0.1406p pd=1.12u as=0.2516p ps=2.16u w=0.74u l=0.13u
X192 a_9675_1044# a_9465_1044# VSS.t78 VSS.t77 sg13_lv_nmos ad=0.1406p pd=1.12u as=0.1665p ps=1.19u w=0.74u l=0.13u
X193 a_20593_1842# a_20397_1842# VSS.t200 VSS.t199 sg13_lv_nmos ad=0.2516p pd=2.16u as=0.1406p ps=1.12u w=0.74u l=0.13u
X194 VSS.t133 a_2595_1047.t8 a_8231_1008# VSS.t132 sg13_lv_nmos ad=0.2516p pd=2.16u as=0.2516p ps=2.16u w=0.74u l=0.13u
X195 VSS.t511 a_6283_1842# a_6717_1842# VSS.t530 sg13_lv_nmos ad=0.1406p pd=1.12u as=0.2516p ps=2.16u w=0.74u l=0.13u
X196 a_10430_1044# a_10404_1008# a_10328_1044# VDD sg13_lv_pmos ad=0.3808p pd=2.92u as=0.2128p ps=1.5u w=1.12u l=0.13u
X197 VDD DELAY_VBIASP.t2 a_26151_2470# VDD sg13_lv_pmos ad=0.3808p pd=2.92u as=0.2128p ps=1.5u w=1.12u l=0.6u
X198 a_7390_1044# a_8884_1008# a_8808_1044# VDD sg13_lv_pmos ad=0.3808p pd=2.92u as=0.2128p ps=1.5u w=1.12u l=0.13u
X199 VDD DELAY_VBIASP.t30 a_4871_2470# VDD sg13_lv_pmos ad=0.3808p pd=2.92u as=0.2128p ps=1.5u w=1.12u l=0.6u
X200 a_3449_331# MUX_SEL2 VDD VDD sg13_lv_pmos ad=0.1596p pd=1.22u as=0.2856p ps=2.36u w=0.84u l=0.13u
X201 VDD VSS.t575 VDD VDD sg13_lv_pmos ad=0.19p pd=1.38u as=0 ps=0 w=1u l=1u
X202 a_19073_1842# a_18877_1842# VSS.t49 VSS.t50 sg13_lv_nmos ad=0.2516p pd=2.16u as=0.1406p ps=1.12u w=0.74u l=0.13u
X203 VDD a_15077_1842# a_15545_1044# VDD sg13_lv_pmos ad=0.252p pd=1.57u as=0.3808p ps=2.92u w=1.12u l=0.13u
X204 a_19550_1044# a_2019_1047.t4 a_19448_1044# VSS.t83 sg13_lv_nmos ad=0.2516p pd=2.16u as=0.1406p ps=1.12u w=0.74u l=0.13u
X205 VDD VDD VDD VDD sg13_lv_pmos ad=0.3808p pd=2.92u as=0 ps=0 w=1.12u l=0.6u
X206 VSS.t360 VDD VSS.t358 VSS.t359 sg13_lv_nmos ad=79.8f pd=0.8u as=0 ps=0 w=0.42u l=1u
X207 VSS.t56 a_19203_1842# a_19637_1842# VSS.t537 sg13_lv_nmos ad=0.1406p pd=1.12u as=0.2516p ps=2.16u w=0.74u l=0.13u
X208 VDD VSS.t577 VDD VDD sg13_lv_pmos ad=0.19p pd=1.38u as=0 ps=0 w=1u l=1u
X209 VDD VSS.t588 VDD VDD sg13_lv_pmos ad=0.34p pd=2.68u as=0 ps=0 w=1u l=1u
X210 a_27433_1842# a_27237_1842# VDD VDD sg13_lv_pmos ad=0.3808p pd=2.92u as=0.2128p ps=1.5u w=1.12u l=0.13u
X211 VDD a_1256_289# a_2873_331# VDD sg13_lv_pmos ad=0.1918p pd=1.5u as=0.1596p ps=1.22u w=0.84u l=0.13u
X212 a_13470_1044# a_2595_1047.t6 a_14235_1044# VSS.t254 sg13_lv_nmos ad=0.2516p pd=2.16u as=0.1406p ps=1.12u w=0.74u l=0.13u
X213 VSS.t15 a_8563_1842# a_8997_1842# VSS.t14 sg13_lv_nmos ad=0.1406p pd=1.12u as=0.2516p ps=2.16u w=0.74u l=0.13u
X214 VSS.t476 DELAY_VBIASN.t19 a_13231_1842# VSS.t475 sg13_lv_nmos ad=0.2516p pd=2.16u as=0.1406p ps=1.12u w=0.74u l=0.6u
X215 VDD a_3171_1047.t7 a_11924_1008# VDD sg13_lv_pmos ad=0.3808p pd=2.92u as=0.3808p ps=2.92u w=1.12u l=0.13u
X216 VSS.t247 a_2019_1047.t3 a_22564_1008# VSS.t246 sg13_lv_nmos ad=0.2516p pd=2.16u as=0.2516p ps=2.16u w=0.74u l=0.13u
X217 VSS.t419 a_23003_1842# a_23437_1842# VSS.t538 sg13_lv_nmos ad=0.1406p pd=1.12u as=0.2516p ps=2.16u w=0.74u l=0.13u
X218 VSS.t363 VDD VSS.t362 VSS.t361 sg13_lv_nmos ad=0.1428p pd=1.52u as=0 ps=0 w=0.42u l=1u
X219 VDD DELAY_VBIASP.t27 a_7151_2470# VDD sg13_lv_pmos ad=0.3808p pd=2.92u as=0.2128p ps=1.5u w=1.12u l=0.6u
X220 a_25630_1044# a_25604_1008# a_25528_1044# VDD sg13_lv_pmos ad=0.3808p pd=2.92u as=0.2128p ps=1.5u w=1.12u l=0.13u
X221 a_15511_1842# a_15273_1842# a_15403_1842# VSS.t112 sg13_lv_nmos ad=0.1406p pd=1.12u as=0.2516p ps=2.16u w=0.74u l=0.2u
X222 a_18313_1842# a_18117_1842# VDD VDD sg13_lv_pmos ad=0.3808p pd=2.92u as=0.2128p ps=1.5u w=1.12u l=0.13u
X223 a_5731_289# a_11785_519# a_10430_1044# VDD sg13_lv_pmos ad=0.3808p pd=2.92u as=0.3808p ps=2.92u w=1.12u l=0.13u
X224 VSS.t280 VDD VSS.t278 VSS.t279 sg13_lv_nmos ad=79.8f pd=0.8u as=0 ps=0 w=0.42u l=1u
X225 a_9431_2470# a_9193_1842# a_9323_1842# VDD sg13_lv_pmos ad=0.2128p pd=1.5u as=0.3808p ps=2.92u w=1.12u l=0.2u
X226 a_17275_1044# a_17065_1044# VSS.t223 VSS.t222 sg13_lv_nmos ad=0.1406p pd=1.12u as=0.1665p ps=1.19u w=0.74u l=0.13u
X227 VDD VSS.t574 VDD VDD sg13_lv_pmos ad=0.34p pd=2.68u as=0 ps=0 w=1u l=1u
X228 VSS.t241 a_3747_1047.t6 a_15831_1008# VSS.t240 sg13_lv_nmos ad=0.2516p pd=2.16u as=0.2516p ps=2.16u w=0.74u l=0.13u
X229 a_23871_2470# a_23633_1842# a_23763_1842# VDD sg13_lv_pmos ad=0.2128p pd=1.5u as=0.3808p ps=2.92u w=1.12u l=0.2u
X230 VSS.t185 a_13883_1842# a_14317_1842# VSS.t558 sg13_lv_nmos ad=0.1406p pd=1.12u as=0.2516p ps=2.16u w=0.74u l=0.13u
X231 VSS.t91 a_3747_311.t2 a_26985_519# VSS.t90 sg13_lv_nmos ad=0.2516p pd=2.16u as=0.2516p ps=2.16u w=0.74u l=0.13u
X232 a_8433_1842# a_8237_1842# VDD VDD sg13_lv_pmos ad=0.3808p pd=2.92u as=0.2128p ps=1.5u w=1.12u l=0.13u
X233 VDD a_18443_1842# a_18877_1842# VDD sg13_lv_pmos ad=0.2128p pd=1.5u as=0.3808p ps=2.92u w=1.12u l=0.13u
X234 a_22113_1842# a_21917_1842# VDD VDD sg13_lv_pmos ad=0.3808p pd=2.92u as=0.2128p ps=1.5u w=1.12u l=0.13u
X235 a_4350_1044# a_2019_1047.t9 a_4248_1044# VSS.t251 sg13_lv_nmos ad=0.2516p pd=2.16u as=0.1406p ps=1.12u w=0.74u l=0.13u
X236 a_14888_1044# a_14317_1842# VSS.t183 VSS.t182 sg13_lv_nmos ad=0.1406p pd=1.12u as=0.2516p ps=2.16u w=0.74u l=0.13u
X237 a_16108_289# a_3747_311.t2 a_25630_1044# VSS.t89 sg13_lv_nmos ad=0.2516p pd=2.16u as=0.2516p ps=2.16u w=0.74u l=0.13u
X238 VDD DELAY_VBIASP.t20 a_12471_2470# VDD sg13_lv_pmos ad=0.3808p pd=2.92u as=0.2128p ps=1.5u w=1.12u l=0.6u
X239 VSS.t208 a_4003_1842# a_4437_1842# VSS.t410 sg13_lv_nmos ad=0.1406p pd=1.12u as=0.2516p ps=2.16u w=0.74u l=0.13u
X240 a_16510_1044# a_16484_1008# a_16408_1044# VDD sg13_lv_pmos ad=0.3808p pd=2.92u as=0.2128p ps=1.5u w=1.12u l=0.13u
X241 VDD a_22243_1842# a_22677_1842# VDD sg13_lv_pmos ad=0.2128p pd=1.5u as=0.3808p ps=2.92u w=1.12u l=0.13u
X242 VDD a_3171_1047.t2 a_27124_1008# VDD sg13_lv_pmos ad=0.3808p pd=2.92u as=0.3808p ps=2.92u w=1.12u l=0.13u
X243 VDD MUX_SEL3 a_3449_331# VDD sg13_lv_pmos ad=0.1918p pd=1.5u as=0.1596p ps=1.22u w=0.84u l=0.13u
X244 a_2595_311.t0 a_2297_331# VDD VDD sg13_lv_pmos ad=0.2128p pd=1.5u as=0.1918p ps=1.5u w=1.12u l=0.13u
X245 a_10430_1044# a_11271_1008# a_11195_1044# VDD sg13_lv_pmos ad=0.3808p pd=2.92u as=0.2128p ps=1.5u w=1.12u l=0.13u
X246 a_23355_1044# a_23145_1044# VDD VDD sg13_lv_pmos ad=0.2128p pd=1.5u as=0.252p ps=1.57u w=1.12u l=0.13u
X247 VDD a_3747_1047.t4 a_21911_1008# VDD sg13_lv_pmos ad=0.3808p pd=2.92u as=0.3808p ps=2.92u w=1.12u l=0.13u
X248 VSS.t78 a_8997_1842# a_9465_1044# VSS.t427 sg13_lv_nmos ad=0.1665p pd=1.19u as=0.2516p ps=2.16u w=0.74u l=0.13u
X249 a_20968_1044# a_20397_1842# VDD VDD sg13_lv_pmos ad=0.2128p pd=1.5u as=0.3808p ps=2.92u w=1.12u l=0.13u
X250 a_10951_1842# a_10713_1842# a_10843_1842# VSS.t522 sg13_lv_nmos ad=0.1406p pd=1.12u as=0.2516p ps=2.16u w=0.74u l=0.2u
X251 VSS.t96 a_2019_1047.t5 a_16484_1008# VSS.t95 sg13_lv_nmos ad=0.2516p pd=2.16u as=0.2516p ps=2.16u w=0.74u l=0.13u
X252 a_26151_2470# a_25913_1842# a_26043_1842# VDD sg13_lv_pmos ad=0.2128p pd=1.5u as=0.3808p ps=2.92u w=1.12u l=0.2u
X253 a_13753_1842# a_13557_1842# VDD VDD sg13_lv_pmos ad=0.3808p pd=2.92u as=0.2128p ps=1.5u w=1.12u l=0.13u
X254 VDD a_1721_331# a_2019_311# VDD sg13_lv_pmos ad=0.4256p pd=3u as=0.2128p ps=1.5u w=1.12u l=0.13u
X255 a_4871_2470# a_4633_1842# a_4763_1842# VDD sg13_lv_pmos ad=0.2128p pd=1.5u as=0.3808p ps=2.92u w=1.12u l=0.2u
X256 VSS.t262 a_3171_1047.t9 a_5844_1008# VSS.t261 sg13_lv_nmos ad=0.2516p pd=2.16u as=0.2516p ps=2.16u w=0.74u l=0.13u
X257 VSS.t320 VDD VSS.t318 VSS.t319 sg13_lv_nmos ad=79.8f pd=0.8u as=0 ps=0 w=0.42u l=1u
X258 VDD a_2595_311.t2 a_20905_519# VDD sg13_lv_pmos ad=0.3808p pd=2.92u as=0.3808p ps=2.92u w=1.12u l=0.13u
X259 VDD a_2297_331# a_2595_311.t0 VDD sg13_lv_pmos ad=0.4256p pd=3u as=0.2128p ps=1.5u w=1.12u l=0.13u
X260 VSS.t40 a_2595_1047.t7 a_11271_1008# VSS.t39 sg13_lv_nmos ad=0.2516p pd=2.16u as=0.2516p ps=2.16u w=0.74u l=0.13u
X261 VSS.t490 DELAY_VBIASN.t11 a_19311_1842# VSS.t489 sg13_lv_nmos ad=0.2516p pd=2.16u as=0.1406p ps=1.12u w=0.74u l=0.6u
X262 VDD a_24523_1842# a_24957_1842# VDD sg13_lv_pmos ad=0.2128p pd=1.5u as=0.3808p ps=2.92u w=1.12u l=0.13u
X263 VSS.t552 a_3747_1047.t8 a_9751_1008# VSS.t551 sg13_lv_nmos ad=0.2516p pd=2.16u as=0.2516p ps=2.16u w=0.74u l=0.13u
X264 VSS.t470 DELAY_VBIASN.t24 a_9431_1842# VSS.t469 sg13_lv_nmos ad=0.2516p pd=2.16u as=0.1406p ps=1.12u w=0.74u l=0.6u
X265 a_19448_1044# a_18877_1842# VDD VDD sg13_lv_pmos ad=0.2128p pd=1.5u as=0.3808p ps=2.92u w=1.12u l=0.13u
X266 VSS.t446 DELAY_VBIASN.t6 a_23111_1842# VSS.t445 sg13_lv_nmos ad=0.2516p pd=2.16u as=0.1406p ps=1.12u w=0.74u l=0.6u
X267 a_10430_1044# a_11924_1008# a_11848_1044# VDD sg13_lv_pmos ad=0.3808p pd=2.92u as=0.2128p ps=1.5u w=1.12u l=0.13u
X268 VDD DELAY_VBIASP.t0 a_27671_2470# VDD sg13_lv_pmos ad=0.3808p pd=2.92u as=0.2128p ps=1.5u w=1.12u l=0.6u
X269 a_25630_1044# a_26471_1008# a_26395_1044# VDD sg13_lv_pmos ad=0.3808p pd=2.92u as=0.2128p ps=1.5u w=1.12u l=0.13u
X270 a_7151_2470# a_6913_1842# a_7043_1842# VDD sg13_lv_pmos ad=0.2128p pd=1.5u as=0.3808p ps=2.92u w=1.12u l=0.2u
X271 a_16033_1842# a_15837_1842# VDD VDD sg13_lv_pmos ad=0.3808p pd=2.92u as=0.2128p ps=1.5u w=1.12u l=0.13u
X272 VDD a_15964_289# a_16851_309# VDD sg13_lv_pmos ad=0.2086p pd=1.5u as=0.34p ps=2.68u w=1u l=0.13u
X273 VDD VSS.t576 VDD VDD sg13_lv_pmos ad=0.34p pd=2.68u as=0 ps=0 w=1u l=1u
X274 VSS.t398 a_11603_1842# a_12037_1842# VSS.t397 sg13_lv_nmos ad=0.1406p pd=1.12u as=0.2516p ps=2.16u w=0.74u l=0.13u
X275 VSS.t340 VDD VSS.t338 VSS.t339 sg13_lv_nmos ad=79.8f pd=0.8u as=0 ps=0 w=0.42u l=1u
X276 VDD VSS.t590 VDD VDD sg13_lv_pmos ad=0.34p pd=2.68u as=0 ps=0 w=1u l=1u
X277 VDD a_5957_1842# a_6425_1044# VDD sg13_lv_pmos ad=0.252p pd=1.57u as=0.3808p ps=2.92u w=1.12u l=0.13u
X278 a_24393_1842# a_24197_1842# VSS.t114 VSS.t202 sg13_lv_nmos ad=0.2516p pd=2.16u as=0.1406p ps=1.12u w=0.74u l=0.13u
X279 a_3747_1047.t1 a_3449_1395# VSS.t74 VSS.t73 sg13_lv_nmos ad=0.1406p pd=1.12u as=0.1331p ps=1.12u w=0.74u l=0.13u
X280 a_1544_1044# MUX_SEL1 VSS.t533 VSS.t532 sg13_lv_nmos ad=0.2516p pd=2.16u as=0.2516p ps=2.16u w=0.74u l=0.13u
X281 VDD VSS.t578 VDD VDD sg13_lv_pmos ad=0.34p pd=2.68u as=0 ps=0 w=1u l=1u
X282 a_3171_1047.t0 a_2873_1395# VDD VDD sg13_lv_pmos ad=0.2128p pd=1.5u as=0.1918p ps=1.5u w=1.12u l=0.13u
X283 a_13470_1044# a_3747_1047.t6 a_15755_1044# VSS.t239 sg13_lv_nmos ad=0.2516p pd=2.16u as=0.1406p ps=1.12u w=0.74u l=0.13u
X284 VDD a_5523_1842# a_5957_1842# VDD sg13_lv_pmos ad=0.2128p pd=1.5u as=0.3808p ps=2.92u w=1.12u l=0.13u
X285 VDD a_2297_1395# a_2595_1047.t0 VDD sg13_lv_pmos ad=0.4256p pd=3u as=0.2128p ps=1.5u w=1.12u l=0.13u
X286 VSS.t484 DELAY_VBIASN.t17 a_14751_1842# VSS.t483 sg13_lv_nmos ad=0.2516p pd=2.16u as=0.1406p ps=1.12u w=0.74u l=0.6u
X287 a_2967_1395# MUX_SEL1 a_2873_1395# VSS.t534 sg13_lv_nmos ad=0.1216p pd=1.02u as=0.2176p ps=1.96u w=0.64u l=0.13u
X288 a_4350_1044# a_2595_1047.t9 a_5115_1044# VSS.t257 sg13_lv_nmos ad=0.2516p pd=2.16u as=0.1406p ps=1.12u w=0.74u l=0.13u
X289 VDD a_2019_1047.t6 a_13444_1008# VDD sg13_lv_pmos ad=0.3808p pd=2.92u as=0.3808p ps=2.92u w=1.12u l=0.13u
X290 VSS.t102 a_2595_1047.t2 a_26471_1008# VSS.t101 sg13_lv_nmos ad=0.2516p pd=2.16u as=0.2516p ps=2.16u w=0.74u l=0.13u
X291 a_2595_311.t1 a_2297_331# VSS.t146 VSS.t145 sg13_lv_nmos ad=0.1406p pd=1.12u as=0.1331p ps=1.12u w=0.74u l=0.13u
X292 VSS.t456 DELAY_VBIASN.t31 a_4111_1842# VSS.t455 sg13_lv_nmos ad=0.2516p pd=2.16u as=0.1406p ps=1.12u w=0.74u l=0.6u
X293 a_2297_1395# MUX_SEL0 VDD VDD sg13_lv_pmos ad=0.1596p pd=1.22u as=0.2856p ps=2.36u w=0.84u l=0.13u
X294 VSS.t223 a_16597_1842# a_17065_1044# VSS.t436 sg13_lv_nmos ad=0.1665p pd=1.19u as=0.2516p ps=2.16u w=0.74u l=0.13u
X295 VDD DELAY_VBIASP.t25 a_8671_2470# VDD sg13_lv_pmos ad=0.3808p pd=2.92u as=0.2128p ps=1.5u w=1.12u l=0.6u
X296 VDD VSS.t591 VDD VDD sg13_lv_pmos ad=0.19p pd=1.38u as=0 ps=0 w=1u l=1u
X297 VDD a_1544_1044# a_1721_1395# VDD sg13_lv_pmos ad=0.1918p pd=1.5u as=0.1596p ps=1.22u w=0.84u l=0.13u
X298 a_4248_1044# a_4157_1313# VDD VDD sg13_lv_pmos ad=0.2128p pd=1.5u as=0.3808p ps=2.92u w=1.12u l=0.13u
X299 a_12471_2470# a_12233_1842# a_12363_1842# VDD sg13_lv_pmos ad=0.2128p pd=1.5u as=0.3808p ps=2.92u w=1.12u l=0.2u
X300 a_17031_1842# a_16793_1842# a_16923_1842# VSS.t162 sg13_lv_nmos ad=0.1406p pd=1.12u as=0.2516p ps=2.16u w=0.74u l=0.2u
X301 VSS.t152 a_1721_331# a_2019_311# VSS.t151 sg13_lv_nmos ad=0.2812p pd=2.24u as=0.1406p ps=1.12u w=0.74u l=0.13u
X302 a_19550_1044# a_21911_1008# a_21835_1044# VDD sg13_lv_pmos ad=0.3808p pd=2.92u as=0.2128p ps=1.5u w=1.12u l=0.13u
X303 a_16108_289# a_26985_519# a_25630_1044# VDD sg13_lv_pmos ad=0.3808p pd=2.92u as=0.3808p ps=2.92u w=1.12u l=0.13u
X304 VSS.t148 a_2297_331# a_2595_311.t1 VSS.t147 sg13_lv_nmos ad=0.2812p pd=2.24u as=0.1406p ps=1.12u w=0.74u l=0.13u
X305 a_18795_1044# a_18585_1044# VSS.t166 VSS.t536 sg13_lv_nmos ad=0.1406p pd=1.12u as=0.1665p ps=1.19u w=0.74u l=0.13u
X306 a_20831_1842# a_20593_1842# a_20723_1842# VSS.t539 sg13_lv_nmos ad=0.1406p pd=1.12u as=0.2516p ps=2.16u w=0.74u l=0.2u
X307 VSS.t278 VDD VSS.t277 VSS.t276 sg13_lv_nmos ad=0.1428p pd=1.52u as=0 ps=0 w=0.42u l=1u
X308 VDD a_22677_1842# a_23145_1044# VDD sg13_lv_pmos ad=0.252p pd=1.57u as=0.3808p ps=2.92u w=1.12u l=0.13u
X309 VSS.t130 a_2595_1047.t5 a_17351_1008# VSS.t129 sg13_lv_nmos ad=0.2516p pd=2.16u as=0.2516p ps=2.16u w=0.74u l=0.13u
X310 a_5393_1842# a_5197_1842# VSS.t264 VSS.t263 sg13_lv_nmos ad=0.2516p pd=2.16u as=0.1406p ps=1.12u w=0.74u l=0.13u
X311 VSS.t492 DELAY_VBIASN.t14 a_17031_1842# VSS.t491 sg13_lv_nmos ad=0.2516p pd=2.16u as=0.1406p ps=1.12u w=0.74u l=0.6u
X312 a_25630_1044# a_3171_1047.t2 a_27048_1044# VSS.t97 sg13_lv_nmos ad=0.2516p pd=2.16u as=0.1406p ps=1.12u w=0.74u l=0.13u
X313 a_9953_1842# a_9757_1842# VDD VDD sg13_lv_pmos ad=0.3808p pd=2.92u as=0.2128p ps=1.5u w=1.12u l=0.13u
X314 VDD a_10843_1842# a_11277_1842# VDD sg13_lv_pmos ad=0.2128p pd=1.5u as=0.3808p ps=2.92u w=1.12u l=0.13u
X315 VSS.t403 a_26803_1842# a_27237_1842# VSS.t402 sg13_lv_nmos ad=0.1406p pd=1.12u as=0.2516p ps=2.16u w=0.74u l=0.13u
X316 a_4350_1044# a_3171_1047.t9 a_5768_1044# VSS.t260 sg13_lv_nmos ad=0.2516p pd=2.16u as=0.1406p ps=1.12u w=0.74u l=0.13u
X317 a_10430_1044# a_12791_1008# a_12715_1044# VDD sg13_lv_pmos ad=0.3808p pd=2.92u as=0.2128p ps=1.5u w=1.12u l=0.13u
X318 a_19311_1842# a_19073_1842# a_19203_1842# VSS.t429 sg13_lv_nmos ad=0.1406p pd=1.12u as=0.2516p ps=2.16u w=0.74u l=0.2u
X319 a_24875_1044# a_24665_1044# VDD VDD sg13_lv_pmos ad=0.2128p pd=1.5u as=0.252p ps=1.57u w=1.12u l=0.13u
X320 VDD a_2595_1047.t3 a_23431_1008# VDD sg13_lv_pmos ad=0.3808p pd=2.92u as=0.3808p ps=2.92u w=1.12u l=0.13u
X321 VDD a_13557_1842# a_14025_1044# VDD sg13_lv_pmos ad=0.252p pd=1.57u as=0.3808p ps=2.92u w=1.12u l=0.13u
X322 a_23111_1842# a_22873_1842# a_23003_1842# VSS.t167 sg13_lv_nmos ad=0.1406p pd=1.12u as=0.2516p ps=2.16u w=0.74u l=0.2u
X323 a_27671_2470# a_27433_1842# a_27563_1842# VDD sg13_lv_pmos ad=0.2128p pd=1.5u as=0.3808p ps=2.92u w=1.12u l=0.2u
X324 VSS.t164 a_17683_1842# a_18117_1842# VSS.t557 sg13_lv_nmos ad=0.1406p pd=1.12u as=0.2516p ps=2.16u w=0.74u l=0.13u
X325 VSS.t335 VDD VSS.t333 VSS.t334 sg13_lv_nmos ad=79.8f pd=0.8u as=0 ps=0 w=0.42u l=1u
X326 a_10713_1842# a_10517_1842# VSS.t393 VSS.t392 sg13_lv_nmos ad=0.2516p pd=2.16u as=0.1406p ps=1.12u w=0.74u l=0.13u
X327 VSS.t231 a_2019_1047.t8 a_7364_1008# VSS.t230 sg13_lv_nmos ad=0.2516p pd=2.16u as=0.2516p ps=2.16u w=0.74u l=0.13u
X328 VSS.t431 a_7803_1842# a_8237_1842# VSS.t519 sg13_lv_nmos ad=0.1406p pd=1.12u as=0.2516p ps=2.16u w=0.74u l=0.13u
X329 VDD DELAY_VBIASP.t15 a_16271_2470# VDD sg13_lv_pmos ad=0.3808p pd=2.92u as=0.2128p ps=1.5u w=1.12u l=0.6u
X330 VSS.t330 VDD VSS.t328 VSS.t329 sg13_lv_nmos ad=79.8f pd=0.8u as=0 ps=0 w=0.42u l=1u
X331 VSS.t303 VDD VSS.t302 VSS.t301 sg13_lv_nmos ad=0.1428p pd=1.52u as=0 ps=0 w=0.42u l=1u
X332 VDD a_26043_1842# a_26477_1842# VDD sg13_lv_pmos ad=0.2128p pd=1.5u as=0.3808p ps=2.92u w=1.12u l=0.13u
X333 a_3543_331# MUX_SEL2 a_3449_331# VSS.t235 sg13_lv_nmos ad=0.1216p pd=1.02u as=0.2176p ps=1.96u w=0.64u l=0.13u
X334 a_22488_1044# a_21917_1842# VSS.t524 VSS.t523 sg13_lv_nmos ad=0.1406p pd=1.12u as=0.2516p ps=2.16u w=0.74u l=0.13u
X335 VDD VSS.t593 VDD VDD sg13_lv_pmos ad=0.19p pd=1.38u as=0 ps=0 w=1u l=1u
X336 a_22590_1044# a_24084_1008# a_24008_1044# VDD sg13_lv_pmos ad=0.3808p pd=2.92u as=0.2128p ps=1.5u w=1.12u l=0.13u
X337 VDD DELAY_VBIASP.t10 a_20071_2470# VDD sg13_lv_pmos ad=0.3808p pd=2.92u as=0.2128p ps=1.5u w=1.12u l=0.6u
X338 a_14751_1842# a_14513_1842# a_14643_1842# VSS.t186 sg13_lv_nmos ad=0.1406p pd=1.12u as=0.2516p ps=2.16u w=0.74u l=0.2u
X339 VSS.t217 a_2873_1395# a_3171_1047.t1 VSS.t216 sg13_lv_nmos ad=0.2812p pd=2.24u as=0.1406p ps=1.12u w=0.74u l=0.13u
X340 VDD VSS.t567 VDD VDD sg13_lv_pmos ad=0.19p pd=1.38u as=0 ps=0 w=1u l=1u
X341 a_25630_1044# a_27991_1008# a_27915_1044# VDD sg13_lv_pmos ad=0.3808p pd=2.92u as=0.2128p ps=1.5u w=1.12u l=0.13u
X342 VSS.t373 VSS.t371 VSS.t369 VSS.t372 sg13_lv_nmos ad=0.1406p pd=1.12u as=0 ps=0 w=0.74u l=0.13u
X343 a_4111_1842# DELAY_IN a_4003_1842# VSS.t268 sg13_lv_nmos ad=0.1406p pd=1.12u as=0.2516p ps=2.16u w=0.74u l=0.2u
X344 a_8671_2470# a_8433_1842# a_8563_1842# VDD sg13_lv_pmos ad=0.2128p pd=1.5u as=0.3808p ps=2.92u w=1.12u l=0.2u
X345 a_17553_1842# a_17357_1842# VDD VDD sg13_lv_pmos ad=0.3808p pd=2.92u as=0.2128p ps=1.5u w=1.12u l=0.13u
X346 VSS.t26 a_1544_1044# a_2391_1395# VSS.t541 sg13_lv_nmos ad=0.1331p pd=1.12u as=0.1216p ps=1.02u w=0.64u l=0.13u
X347 VSS.t155 a_3747_311.t3 a_14825_519# VSS.t154 sg13_lv_nmos ad=0.2516p pd=2.16u as=0.2516p ps=2.16u w=0.74u l=0.13u
X348 VSS.t47 a_1256_289# a_2967_331# VSS.t46 sg13_lv_nmos ad=0.1331p pd=1.12u as=0.1216p ps=1.02u w=0.64u l=0.13u
X349 a_2019_1047.t1 a_1721_1395# VSS.t30 VSS.t29 sg13_lv_nmos ad=0.1406p pd=1.12u as=0.1331p ps=1.12u w=0.74u l=0.13u
X350 a_15964_289# a_15765_463# a_5731_289# VSS.t553 sg13_lv_nmos ad=0.2183p pd=1.33u as=0.2516p ps=2.16u w=0.74u l=0.13u
X351 a_13470_1044# a_2019_1047.t6 a_13368_1044# VSS.t242 sg13_lv_nmos ad=0.2516p pd=2.16u as=0.1406p ps=1.12u w=0.74u l=0.13u
X352 VSS.t396 a_13123_1842# a_13557_1842# VSS.t555 sg13_lv_nmos ad=0.1406p pd=1.12u as=0.2516p ps=2.16u w=0.74u l=0.13u
X353 VDD VSS.t566 VDD VDD sg13_lv_pmos ad=0.34p pd=2.68u as=0 ps=0 w=1u l=1u
X354 VSS.t5 a_3171_1047.t3 a_24084_1008# VSS.t4 sg13_lv_nmos ad=0.2516p pd=2.16u as=0.2516p ps=2.16u w=0.74u l=0.13u
X355 a_25913_1842# a_25717_1842# VSS.t13 VSS.t181 sg13_lv_nmos ad=0.2516p pd=2.16u as=0.1406p ps=1.12u w=0.74u l=0.13u
X356 a_21353_1842# a_21157_1842# VDD VDD sg13_lv_pmos ad=0.3808p pd=2.92u as=0.2128p ps=1.5u w=1.12u l=0.13u
X357 VSS.t338 VDD VSS.t337 VSS.t336 sg13_lv_nmos ad=0.1428p pd=1.52u as=0 ps=0 w=0.42u l=1u
X358 a_2297_331# MUX_SEL2 VDD VDD sg13_lv_pmos ad=0.1596p pd=1.22u as=0.2856p ps=2.36u w=0.84u l=0.13u
X359 VDD a_7043_1842# a_7477_1842# VDD sg13_lv_pmos ad=0.2128p pd=1.5u as=0.3808p ps=2.92u w=1.12u l=0.13u
X360 a_2873_331# MUX_SEL3 VDD VDD sg13_lv_pmos ad=0.1596p pd=1.22u as=0.2856p ps=2.36u w=0.84u l=0.13u
X361 a_8155_1044# a_7945_1044# VDD VDD sg13_lv_pmos ad=0.2128p pd=1.5u as=0.252p ps=1.57u w=1.12u l=0.13u
X362 VSS.t166 a_18117_1842# a_18585_1044# VSS.t165 sg13_lv_nmos ad=0.1665p pd=1.19u as=0.2516p ps=2.16u w=0.74u l=0.13u
X363 a_27048_1044# a_26477_1842# VDD VDD sg13_lv_pmos ad=0.2128p pd=1.5u as=0.3808p ps=2.92u w=1.12u l=0.13u
X364 a_5768_1044# a_5197_1842# VDD VDD sg13_lv_pmos ad=0.2128p pd=1.5u as=0.3808p ps=2.92u w=1.12u l=0.13u
X365 a_13991_2470# a_13753_1842# a_13883_1842# VDD sg13_lv_pmos ad=0.2128p pd=1.5u as=0.3808p ps=2.92u w=1.12u l=0.2u
X366 VSS.t2 a_3171_1047.t6 a_14964_1008# VSS.t1 sg13_lv_nmos ad=0.2516p pd=2.16u as=0.2516p ps=2.16u w=0.74u l=0.13u
X367 VDD a_2019_311# a_17865_519# VDD sg13_lv_pmos ad=0.3808p pd=2.92u as=0.3808p ps=2.92u w=1.12u l=0.13u
X368 DELAY_OUT_LAST a_27997_1842# VSS.t62 VSS.t61 sg13_lv_nmos ad=0.2516p pd=2.16u as=0.1406p ps=1.12u w=0.74u l=0.13u
X369 a_11195_1044# a_10985_1044# VSS.t221 VSS.t220 sg13_lv_nmos ad=0.1406p pd=1.12u as=0.1665p ps=1.19u w=0.74u l=0.13u
X370 VDD a_24197_1842# a_24665_1044# VDD sg13_lv_pmos ad=0.252p pd=1.57u as=0.3808p ps=2.92u w=1.12u l=0.13u
X371 a_6913_1842# a_6717_1842# VSS.t511 VSS.t510 sg13_lv_nmos ad=0.2516p pd=2.16u as=0.1406p ps=1.12u w=0.74u l=0.13u
X372 VSS.t494 DELAY_VBIASN.t12 a_18551_1842# VSS.t493 sg13_lv_nmos ad=0.2516p pd=2.16u as=0.1406p ps=1.12u w=0.74u l=0.6u
X373 a_16510_1044# a_18004_1008# a_17928_1044# VDD sg13_lv_pmos ad=0.3808p pd=2.92u as=0.2128p ps=1.5u w=1.12u l=0.13u
X374 VDD a_12363_1842# a_12797_1842# VDD sg13_lv_pmos ad=0.2128p pd=1.5u as=0.3808p ps=2.92u w=1.12u l=0.13u
X375 VSS.t66 MUX_SEL3 a_3543_331# VSS.t384 sg13_lv_nmos ad=0.1331p pd=1.12u as=0.1216p ps=1.02u w=0.64u l=0.13u
X376 a_22590_1044# a_2595_1047.t3 a_23355_1044# VSS.t547 sg13_lv_nmos ad=0.2516p pd=2.16u as=0.1406p ps=1.12u w=0.74u l=0.13u
X377 VSS.t454 DELAY_VBIASN.t7 a_22351_1842# VSS.t453 sg13_lv_nmos ad=0.2516p pd=2.16u as=0.1406p ps=1.12u w=0.74u l=0.6u
X378 VDD a_3171_1047.t4 a_21044_1008# VDD sg13_lv_pmos ad=0.3808p pd=2.92u as=0.3808p ps=2.92u w=1.12u l=0.13u
X379 VDD VSS.t569 VDD VDD sg13_lv_pmos ad=0.19p pd=1.38u as=0 ps=0 w=1u l=1u
X380 a_16271_2470# a_16033_1842# a_16163_1842# VDD sg13_lv_pmos ad=0.2128p pd=1.5u as=0.3808p ps=2.92u w=1.12u l=0.2u
X381 VDD VSS.t583 VDD VDD sg13_lv_pmos ad=0.19p pd=1.38u as=0 ps=0 w=1u l=1u
X382 a_19833_1842# a_19637_1842# VSS.t56 VSS.t55 sg13_lv_nmos ad=0.2516p pd=2.16u as=0.1406p ps=1.12u w=0.74u l=0.13u
X383 VDD a_2019_311# a_5705_519# VDD sg13_lv_pmos ad=0.3808p pd=2.92u as=0.3808p ps=2.92u w=1.12u l=0.13u
X384 a_20071_2470# a_19833_1842# a_19963_1842# VDD sg13_lv_pmos ad=0.2128p pd=1.5u as=0.3808p ps=2.92u w=1.12u l=0.2u
X385 a_9193_1842# a_8997_1842# VSS.t15 VSS.t428 sg13_lv_nmos ad=0.2516p pd=2.16u as=0.1406p ps=1.12u w=0.74u l=0.13u
X386 a_24631_1842# a_24393_1842# a_24523_1842# VSS.t387 sg13_lv_nmos ad=0.1406p pd=1.12u as=0.2516p ps=2.16u w=0.74u l=0.2u
X387 VDD VSS.t582 VDD VDD sg13_lv_pmos ad=0.34p pd=2.68u as=0 ps=0 w=1u l=1u
X388 VSS.t88 a_2019_1047.t7 a_10404_1008# VSS.t87 sg13_lv_nmos ad=0.2516p pd=2.16u as=0.2516p ps=2.16u w=0.74u l=0.13u
X389 VDD a_14643_1842# a_15077_1842# VDD sg13_lv_pmos ad=0.2128p pd=1.5u as=0.3808p ps=2.92u w=1.12u l=0.13u
X390 VDD a_1544_289# a_2297_331# VDD sg13_lv_pmos ad=0.1918p pd=1.5u as=0.1596p ps=1.22u w=0.84u l=0.13u
X391 a_23633_1842# a_23437_1842# VSS.t419 VSS.t418 sg13_lv_nmos ad=0.2516p pd=2.16u as=0.1406p ps=1.12u w=0.74u l=0.13u
X392 VSS.t333 VDD VSS.t332 VSS.t331 sg13_lv_nmos ad=0.1428p pd=1.52u as=0 ps=0 w=0.42u l=1u
X393 a_2019_311# a_1721_331# VDD VDD sg13_lv_pmos ad=0.2128p pd=1.5u as=0.1918p ps=1.5u w=1.12u l=0.13u
X394 VSS.t157 a_9323_1842# a_9757_1842# VSS.t161 sg13_lv_nmos ad=0.1406p pd=1.12u as=0.2516p ps=2.16u w=0.74u l=0.13u
X395 a_26395_1044# a_26185_1044# VSS.t44 VSS.t43 sg13_lv_nmos ad=0.1406p pd=1.12u as=0.1665p ps=1.19u w=0.74u l=0.13u
X396 VDD DELAY_VBIASP.t13 a_17791_2470# VDD sg13_lv_pmos ad=0.3808p pd=2.92u as=0.2128p ps=1.5u w=1.12u l=0.6u
X397 VSS.t81 a_3747_1047.t3 a_24951_1008# VSS.t80 sg13_lv_nmos ad=0.2516p pd=2.16u as=0.2516p ps=2.16u w=0.74u l=0.13u
X398 VSS.t298 VDD VSS.t297 VSS.t296 sg13_lv_nmos ad=0.1428p pd=1.52u as=0 ps=0 w=0.42u l=1u
X399 VSS.t328 VDD VSS.t327 VSS.t326 sg13_lv_nmos ad=0.1428p pd=1.52u as=0 ps=0 w=0.42u l=1u
X400 a_3747_1047.t0 a_3449_1395# VDD VDD sg13_lv_pmos ad=0.2128p pd=1.5u as=0.1918p ps=1.5u w=1.12u l=0.13u
X401 a_13368_1044# a_12797_1842# VDD VDD sg13_lv_pmos ad=0.2128p pd=1.5u as=0.3808p ps=2.92u w=1.12u l=0.13u
X402 a_24008_1044# a_23437_1842# VSS.t417 VSS.t416 sg13_lv_nmos ad=0.1406p pd=1.12u as=0.2516p ps=2.16u w=0.74u l=0.13u
X403 VDD DELAY_VBIASP.t8 a_21591_2470# VDD sg13_lv_pmos ad=0.3808p pd=2.92u as=0.2128p ps=1.5u w=1.12u l=0.6u
X404 a_15964_289# MUX_SEL4 a_5731_289# VDD sg13_lv_pmos ad=0.3304p pd=1.71u as=0.3808p ps=2.92u w=1.12u l=0.13u
X405 a_4350_1044# a_6711_1008# a_6635_1044# VDD sg13_lv_pmos ad=0.3808p pd=2.92u as=0.2128p ps=1.5u w=1.12u l=0.13u
X406 a_2873_1395# MUX_SEL1 VDD VDD sg13_lv_pmos ad=0.1596p pd=1.22u as=0.2856p ps=2.36u w=0.84u l=0.13u
X407 a_1256_1044# MUX_SEL0 VSS.t515 VSS.t514 sg13_lv_nmos ad=0.2516p pd=2.16u as=0.2516p ps=2.16u w=0.74u l=0.13u
X408 VSS.t295 VDD VSS.t293 VSS.t294 sg13_lv_nmos ad=79.8f pd=0.8u as=0 ps=0 w=0.42u l=1u
X409 a_19550_1044# a_20391_1008# a_20315_1044# VDD sg13_lv_pmos ad=0.3808p pd=2.92u as=0.2128p ps=1.5u w=1.12u l=0.13u
X410 VDD VDD VDD VDD sg13_lv_pmos ad=0.2128p pd=1.5u as=0 ps=0 w=1.12u l=0.2u
X411 a_5631_1842# a_5393_1842# a_5523_1842# VSS.t82 sg13_lv_nmos ad=0.1406p pd=1.12u as=0.2516p ps=2.16u w=0.74u l=0.2u
X412 a_14513_1842# a_14317_1842# VSS.t185 VSS.t184 sg13_lv_nmos ad=0.2516p pd=2.16u as=0.1406p ps=1.12u w=0.74u l=0.13u
X413 VSS.t228 a_2595_311.t2 a_20905_519# VSS.t227 sg13_lv_nmos ad=0.2516p pd=2.16u as=0.2516p ps=2.16u w=0.74u l=0.13u
X414 VDD a_7477_1842# a_7945_1044# VDD sg13_lv_pmos ad=0.252p pd=1.57u as=0.3808p ps=2.92u w=1.12u l=0.13u
X415 a_13470_1044# a_3171_1047.t6 a_14888_1044# VSS.t0 sg13_lv_nmos ad=0.2516p pd=2.16u as=0.1406p ps=1.12u w=0.74u l=0.13u
X416 a_4633_1842# a_4437_1842# VSS.t208 VSS.t207 sg13_lv_nmos ad=0.2516p pd=2.16u as=0.1406p ps=1.12u w=0.74u l=0.13u
X417 a_1256_289# MUX_SEL2 VSS.t233 VSS.t232 sg13_lv_nmos ad=0.2516p pd=2.16u as=0.2516p ps=2.16u w=0.74u l=0.13u
X418 VSS.t124 a_2019_1047.t2 a_25604_1008# VSS.t123 sg13_lv_nmos ad=0.2516p pd=2.16u as=0.2516p ps=2.16u w=0.74u l=0.13u
X419 a_16108_289# MUX_SEL4 a_15964_289# VSS.t203 sg13_lv_nmos ad=0.2516p pd=2.16u as=0.2183p ps=1.33u w=0.74u l=0.13u
X420 a_22873_1842# a_22677_1842# VDD VDD sg13_lv_pmos ad=0.3808p pd=2.92u as=0.2128p ps=1.5u w=1.12u l=0.13u
X421 a_21835_1044# a_21625_1044# VSS.t225 VSS.t224 sg13_lv_nmos ad=0.1406p pd=1.12u as=0.1665p ps=1.19u w=0.74u l=0.13u
X422 VSS.t24 a_2595_1047.t4 a_20391_1008# VSS.t23 sg13_lv_nmos ad=0.2516p pd=2.16u as=0.2516p ps=2.16u w=0.74u l=0.13u
X423 a_9675_1044# a_9465_1044# VDD VDD sg13_lv_pmos ad=0.2128p pd=1.5u as=0.252p ps=1.57u w=1.12u l=0.13u
X424 VSS.t221 a_10517_1842# a_10985_1044# VSS.t391 sg13_lv_nmos ad=0.1665p pd=1.19u as=0.2516p ps=2.16u w=0.74u l=0.13u
X425 VDD a_2595_1047.t8 a_8231_1008# VDD sg13_lv_pmos ad=0.3808p pd=2.92u as=0.3808p ps=2.92u w=1.12u l=0.13u
X426 a_18551_1842# a_18313_1842# a_18443_1842# VSS.t187 sg13_lv_nmos ad=0.1406p pd=1.12u as=0.2516p ps=2.16u w=0.74u l=0.2u
X427 a_22351_1842# a_22113_1842# a_22243_1842# VSS.t434 sg13_lv_nmos ad=0.1406p pd=1.12u as=0.2516p ps=2.16u w=0.74u l=0.2u
X428 VSS.t127 a_3747_1047.t5 a_18871_1008# VSS.t126 sg13_lv_nmos ad=0.2516p pd=2.16u as=0.2516p ps=2.16u w=0.74u l=0.13u
X429 VSS.t104 a_16923_1842# a_17357_1842# VSS.t407 sg13_lv_nmos ad=0.1406p pd=1.12u as=0.2516p ps=2.16u w=0.74u l=0.13u
X430 VDD a_3171_311.t2 a_23945_519# VDD sg13_lv_pmos ad=0.3808p pd=2.92u as=0.3808p ps=2.92u w=1.12u l=0.13u
X431 a_2019_311# a_1721_331# VSS.t150 VSS.t149 sg13_lv_nmos ad=0.1406p pd=1.12u as=0.1331p ps=1.12u w=0.74u l=0.13u
X432 a_25153_1842# a_24957_1842# VDD VDD sg13_lv_pmos ad=0.3808p pd=2.92u as=0.2128p ps=1.5u w=1.12u l=0.13u
X433 a_17928_1044# a_17357_1842# VSS.t106 VSS.t105 sg13_lv_nmos ad=0.1406p pd=1.12u as=0.2516p ps=2.16u w=0.74u l=0.13u
X434 a_12715_1044# a_12505_1044# VSS.t42 VSS.t41 sg13_lv_nmos ad=0.1406p pd=1.12u as=0.1665p ps=1.19u w=0.74u l=0.13u
X435 VDD MUX_SEL4 a_15765_463# VDD sg13_lv_pmos ad=0.3808p pd=2.92u as=0.3808p ps=2.92u w=1.12u l=0.13u
X436 a_19550_1044# a_3171_1047.t4 a_20968_1044# VSS.t16 sg13_lv_nmos ad=0.2516p pd=2.16u as=0.1406p ps=1.12u w=0.74u l=0.13u
X437 VSS.t472 DELAY_VBIASN.t22 a_10951_1842# VSS.t471 sg13_lv_nmos ad=0.2516p pd=2.16u as=0.1406p ps=1.12u w=0.74u l=0.6u
X438 a_19550_1044# a_19524_1008# a_19448_1044# VDD sg13_lv_pmos ad=0.3808p pd=2.92u as=0.2128p ps=1.5u w=1.12u l=0.13u
X439 a_7288_1044# a_6717_1842# VSS.t513 VSS.t512 sg13_lv_nmos ad=0.1406p pd=1.12u as=0.2516p ps=2.16u w=0.74u l=0.13u
X440 VSS.t274 a_20723_1842# a_21157_1842# VSS.t273 sg13_lv_nmos ad=0.1406p pd=1.12u as=0.2516p ps=2.16u w=0.74u l=0.13u
X441 a_1544_289# MUX_SEL3 VSS.t382 VSS.t381 sg13_lv_nmos ad=0.2516p pd=2.16u as=0.2516p ps=2.16u w=0.74u l=0.13u
X442 a_13470_1044# a_14311_1008# a_14235_1044# VDD sg13_lv_pmos ad=0.3808p pd=2.92u as=0.2128p ps=1.5u w=1.12u l=0.13u
X443 a_22590_1044# a_3747_1047.t3 a_24875_1044# VSS.t79 sg13_lv_nmos ad=0.2516p pd=2.16u as=0.1406p ps=1.12u w=0.74u l=0.13u
X444 VSS.t450 DELAY_VBIASN.t5 a_23871_1842# VSS.t449 sg13_lv_nmos ad=0.2516p pd=2.16u as=0.1406p ps=1.12u w=0.74u l=0.6u
X445 VDD a_2019_1047.t3 a_22564_1008# VDD sg13_lv_pmos ad=0.3808p pd=2.92u as=0.3808p ps=2.92u w=1.12u l=0.13u
X446 VSS.t44 a_25717_1842# a_26185_1044# VSS.t180 sg13_lv_nmos ad=0.1665p pd=1.19u as=0.2516p ps=2.16u w=0.74u l=0.13u
X447 a_13231_1842# a_12993_1842# a_13123_1842# VSS.t509 sg13_lv_nmos ad=0.1406p pd=1.12u as=0.2516p ps=2.16u w=0.74u l=0.2u
X448 VSS.t290 VDD VSS.t288 VSS.t289 sg13_lv_nmos ad=79.8f pd=0.8u as=0 ps=0 w=0.42u l=1u
X449 a_17791_2470# a_17553_1842# a_17683_1842# VDD sg13_lv_pmos ad=0.2128p pd=1.5u as=0.3808p ps=2.92u w=1.12u l=0.2u
X450 VSS.t37 a_4437_1842# a_4905_1044# VSS.t206 sg13_lv_nmos ad=0.1665p pd=1.19u as=0.2516p ps=2.16u w=0.74u l=0.13u
X451 VDD VSS.t570 VDD VDD sg13_lv_pmos ad=0.34p pd=2.68u as=0 ps=0 w=1u l=1u
X452 a_12233_1842# a_12037_1842# VSS.t398 VSS.t409 sg13_lv_nmos ad=0.2516p pd=2.16u as=0.1406p ps=1.12u w=0.74u l=0.13u
X453 VSS.t76 a_3449_1395# a_3747_1047.t1 VSS.t75 sg13_lv_nmos ad=0.2812p pd=2.24u as=0.1406p ps=1.12u w=0.74u l=0.13u
X454 VDD VSS.t584 VDD VDD sg13_lv_pmos ad=0.34p pd=2.68u as=0 ps=0 w=1u l=1u
X455 VDD VSS.t579 VDD VDD sg13_lv_pmos ad=0.19p pd=1.38u as=0 ps=0 w=1u l=1u
X456 VSS.t355 VDD VSS.t353 VSS.t354 sg13_lv_nmos ad=79.8f pd=0.8u as=0 ps=0 w=0.42u l=1u
X457 VSS.t8 a_3171_1047.t8 a_8884_1008# VSS.t7 sg13_lv_nmos ad=0.2516p pd=2.16u as=0.2516p ps=2.16u w=0.74u l=0.13u
X458 a_21591_2470# a_21353_1842# a_21483_1842# VDD sg13_lv_pmos ad=0.2128p pd=1.5u as=0.3808p ps=2.92u w=1.12u l=0.2u
X459 VDD a_2873_1395# a_3171_1047.t0 VDD sg13_lv_pmos ad=0.4256p pd=3u as=0.2128p ps=1.5u w=1.12u l=0.13u
X460 a_6153_1842# a_5957_1842# VDD VDD sg13_lv_pmos ad=0.3808p pd=2.92u as=0.2128p ps=1.5u w=1.12u l=0.13u
X461 VDD a_16163_1842# a_16597_1842# VDD sg13_lv_pmos ad=0.2128p pd=1.5u as=0.3808p ps=2.92u w=1.12u l=0.13u
X462 a_3543_1395# MUX_SEL0 a_3449_1395# VSS.t517 sg13_lv_nmos ad=0.1216p pd=1.02u as=0.2176p ps=1.96u w=0.64u l=0.13u
X463 VDD a_1544_1044# a_2297_1395# VDD sg13_lv_pmos ad=0.1918p pd=1.5u as=0.1596p ps=1.22u w=0.84u l=0.13u
X464 VDD DELAY_VBIASP.t23 a_10191_2470# VDD sg13_lv_pmos ad=0.3808p pd=2.92u as=0.2128p ps=1.5u w=1.12u l=0.6u
X465 a_17275_1044# a_17065_1044# VDD VDD sg13_lv_pmos ad=0.2128p pd=1.5u as=0.252p ps=1.57u w=1.12u l=0.13u
X466 a_2019_1047.t0 a_1721_1395# VDD VDD sg13_lv_pmos ad=0.2128p pd=1.5u as=0.1918p ps=1.5u w=1.12u l=0.13u
X467 a_27915_1044# a_27705_1044# VSS.t121 VSS.t120 sg13_lv_nmos ad=0.1406p pd=1.12u as=0.1665p ps=1.19u w=0.74u l=0.13u
X468 VSS.t464 DELAY_VBIASN.t2 a_26151_1842# VSS.t463 sg13_lv_nmos ad=0.2516p pd=2.16u as=0.1406p ps=1.12u w=0.74u l=0.6u
X469 VDD a_3747_1047.t6 a_15831_1008# VDD sg13_lv_pmos ad=0.3808p pd=2.92u as=0.3808p ps=2.92u w=1.12u l=0.13u
X470 VDD a_19963_1842# a_20397_1842# VDD sg13_lv_pmos ad=0.2128p pd=1.5u as=0.3808p ps=2.92u w=1.12u l=0.13u
X471 VSS.t358 VDD VSS.t357 VSS.t356 sg13_lv_nmos ad=0.1428p pd=1.52u as=0 ps=0 w=0.42u l=1u
X472 VSS.t458 DELAY_VBIASN.t30 a_4871_1842# VSS.t457 sg13_lv_nmos ad=0.2516p pd=2.16u as=0.1406p ps=1.12u w=0.74u l=0.6u
X473 a_14888_1044# a_14317_1842# VDD VDD sg13_lv_pmos ad=0.2128p pd=1.5u as=0.3808p ps=2.92u w=1.12u l=0.13u
X474 a_4350_1044# a_4324_1008# a_4248_1044# VDD sg13_lv_pmos ad=0.3808p pd=2.92u as=0.2128p ps=1.5u w=1.12u l=0.13u
X475 a_1256_289# MUX_SEL2 VDD VDD sg13_lv_pmos ad=0.3808p pd=2.92u as=0.3808p ps=2.92u w=1.12u l=0.13u
X476 VSS.t377 VSS.t374 VSS.t376 VSS.t375 sg13_lv_nmos ad=0.2516p pd=2.16u as=0 ps=0 w=0.74u l=0.6u
X477 a_16108_289# a_15765_463# a_15964_289# VDD sg13_lv_pmos ad=0.3808p pd=2.92u as=0.3304p ps=1.71u w=1.12u l=0.13u
X478 a_11473_1842# a_11277_1842# VDD VDD sg13_lv_pmos ad=0.3808p pd=2.92u as=0.2128p ps=1.5u w=1.12u l=0.13u
X479 VDD a_8997_1842# a_9465_1044# VDD sg13_lv_pmos ad=0.252p pd=1.57u as=0.3808p ps=2.92u w=1.12u l=0.13u
X480 a_27433_1842# a_27237_1842# VSS.t403 VSS.t545 sg13_lv_nmos ad=0.2516p pd=2.16u as=0.1406p ps=1.12u w=0.74u l=0.13u
X481 a_2391_331# MUX_SEL2 a_2297_331# VSS.t234 sg13_lv_nmos ad=0.1216p pd=1.02u as=0.2176p ps=1.96u w=0.64u l=0.13u
X482 a_2967_331# MUX_SEL3 a_2873_331# VSS.t383 sg13_lv_nmos ad=0.1216p pd=1.02u as=0.2176p ps=1.96u w=0.64u l=0.13u
X483 VDD a_2019_1047.t5 a_16484_1008# VDD sg13_lv_pmos ad=0.3808p pd=2.92u as=0.3808p ps=2.92u w=1.12u l=0.13u
X484 a_7390_1044# a_2595_1047.t8 a_8155_1044# VSS.t131 sg13_lv_nmos ad=0.2516p pd=2.16u as=0.1406p ps=1.12u w=0.74u l=0.13u
X485 VSS.t462 DELAY_VBIASN.t27 a_7151_1842# VSS.t461 sg13_lv_nmos ad=0.2516p pd=2.16u as=0.1406p ps=1.12u w=0.74u l=0.6u
X486 VDD a_3171_1047.t9 a_5844_1008# VDD sg13_lv_pmos ad=0.3808p pd=2.92u as=0.3808p ps=2.92u w=1.12u l=0.13u
X487 VDD DELAY_VBIASP.t3 a_25391_2470# VDD sg13_lv_pmos ad=0.3808p pd=2.92u as=0.2128p ps=1.5u w=1.12u l=0.6u
X488 VDD a_2595_1047.t7 a_11271_1008# VDD sg13_lv_pmos ad=0.3808p pd=2.92u as=0.3808p ps=2.92u w=1.12u l=0.13u
X489 VDD VSS.t587 VDD VDD sg13_lv_pmos ad=0.19p pd=1.38u as=0 ps=0 w=1u l=1u
X490 VSS.t42 a_12037_1842# a_12505_1044# VSS.t408 sg13_lv_nmos ad=0.1665p pd=1.19u as=0.2516p ps=2.16u w=0.74u l=0.13u
X491 VDD a_3747_1047.t8 a_9751_1008# VDD sg13_lv_pmos ad=0.3808p pd=2.92u as=0.3808p ps=2.92u w=1.12u l=0.13u
X492 a_9431_1842# a_9193_1842# a_9323_1842# VSS.t546 sg13_lv_nmos ad=0.1406p pd=1.12u as=0.2516p ps=2.16u w=0.74u l=0.2u
X493 a_18313_1842# a_18117_1842# VSS.t164 VSS.t163 sg13_lv_nmos ad=0.2516p pd=2.16u as=0.1406p ps=1.12u w=0.74u l=0.13u
X494 MUX_OUT a_16851_309# VSS.t93 VSS.t177 sg13_lv_nmos ad=0.1406p pd=1.12u as=0.1371p ps=1.12u w=0.74u l=0.13u
X495 VSS.t350 VDD VSS.t348 VSS.t349 sg13_lv_nmos ad=79.8f pd=0.8u as=0 ps=0 w=0.42u l=1u
X496 a_23871_1842# a_23633_1842# a_23763_1842# VSS.t505 sg13_lv_nmos ad=0.1406p pd=1.12u as=0.2516p ps=2.16u w=0.74u l=0.2u
X497 a_8433_1842# a_8237_1842# VSS.t431 VSS.t430 sg13_lv_nmos ad=0.2516p pd=2.16u as=0.1406p ps=1.12u w=0.74u l=0.13u
X498 VSS.t49 a_18443_1842# a_18877_1842# VSS.t48 sg13_lv_nmos ad=0.1406p pd=1.12u as=0.2516p ps=2.16u w=0.74u l=0.13u
X499 VSS.t315 VDD VSS.t313 VSS.t314 sg13_lv_nmos ad=79.8f pd=0.8u as=0 ps=0 w=0.42u l=1u
X500 a_22113_1842# a_21917_1842# VSS.t386 VSS.t525 sg13_lv_nmos ad=0.2516p pd=2.16u as=0.1406p ps=1.12u w=0.74u l=0.13u
X501 a_1544_289# MUX_SEL3 VDD VDD sg13_lv_pmos ad=0.3808p pd=2.92u as=0.3808p ps=2.92u w=1.12u l=0.13u
X502 a_26673_1842# a_26477_1842# VDD VDD sg13_lv_pmos ad=0.3808p pd=2.92u as=0.2128p ps=1.5u w=1.12u l=0.13u
X503 a_10328_1044# a_9757_1842# VSS.t159 VSS.t158 sg13_lv_nmos ad=0.1406p pd=1.12u as=0.2516p ps=2.16u w=0.74u l=0.13u
X504 VSS.t318 VDD VSS.t317 VSS.t316 sg13_lv_nmos ad=0.1428p pd=1.52u as=0 ps=0 w=0.42u l=1u
X505 a_22590_1044# a_2019_1047.t3 a_22488_1044# VSS.t245 sg13_lv_nmos ad=0.2516p pd=2.16u as=0.1406p ps=1.12u w=0.74u l=0.13u
X506 VSS.t440 DELAY_VBIASN.t20 a_12471_1842# VSS.t439 sg13_lv_nmos ad=0.2516p pd=2.16u as=0.1406p ps=1.12u w=0.74u l=0.6u
X507 a_8808_1044# a_8237_1842# VSS.t433 VSS.t432 sg13_lv_nmos ad=0.1406p pd=1.12u as=0.2516p ps=2.16u w=0.74u l=0.13u
X508 VSS.t406 a_22243_1842# a_22677_1842# VSS.t405 sg13_lv_nmos ad=0.1406p pd=1.12u as=0.2516p ps=2.16u w=0.74u l=0.13u
X509 VDD DELAY_VBIASP.t28 a_6391_2470# VDD sg13_lv_pmos ad=0.3808p pd=2.92u as=0.2128p ps=1.5u w=1.12u l=0.6u
X510 a_13470_1044# a_15831_1008# a_15755_1044# VDD sg13_lv_pmos ad=0.3808p pd=2.92u as=0.2128p ps=1.5u w=1.12u l=0.13u
X511 a_1544_1044# MUX_SEL1 VDD VDD sg13_lv_pmos ad=0.3808p pd=2.92u as=0.3808p ps=2.92u w=1.12u l=0.13u
X512 VDD DELAY_VBIASP.t9 a_20831_2470# VDD sg13_lv_pmos ad=0.3808p pd=2.92u as=0.2128p ps=1.5u w=1.12u l=0.6u
X513 VDD a_2595_1047.t2 a_26471_1008# VDD sg13_lv_pmos ad=0.3808p pd=2.92u as=0.3808p ps=2.92u w=1.12u l=0.13u
X514 a_4350_1044# a_5191_1008# a_5115_1044# VDD sg13_lv_pmos ad=0.3808p pd=2.92u as=0.2128p ps=1.5u w=1.12u l=0.13u
X515 VDD a_16597_1842# a_17065_1044# VDD sg13_lv_pmos ad=0.252p pd=1.57u as=0.3808p ps=2.92u w=1.12u l=0.13u
X516 VSS.t121 a_27237_1842# a_27705_1044# VSS.t544 sg13_lv_nmos ad=0.1665p pd=1.19u as=0.2516p ps=2.16u w=0.74u l=0.13u
X517 a_10191_2470# a_9953_1842# a_10083_1842# VDD sg13_lv_pmos ad=0.2128p pd=1.5u as=0.3808p ps=2.92u w=1.12u l=0.2u
X518 a_2595_1047.t1 a_2297_1395# VSS.t26 VSS.t25 sg13_lv_nmos ad=0.1406p pd=1.12u as=0.1331p ps=1.12u w=0.74u l=0.13u
X519 a_26151_1842# a_25913_1842# a_26043_1842# VSS.t196 sg13_lv_nmos ad=0.1406p pd=1.12u as=0.2516p ps=2.16u w=0.74u l=0.2u
X520 VSS.t176 a_2019_311# a_17865_519# VSS.t175 sg13_lv_nmos ad=0.2516p pd=2.16u as=0.2516p ps=2.16u w=0.74u l=0.13u
X521 VSS.t146 a_1544_289# a_2391_331# VSS.t562 sg13_lv_nmos ad=0.1331p pd=1.12u as=0.1216p ps=1.02u w=0.64u l=0.13u
X522 a_4871_1842# a_4633_1842# a_4763_1842# VSS.t404 sg13_lv_nmos ad=0.1406p pd=1.12u as=0.2516p ps=2.16u w=0.74u l=0.2u
X523 a_13753_1842# a_13557_1842# VSS.t396 VSS.t395 sg13_lv_nmos ad=0.2516p pd=2.16u as=0.1406p ps=1.12u w=0.74u l=0.13u
X524 a_1815_1395# a_1256_1044# a_1721_1395# VSS.t33 sg13_lv_nmos ad=0.1216p pd=1.02u as=0.2176p ps=1.96u w=0.64u l=0.13u
X525 a_7673_1842# a_7477_1842# VDD VDD sg13_lv_pmos ad=0.3808p pd=2.92u as=0.2128p ps=1.5u w=1.12u l=0.13u
X526 VDD VSS.t580 VDD VDD sg13_lv_pmos ad=0.34p pd=2.68u as=0 ps=0 w=1u l=1u
X527 a_1721_331# a_1256_289# VDD VDD sg13_lv_pmos ad=0.1596p pd=1.22u as=0.2856p ps=2.36u w=0.84u l=0.13u
X528 VSS.t529 a_24523_1842# a_24957_1842# VSS.t559 sg13_lv_nmos ad=0.1406p pd=1.12u as=0.2516p ps=2.16u w=0.74u l=0.13u
X529 a_6635_1044# a_6425_1044# VSS.t141 VSS.t140 sg13_lv_nmos ad=0.1406p pd=1.12u as=0.1665p ps=1.19u w=0.74u l=0.13u
X530 VSS.t259 a_2595_1047.t9 a_5191_1008# VSS.t258 sg13_lv_nmos ad=0.2516p pd=2.16u as=0.2516p ps=2.16u w=0.74u l=0.13u
X531 a_20315_1044# a_20105_1044# VSS.t54 VSS.t144 sg13_lv_nmos ad=0.1406p pd=1.12u as=0.1665p ps=1.19u w=0.74u l=0.13u
X532 VDD DELAY_VBIASP.t21 a_11711_2470# VDD sg13_lv_pmos ad=0.3808p pd=2.92u as=0.2128p ps=1.5u w=1.12u l=0.6u
X533 a_18795_1044# a_18585_1044# VDD VDD sg13_lv_pmos ad=0.2128p pd=1.5u as=0.252p ps=1.57u w=1.12u l=0.13u
X534 a_25528_1044# a_24957_1842# VSS.t527 VSS.t526 sg13_lv_nmos ad=0.1406p pd=1.12u as=0.2516p ps=2.16u w=0.74u l=0.13u
X535 VSS.t500 DELAY_VBIASN.t0 a_27671_1842# VSS.t499 sg13_lv_nmos ad=0.2516p pd=2.16u as=0.1406p ps=1.12u w=0.74u l=0.6u
X536 a_5731_289# a_3747_311.t3 a_13470_1044# VSS.t153 sg13_lv_nmos ad=0.2516p pd=2.16u as=0.2516p ps=2.16u w=0.74u l=0.13u
X537 a_25630_1044# a_27124_1008# a_27048_1044# VDD sg13_lv_pmos ad=0.3808p pd=2.92u as=0.2128p ps=1.5u w=1.12u l=0.13u
X538 VDD a_2595_1047.t5 a_17351_1008# VDD sg13_lv_pmos ad=0.3808p pd=2.92u as=0.3808p ps=2.92u w=1.12u l=0.13u
X539 VDD a_21483_1842# a_21917_1842# VDD sg13_lv_pmos ad=0.2128p pd=1.5u as=0.3808p ps=2.92u w=1.12u l=0.13u
X540 a_4350_1044# a_5844_1008# a_5768_1044# VDD sg13_lv_pmos ad=0.3808p pd=2.92u as=0.2128p ps=1.5u w=1.12u l=0.13u
X541 VSS.t179 a_16851_309# MUX_OUT VSS.t178 sg13_lv_nmos ad=0.2516p pd=2.16u as=0.1406p ps=1.12u w=0.74u l=0.13u
X542 VSS.t173 a_2019_311# a_5705_519# VSS.t172 sg13_lv_nmos ad=0.2516p pd=2.16u as=0.2516p ps=2.16u w=0.74u l=0.13u
X543 VDD a_1544_289# a_1721_331# VDD sg13_lv_pmos ad=0.1918p pd=1.5u as=0.1596p ps=1.22u w=0.84u l=0.13u
X544 a_7151_1842# a_6913_1842# a_7043_1842# VSS.t366 sg13_lv_nmos ad=0.1406p pd=1.12u as=0.2516p ps=2.16u w=0.74u l=0.2u
X545 a_16033_1842# a_15837_1842# VSS.t60 VSS.t59 sg13_lv_nmos ad=0.2516p pd=2.16u as=0.1406p ps=1.12u w=0.74u l=0.13u
X546 MUX_OUT a_16851_309# VDD VDD sg13_lv_pmos ad=0.2128p pd=1.5u as=0.2086p ps=1.5u w=1.12u l=0.13u
X547 a_25391_2470# a_25153_1842# a_25283_1842# VDD sg13_lv_pmos ad=0.2128p pd=1.5u as=0.3808p ps=2.92u w=1.12u l=0.2u
X548 VDD VSS.t592 VDD VDD sg13_lv_pmos ad=0.34p pd=2.68u as=0 ps=0 w=1u l=1u
X549 a_12993_1842# a_12797_1842# VDD VDD sg13_lv_pmos ad=0.3808p pd=2.92u as=0.2128p ps=1.5u w=1.12u l=0.13u
X550 a_16408_1044# a_15837_1842# VSS.t58 VSS.t57 sg13_lv_nmos ad=0.1406p pd=1.12u as=0.2516p ps=2.16u w=0.74u l=0.13u
X551 VSS.t390 a_5523_1842# a_5957_1842# VSS.t531 sg13_lv_nmos ad=0.1406p pd=1.12u as=0.2516p ps=2.16u w=0.74u l=0.13u
X552 VDD DELAY_VBIASP.t18 a_13991_2470# VDD sg13_lv_pmos ad=0.3808p pd=2.92u as=0.2128p ps=1.5u w=1.12u l=0.6u
X553 a_5731_289# a_2019_311# a_4350_1044# VSS.t171 sg13_lv_nmos ad=0.2516p pd=2.16u as=0.2516p ps=2.16u w=0.74u l=0.13u
X554 a_7390_1044# a_3747_1047.t8 a_9675_1044# VSS.t550 sg13_lv_nmos ad=0.2516p pd=2.16u as=0.1406p ps=1.12u w=0.74u l=0.13u
X555 VDD a_23763_1842# a_24197_1842# VDD sg13_lv_pmos ad=0.2128p pd=1.5u as=0.3808p ps=2.92u w=1.12u l=0.13u
X556 VSS.t438 DELAY_VBIASN.t25 a_8671_1842# VSS.t437 sg13_lv_nmos ad=0.2516p pd=2.16u as=0.1406p ps=1.12u w=0.74u l=0.6u
X557 VDD a_2019_1047.t8 a_7364_1008# VDD sg13_lv_pmos ad=0.3808p pd=2.92u as=0.3808p ps=2.92u w=1.12u l=0.13u
X558 VDD DELAY_VBIASP.t1 a_26911_2470# VDD sg13_lv_pmos ad=0.3808p pd=2.92u as=0.2128p ps=1.5u w=1.12u l=0.6u
X559 VDD VSS.t563 VDD VDD sg13_lv_pmos ad=0.19p pd=1.38u as=0 ps=0 w=1u l=1u
X560 a_12471_1842# a_12233_1842# a_12363_1842# VSS.t540 sg13_lv_nmos ad=0.1406p pd=1.12u as=0.2516p ps=2.16u w=0.74u l=0.2u
X561 a_22488_1044# a_21917_1842# VDD VDD sg13_lv_pmos ad=0.2128p pd=1.5u as=0.3808p ps=2.92u w=1.12u l=0.13u
X562 VDD a_2595_311.t3 a_8745_519# VDD sg13_lv_pmos ad=0.3808p pd=2.92u as=0.3808p ps=2.92u w=1.12u l=0.13u
X563 VSS.t72 a_3171_1047.t5 a_18004_1008# VSS.t71 sg13_lv_nmos ad=0.2516p pd=2.16u as=0.2516p ps=2.16u w=0.74u l=0.13u
X564 a_6391_2470# a_6153_1842# a_6283_1842# VDD sg13_lv_pmos ad=0.2128p pd=1.5u as=0.3808p ps=2.92u w=1.12u l=0.2u
X565 a_15273_1842# a_15077_1842# VDD VDD sg13_lv_pmos ad=0.3808p pd=2.92u as=0.2128p ps=1.5u w=1.12u l=0.13u
X566 a_14235_1044# a_14025_1044# VSS.t119 VSS.t118 sg13_lv_nmos ad=0.1406p pd=1.12u as=0.1665p ps=1.19u w=0.74u l=0.13u
X567 VSS.t139 a_3747_1047.t7 a_12791_1008# VSS.t138 sg13_lv_nmos ad=0.2516p pd=2.16u as=0.2516p ps=2.16u w=0.74u l=0.13u
X568 a_9953_1842# a_9757_1842# VSS.t157 VSS.t156 sg13_lv_nmos ad=0.2516p pd=2.16u as=0.1406p ps=1.12u w=0.74u l=0.13u
X569 VSS.t272 a_10843_1842# a_11277_1842# VSS.t271 sg13_lv_nmos ad=0.1406p pd=1.12u as=0.2516p ps=2.16u w=0.74u l=0.13u
X570 VSS.t348 VDD VSS.t347 VSS.t346 sg13_lv_nmos ad=0.1428p pd=1.52u as=0 ps=0 w=0.42u l=1u
X571 VDD a_15403_1842# a_15837_1842# VDD sg13_lv_pmos ad=0.2128p pd=1.5u as=0.3808p ps=2.92u w=1.12u l=0.13u
X572 VSS.t313 VDD VSS.t312 VSS.t311 sg13_lv_nmos ad=0.1428p pd=1.52u as=0 ps=0 w=0.42u l=1u
X573 a_11848_1044# a_11277_1842# VSS.t423 VSS.t422 sg13_lv_nmos ad=0.1406p pd=1.12u as=0.2516p ps=2.16u w=0.74u l=0.13u
X574 VDD a_4763_1842# a_5197_1842# VDD sg13_lv_pmos ad=0.2128p pd=1.5u as=0.3808p ps=2.92u w=1.12u l=0.13u
X575 VSS.t325 VDD VSS.t323 VSS.t324 sg13_lv_nmos ad=79.8f pd=0.8u as=0 ps=0 w=0.42u l=1u
X576 a_13470_1044# a_13444_1008# a_13368_1044# VDD sg13_lv_pmos ad=0.3808p pd=2.92u as=0.2128p ps=1.5u w=1.12u l=0.13u
X577 VDD a_3449_1395# a_3747_1047.t0 VDD sg13_lv_pmos ad=0.4256p pd=3u as=0.2128p ps=1.5u w=1.12u l=0.13u
X578 VDD a_3171_1047.t3 a_24084_1008# VDD sg13_lv_pmos ad=0.3808p pd=2.92u as=0.3808p ps=2.92u w=1.12u l=0.13u
X579 a_3449_1395# MUX_SEL0 VDD VDD sg13_lv_pmos ad=0.1596p pd=1.22u as=0.2856p ps=2.36u w=0.84u l=0.13u
X580 VDD DELAY_VBIASP.t26 a_7911_2470# VDD sg13_lv_pmos ad=0.3808p pd=2.92u as=0.2128p ps=1.5u w=1.12u l=0.6u
X581 VDD VSS.t595 VDD VDD sg13_lv_pmos ad=0.19p pd=1.38u as=0 ps=0 w=1u l=1u
X582 VDD VSS.t594 VDD VDD sg13_lv_pmos ad=0.34p pd=2.68u as=0 ps=0 w=1u l=1u
X583 VDD a_16851_309# MUX_OUT VDD sg13_lv_pmos ad=0.7336p pd=3.55u as=0.2128p ps=1.5u w=1.12u l=0.13u
X584 VSS.t250 a_3171_311.t2 a_23945_519# VSS.t249 sg13_lv_nmos ad=0.2516p pd=2.16u as=0.2516p ps=2.16u w=0.74u l=0.13u
X585 VDD a_18117_1842# a_18585_1044# VDD sg13_lv_pmos ad=0.252p pd=1.57u as=0.3808p ps=2.92u w=1.12u l=0.13u
X586 VSS.t54 a_19637_1842# a_20105_1044# VSS.t53 sg13_lv_nmos ad=0.1665p pd=1.19u as=0.2516p ps=2.16u w=0.74u l=0.13u
X587 a_11711_2470# a_11473_1842# a_11603_1842# VDD sg13_lv_pmos ad=0.2128p pd=1.5u as=0.3808p ps=2.92u w=1.12u l=0.2u
X588 a_27671_1842# a_27433_1842# a_27563_1842# VSS.t426 sg13_lv_nmos ad=0.1406p pd=1.12u as=0.2516p ps=2.16u w=0.74u l=0.2u
X589 VSS.t205 MUX_SEL4 a_15765_463# VSS.t204 sg13_lv_nmos ad=0.2516p pd=2.16u as=0.2516p ps=2.16u w=0.74u l=0.13u
X590 a_5731_289# a_14825_519# a_13470_1044# VDD sg13_lv_pmos ad=0.3808p pd=2.92u as=0.3808p ps=2.92u w=1.12u l=0.13u
X591 a_16510_1044# a_2595_1047.t5 a_17275_1044# VSS.t128 sg13_lv_nmos ad=0.2516p pd=2.16u as=0.1406p ps=1.12u w=0.74u l=0.13u
X592 VSS.t486 DELAY_VBIASN.t15 a_16271_1842# VSS.t485 sg13_lv_nmos ad=0.2516p pd=2.16u as=0.1406p ps=1.12u w=0.74u l=0.6u
X593 VDD VSS.t568 VDD VDD sg13_lv_pmos ad=0.34p pd=2.68u as=0 ps=0 w=1u l=1u
X594 VDD a_3171_1047.t6 a_14964_1008# VDD sg13_lv_pmos ad=0.3808p pd=2.92u as=0.3808p ps=2.92u w=1.12u l=0.13u
X595 VDD a_10083_1842# a_10517_1842# VDD sg13_lv_pmos ad=0.2128p pd=1.5u as=0.3808p ps=2.92u w=1.12u l=0.13u
X596 VSS.t136 a_3747_1047.t2 a_27991_1008# VSS.t135 sg13_lv_nmos ad=0.2516p pd=2.16u as=0.2516p ps=2.16u w=0.74u l=0.13u
X597 VSS.t109 a_26043_1842# a_26477_1842# VSS.t520 sg13_lv_nmos ad=0.1406p pd=1.12u as=0.2516p ps=2.16u w=0.74u l=0.13u
X598 a_11195_1044# a_10985_1044# VDD VDD sg13_lv_pmos ad=0.2128p pd=1.5u as=0.252p ps=1.57u w=1.12u l=0.13u
X599 VSS.t117 a_3747_1047.t9 a_6711_1008# VSS.t116 sg13_lv_nmos ad=0.2516p pd=2.16u as=0.2516p ps=2.16u w=0.74u l=0.13u
X600 a_16108_289# a_2595_311.t2 a_19550_1044# VSS.t226 sg13_lv_nmos ad=0.2516p pd=2.16u as=0.2516p ps=2.16u w=0.74u l=0.13u
X601 VSS.t496 DELAY_VBIASN.t10 a_20071_1842# VSS.t495 sg13_lv_nmos ad=0.2516p pd=2.16u as=0.1406p ps=1.12u w=0.74u l=0.6u
X602 VDD DELAY_VBIASP.t4 a_24631_2470# VDD sg13_lv_pmos ad=0.3808p pd=2.92u as=0.2128p ps=1.5u w=1.12u l=0.6u
X603 a_22590_1044# a_23431_1008# a_23355_1044# VDD sg13_lv_pmos ad=0.3808p pd=2.92u as=0.2128p ps=1.5u w=1.12u l=0.13u
X604 VSS.t305 VDD VSS.t303 VSS.t304 sg13_lv_nmos ad=79.8f pd=0.8u as=0 ps=0 w=0.42u l=1u
X605 a_8671_1842# a_8433_1842# a_8563_1842# VSS.t209 sg13_lv_nmos ad=0.1406p pd=1.12u as=0.2516p ps=2.16u w=0.74u l=0.2u
X606 a_17553_1842# a_17357_1842# VSS.t104 VSS.t103 sg13_lv_nmos ad=0.2516p pd=2.16u as=0.1406p ps=1.12u w=0.74u l=0.13u
X607 a_5731_289# a_5705_519# a_4350_1044# VDD sg13_lv_pmos ad=0.3808p pd=2.92u as=0.3808p ps=2.92u w=1.12u l=0.13u
X608 VDD VDD VDD VDD sg13_lv_pmos ad=0.3808p pd=2.92u as=0 ps=0 w=1.12u l=0.13u
X609 a_26911_2470# a_26673_1842# a_26803_1842# VDD sg13_lv_pmos ad=0.2128p pd=1.5u as=0.3808p ps=2.92u w=1.12u l=0.2u
X610 a_7390_1044# a_2019_1047.t8 a_7288_1044# VSS.t229 sg13_lv_nmos ad=0.2516p pd=2.16u as=0.1406p ps=1.12u w=0.74u l=0.13u
X611 a_21353_1842# a_21157_1842# VSS.t274 VSS.t400 sg13_lv_nmos ad=0.2516p pd=2.16u as=0.1406p ps=1.12u w=0.74u l=0.13u
X612 VSS.t508 a_7043_1842# a_7477_1842# VSS.t521 sg13_lv_nmos ad=0.1406p pd=1.12u as=0.2516p ps=2.16u w=0.74u l=0.13u
X613 VDD DELAY_VBIASP.t16 a_15511_2470# VDD sg13_lv_pmos ad=0.3808p pd=2.92u as=0.2128p ps=1.5u w=1.12u l=0.6u
X614 VDD a_2019_1047.t7 a_10404_1008# VDD sg13_lv_pmos ad=0.3808p pd=2.92u as=0.3808p ps=2.92u w=1.12u l=0.13u
X615 VDD a_25283_1842# a_25717_1842# VDD sg13_lv_pmos ad=0.2128p pd=1.5u as=0.3808p ps=2.92u w=1.12u l=0.13u
X616 VDD DELAY_VBIASP.t29 a_5631_2470# VDD sg13_lv_pmos ad=0.3808p pd=2.92u as=0.2128p ps=1.5u w=1.12u l=0.6u
X617 a_26395_1044# a_26185_1044# VDD VDD sg13_lv_pmos ad=0.2128p pd=1.5u as=0.252p ps=1.57u w=1.12u l=0.13u
X618 VDD a_3747_1047.t3 a_24951_1008# VDD sg13_lv_pmos ad=0.3808p pd=2.92u as=0.3808p ps=2.92u w=1.12u l=0.13u
X619 VDD VSS.t571 VDD VDD sg13_lv_pmos ad=0.19p pd=1.38u as=0 ps=0 w=1u l=1u
X620 a_13991_1842# a_13753_1842# a_13883_1842# VSS.t554 sg13_lv_nmos ad=0.1406p pd=1.12u as=0.2516p ps=2.16u w=0.74u l=0.2u
X621 a_24008_1044# a_23437_1842# VDD VDD sg13_lv_pmos ad=0.2128p pd=1.5u as=0.3808p ps=2.92u w=1.12u l=0.13u
X622 VDD VSS.t585 VDD VDD sg13_lv_pmos ad=0.19p pd=1.38u as=0 ps=0 w=1u l=1u
X623 VSS.t85 a_2019_1047.t4 a_19524_1008# VSS.t84 sg13_lv_nmos ad=0.2516p pd=2.16u as=0.2516p ps=2.16u w=0.74u l=0.13u
X624 a_7911_2470# a_7673_1842# a_7803_1842# VDD sg13_lv_pmos ad=0.2128p pd=1.5u as=0.3808p ps=2.92u w=1.12u l=0.2u
X625 a_16793_1842# a_16597_1842# VDD VDD sg13_lv_pmos ad=0.3808p pd=2.92u as=0.2128p ps=1.5u w=1.12u l=0.13u
X626 VSS.t74 MUX_SEL1 a_3543_1395# VSS.t535 sg13_lv_nmos ad=0.1331p pd=1.12u as=0.1216p ps=1.02u w=0.64u l=0.13u
X627 a_15755_1044# a_15545_1044# VSS.t219 VSS.t218 sg13_lv_nmos ad=0.1406p pd=1.12u as=0.1665p ps=1.19u w=0.74u l=0.13u
X628 a_2595_1047.t0 a_2297_1395# VDD VDD sg13_lv_pmos ad=0.2128p pd=1.5u as=0.1918p ps=1.5u w=1.12u l=0.13u
X629 VSS.t256 a_2595_1047.t6 a_14311_1008# VSS.t255 sg13_lv_nmos ad=0.2516p pd=2.16u as=0.2516p ps=2.16u w=0.74u l=0.13u
X630 VSS.t189 a_12363_1842# a_12797_1842# VSS.t502 sg13_lv_nmos ad=0.1406p pd=1.12u as=0.2516p ps=2.16u w=0.74u l=0.13u
X631 a_5115_1044# a_4905_1044# VSS.t37 VSS.t36 sg13_lv_nmos ad=0.1406p pd=1.12u as=0.1665p ps=1.19u w=0.74u l=0.13u
X632 a_1256_1044# MUX_SEL0 VDD VDD sg13_lv_pmos ad=0.3808p pd=2.92u as=0.3808p ps=2.92u w=1.12u l=0.13u
X633 VDD a_27563_1842# a_27997_1842# VDD sg13_lv_pmos ad=0.2128p pd=1.5u as=0.3808p ps=2.92u w=1.12u l=0.13u
X634 a_20593_1842# a_20397_1842# VDD VDD sg13_lv_pmos ad=0.3808p pd=2.92u as=0.2128p ps=1.5u w=1.12u l=0.13u
X635 a_1721_1395# a_1256_1044# VDD VDD sg13_lv_pmos ad=0.1596p pd=1.22u as=0.2856p ps=2.36u w=0.84u l=0.13u
X636 VDD a_6283_1842# a_6717_1842# VDD sg13_lv_pmos ad=0.2128p pd=1.5u as=0.3808p ps=2.92u w=1.12u l=0.13u
X637 a_13470_1044# a_14964_1008# a_14888_1044# VDD sg13_lv_pmos ad=0.3808p pd=2.92u as=0.2128p ps=1.5u w=1.12u l=0.13u
X638 VSS.t323 VDD VSS.t322 VSS.t321 sg13_lv_nmos ad=0.1428p pd=1.52u as=0 ps=0 w=0.42u l=1u
X639 VDD a_2019_1047.t2 a_25604_1008# VDD sg13_lv_pmos ad=0.3808p pd=2.92u as=0.3808p ps=2.92u w=1.12u l=0.13u
X640 a_16271_1842# a_16033_1842# a_16163_1842# VSS.t267 sg13_lv_nmos ad=0.1406p pd=1.12u as=0.2516p ps=2.16u w=0.74u l=0.2u
X641 a_21835_1044# a_21625_1044# VDD VDD sg13_lv_pmos ad=0.2128p pd=1.5u as=0.252p ps=1.57u w=1.12u l=0.13u
X642 VDD VSS.t596 VDD VDD sg13_lv_pmos ad=0.34p pd=2.68u as=0 ps=0 w=1u l=1u
X643 VDD a_2595_1047.t4 a_20391_1008# VDD sg13_lv_pmos ad=0.3808p pd=2.92u as=0.3808p ps=2.92u w=1.12u l=0.13u
X644 a_19073_1842# a_18877_1842# VDD VDD sg13_lv_pmos ad=0.3808p pd=2.92u as=0.2128p ps=1.5u w=1.12u l=0.13u
X645 VDD a_10517_1842# a_10985_1044# VDD sg13_lv_pmos ad=0.252p pd=1.57u as=0.3808p ps=2.92u w=1.12u l=0.13u
X646 VSS.t225 a_21157_1842# a_21625_1044# VSS.t399 sg13_lv_nmos ad=0.1665p pd=1.19u as=0.2516p ps=2.16u w=0.74u l=0.13u
X647 a_20071_1842# a_19833_1842# a_19963_1842# VSS.t518 sg13_lv_nmos ad=0.1406p pd=1.12u as=0.2516p ps=2.16u w=0.74u l=0.2u
X648 VSS.t425 a_14643_1842# a_15077_1842# VSS.t424 sg13_lv_nmos ad=0.1406p pd=1.12u as=0.2516p ps=2.16u w=0.74u l=0.13u
X649 a_1815_331# a_1256_289# a_1721_331# VSS.t45 sg13_lv_nmos ad=0.1216p pd=1.02u as=0.2176p ps=1.96u w=0.64u l=0.13u
X650 VDD a_19203_1842# a_19637_1842# VDD sg13_lv_pmos ad=0.2128p pd=1.5u as=0.3808p ps=2.92u w=1.12u l=0.13u
X651 VSS.t253 a_2019_1047.t9 a_4324_1008# VSS.t252 sg13_lv_nmos ad=0.2516p pd=2.16u as=0.2516p ps=2.16u w=0.74u l=0.13u
X652 a_16108_289# a_20905_519# a_19550_1044# VDD sg13_lv_pmos ad=0.3808p pd=2.92u as=0.3808p ps=2.92u w=1.12u l=0.13u
X653 a_16510_1044# a_3747_1047.t5 a_18795_1044# VSS.t125 sg13_lv_nmos ad=0.2516p pd=2.16u as=0.1406p ps=1.12u w=0.74u l=0.13u
X654 VDD a_8563_1842# a_8997_1842# VDD sg13_lv_pmos ad=0.2128p pd=1.5u as=0.3808p ps=2.92u w=1.12u l=0.13u
X655 VDD DELAY_VBIASP.t19 a_13231_2470# VDD sg13_lv_pmos ad=0.3808p pd=2.92u as=0.2128p ps=1.5u w=1.12u l=0.6u
X656 VSS.t488 DELAY_VBIASN.t13 a_17791_1842# VSS.t487 sg13_lv_nmos ad=0.2516p pd=2.16u as=0.1406p ps=1.12u w=0.74u l=0.6u
X657 VSS.t293 VDD VSS.t292 VSS.t291 sg13_lv_nmos ad=0.1428p pd=1.52u as=0 ps=0 w=0.42u l=1u
X658 VDD a_3747_1047.t5 a_18871_1008# VDD sg13_lv_pmos ad=0.3808p pd=2.92u as=0.3808p ps=2.92u w=1.12u l=0.13u
X659 VDD a_23003_1842# a_23437_1842# VDD sg13_lv_pmos ad=0.2128p pd=1.5u as=0.3808p ps=2.92u w=1.12u l=0.13u
X660 a_12715_1044# a_12505_1044# VDD VDD sg13_lv_pmos ad=0.2128p pd=1.5u as=0.252p ps=1.57u w=1.12u l=0.13u
X661 a_19550_1044# a_21044_1008# a_20968_1044# VDD sg13_lv_pmos ad=0.3808p pd=2.92u as=0.2128p ps=1.5u w=1.12u l=0.13u
X662 a_17928_1044# a_17357_1842# VDD VDD sg13_lv_pmos ad=0.2128p pd=1.5u as=0.3808p ps=2.92u w=1.12u l=0.13u
X663 VSS.t466 DELAY_VBIASN.t8 a_21591_1842# VSS.t465 sg13_lv_nmos ad=0.2516p pd=2.16u as=0.1406p ps=1.12u w=0.74u l=0.6u
X664 VSS.t150 a_1544_289# a_1815_331# VSS.t561 sg13_lv_nmos ad=0.1331p pd=1.12u as=0.1216p ps=1.02u w=0.64u l=0.13u
X665 a_7288_1044# a_6717_1842# VDD VDD sg13_lv_pmos ad=0.2128p pd=1.5u as=0.3808p ps=2.92u w=1.12u l=0.13u
X666 a_15511_2470# a_15273_1842# a_15403_1842# VDD sg13_lv_pmos ad=0.2128p pd=1.5u as=0.3808p ps=2.92u w=1.12u l=0.2u
X667 VSS.t376 VSS.t378 VSS.t380 VSS.t379 sg13_lv_nmos ad=0.1406p pd=1.12u as=0 ps=0 w=0.74u l=0.2u
X668 a_22590_1044# a_24951_1008# a_24875_1044# VDD sg13_lv_pmos ad=0.3808p pd=2.92u as=0.2128p ps=1.5u w=1.12u l=0.13u
X669 VSS.t365 VDD VSS.t363 VSS.t364 sg13_lv_nmos ad=79.8f pd=0.8u as=0 ps=0 w=0.42u l=1u
X670 a_10430_1044# a_2019_1047.t7 a_10328_1044# VSS.t86 sg13_lv_nmos ad=0.2516p pd=2.16u as=0.1406p ps=1.12u w=0.74u l=0.13u
X671 VDD a_25717_1842# a_26185_1044# VDD sg13_lv_pmos ad=0.252p pd=1.57u as=0.3808p ps=2.92u w=1.12u l=0.13u
X672 VDD a_13883_1842# a_14317_1842# VDD sg13_lv_pmos ad=0.2128p pd=1.5u as=0.3808p ps=2.92u w=1.12u l=0.13u
X673 VDD a_4437_1842# a_4905_1044# VDD sg13_lv_pmos ad=0.252p pd=1.57u as=0.3808p ps=2.92u w=1.12u l=0.13u
X674 a_4157_1313# DELAY_IN VSS.t270 VSS.t269 sg13_lv_nmos ad=0.2516p pd=2.16u as=0.2553p ps=2.17u w=0.74u l=0.13u
X675 a_7390_1044# a_3171_1047.t8 a_8808_1044# VSS.t6 sg13_lv_nmos ad=0.2516p pd=2.16u as=0.1406p ps=1.12u w=0.74u l=0.13u
X676 a_22873_1842# a_22677_1842# VSS.t406 VSS.t412 sg13_lv_nmos ad=0.2516p pd=2.16u as=0.1406p ps=1.12u w=0.74u l=0.13u
X677 VDD a_3171_1047.t8 a_8884_1008# VDD sg13_lv_pmos ad=0.3808p pd=2.92u as=0.3808p ps=2.92u w=1.12u l=0.13u
C0 a_4633_1842# a_5197_1842# 0.0114f
C1 a_22677_1842# a_21917_1842# 0.06198f
C2 a_17865_519# VDD 0.29444f
C3 a_12233_1842# a_12037_1842# 0.77122f
C4 a_9757_1842# a_10328_1044# 0.10864f
C5 a_17357_1842# a_17553_1842# 0.76914f
C6 a_16271_2470# a_16163_1842# 0.01697f
C7 a_20593_1842# a_21157_1842# 0.0114f
C8 a_19448_1044# a_19524_1008# 0.01176f
C9 a_15831_1008# a_15837_1842# 0.02354f
C10 a_21625_1044# a_21911_1008# 0.01885f
C11 a_12363_1842# a_10430_1044# 0.01012f
C12 MUX_SEL4 VDD 2.63176f
C13 a_6425_1044# VDD 0.29722f
C14 a_8884_1008# VDD 0.28225f
C15 a_11277_1842# a_10843_1842# 0.6972f
C16 a_27433_1842# a_27563_1842# 0.70845f
C17 a_22488_1044# a_21917_1842# 0.10864f
C18 VDD a_15755_1044# 0.15389f
C19 a_6635_1044# a_4350_1044# 0.39036f
C20 VDD a_11271_1008# 0.28336f
C21 VDD a_6717_1842# 0.87726f
C22 a_9757_1842# a_10083_1842# 0.01427f
C23 DELAY_VBIASP a_16923_1842# 0.06627f
C24 DELAY_VBIASN a_16793_1842# 0.0961f
C25 a_8997_1842# a_8563_1842# 0.6972f
C26 a_7288_1044# a_6717_1842# 0.10864f
C27 a_4871_2470# a_4763_1842# 0.01697f
C28 a_16108_289# a_19550_1044# 0.58202f
C29 a_24393_1842# a_24197_1842# 0.77122f
C30 a_1721_331# VDD 0.45259f
C31 VDD a_20723_1842# 0.49671f
C32 a_13557_1842# a_13123_1842# 0.69698f
C33 VDD a_11473_1842# 0.49417f
C34 a_16510_1044# a_17357_1842# 0.08038f
C35 DELAY_VBIASP a_26673_1842# 0.11222f
C36 a_15831_1008# a_13470_1044# 0.26208f
C37 a_26911_1842# a_26803_1842# 0.01163f
C38 VDD a_22351_2470# 0.01806f
C39 a_12791_1008# a_12715_1044# 0.01194f
C40 a_22590_1044# a_23003_1842# 0.01012f
C41 a_5844_1008# a_5197_1842# 0.02312f
C42 a_23633_1842# a_24197_1842# 0.0114f
C43 a_14317_1842# a_14513_1842# 0.76914f
C44 a_9193_1842# VDD 0.49285f
C45 a_7151_1842# a_7043_1842# 0.01163f
C46 a_24875_1044# a_22590_1044# 0.39036f
C47 MUX_SEL4 a_1544_289# 0.47529f
C48 MUX_OUT a_1256_289# 0.1134f
C49 a_15755_1044# a_15545_1044# 0.09424f
C50 DELAY_VBIASP a_18443_1842# 0.06627f
C51 a_15964_289# a_16851_309# 0.16757f
C52 a_12363_1842# VDD 0.4973f
C53 a_25717_1842# a_25604_1008# 0.05157f
C54 a_25913_1842# a_26477_1842# 0.0114f
C55 a_15077_1842# a_15837_1842# 0.02912f
C56 a_18877_1842# a_19073_1842# 0.76914f
C57 VDD a_21044_1008# 0.28225f
C58 VDD a_23437_1842# 0.86909f
C59 a_26185_1044# a_26471_1008# 0.01885f
C60 a_24084_1008# VDD 0.28225f
C61 a_16510_1044# a_18877_1842# 0.02479f
C62 a_14317_1842# a_14888_1044# 0.10863f
C63 a_25717_1842# VDD 0.86707f
C64 VDD a_14513_1842# 0.49417f
C65 DELAY_VBIASP a_6913_1842# 0.11222f
C66 a_15765_463# MUX_SEL4 0.65508f
C67 DELAY_VBIASN a_6717_1842# 0.09992f
C68 a_2297_1395# MUX_SEL0 0.10655f
C69 a_2873_1395# a_1256_1044# 0.28892f
C70 a_24957_1842# a_25717_1842# 0.06198f
C71 a_2297_331# a_1256_289# 0.04261f
C72 a_1721_331# a_1544_289# 0.36963f
C73 a_7803_1842# DELAY_VBIASP 0.06627f
C74 a_16851_309# a_2019_311# 0.01299f
C75 a_4157_1313# a_4437_1842# 0.01771f
C76 a_3449_331# DELAY_IN 0.01017f
C77 a_8231_1008# a_8237_1842# 0.02349f
C78 a_13231_2470# a_13123_1842# 0.01697f
C79 VDD a_26043_1842# 0.4973f
C80 DELAY_VBIASN a_20723_1842# 0.07254f
C81 DELAY_VBIASP a_21917_1842# 0.0414f
C82 a_4633_1842# DELAY_VBIASP 0.11222f
C83 a_5191_1008# VDD 0.28565f
C84 a_6717_1842# a_7043_1842# 0.01427f
C85 a_7390_1044# a_9675_1044# 0.39036f
C86 DELAY_VBIASN a_11473_1842# 0.0961f
C87 DELAY_VBIASP a_11603_1842# 0.06627f
C88 MUX_SEL4 a_5705_519# 0.03556f
C89 MUX_SEL3 a_2019_311# 0.06209f
C90 VDD a_14888_1044# 0.17499f
C91 a_8671_2470# VDD 0.01806f
C92 a_9323_1842# DELAY_VBIASP 0.06627f
C93 MUX_OUT a_1544_1044# 0.04258f
C94 MUX_SEL1 a_2297_1395# 0.01995f
C95 a_13470_1044# a_15077_1842# 0.05231f
C96 a_9193_1842# DELAY_VBIASN 0.0961f
C97 a_7364_1008# a_6717_1842# 0.02011f
C98 a_24393_1842# DELAY_VBIASP 0.11222f
C99 a_10430_1044# a_11195_1044# 0.39037f
C100 VDD a_19524_1008# 0.28633f
C101 VDD a_26911_2470# 0.01806f
C102 VDD a_16163_1842# 0.4973f
C103 VDD a_20105_1044# 0.30409f
C104 VDD a_27563_1842# 0.49811f
C105 a_11711_2470# VDD 0.01806f
C106 a_16597_1842# a_16163_1842# 0.69698f
C107 a_12363_1842# DELAY_VBIASN 0.07254f
C108 a_13557_1842# DELAY_VBIASP 0.0414f
C109 a_5393_1842# a_5523_1842# 0.70845f
C110 a_27124_1008# a_25630_1044# 0.28279f
C111 a_9953_1842# a_10517_1842# 0.0114f
C112 DELAY_VBIASP a_23633_1842# 0.11222f
C113 DELAY_VBIASN a_23437_1842# 0.09974f
C114 a_8997_1842# a_8237_1842# 0.03319f
C115 a_21353_1842# a_21483_1842# 0.70845f
C116 DELAY_VBIASN a_14513_1842# 0.0961f
C117 DELAY_VBIASP a_14643_1842# 0.06627f
C118 a_13470_1044# a_14964_1008# 0.28279f
C119 a_14235_1044# a_14311_1008# 0.01194f
C120 VDD a_20397_1842# 0.86909f
C121 a_25913_1842# DELAY_VBIASP 0.11222f
C122 a_25717_1842# DELAY_VBIASN 0.08411f
C123 a_10430_1044# a_10843_1842# 0.01012f
C124 a_7390_1044# a_9757_1842# 0.02479f
C125 a_27048_1044# VDD 0.17499f
C126 a_16851_309# VDD 0.51536f
C127 a_5731_289# a_8745_519# 0.28635f
C128 a_17357_1842# a_16923_1842# 0.6972f
C129 VDD a_17928_1044# 0.17499f
C130 a_23111_1842# a_23003_1842# 0.01163f
C131 a_19448_1044# a_19550_1044# 0.37183f
C132 DELAY_VBIASN a_26043_1842# 0.07254f
C133 a_21625_1044# a_21835_1044# 0.09424f
C134 a_18004_1008# a_17357_1842# 0.02312f
C135 a_12797_1842# a_10430_1044# 0.02479f
C136 a_27705_1044# VDD 0.29918f
C137 MUX_SEL3 VDD 0.4053f
C138 a_9757_1842# a_9953_1842# 0.76914f
C139 a_4905_1044# VDD 0.30126f
C140 a_26803_1842# a_26911_2470# 0.01697f
C141 a_8808_1044# VDD 0.17499f
C142 a_10713_1842# a_10843_1842# 0.70845f
C143 a_12233_1842# a_12363_1842# 0.70845f
C144 a_27433_1842# a_27997_1842# 0.0114f
C145 a_26985_519# VDD 0.29292f
C146 a_21911_1008# a_21917_1842# 0.02354f
C147 a_12791_1008# a_12505_1044# 0.01885f
C148 VDD a_11195_1044# 0.15389f
C149 a_5844_1008# a_4350_1044# 0.28279f
C150 a_6711_1008# a_6425_1044# 0.01885f
C151 a_2297_1395# VDD 0.46536f
C152 a_5523_1842# VDD 0.49671f
C153 a_4324_1008# a_4437_1842# 0.05157f
C154 VDD a_17031_2470# 0.01806f
C155 DELAY_VBIASP a_17357_1842# 0.0414f
C156 a_19524_1008# a_19637_1842# 0.05157f
C157 DELAY_VBIASN a_16163_1842# 0.07254f
C158 a_16108_289# a_5731_289# 0.01334f
C159 DELAY_VBIASN a_27563_1842# 0.07259f
C160 MUX_SEL4 a_11785_519# 0.03255f
C161 a_8433_1842# a_8563_1842# 0.70845f
C162 a_6711_1008# a_6717_1842# 0.02354f
C163 a_20105_1044# a_19637_1842# 0.19203f
C164 a_27124_1008# a_27237_1842# 0.02055f
C165 a_12993_1842# a_13123_1842# 0.70845f
C166 VDD a_21157_1842# 0.85848f
C167 a_4324_1008# a_4157_1313# 0.02463f
C168 a_27915_1044# a_27991_1008# 0.01194f
C169 MUX_SEL4 a_13470_1044# 0.256f
C170 a_17351_1008# a_17065_1044# 0.01885f
C171 VDD a_10843_1842# 0.4973f
C172 DELAY_VBIASN a_20397_1842# 0.09974f
C173 a_15755_1044# a_13470_1044# 0.39036f
C174 a_19637_1842# a_20397_1842# 0.01669f
C175 a_22590_1044# a_23437_1842# 0.08038f
C176 a_10951_2470# a_10843_1842# 0.01697f
C177 VDD a_21591_2470# 0.01806f
C178 a_5768_1044# a_5197_1842# 0.10863f
C179 a_23437_1842# a_23763_1842# 0.01427f
C180 a_8563_1842# VDD 0.49671f
C181 a_23431_1008# a_23355_1044# 0.01194f
C182 a_24084_1008# a_22590_1044# 0.28279f
C183 a_26395_1044# a_26471_1008# 0.01194f
C184 DELAY_IN DELAY_VBIASP 0.07719f
C185 a_7803_1842# a_7911_1842# 0.01163f
C186 MUX_SEL4 a_1256_289# 0.65005f
C187 a_21591_1842# a_21483_1842# 0.01163f
C188 MUX_SEL3 a_1544_289# 0.15976f
C189 DELAY_VBIASP a_18877_1842# 0.0414f
C190 a_15964_289# a_16108_289# 0.42202f
C191 a_12797_1842# VDD 0.87771f
C192 a_25717_1842# a_25630_1044# 0.1088f
C193 a_18877_1842# a_18443_1842# 0.6972f
C194 a_15077_1842# a_15273_1842# 0.77122f
C195 a_17865_519# a_16510_1044# 0.02165f
C196 MUX_SEL2 MUX_SEL0 0.01204f
C197 VDD a_20968_1044# 0.17499f
C198 VDD a_22873_1842# 0.49294f
C199 MUX_OUT a_1256_1044# 0.02466f
C200 a_17275_1044# a_17351_1008# 0.01194f
C201 a_7390_1044# a_9465_1044# 0.03208f
C202 a_24008_1044# VDD 0.17499f
C203 a_26185_1044# a_26395_1044# 0.09424f
C204 DELAY_VBIASP a_10517_1842# 0.0414f
C205 a_14317_1842# a_14311_1008# 0.02349f
C206 a_25153_1842# VDD 0.49426f
C207 a_5957_1842# a_6153_1842# 0.77122f
C208 DELAY_VBIASP a_6283_1842# 0.06627f
C209 a_4248_1044# a_4350_1044# 0.37183f
C210 a_14825_519# MUX_SEL4 0.03307f
C211 a_25630_1044# a_26043_1842# 0.01012f
C212 a_5523_1842# DELAY_VBIASN 0.07254f
C213 a_1721_331# a_1256_289# 0.13421f
C214 a_24957_1842# a_25153_1842# 0.76914f
C215 a_9675_1044# a_9751_1008# 0.01194f
C216 a_7673_1842# a_8237_1842# 0.0114f
C217 a_16108_289# a_2019_311# 0.33889f
C218 a_12505_1044# a_12037_1842# 0.2079f
C219 a_4350_1044# a_6283_1842# 0.01012f
C220 DELAY_VBIASP a_21353_1842# 0.11222f
C221 a_11848_1044# a_11924_1008# 0.01176f
C222 DELAY_VBIASN a_21157_1842# 0.09156f
C223 a_12797_1842# a_13444_1008# 0.02011f
C224 a_4003_1842# DELAY_VBIASP 0.05992f
C225 a_5115_1044# VDD 0.15389f
C226 MUX_SEL4 a_7390_1044# 0.34655f
C227 a_8155_1044# a_8231_1008# 0.01194f
C228 a_7390_1044# a_8884_1008# 0.28279f
C229 a_6717_1842# a_7477_1842# 0.06198f
C230 DELAY_VBIASN a_10843_1842# 0.07254f
C231 DELAY_VBIASP a_12037_1842# 0.04141f
C232 MUX_SEL4 a_3449_331# 0.05166f
C233 VDD a_14311_1008# 0.28336f
C234 a_2019_311# a_4157_1313# 0.01018f
C235 a_15837_1842# a_16163_1842# 0.01427f
C236 a_7911_2470# VDD 0.01806f
C237 a_25630_1044# a_27563_1842# 0.01024f
C238 a_8563_1842# DELAY_VBIASN 0.07254f
C239 MUX_SEL4 a_1544_1044# 0.03407f
C240 a_9757_1842# DELAY_VBIASP 0.0414f
C241 a_8745_519# VDD 0.29292f
C242 VDD a_18313_1842# 0.49285f
C243 a_10430_1044# a_10404_1008# 0.277f
C244 VDD a_19550_1044# 0.89766f
C245 a_17031_1842# a_16923_1842# 0.01163f
C246 VDD a_26151_2470# 0.01806f
C247 VDD a_18585_1044# 0.29722f
C248 VDD a_27997_1842# 0.76025f
C249 a_11924_1008# a_12037_1842# 0.02055f
C250 a_12993_1842# DELAY_VBIASP 0.11222f
C251 a_12797_1842# DELAY_VBIASN 0.09992f
C252 a_9751_1008# a_9757_1842# 0.02354f
C253 a_5393_1842# a_5957_1842# 0.0114f
C254 a_27048_1044# a_25630_1044# 0.38994f
C255 a_26477_1842# a_27124_1008# 0.02312f
C256 DELAY_VBIASN a_22873_1842# 0.0961f
C257 DELAY_VBIASP a_23003_1842# 0.06627f
C258 a_8433_1842# a_8237_1842# 0.76914f
C259 a_21353_1842# a_21917_1842# 0.0114f
C260 DELAY_VBIASP a_15077_1842# 0.04141f
C261 a_25283_1842# DELAY_VBIASP 0.06627f
C262 a_13470_1044# a_14888_1044# 0.38994f
C263 VDD a_19833_1842# 0.49294f
C264 a_25153_1842# DELAY_VBIASN 0.0961f
C265 a_10430_1044# a_11277_1842# 0.08038f
C266 a_18313_1842# a_18117_1842# 0.77122f
C267 a_26471_1008# VDD 0.28336f
C268 a_16108_289# VDD 1.25759f
C269 a_11711_1842# a_11603_1842# 0.01163f
C270 a_27705_1044# a_25630_1044# 0.03208f
C271 a_12037_1842# a_11603_1842# 0.6972f
C272 a_18585_1044# a_18117_1842# 0.2079f
C273 a_16793_1842# a_16923_1842# 0.70845f
C274 a_16108_289# a_24957_1842# 0.0157f
C275 VDD a_17351_1008# 0.28565f
C276 a_4437_1842# VDD 0.86998f
C277 a_25630_1044# a_26985_519# 0.02165f
C278 VDD a_8237_1842# 0.86909f
C279 a_24523_1842# a_24631_1842# 0.01163f
C280 a_18871_1008# a_18585_1044# 0.01885f
C281 a_15511_1842# a_15403_1842# 0.01163f
C282 a_26185_1044# VDD 0.30409f
C283 MUX_SEL2 VDD 0.50938f
C284 a_9757_1842# a_9323_1842# 0.6972f
C285 a_4157_1313# VDD 0.48935f
C286 a_8231_1008# VDD 0.28336f
C287 a_10713_1842# a_11277_1842# 0.0114f
C288 a_12233_1842# a_12797_1842# 0.0114f
C289 VDD a_10404_1008# 0.28633f
C290 DELAY_VBIASN a_18313_1842# 0.0961f
C291 a_5768_1044# a_4350_1044# 0.38994f
C292 a_6635_1044# a_6425_1044# 0.09424f
C293 DELAY_VBIASN a_19550_1044# 0.02115f
C294 a_5957_1842# VDD 0.85848f
C295 a_19550_1044# a_19637_1842# 0.1088f
C296 a_19311_1842# a_19203_1842# 0.01163f
C297 a_22677_1842# a_23437_1842# 0.01669f
C298 DELAY_VBIASP a_16793_1842# 0.11222f
C299 DELAY_VBIASN a_27997_1842# 0.04176f
C300 a_15964_289# a_5731_289# 0.2778f
C301 a_8433_1842# a_8997_1842# 0.0114f
C302 VDD a_20593_1842# 0.49417f
C303 a_12993_1842# a_13557_1842# 0.0114f
C304 a_17275_1044# a_17065_1044# 0.09424f
C305 DELAY_VBIASN a_19833_1842# 0.0961f
C306 VDD a_11277_1842# 0.86909f
C307 a_19637_1842# a_19833_1842# 0.73897f
C308 a_21835_1044# a_21911_1008# 0.01194f
C309 a_23437_1842# a_24197_1842# 0.03319f
C310 VDD a_20831_2470# 0.01806f
C311 a_5191_1008# a_5197_1842# 0.02349f
C312 a_2019_311# a_5731_289# 1.15781f
C313 a_8997_1842# VDD 0.85848f
C314 VDD a_23355_1044# 0.15389f
C315 a_5731_289# a_10430_1044# 0.41176f
C316 a_24008_1044# a_22590_1044# 0.38994f
C317 a_24084_1008# a_24197_1842# 0.02055f
C318 a_27705_1044# a_27237_1842# 0.2079f
C319 a_5631_2470# a_5523_1842# 0.01697f
C320 a_20397_1842# a_19963_1842# 0.6972f
C321 a_4437_1842# DELAY_VBIASN 0.08375f
C322 a_9751_1008# a_9465_1044# 0.01885f
C323 MUX_SEL3 a_1256_289# 1.41161f
C324 MUX_SEL2 a_1544_289# 0.07405f
C325 VDD a_16033_1842# 0.49413f
C326 DELAY_VBIASN a_8237_1842# 0.09974f
C327 a_15765_463# a_16108_289# 0.42004f
C328 a_24875_1044# a_24951_1008# 0.01194f
C329 a_16033_1842# a_16597_1842# 0.0114f
C330 a_10985_1044# a_10517_1842# 0.19203f
C331 a_15077_1842# a_14643_1842# 0.6972f
C332 a_25717_1842# a_26477_1842# 0.01669f
C333 a_9431_2470# a_9323_1842# 0.01697f
C334 a_4003_1842# a_4111_1842# 0.01163f
C335 a_16851_309# a_16510_1044# 0.02131f
C336 MUX_SEL1 MUX_SEL0 3.14917f
C337 a_3449_1395# MUX_SEL0 0.10753f
C338 a_4157_1313# DELAY_VBIASN 0.01202f
C339 VDD a_22243_1842# 0.49737f
C340 MUX_SEL4 a_1256_1044# 0.04908f
C341 a_16510_1044# a_17928_1044# 0.38994f
C342 a_23431_1008# VDD 0.28336f
C343 a_24523_1842# VDD 0.4973f
C344 MUX_SEL4 a_4350_1044# 0.31434f
C345 DELAY_VBIASP a_6717_1842# 0.0414f
C346 a_26477_1842# a_26043_1842# 0.6972f
C347 a_6425_1044# a_4350_1044# 0.03208f
C348 a_5957_1842# DELAY_VBIASN 0.09156f
C349 a_24957_1842# a_24523_1842# 0.6972f
C350 a_15964_289# a_2019_311# 0.02413f
C351 a_4350_1044# a_6717_1842# 0.02479f
C352 DELAY_VBIASN a_20593_1842# 0.0961f
C353 DELAY_VBIASP a_20723_1842# 0.06627f
C354 MUX_SEL1 a_3449_1395# 0.29404f
C355 a_4003_1842# DELAY_IN 0.54998f
C356 a_4324_1008# VDD 0.28597f
C357 DELAY_VBIASN a_11277_1842# 0.09974f
C358 VDD a_17683_1842# 0.49671f
C359 a_6717_1842# a_6913_1842# 0.76914f
C360 a_7390_1044# a_8808_1044# 0.38994f
C361 DELAY_VBIASP a_11473_1842# 0.11222f
C362 a_16271_2470# VDD 0.01806f
C363 MUX_SEL3 a_3449_331# 0.28429f
C364 MUX_SEL4 a_2873_331# 0.04916f
C365 MUX_OUT a_2297_331# 0.01179f
C366 VDD a_14235_1044# 0.15389f
C367 a_7151_2470# VDD 0.01806f
C368 a_9193_1842# DELAY_VBIASP 0.11222f
C369 a_5731_289# VDD 0.6143f
C370 a_8997_1842# DELAY_VBIASN 0.09156f
C371 a_5768_1044# a_5844_1008# 0.01176f
C372 a_10328_1044# a_10404_1008# 0.01176f
C373 VDD a_19448_1044# 0.17274f
C374 VDD a_25391_2470# 0.01806f
C375 DELAY_VBIASN a_16033_1842# 0.0961f
C376 VDD a_17065_1044# 0.30218f
C377 VDD a_27433_1842# 0.49285f
C378 a_16108_289# a_22590_1044# 0.58202f
C379 a_1544_1044# a_2297_1395# 0.28651f
C380 a_24523_1842# a_24631_2470# 0.01697f
C381 a_12363_1842# DELAY_VBIASP 0.06627f
C382 a_17065_1044# a_16597_1842# 0.19203f
C383 a_21625_1044# a_21157_1842# 0.2079f
C384 a_5197_1842# a_5523_1842# 0.01427f
C385 a_26471_1008# a_25630_1044# 0.28268f
C386 a_26477_1842# a_27048_1044# 0.10863f
C387 a_16108_289# a_25630_1044# 0.55833f
C388 VDD a_6153_1842# 0.49285f
C389 a_18117_1842# a_17683_1842# 0.6972f
C390 DELAY_VBIASP a_23437_1842# 0.0414f
C391 a_9757_1842# a_10517_1842# 0.06198f
C392 DELAY_VBIASN a_22243_1842# 0.07254f
C393 VDD MUX_SEL0 0.56365f
C394 a_20315_1044# a_20391_1008# 0.01194f
C395 VDD a_19203_1842# 0.49737f
C396 DELAY_VBIASP a_14513_1842# 0.11222f
C397 a_13470_1044# a_14311_1008# 0.28268f
C398 a_25717_1842# DELAY_VBIASP 0.0414f
C399 a_24523_1842# DELAY_VBIASN 0.07254f
C400 a_23145_1044# a_23355_1044# 0.09424f
C401 a_26395_1044# VDD 0.15389f
C402 a_15964_289# VDD 0.31312f
C403 a_21591_2470# a_21483_1842# 0.01697f
C404 a_16793_1842# a_17357_1842# 0.0114f
C405 a_26185_1044# a_25630_1044# 0.03209f
C406 a_11473_1842# a_11603_1842# 0.70845f
C407 VDD a_17275_1044# 0.15389f
C408 a_14311_1008# a_14025_1044# 0.01885f
C409 VDD a_7673_1842# 0.49294f
C410 DELAY_VBIASP a_26043_1842# 0.06627f
C411 DELAY_VBIASN a_17683_1842# 0.07254f
C412 a_18795_1044# a_18585_1044# 0.09424f
C413 a_14317_1842# a_13883_1842# 0.6972f
C414 MUX_SEL1 VDD 0.50267f
C415 a_24665_1044# VDD 0.29722f
C416 a_9193_1842# a_9323_1842# 0.70845f
C417 a_8155_1044# VDD 0.15389f
C418 a_3449_1395# VDD 0.46731f
C419 a_12471_1842# a_12363_1842# 0.01163f
C420 a_23145_1044# a_23431_1008# 0.01885f
C421 a_2019_311# VDD 1.43004f
C422 a_22243_1842# a_22113_1842# 0.70845f
C423 VDD a_10430_1044# 0.88416f
C424 a_5191_1008# a_4350_1044# 0.28268f
C425 a_5393_1842# VDD 0.49417f
C426 a_22677_1842# a_22873_1842# 0.73897f
C427 DELAY_VBIASP a_16163_1842# 0.06627f
C428 DELAY_VBIASP a_27563_1842# 0.06629f
C429 DELAY_VBIASN a_27433_1842# 0.0961f
C430 DELAY_OUT_LAST a_27997_1842# 0.70955f
C431 a_15765_463# a_5731_289# 0.23301f
C432 a_22590_1044# a_23355_1044# 0.39037f
C433 a_20071_1842# a_19963_1842# 0.01163f
C434 a_7151_2470# a_7043_1842# 0.01697f
C435 a_19550_1044# a_19963_1842# 0.01012f
C436 VDD a_13883_1842# 0.4973f
C437 DELAY_VBIASN a_6153_1842# 0.0961f
C438 a_18004_1008# a_17928_1044# 0.01176f
C439 a_12797_1842# a_13123_1842# 0.01427f
C440 DELAY_VBIASP a_20397_1842# 0.0414f
C441 DELAY_VBIASN a_19203_1842# 0.07254f
C442 a_16510_1044# a_18585_1044# 0.03208f
C443 VDD a_10713_1842# 0.49294f
C444 a_14317_1842# VDD 0.86909f
C445 a_7390_1044# a_8745_519# 0.01756f
C446 a_15837_1842# a_16033_1842# 0.76914f
C447 a_19637_1842# a_19203_1842# 0.69698f
C448 VDD a_20071_2470# 0.01806f
C449 a_23437_1842# a_23633_1842# 0.76914f
C450 a_21625_1044# a_19550_1044# 0.03208f
C451 a_8433_1842# VDD 0.49417f
C452 a_17031_2470# a_16923_1842# 0.01697f
C453 a_5705_519# a_5731_289# 0.28954f
C454 VDD a_22564_1008# 0.28633f
C455 a_23431_1008# a_22590_1044# 0.28268f
C456 a_24523_1842# a_22590_1044# 0.01012f
C457 a_9675_1044# a_9465_1044# 0.09424f
C458 a_19833_1842# a_19963_1842# 0.70845f
C459 a_27705_1044# a_27991_1008# 0.01885f
C460 a_19550_1044# a_21483_1842# 0.01012f
C461 a_25604_1008# VDD 0.28633f
C462 MUX_SEL2 a_1256_289# 0.33134f
C463 VDD a_15403_1842# 0.4973f
C464 a_15765_463# a_15964_289# 0.061f
C465 DELAY_VBIASN a_7673_1842# 0.0961f
C466 a_24957_1842# a_25604_1008# 0.02011f
C467 a_10985_1044# a_11271_1008# 0.01885f
C468 a_14513_1842# a_14643_1842# 0.70845f
C469 a_2019_311# a_1544_289# 0.01747f
C470 a_25717_1842# a_25913_1842# 0.73897f
C471 a_16108_289# a_16510_1044# 0.56108f
C472 a_4003_1842# a_4111_2470# 0.01697f
C473 MUX_SEL4 DELAY_IN 0.0663f
C474 a_23003_1842# a_23111_2470# 0.01697f
C475 a_16510_1044# a_17351_1008# 0.28268f
C476 a_11711_2470# a_11603_1842# 0.01697f
C477 DELAY_VBIASN a_10430_1044# 0.02115f
C478 VDD a_16597_1842# 0.86876f
C479 a_24957_1842# VDD 0.87825f
C480 a_10951_2470# VDD 0.01806f
C481 a_1721_1395# MUX_SEL0 0.01315f
C482 MUX_SEL4 MUX_OUT 0.91933f
C483 a_5523_1842# DELAY_VBIASP 0.06627f
C484 a_5393_1842# DELAY_VBIASN 0.0961f
C485 a_4905_1044# a_4350_1044# 0.03209f
C486 a_8563_1842# a_8671_1842# 0.01163f
C487 a_25913_1842# a_26043_1842# 0.70845f
C488 a_7288_1044# VDD 0.17274f
C489 a_2297_1395# a_1256_1044# 0.04619f
C490 a_7477_1842# a_8237_1842# 0.01669f
C491 a_15765_463# a_2019_311# 0.05969f
C492 a_15755_1044# a_15831_1008# 0.01194f
C493 a_15511_2470# a_15403_1842# 0.01697f
C494 a_7390_1044# a_8237_1842# 0.08038f
C495 a_14964_1008# a_15077_1842# 0.02055f
C496 DELAY_VBIASN a_13883_1842# 0.07254f
C497 DELAY_VBIASP a_21157_1842# 0.04141f
C498 a_12797_1842# a_13368_1044# 0.10864f
C499 a_4437_1842# a_5197_1842# 0.01669f
C500 DELAY_VBIASN a_10713_1842# 0.0961f
C501 a_6717_1842# a_6283_1842# 0.6972f
C502 a_7390_1044# a_8231_1008# 0.28268f
C503 DELAY_VBIASP a_10843_1842# 0.06627f
C504 VDD a_18117_1842# 0.85848f
C505 a_15511_2470# VDD 0.01806f
C506 MUX_SEL4 a_2297_331# 0.04338f
C507 MUX_SEL3 a_2873_331# 0.12606f
C508 MUX_SEL2 a_3449_331# 0.10741f
C509 VDD a_13444_1008# 0.28633f
C510 a_14317_1842# DELAY_VBIASN 0.09974f
C511 a_6391_2470# VDD 0.01806f
C512 a_8433_1842# DELAY_VBIASN 0.0961f
C513 a_8563_1842# DELAY_VBIASP 0.06627f
C514 a_5705_519# a_2019_311# 0.13872f
C515 a_19311_2470# a_19203_1842# 0.01697f
C516 a_10328_1044# a_10430_1044# 0.37183f
C517 VDD a_18871_1008# 0.2822f
C518 VDD a_24631_2470# 0.01806f
C519 VDD a_15545_1044# 0.29918f
C520 DELAY_VBIASN a_15403_1842# 0.07254f
C521 VDD a_26803_1842# 0.49671f
C522 MUX_SEL4 a_9757_1842# 0.01829f
C523 a_12797_1842# DELAY_VBIASP 0.0414f
C524 a_1544_289# VDD 0.39113f
C525 a_5197_1842# a_5957_1842# 0.03319f
C526 a_26395_1044# a_25630_1044# 0.39037f
C527 a_26477_1842# a_26471_1008# 0.02349f
C528 a_5731_289# a_11785_519# 0.28056f
C529 DELAY_VBIASP a_22873_1842# 0.11222f
C530 a_15964_289# a_15837_1842# 0.02f
C531 a_17553_1842# a_17683_1842# 0.70845f
C532 VDD DELAY_VBIASN 0.93419f
C533 a_21157_1842# a_21917_1842# 0.02912f
C534 DELAY_VBIASN a_16597_1842# 0.08375f
C535 a_13991_1842# a_13883_1842# 0.01163f
C536 VDD a_19637_1842# 0.86707f
C537 a_25153_1842# DELAY_VBIASP 0.11222f
C538 a_13470_1044# a_14235_1044# 0.39037f
C539 a_24957_1842# DELAY_VBIASN 0.09992f
C540 a_24665_1044# a_22590_1044# 0.03208f
C541 a_7390_1044# a_8997_1842# 0.05231f
C542 a_5731_289# a_13470_1044# 0.41365f
C543 a_17791_1842# a_17683_1842# 0.01163f
C544 a_20391_1008# a_20105_1044# 0.01885f
C545 a_15765_463# VDD 0.35368f
C546 a_11473_1842# a_12037_1842# 0.0114f
C547 VDD a_16484_1008# 0.28597f
C548 a_14235_1044# a_14025_1044# 0.09424f
C549 a_16484_1008# a_16597_1842# 0.05157f
C550 VDD a_7043_1842# 0.49723f
C551 a_20391_1008# a_20397_1842# 0.02349f
C552 DELAY_VBIASN a_18117_1842# 0.09156f
C553 a_13753_1842# a_13883_1842# 0.70845f
C554 a_23145_1044# VDD 0.30409f
C555 a_9193_1842# a_9757_1842# 0.0114f
C556 a_7364_1008# VDD 0.28633f
C557 a_27237_1842# a_27433_1842# 0.77122f
C558 a_5705_519# VDD 0.29556f
C559 VDD a_10328_1044# 0.17274f
C560 DELAY_VBIASP a_18313_1842# 0.11222f
C561 VDD a_22113_1842# 0.49426f
C562 a_5115_1044# a_4350_1044# 0.39037f
C563 a_13753_1842# a_14317_1842# 0.0114f
C564 a_7288_1044# a_7364_1008# 0.01176f
C565 a_1721_1395# VDD 0.4533f
C566 a_18313_1842# a_18443_1842# 0.70845f
C567 a_12233_1842# VDD 0.49285f
C568 a_4763_1842# VDD 0.4973f
C569 a_22677_1842# a_22243_1842# 0.69698f
C570 a_19524_1008# a_18877_1842# 0.02011f
C571 a_17928_1044# a_17357_1842# 0.10863f
C572 DELAY_VBIASN a_26803_1842# 0.07254f
C573 a_14825_519# a_5731_289# 0.28056f
C574 DELAY_VBIASP a_27997_1842# 0.04001f
C575 a_27671_1842# a_27563_1842# 0.01163f
C576 a_22590_1044# a_22564_1008# 0.277f
C577 a_11785_519# a_10430_1044# 0.02058f
C578 a_12797_1842# a_13557_1842# 0.06198f
C579 a_7911_2470# a_7803_1842# 0.01697f
C580 a_16510_1044# a_17065_1044# 0.03209f
C581 a_16108_289# a_23945_519# 0.2906f
C582 DELAY_VBIASP a_19833_1842# 0.11222f
C583 DELAY_VBIASN a_19637_1842# 0.08375f
C584 VDD a_10083_1842# 0.49727f
C585 a_25630_1044# a_25604_1008# 0.277f
C586 a_13753_1842# VDD 0.49294f
C587 a_7390_1044# a_5731_289# 0.41331f
C588 a_15837_1842# a_15403_1842# 0.6972f
C589 a_19073_1842# a_19203_1842# 0.70845f
C590 a_23437_1842# a_23003_1842# 0.6972f
C591 VDD a_19311_2470# 0.01806f
C592 VDD a_22590_1044# 0.89557f
C593 a_6391_1842# a_6283_1842# 0.01163f
C594 VDD a_23763_1842# 0.49671f
C595 a_24957_1842# a_22590_1044# 0.02479f
C596 a_4437_1842# DELAY_VBIASP 0.0414f
C597 a_27705_1044# a_27915_1044# 0.09424f
C598 a_19550_1044# a_21917_1842# 0.02479f
C599 a_25630_1044# VDD 0.8955f
C600 VDD a_15837_1842# 0.87963f
C601 a_16851_309# MUX_OUT 0.45865f
C602 DELAY_VBIASN a_7043_1842# 0.07254f
C603 DELAY_VBIASP a_8237_1842# 0.0414f
C604 a_10985_1044# a_11195_1044# 0.09424f
C605 a_15837_1842# a_16597_1842# 0.06198f
C606 a_14513_1842# a_15077_1842# 0.0114f
C607 a_25717_1842# a_25283_1842# 0.69698f
C608 a_2019_311# a_1256_289# 0.02904f
C609 a_13470_1044# a_13883_1842# 0.01012f
C610 a_15964_289# a_16510_1044# 0.05416f
C611 a_4350_1044# a_4437_1842# 0.1088f
C612 a_16510_1044# a_17275_1044# 0.39037f
C613 a_10191_1842# a_10083_1842# 0.01163f
C614 a_14317_1842# a_13470_1044# 0.08038f
C615 DELAY_VBIASN a_22113_1842# 0.0961f
C616 a_12233_1842# DELAY_VBIASN 0.0961f
C617 a_1544_1044# MUX_SEL0 0.07603f
C618 MUX_SEL3 MUX_OUT 0.79533f
C619 a_5957_1842# DELAY_VBIASP 0.04141f
C620 a_4157_1313# a_4350_1044# 0.04624f
C621 a_4763_1842# DELAY_VBIASN 0.07254f
C622 a_6711_1008# VDD 0.2822f
C623 a_7477_1842# a_7673_1842# 0.73897f
C624 a_8231_1008# a_7945_1044# 0.01885f
C625 a_7803_1842# a_8237_1842# 0.6972f
C626 a_16108_289# a_21917_1842# 0.0157f
C627 a_11785_519# VDD 0.29292f
C628 MUX_SEL4 a_6717_1842# 0.0195f
C629 a_2019_311# a_16510_1044# 0.03139f
C630 a_4350_1044# a_5957_1842# 0.05231f
C631 a_13470_1044# a_15403_1842# 0.01012f
C632 a_21911_1008# a_19550_1044# 0.26208f
C633 a_12471_2470# a_12363_1842# 0.01697f
C634 a_10430_1044# a_12715_1044# 0.39036f
C635 DELAY_VBIASP a_20593_1842# 0.11222f
C636 a_12797_1842# a_12791_1008# 0.02354f
C637 a_4437_1842# a_4633_1842# 0.73897f
C638 a_7390_1044# a_8155_1044# 0.39037f
C639 DELAY_VBIASP a_11277_1842# 0.0414f
C640 DELAY_VBIASN a_10083_1842# 0.07254f
C641 VDD a_17553_1842# 0.49417f
C642 MUX_SEL3 a_2297_331# 0.01595f
C643 MUX_SEL4 a_1721_331# 0.05813f
C644 a_14751_2470# VDD 0.01806f
C645 MUX_SEL2 a_2873_331# 0.01422f
C646 a_13753_1842# DELAY_VBIASN 0.0961f
C647 VDD a_13470_1044# 0.87936f
C648 a_5631_2470# VDD 0.01806f
C649 a_8997_1842# DELAY_VBIASP 0.04141f
C650 MUX_SEL1 a_1544_1044# 0.1672f
C651 a_3449_331# a_2019_311# 0.01176f
C652 DELAY_VBIASN a_22590_1044# 0.02115f
C653 DELAY_VBIASN a_23763_1842# 0.07254f
C654 VDD a_18795_1044# 0.15406f
C655 VDD a_23871_2470# 0.01806f
C656 a_25630_1044# DELAY_VBIASN 0.02756f
C657 DELAY_VBIASP a_16033_1842# 0.11222f
C658 a_14888_1044# a_14964_1008# 0.01176f
C659 VDD a_14025_1044# 0.30409f
C660 DELAY_VBIASN a_15837_1842# 0.09992f
C661 VDD a_27237_1842# 0.85969f
C662 a_20071_2470# a_19963_1842# 0.01697f
C663 a_11924_1008# a_11277_1842# 0.02312f
C664 a_1256_289# VDD 0.40292f
C665 a_5197_1842# a_5393_1842# 0.76914f
C666 DELAY_VBIASP a_22243_1842# 0.06627f
C667 a_17553_1842# a_18117_1842# 0.0114f
C668 VDD DELAY_OUT_LAST 0.46312f
C669 a_23871_1842# a_23763_1842# 0.01163f
C670 a_21157_1842# a_21353_1842# 0.77122f
C671 a_16484_1008# a_15837_1842# 0.02011f
C672 a_13470_1044# a_13444_1008# 0.277f
C673 a_24523_1842# DELAY_VBIASP 0.06627f
C674 VDD a_19073_1842# 0.49426f
C675 a_19550_1044# a_20391_1008# 0.28268f
C676 a_23145_1044# a_22590_1044# 0.03209f
C677 a_24665_1044# a_24197_1842# 0.2079f
C678 a_20315_1044# a_20105_1044# 0.09424f
C679 a_14825_519# VDD 0.29292f
C680 a_27563_1842# a_27671_2470# 0.01697f
C681 VDD a_19963_1842# 0.4973f
C682 a_11277_1842# a_11603_1842# 0.01427f
C683 VDD a_16510_1044# 0.8795f
C684 a_13470_1044# a_15545_1044# 0.03208f
C685 VDD a_12715_1044# 0.15406f
C686 a_16510_1044# a_16597_1842# 0.1088f
C687 VDD a_7477_1842# 0.86707f
C688 a_18795_1044# a_18871_1008# 0.01194f
C689 a_22564_1008# a_22677_1842# 0.05157f
C690 DELAY_VBIASN a_17553_1842# 0.0961f
C691 DELAY_VBIASP a_17683_1842# 0.06627f
C692 a_21625_1044# VDD 0.29722f
C693 a_7390_1044# VDD 0.8686f
C694 DELAY_VBIASN a_13470_1044# 0.02115f
C695 a_27237_1842# a_26803_1842# 0.6972f
C696 a_20905_519# a_19550_1044# 0.02165f
C697 a_22243_1842# a_21917_1842# 0.01427f
C698 a_3449_331# VDD 0.46596f
C699 a_12797_1842# a_12037_1842# 0.02912f
C700 VDD a_21483_1842# 0.4973f
C701 a_4324_1008# a_4350_1044# 0.277f
C702 a_1544_1044# VDD 0.45079f
C703 a_1256_289# a_1544_289# 1.25711f
C704 a_7288_1044# a_7390_1044# 0.37183f
C705 a_18313_1842# a_18877_1842# 0.0114f
C706 a_5197_1842# VDD 0.86909f
C707 a_16510_1044# a_18117_1842# 0.05231f
C708 a_17351_1008# a_17357_1842# 0.02349f
C709 DELAY_VBIASP a_27433_1842# 0.11222f
C710 DELAY_VBIASN a_27237_1842# 0.09456f
C711 a_4350_1044# a_5731_289# 0.41099f
C712 VDD a_22677_1842# 0.86707f
C713 a_4763_1842# a_4871_1842# 0.01163f
C714 a_22488_1044# a_22564_1008# 0.01176f
C715 a_5844_1008# a_5957_1842# 0.02055f
C716 a_9953_1842# VDD 0.49426f
C717 a_12797_1842# a_12993_1842# 0.76914f
C718 DELAY_VBIASP a_6153_1842# 0.11222f
C719 a_18871_1008# a_16510_1044# 0.26208f
C720 DELAY_OUT_LAST DELAY_VBIASN 0.04786f
C721 a_27048_1044# a_27124_1008# 0.01176f
C722 a_24393_1842# a_24523_1842# 0.70845f
C723 MUX_SEL0 a_1256_1044# 0.3314f
C724 a_16108_289# a_20905_519# 0.2906f
C725 DELAY_VBIASN a_19073_1842# 0.0961f
C726 DELAY_VBIASP a_19203_1842# 0.06627f
C727 a_25528_1044# a_25604_1008# 0.01176f
C728 a_15273_1842# a_15403_1842# 0.70845f
C729 a_19073_1842# a_19637_1842# 0.0114f
C730 a_13123_1842# VDD 0.49727f
C731 VDD a_18551_2470# 0.01806f
C732 a_22873_1842# a_23003_1842# 0.70845f
C733 VDD a_22488_1044# 0.17274f
C734 VDD a_24197_1842# 0.85848f
C735 DELAY_VBIASN a_19963_1842# 0.07254f
C736 a_16108_289# a_18877_1842# 0.0157f
C737 a_4437_1842# DELAY_IN 0.05007f
C738 a_24084_1008# a_23437_1842# 0.02312f
C739 DELAY_VBIASN a_16510_1044# 0.02115f
C740 a_24957_1842# a_24197_1842# 0.02912f
C741 a_20831_1842# a_20723_1842# 0.01163f
C742 a_25528_1044# VDD 0.17274f
C743 VDD a_15273_1842# 0.49285f
C744 DELAY_VBIASP a_7673_1842# 0.11222f
C745 a_26477_1842# VDD 0.86909f
C746 DELAY_VBIASN a_7477_1842# 0.08375f
C747 a_16108_289# MUX_OUT 0.24265f
C748 a_2873_1395# MUX_SEL0 0.01504f
C749 a_12505_1044# a_10430_1044# 0.03208f
C750 a_24957_1842# a_25528_1044# 0.10864f
C751 a_25153_1842# a_25283_1842# 0.70845f
C752 a_13991_2470# a_13883_1842# 0.01697f
C753 a_4157_1313# DELAY_IN 0.50642f
C754 a_7390_1044# DELAY_VBIASN 0.02115f
C755 MUX_SEL1 a_1256_1044# 1.44243f
C756 a_16510_1044# a_16484_1008# 0.277f
C757 a_17791_2470# a_17683_1842# 0.01697f
C758 DELAY_VBIASN a_21483_1842# 0.07254f
C759 MUX_SEL3 MUX_SEL4 0.75489f
C760 MUX_SEL2 MUX_OUT 0.08497f
C761 a_4157_1313# a_4248_1044# 0.11672f
C762 a_5393_1842# DELAY_VBIASP 0.11222f
C763 a_20397_1842# a_20723_1842# 0.01427f
C764 a_5197_1842# DELAY_VBIASN 0.09974f
C765 a_8155_1044# a_7945_1044# 0.09424f
C766 a_6635_1044# VDD 0.15406f
C767 a_7477_1842# a_7043_1842# 0.69698f
C768 a_8808_1044# a_8884_1008# 0.01176f
C769 a_2019_311# a_4350_1044# 0.02042f
C770 DELAY_VBIASN a_22677_1842# 0.08375f
C771 a_7803_1842# a_7673_1842# 0.70845f
C772 a_9953_1842# DELAY_VBIASN 0.0961f
C773 a_13470_1044# a_15837_1842# 0.02479f
C774 MUX_SEL1 a_2873_1395# 0.13092f
C775 a_7364_1008# a_7477_1842# 0.05157f
C776 a_22351_1842# a_22243_1842# 0.01163f
C777 a_21835_1044# a_19550_1044# 0.39036f
C778 DELAY_VBIASP a_13883_1842# 0.06627f
C779 a_10430_1044# a_11924_1008# 0.28279f
C780 a_11195_1044# a_11271_1008# 0.01194f
C781 a_23763_1842# a_23871_2470# 0.01697f
C782 a_10404_1008# a_10517_1842# 0.05157f
C783 a_4437_1842# a_4003_1842# 0.69698f
C784 DELAY_VBIASP a_10713_1842# 0.11222f
C785 a_7390_1044# a_7364_1008# 0.277f
C786 VDD a_16923_1842# 0.4973f
C787 MUX_SEL2 a_2297_331# 0.10655f
C788 a_13991_2470# VDD 0.01806f
C789 a_25630_1044# a_27237_1842# 0.05253f
C790 a_14317_1842# DELAY_VBIASP 0.0414f
C791 VDD a_13368_1044# 0.17274f
C792 a_13123_1842# DELAY_VBIASN 0.07254f
C793 a_26477_1842# a_26803_1842# 0.01427f
C794 a_8433_1842# DELAY_VBIASP 0.11222f
C795 DELAY_VBIASN a_24197_1842# 0.09156f
C796 VDD a_18004_1008# 0.28225f
C797 a_21044_1008# a_20397_1842# 0.02312f
C798 a_23145_1044# a_22677_1842# 0.19203f
C799 DELAY_VBIASP a_15403_1842# 0.06627f
C800 DELAY_VBIASN a_15273_1842# 0.0961f
C801 a_26477_1842# DELAY_VBIASN 0.10224f
C802 VDD a_12505_1044# 0.29722f
C803 a_1544_1044# a_1721_1395# 0.38063f
C804 VDD a_26673_1842# 0.49417f
C805 a_11848_1044# a_11277_1842# 0.10863f
C806 a_10517_1842# a_11277_1842# 0.01669f
C807 a_27991_1008# VDD 0.28201f
C808 a_5197_1842# a_4763_1842# 0.6972f
C809 a_22677_1842# a_22113_1842# 0.0114f
C810 a_23945_519# VDD 0.29292f
C811 a_9757_1842# a_10404_1008# 0.02011f
C812 a_17357_1842# a_17683_1842# 0.01427f
C813 VDD DELAY_VBIASP 13.3528f
C814 a_21157_1842# a_20723_1842# 0.6972f
C815 MUX_SEL4 a_12797_1842# 0.01829f
C816 VDD a_1256_1044# 0.475f
C817 DELAY_VBIASP a_16597_1842# 0.0414f
C818 a_24957_1842# DELAY_VBIASP 0.0414f
C819 a_19550_1044# a_20315_1044# 0.39037f
C820 VDD a_18443_1842# 0.4973f
C821 a_13368_1044# a_13444_1008# 0.01176f
C822 a_25283_1842# a_25391_1842# 0.01163f
C823 a_18004_1008# a_18117_1842# 0.02055f
C824 a_4350_1044# VDD 0.87635f
C825 a_9751_1008# VDD 0.2822f
C826 a_24665_1044# a_24951_1008# 0.01885f
C827 a_7945_1044# VDD 0.30409f
C828 a_11277_1842# a_12037_1842# 0.03319f
C829 VDD a_16408_1044# 0.17274f
C830 a_22564_1008# a_21917_1842# 0.02011f
C831 a_13470_1044# a_14025_1044# 0.03209f
C832 VDD a_11924_1008# 0.28225f
C833 VDD a_6913_1842# 0.49426f
C834 a_9953_1842# a_10083_1842# 0.70845f
C835 a_2873_1395# VDD 0.46517f
C836 a_26151_1842# a_26043_1842# 0.01163f
C837 a_22590_1044# a_22677_1842# 0.1088f
C838 a_14751_1842# a_14643_1842# 0.01163f
C839 a_7803_1842# VDD 0.4973f
C840 DELAY_VBIASP a_18117_1842# 0.04141f
C841 DELAY_VBIASN a_16923_1842# 0.07254f
C842 a_8997_1842# a_9757_1842# 0.02912f
C843 a_26673_1842# a_26803_1842# 0.70845f
C844 a_21044_1008# a_21157_1842# 0.02055f
C845 a_2873_331# VDD 0.46491f
C846 a_4324_1008# a_4248_1044# 0.01176f
C847 VDD a_21917_1842# 0.87825f
C848 a_13557_1842# a_14317_1842# 0.01669f
C849 a_5191_1008# a_4905_1044# 0.01885f
C850 a_4633_1842# VDD 0.49285f
C851 a_14825_519# a_13470_1044# 0.02058f
C852 a_19448_1044# a_18877_1842# 0.10864f
C853 a_18551_1842# a_18443_1842# 0.01163f
C854 VDD a_11603_1842# 0.49671f
C855 DELAY_VBIASN a_26673_1842# 0.0961f
C856 MUX_SEL4 a_8745_519# 0.04472f
C857 MUX_OUT a_5731_289# 1.04829f
C858 DELAY_VBIASP a_26803_1842# 0.06627f
C859 a_22488_1044# a_22590_1044# 0.37183f
C860 a_22590_1044# a_24197_1842# 0.05231f
C861 a_24197_1842# a_23763_1842# 0.6972f
C862 a_14317_1842# a_14643_1842# 0.01427f
C863 a_9323_1842# VDD 0.4973f
C864 a_24393_1842# VDD 0.49285f
C865 a_12797_1842# a_12363_1842# 0.6972f
C866 a_18795_1044# a_16510_1044# 0.39036f
C867 DELAY_VBIASP DELAY_VBIASN 3.50557f
C868 DELAY_IN MUX_SEL0 0.14089f
C869 a_24393_1842# a_24957_1842# 0.0114f
C870 a_16108_289# a_17865_519# 0.29564f
C871 DELAY_VBIASN a_18443_1842# 0.07254f
C872 DELAY_VBIASP a_19637_1842# 0.0414f
C873 a_25528_1044# a_25630_1044# 0.37183f
C874 a_26477_1842# a_25630_1044# 0.08038f
C875 a_20968_1044# a_21044_1008# 0.01176f
C876 a_13557_1842# VDD 0.86707f
C877 a_15273_1842# a_15837_1842# 0.0114f
C878 a_18877_1842# a_19203_1842# 0.01427f
C879 VDD a_17791_2470# 0.01806f
C880 a_22873_1842# a_23437_1842# 0.0114f
C881 a_12791_1008# a_10430_1044# 0.26208f
C882 a_16271_1842# a_16163_1842# 0.01163f
C883 a_4350_1044# DELAY_VBIASN 0.02115f
C884 VDD a_21911_1008# 0.2822f
C885 VDD a_23633_1842# 0.49417f
C886 a_24008_1044# a_23437_1842# 0.10863f
C887 a_6153_1842# a_6283_1842# 0.70845f
C888 a_24951_1008# VDD 0.2822f
C889 VDD a_14643_1842# 0.49671f
C890 a_25913_1842# VDD 0.49294f
C891 DELAY_VBIASP a_7043_1842# 0.06627f
C892 DELAY_VBIASN a_6913_1842# 0.0961f
C893 a_24008_1044# a_24084_1008# 0.01176f
C894 a_16108_289# MUX_SEL4 0.1283f
C895 a_15964_289# MUX_OUT 0.01307f
C896 a_10985_1044# a_10430_1044# 0.03209f
C897 a_24957_1842# a_24951_1008# 0.02354f
C898 a_25153_1842# a_25717_1842# 0.0114f
C899 a_8671_2470# a_8563_1842# 0.01697f
C900 a_7803_1842# DELAY_VBIASN 0.07254f
C901 MUX_SEL1 DELAY_IN 0.01858f
C902 a_3449_1395# DELAY_IN 0.01058f
C903 a_16408_1044# a_16484_1008# 0.01176f
C904 a_8884_1008# a_8237_1842# 0.02312f
C905 DELAY_VBIASN a_21917_1842# 0.09992f
C906 a_13557_1842# a_13444_1008# 0.05157f
C907 DELAY_VBIASP a_22113_1842# 0.11222f
C908 MUX_SEL1 MUX_OUT 0.09357f
C909 MUX_SEL2 MUX_SEL4 0.01978f
C910 a_4763_1842# DELAY_VBIASP 0.06627f
C911 a_12233_1842# DELAY_VBIASP 0.11222f
C912 a_4633_1842# DELAY_VBIASN 0.0961f
C913 MUX_SEL4 a_4157_1313# 0.08229f
C914 a_20397_1842# a_21157_1842# 0.03319f
C915 a_1721_1395# a_1256_1044# 0.13421f
C916 a_6913_1842# a_7043_1842# 0.70845f
C917 a_5844_1008# VDD 0.28225f
C918 DELAY_VBIASN a_11603_1842# 0.07254f
C919 MUX_OUT a_2019_311# 8.45486f
C920 a_5705_519# a_4350_1044# 0.02005f
C921 a_10191_2470# VDD 0.01806f
C922 a_9323_1842# DELAY_VBIASN 0.07254f
C923 a_6635_1044# a_6711_1008# 0.01194f
C924 a_21044_1008# a_19550_1044# 0.28279f
C925 a_7390_1044# a_7477_1842# 0.1088f
C926 a_4350_1044# a_4763_1842# 0.01012f
C927 a_24393_1842# DELAY_VBIASN 0.0961f
C928 a_6425_1044# a_5957_1842# 0.2079f
C929 a_10430_1044# a_11848_1044# 0.38994f
C930 a_8997_1842# a_9465_1044# 0.2079f
C931 VDD a_20391_1008# 0.28336f
C932 a_10430_1044# a_10517_1842# 0.1088f
C933 VDD a_17357_1842# 0.86909f
C934 DELAY_VBIASP a_10083_1842# 0.06627f
C935 MUX_SEL2 a_1721_331# 0.01315f
C936 a_25283_1842# a_25391_2470# 0.01697f
C937 a_5957_1842# a_6717_1842# 0.02912f
C938 a_23945_519# a_22590_1044# 0.02165f
C939 a_13231_2470# VDD 0.01806f
C940 a_16597_1842# a_17357_1842# 0.01669f
C941 a_13557_1842# DELAY_VBIASN 0.08375f
C942 a_13753_1842# DELAY_VBIASP 0.11222f
C943 VDD a_12791_1008# 0.2822f
C944 a_26477_1842# a_27237_1842# 0.03319f
C945 a_5115_1044# a_5191_1008# 0.01194f
C946 a_2297_331# a_2019_311# 0.04011f
C947 a_27991_1008# a_25630_1044# 0.26208f
C948 DELAY_VBIASN a_23633_1842# 0.0961f
C949 DELAY_VBIASP a_23763_1842# 0.06627f
C950 a_20968_1044# a_20397_1842# 0.10863f
C951 a_21917_1842# a_22113_1842# 0.76914f
C952 a_25630_1044# DELAY_VBIASP 0.01522f
C953 a_25913_1842# DELAY_VBIASN 0.0961f
C954 DELAY_VBIASP a_15837_1842# 0.0414f
C955 DELAY_VBIASN a_14643_1842# 0.07254f
C956 VDD a_10985_1044# 0.30409f
C957 a_26043_1842# a_26151_2470# 0.01697f
C958 a_11271_1008# a_11277_1842# 0.02349f
C959 a_10517_1842# a_10713_1842# 0.73897f
C960 a_10430_1044# a_12037_1842# 0.05231f
C961 a_8884_1008# a_8997_1842# 0.02055f
C962 a_27915_1044# VDD 0.15389f
C963 a_4633_1842# a_4763_1842# 0.70845f
C964 a_20905_519# VDD 0.29292f
C965 a_17357_1842# a_18117_1842# 0.03319f
C966 VDD DELAY_IN 1.33375f
C967 a_20593_1842# a_20723_1842# 0.70845f
C968 a_16408_1044# a_15837_1842# 0.10864f
C969 a_19550_1044# a_19524_1008# 0.277f
C970 VDD a_18877_1842# 0.87825f
C971 a_13368_1044# a_13470_1044# 0.37183f
C972 a_19550_1044# a_20105_1044# 0.03209f
C973 a_4248_1044# VDD 0.17587f
C974 MUX_OUT VDD 0.35871f
C975 a_20831_2470# a_20723_1842# 0.01697f
C976 a_9675_1044# VDD 0.15406f
C977 a_24665_1044# a_24875_1044# 0.09424f
C978 a_13231_1842# a_13123_1842# 0.01163f
C979 a_25717_1842# a_26185_1044# 0.19203f
C980 a_11277_1842# a_11473_1842# 0.76914f
C981 VDD a_15831_1008# 0.2816f
C982 a_27997_1842# a_27563_1842# 0.69646f
C983 VDD a_10517_1842# 0.86707f
C984 a_6711_1008# a_4350_1044# 0.26208f
C985 VDD a_11848_1044# 0.17499f
C986 VDD a_6283_1842# 0.4973f
C987 a_19550_1044# a_20397_1842# 0.08038f
C988 DELAY_VBIASP a_17553_1842# 0.11222f
C989 DELAY_VBIASN a_17357_1842# 0.09974f
C990 a_8997_1842# a_9193_1842# 0.77122f
C991 a_18877_1842# a_18117_1842# 0.02912f
C992 a_26673_1842# a_27237_1842# 0.0114f
C993 a_2297_331# VDD 0.46496f
C994 VDD a_21353_1842# 0.49285f
C995 a_13557_1842# a_13753_1842# 0.73897f
C996 a_5115_1044# a_4905_1044# 0.09424f
C997 a_4003_1842# VDD 0.61559f
C998 a_16510_1044# a_16923_1842# 0.01012f
C999 a_18871_1008# a_18877_1842# 0.02354f
C1000 VDD a_12037_1842# 0.85848f
C1001 DELAY_VBIASP a_27237_1842# 0.06189f
C1002 a_22351_2470# a_22243_1842# 0.01697f
C1003 MUX_SEL4 a_5731_289# 4.60702f
C1004 a_19833_1842# a_20397_1842# 0.0114f
C1005 a_23633_1842# a_23763_1842# 0.70845f
C1006 a_9757_1842# VDD 0.87771f
C1007 a_14317_1842# a_15077_1842# 0.03319f
C1008 a_6391_2470# a_6283_1842# 0.01697f
C1009 a_18004_1008# a_16510_1044# 0.28279f
C1010 a_24951_1008# a_22590_1044# 0.26208f
C1011 DELAY_VBIASP DELAY_OUT_LAST 0.21225f
C1012 DELAY_IN DELAY_VBIASN 0.07156f
C1013 MUX_OUT a_1544_289# 0.69943f
C1014 a_15831_1008# a_15545_1044# 0.01885f
C1015 DELAY_VBIASP a_19073_1842# 0.11222f
C1016 DELAY_VBIASN a_18877_1842# 0.09992f
C1017 a_16108_289# a_16851_309# 0.06181f
C1018 a_12505_1044# a_12715_1044# 0.09424f
C1019 a_12993_1842# VDD 0.49426f
C1020 a_18877_1842# a_19637_1842# 0.06198f
C1021 VDD a_21835_1044# 0.15406f
C1022 VDD a_23003_1842# 0.4973f
C1023 DELAY_VBIASP a_19963_1842# 0.06627f
C1024 a_5523_1842# a_5631_1842# 0.01163f
C1025 a_23431_1008# a_23437_1842# 0.02349f
C1026 a_6153_1842# a_6717_1842# 0.0114f
C1027 a_19550_1044# a_21157_1842# 0.05231f
C1028 a_24875_1044# VDD 0.15406f
C1029 a_10191_2470# a_10083_1842# 0.01697f
C1030 a_14317_1842# a_14964_1008# 0.02312f
C1031 a_25283_1842# VDD 0.49737f
C1032 a_16510_1044# a_18443_1842# 0.01012f
C1033 DELAY_VBIASN a_10517_1842# 0.08375f
C1034 VDD a_15077_1842# 0.85963f
C1035 DELAY_VBIASN a_6283_1842# 0.07254f
C1036 DELAY_VBIASP a_7477_1842# 0.0414f
C1037 a_15964_289# MUX_SEL4 0.5544f
C1038 a_24957_1842# a_25283_1842# 0.01427f
C1039 a_2873_331# a_1256_289# 0.27926f
C1040 a_2297_331# a_1544_289# 0.27303f
C1041 a_4871_2470# VDD 0.01806f
C1042 a_9323_1842# a_9431_1842# 0.01163f
C1043 a_16108_289# a_26985_519# 0.2906f
C1044 a_17865_519# a_2019_311# 0.13959f
C1045 a_4905_1044# a_4437_1842# 0.19203f
C1046 a_16408_1044# a_16510_1044# 0.37183f
C1047 VDD a_23111_2470# 0.01806f
C1048 a_7945_1044# a_7477_1842# 0.19203f
C1049 a_8808_1044# a_8237_1842# 0.10863f
C1050 a_13557_1842# a_13470_1044# 0.1088f
C1051 DELAY_VBIASP a_21483_1842# 0.06627f
C1052 DELAY_VBIASN a_21353_1842# 0.0961f
C1053 MUX_SEL2 MUX_SEL3 3.21891f
C1054 MUX_SEL1 MUX_SEL4 0.03574f
C1055 a_5197_1842# DELAY_VBIASP 0.0414f
C1056 a_4003_1842# DELAY_VBIASN 0.06486f
C1057 a_5768_1044# VDD 0.17499f
C1058 a_20397_1842# a_20593_1842# 0.76914f
C1059 a_1544_1044# a_1256_1044# 1.26509f
C1060 a_7390_1044# a_9751_1008# 0.26208f
C1061 a_7390_1044# a_7945_1044# 0.03209f
C1062 a_6913_1842# a_7477_1842# 0.0114f
C1063 DELAY_VBIASN a_12037_1842# 0.09156f
C1064 MUX_SEL4 a_2019_311# 0.90276f
C1065 DELAY_VBIASP a_22677_1842# 0.0414f
C1066 MUX_SEL4 a_10430_1044# 0.24983f
C1067 a_16033_1842# a_16163_1842# 0.70845f
C1068 VDD a_14964_1008# 0.28225f
C1069 a_9431_2470# VDD 0.01806f
C1070 a_14751_2470# a_14643_1842# 0.01697f
C1071 a_9953_1842# DELAY_VBIASP 0.11222f
C1072 a_20968_1044# a_19550_1044# 0.38994f
C1073 a_9757_1842# DELAY_VBIASN 0.09992f
C1074 a_13557_1842# a_14025_1044# 0.19203f
C1075 a_4350_1044# a_5197_1842# 0.08038f
C1076 VDD a_20315_1044# 0.15389f
C1077 a_10430_1044# a_11271_1008# 0.28268f
C1078 a_7390_1044# a_7803_1842# 0.01012f
C1079 VDD a_27671_2470# 0.01806f
C1080 VDD a_16793_1842# 0.49277f
C1081 a_10951_1842# a_10843_1842# 0.01163f
C1082 VDD a_4111_2470# 0.01866f
C1083 a_12471_2470# VDD 0.01806f
C1084 a_16597_1842# a_16793_1842# 0.73897f
C1085 a_13123_1842# DELAY_VBIASP 0.06627f
C1086 a_15545_1044# a_15077_1842# 0.2079f
C1087 a_12993_1842# DELAY_VBIASN 0.0961f
C1088 a_5957_1842# a_5523_1842# 0.6972f
C1089 a_26477_1842# a_26673_1842# 0.76914f
C1090 a_27915_1044# a_25630_1044# 0.39036f
C1091 a_1721_331# a_2019_311# 0.18452f
C1092 DELAY_VBIASN a_23003_1842# 0.07254f
C1093 a_18551_2470# a_18443_1842# 0.01697f
C1094 DELAY_VBIASP a_24197_1842# 0.04141f
C1095 a_8563_1842# a_8237_1842# 0.01427f
C1096 a_21917_1842# a_21483_1842# 0.6972f
C1097 DELAY_VBIASN a_15077_1842# 0.09156f
C1098 a_26477_1842# DELAY_VBIASP 0.04144f
C1099 a_25283_1842# DELAY_VBIASN 0.07254f
C1100 DELAY_VBIASP a_15273_1842# 0.11222f
C1101 VDD a_9465_1044# 0.29722f
C1102 a_10517_1842# a_10083_1842# 0.69698f
C1103 a_7390_1044# a_9323_1842# 0.01012f
C1104 a_27124_1008# VDD 0.28225f
R0 DELAY_VBIASN.n1 DELAY_VBIASN.t31 34.3755
R1 DELAY_VBIASN.n1 DELAY_VBIASN.t30 33.0005
R2 DELAY_VBIASN.n2 DELAY_VBIASN.t29 33.0005
R3 DELAY_VBIASN.n3 DELAY_VBIASN.t28 33.0005
R4 DELAY_VBIASN.n4 DELAY_VBIASN.t27 33.0005
R5 DELAY_VBIASN.n5 DELAY_VBIASN.t26 33.0005
R6 DELAY_VBIASN.n6 DELAY_VBIASN.t25 33.0005
R7 DELAY_VBIASN.n7 DELAY_VBIASN.t24 33.0005
R8 DELAY_VBIASN.n8 DELAY_VBIASN.t23 33.0005
R9 DELAY_VBIASN.n9 DELAY_VBIASN.t22 33.0005
R10 DELAY_VBIASN.n10 DELAY_VBIASN.t21 33.0005
R11 DELAY_VBIASN.n11 DELAY_VBIASN.t20 33.0005
R12 DELAY_VBIASN.n12 DELAY_VBIASN.t19 33.0005
R13 DELAY_VBIASN.n13 DELAY_VBIASN.t18 33.0005
R14 DELAY_VBIASN.n14 DELAY_VBIASN.t17 33.0005
R15 DELAY_VBIASN.n15 DELAY_VBIASN.t16 33.0005
R16 DELAY_VBIASN.n16 DELAY_VBIASN.t15 33.0005
R17 DELAY_VBIASN.n17 DELAY_VBIASN.t14 33.0005
R18 DELAY_VBIASN.n18 DELAY_VBIASN.t13 33.0005
R19 DELAY_VBIASN.n19 DELAY_VBIASN.t12 33.0005
R20 DELAY_VBIASN.n20 DELAY_VBIASN.t11 33.0005
R21 DELAY_VBIASN.n21 DELAY_VBIASN.t10 33.0005
R22 DELAY_VBIASN.n22 DELAY_VBIASN.t9 33.0005
R23 DELAY_VBIASN.n23 DELAY_VBIASN.t8 33.0005
R24 DELAY_VBIASN.n24 DELAY_VBIASN.t7 33.0005
R25 DELAY_VBIASN.n25 DELAY_VBIASN.t6 33.0005
R26 DELAY_VBIASN.n26 DELAY_VBIASN.t5 33.0005
R27 DELAY_VBIASN.n27 DELAY_VBIASN.t4 33.0005
R28 DELAY_VBIASN.n28 DELAY_VBIASN.t3 33.0005
R29 DELAY_VBIASN.n29 DELAY_VBIASN.t2 33.0005
R30 DELAY_VBIASN.n30 DELAY_VBIASN.t1 33.0005
R31 DELAY_VBIASN.n0 DELAY_VBIASN.t0 33.0005
R32 DELAY_VBIASN DELAY_VBIASN.n0 1.55517
R33 DELAY_VBIASN.n0 DELAY_VBIASN.n30 1.3755
R34 DELAY_VBIASN.n30 DELAY_VBIASN.n29 1.3755
R35 DELAY_VBIASN.n29 DELAY_VBIASN.n28 1.3755
R36 DELAY_VBIASN.n28 DELAY_VBIASN.n27 1.3755
R37 DELAY_VBIASN.n27 DELAY_VBIASN.n26 1.3755
R38 DELAY_VBIASN.n26 DELAY_VBIASN.n25 1.3755
R39 DELAY_VBIASN.n25 DELAY_VBIASN.n24 1.3755
R40 DELAY_VBIASN.n24 DELAY_VBIASN.n23 1.3755
R41 DELAY_VBIASN.n23 DELAY_VBIASN.n22 1.3755
R42 DELAY_VBIASN.n22 DELAY_VBIASN.n21 1.3755
R43 DELAY_VBIASN.n21 DELAY_VBIASN.n20 1.3755
R44 DELAY_VBIASN.n20 DELAY_VBIASN.n19 1.3755
R45 DELAY_VBIASN.n19 DELAY_VBIASN.n18 1.3755
R46 DELAY_VBIASN.n18 DELAY_VBIASN.n17 1.3755
R47 DELAY_VBIASN.n17 DELAY_VBIASN.n16 1.3755
R48 DELAY_VBIASN.n16 DELAY_VBIASN.n15 1.3755
R49 DELAY_VBIASN.n15 DELAY_VBIASN.n14 1.3755
R50 DELAY_VBIASN.n14 DELAY_VBIASN.n13 1.3755
R51 DELAY_VBIASN.n13 DELAY_VBIASN.n12 1.3755
R52 DELAY_VBIASN.n12 DELAY_VBIASN.n11 1.3755
R53 DELAY_VBIASN.n11 DELAY_VBIASN.n10 1.3755
R54 DELAY_VBIASN.n10 DELAY_VBIASN.n9 1.3755
R55 DELAY_VBIASN.n9 DELAY_VBIASN.n8 1.3755
R56 DELAY_VBIASN.n8 DELAY_VBIASN.n7 1.3755
R57 DELAY_VBIASN.n7 DELAY_VBIASN.n6 1.3755
R58 DELAY_VBIASN.n6 DELAY_VBIASN.n5 1.3755
R59 DELAY_VBIASN.n5 DELAY_VBIASN.n4 1.3755
R60 DELAY_VBIASN.n4 DELAY_VBIASN.n3 1.3755
R61 DELAY_VBIASN.n3 DELAY_VBIASN.n2 1.3755
R62 DELAY_VBIASN.n2 DELAY_VBIASN.n1 1.3755
R63 DELAY_VBIASP.n1 DELAY_VBIASP.t31 34.3685
R64 DELAY_VBIASP.n1 DELAY_VBIASP.t30 33.0005
R65 DELAY_VBIASP.n2 DELAY_VBIASP.t29 33.0005
R66 DELAY_VBIASP.n3 DELAY_VBIASP.t28 33.0005
R67 DELAY_VBIASP.n4 DELAY_VBIASP.t27 33.0005
R68 DELAY_VBIASP.n5 DELAY_VBIASP.t26 33.0005
R69 DELAY_VBIASP.n6 DELAY_VBIASP.t25 33.0005
R70 DELAY_VBIASP.n7 DELAY_VBIASP.t24 33.0005
R71 DELAY_VBIASP.n8 DELAY_VBIASP.t23 33.0005
R72 DELAY_VBIASP.n9 DELAY_VBIASP.t22 33.0005
R73 DELAY_VBIASP.n10 DELAY_VBIASP.t21 33.0005
R74 DELAY_VBIASP.n11 DELAY_VBIASP.t20 33.0005
R75 DELAY_VBIASP.n12 DELAY_VBIASP.t19 33.0005
R76 DELAY_VBIASP.n13 DELAY_VBIASP.t18 33.0005
R77 DELAY_VBIASP.n14 DELAY_VBIASP.t17 33.0005
R78 DELAY_VBIASP.n15 DELAY_VBIASP.t16 33.0005
R79 DELAY_VBIASP.n16 DELAY_VBIASP.t15 33.0005
R80 DELAY_VBIASP.n17 DELAY_VBIASP.t14 33.0005
R81 DELAY_VBIASP.n18 DELAY_VBIASP.t13 33.0005
R82 DELAY_VBIASP.n19 DELAY_VBIASP.t12 33.0005
R83 DELAY_VBIASP.n20 DELAY_VBIASP.t11 33.0005
R84 DELAY_VBIASP.n21 DELAY_VBIASP.t10 33.0005
R85 DELAY_VBIASP.n22 DELAY_VBIASP.t9 33.0005
R86 DELAY_VBIASP.n23 DELAY_VBIASP.t8 33.0005
R87 DELAY_VBIASP.n24 DELAY_VBIASP.t7 33.0005
R88 DELAY_VBIASP.n25 DELAY_VBIASP.t6 33.0005
R89 DELAY_VBIASP.n26 DELAY_VBIASP.t5 33.0005
R90 DELAY_VBIASP.n27 DELAY_VBIASP.t4 33.0005
R91 DELAY_VBIASP.n28 DELAY_VBIASP.t3 33.0005
R92 DELAY_VBIASP.n29 DELAY_VBIASP.t2 33.0005
R93 DELAY_VBIASP.n30 DELAY_VBIASP.t1 33.0005
R94 DELAY_VBIASP.n0 DELAY_VBIASP.t0 33.0005
R95 DELAY_VBIASP DELAY_VBIASP.n0 1.70586
R96 DELAY_VBIASP.n0 DELAY_VBIASP.n30 1.36852
R97 DELAY_VBIASP.n30 DELAY_VBIASP.n29 1.36852
R98 DELAY_VBIASP.n29 DELAY_VBIASP.n28 1.36852
R99 DELAY_VBIASP.n28 DELAY_VBIASP.n27 1.36852
R100 DELAY_VBIASP.n27 DELAY_VBIASP.n26 1.36852
R101 DELAY_VBIASP.n26 DELAY_VBIASP.n25 1.36852
R102 DELAY_VBIASP.n25 DELAY_VBIASP.n24 1.36852
R103 DELAY_VBIASP.n24 DELAY_VBIASP.n23 1.36852
R104 DELAY_VBIASP.n23 DELAY_VBIASP.n22 1.36852
R105 DELAY_VBIASP.n22 DELAY_VBIASP.n21 1.36852
R106 DELAY_VBIASP.n21 DELAY_VBIASP.n20 1.36852
R107 DELAY_VBIASP.n20 DELAY_VBIASP.n19 1.36852
R108 DELAY_VBIASP.n19 DELAY_VBIASP.n18 1.36852
R109 DELAY_VBIASP.n18 DELAY_VBIASP.n17 1.36852
R110 DELAY_VBIASP.n17 DELAY_VBIASP.n16 1.36852
R111 DELAY_VBIASP.n16 DELAY_VBIASP.n15 1.36852
R112 DELAY_VBIASP.n15 DELAY_VBIASP.n14 1.36852
R113 DELAY_VBIASP.n14 DELAY_VBIASP.n13 1.36852
R114 DELAY_VBIASP.n13 DELAY_VBIASP.n12 1.36852
R115 DELAY_VBIASP.n12 DELAY_VBIASP.n11 1.36852
R116 DELAY_VBIASP.n11 DELAY_VBIASP.n10 1.36852
R117 DELAY_VBIASP.n10 DELAY_VBIASP.n9 1.36852
R118 DELAY_VBIASP.n9 DELAY_VBIASP.n8 1.36852
R119 DELAY_VBIASP.n8 DELAY_VBIASP.n7 1.36852
R120 DELAY_VBIASP.n7 DELAY_VBIASP.n6 1.36852
R121 DELAY_VBIASP.n6 DELAY_VBIASP.n5 1.36852
R122 DELAY_VBIASP.n5 DELAY_VBIASP.n4 1.36852
R123 DELAY_VBIASP.n4 DELAY_VBIASP.n3 1.36852
R124 DELAY_VBIASP.n3 DELAY_VBIASP.n2 1.36852
R125 DELAY_VBIASP.n2 DELAY_VBIASP.n1 1.36852
R126 VSS.n31 VSS.n577 8599.79
R127 VSS.n48 VSS.n421 469.783
R128 VSS.n44 VSS.n410 469.783
R129 VSS.n561 VSS.n29 469.783
R130 VSS.n3 VSS.t281 58.3205
R131 VSS.n491 VSS.n17 454.007
R132 VSS.t309 VSS.n50 321.57
R133 VSS.n42 VSS.t326 402.185
R134 VSS.n545 VSS.n27 454.007
R135 VSS.t354 VSS.n39 321.57
R136 VSS.n420 VSS.n414 454.007
R137 VSS.n24 VSS.n23 0.00596634
R138 VSS.n21 VSS.n25 0.00292781
R139 VSS.n63 VSS.t204 21.1052
R140 VSS.t169 VSS.n6 442.469
R141 VSS.t383 VSS.n442 437.62
R142 VSS.n35 VSS.n62 0.547872
R143 VSS.t361 VSS.n33 413.695
R144 VSS.t346 VSS.n55 413.695
R145 VSS.t331 VSS.n56 413.695
R146 VSS.t316 VSS.n57 413.695
R147 VSS.t301 VSS.n59 413.695
R148 VSS.t286 VSS.n60 413.695
R149 VSS.n448 VSS.t384 403.072
R150 VSS.n17 VSS.t296 402.185
R151 VSS.n27 VSS.t341 402.185
R152 VSS.n64 VSS.t203 412.901
R153 VSS.n446 VSS.t145 391.555
R154 VSS.n445 VSS.t151 380.038
R155 VSS.t561 VSS.n444 357.007
R156 VSS.t562 VSS.n443 333.974
R157 VSS.n15 VSS.t381 97.2225
R158 VSS.n59 VSS.t304 97.2238
R159 VSS.t364 VSS.n33 97.2238
R160 VSS.n491 VSS.t294 305.183
R161 VSS.n42 VSS.t324 321.57
R162 VSS.n545 VSS.t339 305.183
R163 VSS.n447 VSS.t168 299.425
R164 VSS.n4 VSS.n14 0.00353491
R165 VSS.t291 VSS.n53 310.053
R166 VSS.t306 VSS.n19 310.053
R167 VSS.t321 VSS.n414 293.666
R168 VSS.t336 VSS.n22 105.686
R169 VSS.t351 VSS.n25 310.053
R170 VSS.t89 VSS.n32 110.546
R171 VSS.t248 VSS.n28 110.547
R172 VSS.n24 VSS.t227 116.469
R173 VSS.t174 VSS.n37 110.543
R174 VSS.n58 VSS.t154 116.469
R175 VSS.t236 VSS.n20 110.547
R176 VSS.t19 VSS.n61 110.543
R177 VSS.t171 VSS.n34 110.547
R178 VSS.n447 VSS.t46 287.909
R179 VSS.t235 VSS.n6 269.724
R180 VSS.n54 VSS.t65 332.017
R181 VSS.t177 VSS.n36 332.017
R182 VSS.n32 VSS.t90 116.469
R183 VSS.n28 VSS.n21 0.00596633
R184 VSS.t175 VSS.n420 258.233
R185 VSS.n20 VSS.n18 0.00596633
R186 VSS.n14 VSS.n34 0.00596635
R187 VSS.t20 VSS.n53 258.235
R188 VSS.t147 VSS.n8 258.231
R189 VSS.t234 VSS.n443 253.359
R190 VSS.t546 VSS.n251 252.375
R191 VSS.t540 VSS.n271 252.375
R192 VSS.t162 VSS.n302 252.375
R193 VSS.t518 VSS.n323 252.375
R194 VSS.n898 VSS.t268 252.375
R195 VSS.n877 VSS.t404 252.375
R196 VSS.t501 VSS.n231 252.375
R197 VSS.t401 VSS.n240 252.375
R198 VSS.n262 VSS.t522 252.375
R199 VSS.n283 VSS.t554 252.375
R200 VSS.n749 VSS.t112 252.375
R201 VSS.n711 VSS.t187 252.375
R202 VSS.n674 VSS.t556 252.375
R203 VSS.n653 VSS.t167 252.375
R204 VSS.n633 VSS.t387 252.375
R205 VSS.t196 VSS.n361 252.375
R206 VSS.t426 VSS.n372 252.375
R207 VSS.n248 VSS.t209 252.117
R208 VSS.n279 VSS.t509 252.117
R209 VSS.t267 VSS.n298 252.117
R210 VSS.t192 VSS.n309 252.117
R211 VSS.n368 VSS.t69 252.117
R212 VSS.n868 VSS.t82 252.115
R213 VSS.n849 VSS.t366 252.115
R214 VSS.t411 VSS.n111 252.115
R215 VSS.t160 VSS.n115 252.115
R216 VSS.n761 VSS.t186 252.115
R217 VSS.t429 VSS.n130 252.115
R218 VSS.n684 VSS.t539 252.115
R219 VSS.n664 VSS.t434 252.115
R220 VSS.n644 VSS.t505 252.115
R221 VSS.t195 VSS.n143 252.115
R222 VSS.t455 VSS.n221 250.837
R223 VSS.t457 VSS.n224 250.837
R224 VSS.t441 VSS.n230 250.837
R225 VSS.t459 VSS.n233 250.837
R226 VSS.t461 VSS.n239 250.837
R227 VSS.t467 VSS.n243 250.837
R228 VSS.t437 VSS.n250 250.837
R229 VSS.t469 VSS.n254 250.837
R230 VSS.t443 VSS.n261 250.837
R231 VSS.t471 VSS.n264 250.837
R232 VSS.t473 VSS.n270 250.837
R233 VSS.t439 VSS.n274 250.837
R234 VSS.t475 VSS.n281 250.837
R235 VSS.t477 VSS.n285 250.837
R236 VSS.t483 VSS.n291 250.837
R237 VSS.t479 VSS.n293 250.837
R238 VSS.t485 VSS.n301 250.837
R239 VSS.t491 VSS.n304 250.837
R240 VSS.t487 VSS.n312 250.837
R241 VSS.t493 VSS.n316 250.837
R242 VSS.t489 VSS.n322 250.837
R243 VSS.t495 VSS.n326 250.837
R244 VSS.t481 VSS.n332 250.837
R245 VSS.t465 VSS.n334 250.837
R246 VSS.t453 VSS.n341 250.837
R247 VSS.t445 VSS.n344 250.837
R248 VSS.t449 VSS.n350 250.837
R249 VSS.t497 VSS.n353 250.837
R250 VSS.t447 VSS.n359 250.837
R251 VSS.t463 VSS.n363 250.837
R252 VSS.t451 VSS.n370 250.837
R253 VSS.t499 VSS.n375 250.837
R254 VSS.n12 VSS.t232 117.216
R255 VSS.n1 VSS.n2 0.00166569
R256 VSS.n16 VSS.t299 240.956
R257 VSS.n47 VSS.t314 240.956
R258 VSS.n43 VSS.t329 240.956
R259 VSS.n26 VSS.t344 240.956
R260 VSS.n562 VSS.t359 240.956
R261 VSS.n869 VSS.t263 234.114
R262 VSS.n850 VSS.t510 234.114
R263 VSS.n831 VSS.t430 234.114
R264 VSS.n814 VSS.t156 234.114
R265 VSS.n796 VSS.t421 234.114
R266 VSS.n779 VSS.t188 234.114
R267 VSS.n762 VSS.t184 234.114
R268 VSS.n740 VSS.t59 234.114
R269 VSS.n721 VSS.t103 234.114
R270 VSS.n703 VSS.t50 234.114
R271 VSS.n685 VSS.t199 234.114
R272 VSS.n665 VSS.t525 234.114
R273 VSS.n645 VSS.t418 234.114
R274 VSS.n625 VSS.t528 234.114
R275 VSS.n606 VSS.t108 234.114
R276 VSS.n589 VSS.t61 234.114
R277 VSS.t149 VSS.n444 230.327
R278 VSS.t284 VSS.n2 117.528
R279 VSS.t314 VSS.n48 229.44
R280 VSS.t329 VSS.n44 229.44
R281 VSS.t359 VSS.n561 229.44
R282 VSS.n12 VSS.n11 4666.38
R283 VSS.t158 VSS.n260 225.361
R284 VSS.t57 VSS.n300 225.361
R285 VSS.t105 VSS.n311 225.361
R286 VSS.t523 VSS.n340 225.361
R287 VSS.t213 VSS.n96 225.359
R288 VSS.t265 VSS.n100 225.359
R289 VSS.n848 VSS.t512 225.359
R290 VSS.t432 VSS.n107 225.359
R291 VSS.t422 VSS.n116 225.359
R292 VSS.t190 VSS.n120 225.359
R293 VSS.n760 VSS.t182 225.359
R294 VSS.n702 VSS.t51 225.359
R295 VSS.t197 VSS.n134 225.359
R296 VSS.t416 VSS.n140 225.359
R297 VSS.n624 VSS.t526 225.359
R298 VSS.t110 VSS.n146 225.359
R299 VSS.t260 VSS.n101 211.982
R300 VSS.t229 VSS.n104 211.982
R301 VSS.t6 VSS.n108 211.982
R302 VSS.t9 VSS.n117 211.982
R303 VSS.t83 VSS.n131 211.982
R304 VSS.t16 VSS.n135 211.982
R305 VSS.n807 VSS.t86 211.982
R306 VSS.n753 VSS.t0 211.982
R307 VSS.n733 VSS.t94 211.982
R308 VSS.n657 VSS.t245 211.982
R309 VSS.n637 VSS.t3 211.982
R310 VSS.n222 VSS.t251 211.982
R311 VSS.n282 VSS.t242 211.982
R312 VSS.n313 VSS.t70 211.982
R313 VSS.n360 VSS.t122 211.982
R314 VSS.n371 VSS.t97 211.982
R315 VSS.n445 VSS.t149 207.294
R316 VSS.n9 VSS.t234 200.649
R317 VSS.n446 VSS.t147 195.778
R318 VSS.t506 VSS.n242 195.26
R319 VSS.t427 VSS.n253 195.26
R320 VSS.t408 VSS.n273 195.26
R321 VSS.t165 VSS.n315 195.26
R322 VSS.t53 VSS.n325 195.26
R323 VSS.t413 VSS.n343 195.26
R324 VSS.t201 VSS.n352 195.26
R325 VSS.t544 VSS.n374 195.26
R326 VSS.t206 VSS.n98 195.26
R327 VSS.n858 VSS.t388 195.26
R328 VSS.t391 VSS.n113 195.26
R329 VSS.t394 VSS.n122 195.26
R330 VSS.n748 VSS.t504 195.26
R331 VSS.n729 VSS.t436 195.26
R332 VSS.n673 VSS.t399 195.26
R333 VSS.n614 VSS.t180 195.26
R334 VSS.t269 VSS.n14 114.148
R335 VSS.t178 VSS.n36 106.362
R336 VSS.n54 VSS.t67 106.362
R337 VSS.n875 VSS.t36 187.292
R338 VSS.n856 VSS.t140 187.292
R339 VSS.n837 VSS.t63 187.292
R340 VSS.n820 VSS.t77 187.292
R341 VSS.n802 VSS.t220 187.292
R342 VSS.n785 VSS.t41 187.292
R343 VSS.n768 VSS.t118 187.292
R344 VSS.n746 VSS.t218 187.292
R345 VSS.n727 VSS.t222 187.292
R346 VSS.n709 VSS.t536 187.292
R347 VSS.n691 VSS.t144 187.292
R348 VSS.n671 VSS.t224 187.292
R349 VSS.n651 VSS.t543 187.292
R350 VSS.n631 VSS.t142 187.292
R351 VSS.n612 VSS.t43 187.292
R352 VSS.n595 VSS.t120 187.292
R353 VSS.n448 VSS.t235 184.262
R354 VSS.n35 VSS.n37 0.00954674
R355 VSS.n0 VSS.n61 0.00954671
R356 VSS.n58 VSS.t153 110.546
R357 VSS.n24 VSS.t226 110.547
R358 VSS.n31 VSS.n32 0.00588068
R359 VSS.t258 VSS.n228 173.913
R360 VSS.t116 VSS.n237 173.913
R361 VSS.t132 VSS.n247 173.913
R362 VSS.n258 VSS.t551 173.913
R363 VSS.n268 VSS.t39 173.913
R364 VSS.t138 VSS.n278 173.913
R365 VSS.t255 VSS.n289 173.913
R366 VSS.t240 VSS.n297 173.913
R367 VSS.t129 VSS.n308 173.913
R368 VSS.n320 VSS.t126 173.913
R369 VSS.t23 VSS.n330 173.913
R370 VSS.t211 VSS.n338 173.913
R371 VSS.t548 VSS.n348 173.913
R372 VSS.n357 VSS.t80 173.913
R373 VSS.t101 VSS.n367 173.913
R374 VSS.t135 VSS.n379 173.913
R375 VSS.n577 VSS.n383 173.913
R376 VSS.t252 VSS.t207 163.881
R377 VSS.t261 VSS.t389 163.881
R378 VSS.t230 VSS.t507 163.881
R379 VSS.t7 VSS.t428 163.881
R380 VSS.t87 VSS.t392 163.881
R381 VSS.t10 VSS.t409 163.881
R382 VSS.t243 VSS.t395 163.881
R383 VSS.t1 VSS.t503 163.881
R384 VSS.t95 VSS.t435 163.881
R385 VSS.t71 VSS.t163 163.881
R386 VSS.t84 VSS.t55 163.881
R387 VSS.t17 VSS.t400 163.881
R388 VSS.t246 VSS.t412 163.881
R389 VSS.t4 VSS.t202 163.881
R390 VSS.t123 VSS.t181 163.881
R391 VSS.t98 VSS.t545 163.881
R392 VSS.n4 VSS.t276 105.688
R393 VSS.n52 VSS.t291 160.341
R394 VSS.n46 VSS.t306 160.341
R395 VSS.n41 VSS.t321 160.341
R396 VSS.t339 VSS.n22 148.827
R397 VSS.n38 VSS.t351 160.341
R398 VSS.t534 VSS.n90 157.062
R399 VSS.t517 VSS.n92 156.429
R400 VSS.t410 VSS.n222 155.126
R401 VSS.t555 VSS.n282 155.126
R402 VSS.t557 VSS.n313 155.126
R403 VSS.t12 VSS.n360 155.126
R404 VSS.t402 VSS.n371 155.126
R405 VSS.t531 VSS.n101 155.125
R406 VSS.t521 VSS.n104 155.125
R407 VSS.t14 VSS.n108 155.125
R408 VSS.n807 VSS.t420 155.125
R409 VSS.t397 VSS.n117 155.125
R410 VSS.n753 VSS.t424 155.125
R411 VSS.n733 VSS.t193 155.125
R412 VSS.t537 VSS.n131 155.125
R413 VSS.t273 VSS.n135 155.125
R414 VSS.n657 VSS.t405 155.125
R415 VSS.n637 VSS.t113 155.125
R416 VSS.t168 VSS.n7 153.971
R417 VSS.n899 VSS.t75 153.846
R418 VSS.n875 VSS.t257 153.846
R419 VSS.n856 VSS.t115 153.846
R420 VSS.n837 VSS.t131 153.846
R421 VSS.n820 VSS.t550 153.846
R422 VSS.n802 VSS.t38 153.846
R423 VSS.n785 VSS.t137 153.846
R424 VSS.n768 VSS.t254 153.846
R425 VSS.n746 VSS.t239 153.846
R426 VSS.n727 VSS.t128 153.846
R427 VSS.n709 VSS.t125 153.846
R428 VSS.n691 VSS.t22 153.846
R429 VSS.n671 VSS.t210 153.846
R430 VSS.n651 VSS.t547 153.846
R431 VSS.n631 VSS.t79 153.846
R432 VSS.n612 VSS.t100 153.846
R433 VSS.n595 VSS.t134 153.846
R434 VSS.t216 VSS.n92 153.327
R435 VSS.t535 VSS.n93 153.236
R436 VSS.t46 VSS.n442 149.713
R437 VSS.t279 VSS.n3 101.742
R438 VSS.t294 VSS.n52 148.826
R439 VSS.t309 VSS.n46 148.826
R440 VSS.t324 VSS.n41 148.826
R441 VSS.t354 VSS.n38 148.826
R442 VSS.t275 VSS.n227 147.157
R443 VSS.t530 VSS.n236 147.157
R444 VSS.t519 VSS.n246 147.157
R445 VSS.t161 VSS.n257 147.157
R446 VSS.t271 VSS.n267 147.157
R447 VSS.t502 VSS.n277 147.157
R448 VSS.t558 VSS.n288 147.157
R449 VSS.t107 VSS.n296 147.157
R450 VSS.t407 VSS.n307 147.157
R451 VSS.t48 VSS.n319 147.157
R452 VSS.t415 VSS.n329 147.157
R453 VSS.t385 VSS.n337 147.157
R454 VSS.t538 VSS.n347 147.157
R455 VSS.t559 VSS.n356 147.157
R456 VSS.t520 VSS.n366 147.157
R457 VSS.t560 VSS.n378 147.157
R458 VSS.t379 VSS.n151 145.093
R459 VSS.t375 VSS.n151 138.404
R460 VSS.n31 VSS.n33 0.00760728
R461 VSS.t349 VSS.n55 97.2238
R462 VSS.t334 VSS.n56 97.2238
R463 VSS.t319 VSS.n57 97.2238
R464 VSS.n59 VSS.n18 0.00760728
R465 VSS.t289 VSS.n60 97.2238
R466 VSS.n15 VSS.n14 0.00760717
R467 VSS.n913 VSS.t33 134.661
R468 VSS.n380 VSS.t375 131.974
R469 VSS.n5 VSS.t65 130.939
R470 VSS.n62 VSS.t177 131.005
R471 VSS.n910 VSS.t25 126.945
R472 VSS.n911 VSS.t31 123.212
R473 VSS.n93 VSS.t517 120.691
R474 VSS.n13 VSS.t562 119.422
R475 VSS.t532 VSS.n913 117.858
R476 VSS.n383 VSS.t379 117.058
R477 VSS.t542 VSS.n86 115.745
R478 VSS.t541 VSS.n88 108.276
R479 VSS.n878 VSS.t410 107.023
R480 VSS.n869 VSS.t275 107.023
R481 VSS.n859 VSS.t531 107.023
R482 VSS.n850 VSS.t530 107.023
R483 VSS.n839 VSS.t521 107.023
R484 VSS.n831 VSS.t519 107.023
R485 VSS.n822 VSS.t14 107.023
R486 VSS.n814 VSS.t161 107.023
R487 VSS.t420 VSS.n804 107.023
R488 VSS.n796 VSS.t271 107.023
R489 VSS.n787 VSS.t397 107.023
R490 VSS.n779 VSS.t502 107.023
R491 VSS.n770 VSS.t555 107.023
R492 VSS.n762 VSS.t558 107.023
R493 VSS.t424 VSS.n750 107.023
R494 VSS.n740 VSS.t107 107.023
R495 VSS.t193 VSS.n730 107.023
R496 VSS.n721 VSS.t407 107.023
R497 VSS.n712 VSS.t557 107.023
R498 VSS.n703 VSS.t48 107.023
R499 VSS.n693 VSS.t537 107.023
R500 VSS.n685 VSS.t415 107.023
R501 VSS.n675 VSS.t273 107.023
R502 VSS.n665 VSS.t385 107.023
R503 VSS.t405 VSS.n654 107.023
R504 VSS.n645 VSS.t538 107.023
R505 VSS.t113 VSS.n634 107.023
R506 VSS.n625 VSS.t559 107.023
R507 VSS.n615 VSS.t12 107.023
R508 VSS.n606 VSS.t520 107.023
R509 VSS.n597 VSS.t402 107.023
R510 VSS.n589 VSS.t560 107.023
R511 VSS.t368 VSS.n899 100.335
R512 VSS.t257 VSS.n227 100.335
R513 VSS.t115 VSS.n236 100.335
R514 VSS.t131 VSS.n246 100.335
R515 VSS.t550 VSS.n257 100.335
R516 VSS.t38 VSS.n267 100.335
R517 VSS.t137 VSS.n277 100.335
R518 VSS.t254 VSS.n288 100.335
R519 VSS.t239 VSS.n296 100.335
R520 VSS.t128 VSS.n307 100.335
R521 VSS.t125 VSS.n319 100.335
R522 VSS.t22 VSS.n329 100.335
R523 VSS.t210 VSS.n337 100.335
R524 VSS.t547 VSS.n347 100.335
R525 VSS.t79 VSS.n356 100.335
R526 VSS.t100 VSS.n366 100.335
R527 VSS.t134 VSS.n378 100.335
R528 VSS.n909 VSS.t215 97.0758
R529 VSS.n10 VSS.t561 96.3896
R530 VSS.t27 VSS.n90 93.5889
R531 VSS.n909 VSS.t34 93.3421
R532 VSS.n380 VSS.t135 88.4945
R533 VSS.t551 VSS.n111 88.2366
R534 VSS.t39 VSS.n115 88.2366
R535 VSS.t126 VSS.n130 88.2366
R536 VSS.t80 VSS.n143 88.2366
R537 VSS.n868 VSS.t258 88.2366
R538 VSS.n849 VSS.t116 88.2366
R539 VSS.n761 VSS.t255 88.2366
R540 VSS.n684 VSS.t23 88.2366
R541 VSS.n664 VSS.t211 88.2366
R542 VSS.n644 VSS.t548 88.2366
R543 VSS.n248 VSS.t132 88.2359
R544 VSS.n279 VSS.t138 88.2359
R545 VSS.n298 VSS.t240 88.2359
R546 VSS.n309 VSS.t129 88.2359
R547 VSS.n368 VSS.t101 88.2359
R548 VSS.n914 VSS.t514 88.133
R549 VSS.t73 VSS.t368 86.957
R550 VSS.t75 VSS.t372 86.957
R551 VSS.t45 VSS.n10 84.8733
R552 VSS.t514 VSS.n11 82.7875
R553 VSS.n88 VSS.t516 82.1411
R554 VSS.t516 VSS.n87 75.0671
R555 VSS.n907 VSS.t73 74.8579
R556 VSS.t29 VSS.n86 74.6738
R557 VSS.t151 VSS.n9 73.9692
R558 VSS.n878 VSS.t252 70.2346
R559 VSS.n859 VSS.t261 70.2346
R560 VSS.n839 VSS.t230 70.2346
R561 VSS.n822 VSS.t7 70.2346
R562 VSS.n804 VSS.t87 70.2346
R563 VSS.n787 VSS.t10 70.2346
R564 VSS.n770 VSS.t243 70.2346
R565 VSS.n750 VSS.t1 70.2346
R566 VSS.n730 VSS.t95 70.2346
R567 VSS.n712 VSS.t71 70.2346
R568 VSS.n693 VSS.t84 70.2346
R569 VSS.n675 VSS.t17 70.2346
R570 VSS.n654 VSS.t246 70.2346
R571 VSS.n634 VSS.t4 70.2346
R572 VSS.n615 VSS.t123 70.2346
R573 VSS.n597 VSS.t98 70.2346
R574 VSS.n3 VSS.n1 0.00115721
R575 VSS.t296 VSS.n16 68.211
R576 VSS.t311 VSS.n47 68.211
R577 VSS.t326 VSS.n43 68.211
R578 VSS.t341 VSS.n26 68.211
R579 VSS.t356 VSS.n562 68.211
R580 VSS.n911 VSS.t29 67.2065
R581 VSS.n876 VSS.t206 66.8901
R582 VSS.t36 VSS.n224 66.8901
R583 VSS.t388 VSS.n857 66.8901
R584 VSS.t140 VSS.n233 66.8901
R585 VSS.n838 VSS.t506 66.8901
R586 VSS.t63 VSS.n243 66.8901
R587 VSS.n821 VSS.t427 66.8901
R588 VSS.t77 VSS.n254 66.8901
R589 VSS.n803 VSS.t391 66.8901
R590 VSS.t220 VSS.n264 66.8901
R591 VSS.n786 VSS.t408 66.8901
R592 VSS.t41 VSS.n274 66.8901
R593 VSS.n769 VSS.t394 66.8901
R594 VSS.t118 VSS.n285 66.8901
R595 VSS.t504 VSS.n747 66.8901
R596 VSS.t218 VSS.n293 66.8901
R597 VSS.t436 VSS.n728 66.8901
R598 VSS.t222 VSS.n304 66.8901
R599 VSS.n710 VSS.t165 66.8901
R600 VSS.t536 VSS.n316 66.8901
R601 VSS.n692 VSS.t53 66.8901
R602 VSS.t144 VSS.n326 66.8901
R603 VSS.t399 VSS.n672 66.8901
R604 VSS.t224 VSS.n334 66.8901
R605 VSS.n652 VSS.t413 66.8901
R606 VSS.t543 VSS.n344 66.8901
R607 VSS.n632 VSS.t201 66.8901
R608 VSS.t142 VSS.n353 66.8901
R609 VSS.t180 VSS.n613 66.8901
R610 VSS.t43 VSS.n363 66.8901
R611 VSS.n596 VSS.t544 66.8901
R612 VSS.t120 VSS.n375 66.8901
R613 VSS.n910 VSS.t27 63.4728
R614 VSS.t34 VSS.n91 62.2523
R615 VSS.t145 VSS.n13 61.8407
R616 VSS.t215 VSS.n908 58.5186
R617 VSS.t203 VSS.n63 56.6955
R618 VSS.n438 VSS.t286 56.0825
R619 VSS.n51 VSS.t301 56.6955
R620 VSS.n421 VSS.t316 56.0825
R621 VSS.n410 VSS.t331 56.0825
R622 VSS.n40 VSS.t346 56.6955
R623 VSS.n29 VSS.t361 56.0825
R624 VSS.n914 VSS.t532 54.532
R625 VSS.t384 VSS.n5 50.3244
R626 VSS.t92 VSS.n62 44.8755
R627 VSS.t251 VSS.n221 50.1677
R628 VSS.n230 VSS.t260 50.1677
R629 VSS.n239 VSS.t229 50.1677
R630 VSS.n250 VSS.t6 50.1677
R631 VSS.t86 VSS.n261 50.1677
R632 VSS.n270 VSS.t9 50.1677
R633 VSS.t242 VSS.n281 50.1677
R634 VSS.t0 VSS.n291 50.1677
R635 VSS.t94 VSS.n301 50.1677
R636 VSS.t70 VSS.n312 50.1677
R637 VSS.n322 VSS.t83 50.1677
R638 VSS.n332 VSS.t16 50.1677
R639 VSS.t245 VSS.n341 50.1677
R640 VSS.t3 VSS.n350 50.1677
R641 VSS.t122 VSS.n359 50.1677
R642 VSS.t97 VSS.n370 50.1677
R643 VSS.n89 VSS.t541 47.3176
R644 VSS.n912 VSS.t542 39.8503
R645 VSS.n885 VSS.t213 36.7898
R646 VSS.n867 VSS.t265 36.7898
R647 VSS.t512 VSS.n847 36.7898
R648 VSS.n830 VSS.t432 36.7898
R649 VSS.n813 VSS.t158 36.7898
R650 VSS.n795 VSS.t422 36.7898
R651 VSS.n778 VSS.t190 36.7898
R652 VSS.t182 VSS.n759 36.7898
R653 VSS.n739 VSS.t57 36.7898
R654 VSS.n720 VSS.t105 36.7898
R655 VSS.t51 VSS.n701 36.7898
R656 VSS.n683 VSS.t197 36.7898
R657 VSS.n663 VSS.t523 36.7898
R658 VSS.n643 VSS.t416 36.7898
R659 VSS.t526 VSS.n623 36.7898
R660 VSS.n605 VSS.t110 36.7898
R661 VSS.t33 VSS.n912 36.1166
R662 VSS.t31 VSS.n87 33.9948
R663 VSS.t25 VSS.n89 28.6493
R664 VSS.t207 VSS.n877 28.2938
R665 VSS.t389 VSS.n231 28.2938
R666 VSS.t507 VSS.n240 28.2938
R667 VSS.t392 VSS.n262 28.2938
R668 VSS.t395 VSS.n283 28.2938
R669 VSS.t503 VSS.n749 28.2938
R670 VSS.t163 VSS.n711 28.2938
R671 VSS.t400 VSS.n674 28.2938
R672 VSS.t412 VSS.n653 28.2938
R673 VSS.t202 VSS.n633 28.2938
R674 VSS.t181 VSS.n361 28.2938
R675 VSS.t545 VSS.n372 28.2938
R676 VSS.t428 VSS.n251 28.2928
R677 VSS.t409 VSS.n271 28.2928
R678 VSS.t435 VSS.n302 28.2928
R679 VSS.t55 VSS.n323 28.2928
R680 VSS.n907 VSS.t535 28.0359
R681 VSS.n7 VSS.t169 27.2918
R682 VSS.n63 VSS.n35 0.00206574
R683 VSS.n64 VSS.t553 20.3065
R684 VSS.t372 VSS.n898 21.6048
R685 VSS.t263 VSS.n228 20.0674
R686 VSS.t510 VSS.n237 20.0674
R687 VSS.t430 VSS.n247 20.0674
R688 VSS.t156 VSS.n258 20.0674
R689 VSS.t421 VSS.n268 20.0674
R690 VSS.t188 VSS.n278 20.0674
R691 VSS.t184 VSS.n289 20.0674
R692 VSS.t59 VSS.n297 20.0674
R693 VSS.t103 VSS.n308 20.0674
R694 VSS.t50 VSS.n320 20.0674
R695 VSS.t199 VSS.n330 20.0674
R696 VSS.t525 VSS.n338 20.0674
R697 VSS.t418 VSS.n348 20.0674
R698 VSS.t528 VSS.n357 20.0674
R699 VSS.t108 VSS.n367 20.0674
R700 VSS.t61 VSS.n379 20.0674
R701 VSS.t268 VSS.n96 18.0025
R702 VSS.t404 VSS.n98 18.0025
R703 VSS.t82 VSS.n100 18.0025
R704 VSS.t209 VSS.n107 18.0025
R705 VSS.t522 VSS.n113 18.0025
R706 VSS.n116 VSS.t160 18.0025
R707 VSS.t509 VSS.n120 18.0025
R708 VSS.t554 VSS.n122 18.0025
R709 VSS.t539 VSS.n134 18.0025
R710 VSS.t505 VSS.n140 18.0025
R711 VSS.t69 VSS.n146 18.0025
R712 VSS.n858 VSS.t501 18.0025
R713 VSS.t366 VSS.n848 18.0025
R714 VSS.t186 VSS.n760 18.0025
R715 VSS.t112 VSS.n748 18.0025
R716 VSS.n729 VSS.t162 18.0025
R717 VSS.n702 VSS.t429 18.0025
R718 VSS.t556 VSS.n673 18.0025
R719 VSS.n624 VSS.t195 18.0025
R720 VSS.n614 VSS.t196 18.0025
R721 VSS.n242 VSS.t401 18.0017
R722 VSS.n253 VSS.t546 18.0017
R723 VSS.n260 VSS.t411 18.0017
R724 VSS.n273 VSS.t540 18.0017
R725 VSS.n300 VSS.t267 18.0017
R726 VSS.n311 VSS.t192 18.0017
R727 VSS.t187 VSS.n315 18.0017
R728 VSS.n325 VSS.t518 18.0017
R729 VSS.t434 VSS.n340 18.0017
R730 VSS.t167 VSS.n343 18.0017
R731 VSS.t387 VSS.n352 18.0017
R732 VSS.n374 VSS.t426 18.0017
R733 VSS.n908 VSS.t216 17.4483
R734 VSS.n929 VSS.t35 17.3368
R735 VSS.n925 VSS.t26 17.3368
R736 VSS.n921 VSS.t30 17.3368
R737 VSS.n455 VSS.t150 17.3368
R738 VSS.n459 VSS.t146 17.3368
R739 VSS.n463 VSS.t47 17.3368
R740 VSS.n467 VSS.t66 17.3368
R741 VSS.n904 VSS.t74 17.3368
R742 VSS.n523 VSS.t93 17.2607
R743 VSS.n441 VSS.t278 17.2313
R744 VSS.n480 VSS.t283 17.2313
R745 VSS.n484 VSS.t288 17.2313
R746 VSS.n432 VSS.t293 17.2313
R747 VSS.n496 VSS.t298 17.2313
R748 VSS.n500 VSS.t303 17.2313
R749 VSS.n424 VSS.t308 17.2313
R750 VSS.n511 VSS.t313 17.2313
R751 VSS.n515 VSS.t318 17.2313
R752 VSS.n413 VSS.t323 17.2313
R753 VSS.n534 VSS.t328 17.2313
R754 VSS.n538 VSS.t333 17.2313
R755 VSS.n404 VSS.t338 17.2313
R756 VSS.n550 VSS.t343 17.2313
R757 VSS.n554 VSS.t348 17.2313
R758 VSS.n396 VSS.t353 17.2313
R759 VSS.n567 VSS.t358 17.2313
R760 VSS.n572 VSS.t363 17.2313
R761 VSS.n916 VSS.n915 17.0005
R762 VSS.n915 VSS.n86 17.0005
R763 VSS.n915 VSS.n911 17.0005
R764 VSS.n915 VSS.n88 17.0005
R765 VSS.n915 VSS.n910 17.0005
R766 VSS.n915 VSS.n909 17.0005
R767 VSS.n915 VSS.n906 17.0005
R768 VSS.n915 VSS.n220 17.0005
R769 VSS.n915 VSS.n226 17.0005
R770 VSS.n915 VSS.n235 17.0005
R771 VSS.n915 VSS.n245 17.0005
R772 VSS.n915 VSS.n256 17.0005
R773 VSS.n915 VSS.n266 17.0005
R774 VSS.n915 VSS.n276 17.0005
R775 VSS.n915 VSS.n287 17.0005
R776 VSS.n915 VSS.n295 17.0005
R777 VSS.n915 VSS.n306 17.0005
R778 VSS.n915 VSS.n318 17.0005
R779 VSS.n915 VSS.n328 17.0005
R780 VSS.n915 VSS.n336 17.0005
R781 VSS.n915 VSS.n346 17.0005
R782 VSS.n915 VSS.n355 17.0005
R783 VSS.n915 VSS.n365 17.0005
R784 VSS.n915 VSS.n377 17.0005
R785 VSS.n915 VSS.n381 17.0005
R786 VSS.n915 VSS.n588 17.0005
R787 VSS.n915 VSS.n382 17.0005
R788 VSS.n915 VSS.n583 17.0005
R789 VSS.n915 VSS.n384 17.0005
R790 VSS.n915 VSS.n218 17.0005
R791 VSS.n915 VSS.n95 17.0005
R792 VSS.n82 VSS.n30 5.65652
R793 VSS.n30 VSS.n39 0.00104691
R794 VSS.n23 VSS.n545 17.0005
R795 VSS.n45 VSS.n76 5.65652
R796 VSS.n45 VSS.n414 17.0005
R797 VSS.n36 VSS.n35 6.82739
R798 VSS.n64 VSS.n35 0.800314
R799 VSS.n49 VSS.n50 0.00104691
R800 VSS.n49 VSS.n19 0.00107219
R801 VSS.n18 VSS.n70 5.65652
R802 VSS.n0 VSS.n491 17.0005
R803 VSS.n0 VSS.n53 0.0010374
R804 VSS.n1 VSS.n67 5.65652
R805 VSS.n14 VSS.n54 6.82737
R806 VSS.n14 VSS.n448 17.0005
R807 VSS.n14 VSS.n447 17.0005
R808 VSS.n14 VSS.n442 17.0005
R809 VSS.n14 VSS.n446 17.0005
R810 VSS.n14 VSS.n443 17.0005
R811 VSS.n14 VSS.n445 17.0005
R812 VSS.n14 VSS.n444 17.0005
R813 VSS.n450 VSS.n14 17.0005
R814 VSS.n449 VSS.t277 17.0005
R815 VSS.n440 VSS.t280 17.0005
R816 VSS.n478 VSS.t282 17.0005
R817 VSS.n436 VSS.t285 17.0005
R818 VSS.n435 VSS.t287 17.0005
R819 VSS.n434 VSS.t290 17.0005
R820 VSS.n433 VSS.t292 17.0005
R821 VSS.n431 VSS.t295 17.0005
R822 VSS.n494 VSS.t297 17.0005
R823 VSS.n428 VSS.t300 17.0005
R824 VSS.n427 VSS.t302 17.0005
R825 VSS.n426 VSS.t305 17.0005
R826 VSS.n425 VSS.t307 17.0005
R827 VSS.n423 VSS.t310 17.0005
R828 VSS.n509 VSS.t312 17.0005
R829 VSS.n418 VSS.t315 17.0005
R830 VSS.n417 VSS.t317 17.0005
R831 VSS.n416 VSS.t320 17.0005
R832 VSS.n415 VSS.t322 17.0005
R833 VSS.n412 VSS.t325 17.0005
R834 VSS.n532 VSS.t327 17.0005
R835 VSS.n408 VSS.t330 17.0005
R836 VSS.n407 VSS.t332 17.0005
R837 VSS.n406 VSS.t335 17.0005
R838 VSS.n405 VSS.t337 17.0005
R839 VSS.n403 VSS.t340 17.0005
R840 VSS.n548 VSS.t342 17.0005
R841 VSS.n400 VSS.t345 17.0005
R842 VSS.n399 VSS.t347 17.0005
R843 VSS.n398 VSS.t350 17.0005
R844 VSS.n397 VSS.t352 17.0005
R845 VSS.n395 VSS.t355 17.0005
R846 VSS.n394 VSS.t357 17.0005
R847 VSS.n393 VSS.t360 17.0005
R848 VSS.n392 VSS.t362 17.0005
R849 VSS.n574 VSS.t365 17.0005
R850 VSS.n8 VSS.t383 16.3876
R851 VSS.n440 VSS.t597 15.3099
R852 VSS.n436 VSS.t595 15.3099
R853 VSS.n434 VSS.t593 15.3099
R854 VSS.n431 VSS.t591 15.3099
R855 VSS.n428 VSS.t589 15.3099
R856 VSS.n426 VSS.t587 15.3099
R857 VSS.n423 VSS.t585 15.3099
R858 VSS.n418 VSS.t583 15.3099
R859 VSS.n416 VSS.t581 15.3099
R860 VSS.n412 VSS.t579 15.3099
R861 VSS.n408 VSS.t577 15.3099
R862 VSS.n406 VSS.t575 15.3099
R863 VSS.n403 VSS.t573 15.3099
R864 VSS.n400 VSS.t571 15.3099
R865 VSS.n398 VSS.t569 15.3099
R866 VSS.n395 VSS.t567 15.3099
R867 VSS.n393 VSS.t565 15.3099
R868 VSS.n574 VSS.t563 15.3099
R869 VSS.n449 VSS.t598 15.2696
R870 VSS.n478 VSS.t596 15.2696
R871 VSS.n435 VSS.t594 15.2696
R872 VSS.n433 VSS.t592 15.2696
R873 VSS.n494 VSS.t590 15.2696
R874 VSS.n427 VSS.t588 15.2696
R875 VSS.n425 VSS.t586 15.2696
R876 VSS.n509 VSS.t584 15.2696
R877 VSS.n417 VSS.t582 15.2696
R878 VSS.n415 VSS.t580 15.2696
R879 VSS.n532 VSS.t578 15.2696
R880 VSS.n407 VSS.t576 15.2696
R881 VSS.n405 VSS.t574 15.2696
R882 VSS.n548 VSS.t572 15.2696
R883 VSS.n399 VSS.t570 15.2696
R884 VSS.n397 VSS.t568 15.2696
R885 VSS.n394 VSS.t566 15.2696
R886 VSS.n392 VSS.t564 15.2696
R887 VSS.n584 VSS.t374 15.1276
R888 VSS.n387 VSS.t378 15.0005
R889 VSS.n891 VSS.t371 15.0005
R890 VSS.n901 VSS.t367 15.0005
R891 VSS.n91 VSS.t534 13.7147
R892 VSS.n153 VSS.t62 8.85039
R893 VSS.n155 VSS.t403 8.85039
R894 VSS.n157 VSS.t109 8.85039
R895 VSS.n159 VSS.t13 8.85039
R896 VSS.n161 VSS.t529 8.85039
R897 VSS.n163 VSS.t114 8.85039
R898 VSS.n165 VSS.t419 8.85039
R899 VSS.n167 VSS.t406 8.85039
R900 VSS.n169 VSS.t386 8.85039
R901 VSS.n171 VSS.t274 8.85039
R902 VSS.n173 VSS.t200 8.85039
R903 VSS.n175 VSS.t56 8.85039
R904 VSS.n177 VSS.t49 8.85039
R905 VSS.n179 VSS.t164 8.85039
R906 VSS.n181 VSS.t104 8.85039
R907 VSS.n183 VSS.t194 8.85039
R908 VSS.n185 VSS.t60 8.85039
R909 VSS.n187 VSS.t425 8.85039
R910 VSS.n189 VSS.t185 8.85039
R911 VSS.n191 VSS.t396 8.85039
R912 VSS.n193 VSS.t189 8.85039
R913 VSS.n195 VSS.t398 8.85039
R914 VSS.n197 VSS.t272 8.85039
R915 VSS.n199 VSS.t393 8.85039
R916 VSS.n201 VSS.t157 8.85039
R917 VSS.n203 VSS.t15 8.85039
R918 VSS.n205 VSS.t431 8.85039
R919 VSS.n207 VSS.t508 8.85039
R920 VSS.n209 VSS.t511 8.85039
R921 VSS.n211 VSS.t390 8.85039
R922 VSS.n213 VSS.t264 8.85039
R923 VSS.n215 VSS.t208 8.85039
R924 VSS.n931 VSS.t217 8.80385
R925 VSS.n927 VSS.t28 8.80385
R926 VSS.n923 VSS.t32 8.80385
R927 VSS.n895 VSS.t76 8.80385
R928 VSS.n457 VSS.t152 8.80285
R929 VSS.n461 VSS.t148 8.80285
R930 VSS.n465 VSS.t170 8.80285
R931 VSS.n469 VSS.t68 8.80285
R932 VSS.n590 VSS.t136 8.77423
R933 VSS.n376 VSS.t121 8.77423
R934 VSS.n598 VSS.t99 8.77423
R935 VSS.n603 VSS.t111 8.77423
R936 VSS.n607 VSS.t102 8.77423
R937 VSS.n364 VSS.t44 8.77423
R938 VSS.n616 VSS.t124 8.77423
R939 VSS.n621 VSS.t527 8.77423
R940 VSS.n626 VSS.t81 8.77423
R941 VSS.n354 VSS.t143 8.77423
R942 VSS.n635 VSS.t5 8.77423
R943 VSS.n641 VSS.t417 8.77423
R944 VSS.n646 VSS.t549 8.77423
R945 VSS.n345 VSS.t414 8.77423
R946 VSS.n655 VSS.t247 8.77423
R947 VSS.n661 VSS.t524 8.77423
R948 VSS.n666 VSS.t212 8.77423
R949 VSS.n335 VSS.t225 8.77423
R950 VSS.n676 VSS.t18 8.77423
R951 VSS.n681 VSS.t198 8.77423
R952 VSS.n686 VSS.t24 8.77423
R953 VSS.n327 VSS.t54 8.77423
R954 VSS.n694 VSS.t85 8.77423
R955 VSS.n699 VSS.t52 8.77423
R956 VSS.n704 VSS.t127 8.77423
R957 VSS.n317 VSS.t166 8.77423
R958 VSS.n713 VSS.t72 8.77423
R959 VSS.n718 VSS.t106 8.77423
R960 VSS.n722 VSS.t130 8.77423
R961 VSS.n305 VSS.t223 8.77423
R962 VSS.n731 VSS.t96 8.77423
R963 VSS.n737 VSS.t58 8.77423
R964 VSS.n741 VSS.t241 8.77423
R965 VSS.n294 VSS.t219 8.77423
R966 VSS.n751 VSS.t2 8.77423
R967 VSS.n757 VSS.t183 8.77423
R968 VSS.n763 VSS.t256 8.77423
R969 VSS.n286 VSS.t119 8.77423
R970 VSS.n771 VSS.t244 8.77423
R971 VSS.n776 VSS.t191 8.77423
R972 VSS.n780 VSS.t139 8.77423
R973 VSS.n275 VSS.t42 8.77423
R974 VSS.n788 VSS.t11 8.77423
R975 VSS.n793 VSS.t423 8.77423
R976 VSS.n797 VSS.t40 8.77423
R977 VSS.n265 VSS.t221 8.77423
R978 VSS.n805 VSS.t88 8.77423
R979 VSS.n811 VSS.t159 8.77423
R980 VSS.n815 VSS.t552 8.77423
R981 VSS.n255 VSS.t78 8.77423
R982 VSS.n823 VSS.t8 8.77423
R983 VSS.n828 VSS.t433 8.77423
R984 VSS.n832 VSS.t133 8.77423
R985 VSS.n244 VSS.t64 8.77423
R986 VSS.n840 VSS.t231 8.77423
R987 VSS.n845 VSS.t513 8.77423
R988 VSS.n851 VSS.t117 8.77423
R989 VSS.n234 VSS.t141 8.77423
R990 VSS.n860 VSS.t262 8.77423
R991 VSS.n865 VSS.t266 8.77423
R992 VSS.n870 VSS.t259 8.77423
R993 VSS.n225 VSS.t37 8.77423
R994 VSS.n879 VSS.t253 8.77423
R995 VSS.n886 VSS.t214 8.77423
R996 VSS.n473 VSS.t173 8.77323
R997 VSS.n488 VSS.t21 8.77323
R998 VSS.n504 VSS.t238 8.77323
R999 VSS.n519 VSS.t155 8.77323
R1000 VSS.n521 VSS.t205 8.77323
R1001 VSS.n527 VSS.t176 8.77323
R1002 VSS.n542 VSS.t228 8.77323
R1003 VSS.n558 VSS.t250 8.77323
R1004 VSS.n391 VSS.t91 8.77323
R1005 VSS.n471 VSS.t270 8.76689
R1006 VSS.n525 VSS.t179 8.76678
R1007 VSS.n919 VSS.t533 8.75731
R1008 VSS.n917 VSS.t515 8.75731
R1009 VSS.n451 VSS.t233 8.75631
R1010 VSS.n453 VSS.t382 8.75631
R1011 VSS.n577 VSS.n65 88.4708
R1012 VSS.n31 VSS.n83 4.22409
R1013 VSS.n564 VSS.n82 0.0180497
R1014 VSS.n81 VSS.n560 0.0633111
R1015 VSS.n553 VSS.n80 0.0435295
R1016 VSS.n79 VSS.n21 5.65652
R1017 VSS.n78 VSS.n544 0.0633111
R1018 VSS.n77 VSS.n23 4.22409
R1019 VSS.n531 VSS.n76 0.0180497
R1020 VSS.n75 VSS.n529 0.0633111
R1021 VSS.n74 VSS.n35 4.22409
R1022 VSS.n73 VSS.n49 5.65652
R1023 VSS.n72 VSS.n506 0.0633111
R1024 VSS.n71 VSS.n18 4.22409
R1025 VSS.n493 VSS.n70 0.0180497
R1026 VSS.n69 VSS.n490 0.0633111
R1027 VSS.n483 VSS.n68 0.0435295
R1028 VSS.n477 VSS.n67 0.0180497
R1029 VSS.n66 VSS.n475 0.0633111
R1030 VSS.n915 VSS.n899 8.5005
R1031 VSS.n915 VSS.n885 8.5005
R1032 VSS.n915 VSS.n221 8.5005
R1033 VSS.n915 VSS.n878 8.5005
R1034 VSS.n915 VSS.n876 8.5005
R1035 VSS.n915 VSS.n224 8.5005
R1036 VSS.n915 VSS.n875 8.5005
R1037 VSS.n915 VSS.n227 8.5005
R1038 VSS.n915 VSS.n869 8.5005
R1039 VSS.n915 VSS.n228 8.5005
R1040 VSS.n915 VSS.n867 8.5005
R1041 VSS.n915 VSS.n230 8.5005
R1042 VSS.n915 VSS.n859 8.5005
R1043 VSS.n915 VSS.n857 8.5005
R1044 VSS.n915 VSS.n233 8.5005
R1045 VSS.n915 VSS.n856 8.5005
R1046 VSS.n915 VSS.n236 8.5005
R1047 VSS.n915 VSS.n850 8.5005
R1048 VSS.n915 VSS.n237 8.5005
R1049 VSS.n915 VSS.n847 8.5005
R1050 VSS.n915 VSS.n239 8.5005
R1051 VSS.n915 VSS.n839 8.5005
R1052 VSS.n915 VSS.n838 8.5005
R1053 VSS.n915 VSS.n243 8.5005
R1054 VSS.n915 VSS.n837 8.5005
R1055 VSS.n915 VSS.n246 8.5005
R1056 VSS.n915 VSS.n831 8.5005
R1057 VSS.n915 VSS.n247 8.5005
R1058 VSS.n915 VSS.n830 8.5005
R1059 VSS.n915 VSS.n250 8.5005
R1060 VSS.n915 VSS.n822 8.5005
R1061 VSS.n915 VSS.n821 8.5005
R1062 VSS.n915 VSS.n254 8.5005
R1063 VSS.n915 VSS.n820 8.5005
R1064 VSS.n915 VSS.n257 8.5005
R1065 VSS.n915 VSS.n814 8.5005
R1066 VSS.n915 VSS.n258 8.5005
R1067 VSS.n915 VSS.n813 8.5005
R1068 VSS.n915 VSS.n261 8.5005
R1069 VSS.n915 VSS.n804 8.5005
R1070 VSS.n915 VSS.n803 8.5005
R1071 VSS.n915 VSS.n264 8.5005
R1072 VSS.n915 VSS.n802 8.5005
R1073 VSS.n915 VSS.n267 8.5005
R1074 VSS.n915 VSS.n796 8.5005
R1075 VSS.n915 VSS.n268 8.5005
R1076 VSS.n915 VSS.n795 8.5005
R1077 VSS.n915 VSS.n270 8.5005
R1078 VSS.n915 VSS.n787 8.5005
R1079 VSS.n915 VSS.n786 8.5005
R1080 VSS.n915 VSS.n274 8.5005
R1081 VSS.n915 VSS.n785 8.5005
R1082 VSS.n915 VSS.n277 8.5005
R1083 VSS.n915 VSS.n779 8.5005
R1084 VSS.n915 VSS.n278 8.5005
R1085 VSS.n915 VSS.n778 8.5005
R1086 VSS.n915 VSS.n281 8.5005
R1087 VSS.n915 VSS.n770 8.5005
R1088 VSS.n915 VSS.n769 8.5005
R1089 VSS.n915 VSS.n285 8.5005
R1090 VSS.n915 VSS.n768 8.5005
R1091 VSS.n915 VSS.n288 8.5005
R1092 VSS.n915 VSS.n762 8.5005
R1093 VSS.n915 VSS.n289 8.5005
R1094 VSS.n915 VSS.n759 8.5005
R1095 VSS.n915 VSS.n291 8.5005
R1096 VSS.n915 VSS.n750 8.5005
R1097 VSS.n915 VSS.n747 8.5005
R1098 VSS.n915 VSS.n293 8.5005
R1099 VSS.n915 VSS.n746 8.5005
R1100 VSS.n915 VSS.n296 8.5005
R1101 VSS.n915 VSS.n740 8.5005
R1102 VSS.n915 VSS.n297 8.5005
R1103 VSS.n915 VSS.n739 8.5005
R1104 VSS.n915 VSS.n301 8.5005
R1105 VSS.n915 VSS.n730 8.5005
R1106 VSS.n915 VSS.n728 8.5005
R1107 VSS.n915 VSS.n304 8.5005
R1108 VSS.n915 VSS.n727 8.5005
R1109 VSS.n915 VSS.n307 8.5005
R1110 VSS.n915 VSS.n721 8.5005
R1111 VSS.n915 VSS.n308 8.5005
R1112 VSS.n915 VSS.n720 8.5005
R1113 VSS.n915 VSS.n312 8.5005
R1114 VSS.n915 VSS.n712 8.5005
R1115 VSS.n915 VSS.n710 8.5005
R1116 VSS.n915 VSS.n316 8.5005
R1117 VSS.n915 VSS.n709 8.5005
R1118 VSS.n915 VSS.n319 8.5005
R1119 VSS.n915 VSS.n703 8.5005
R1120 VSS.n915 VSS.n320 8.5005
R1121 VSS.n915 VSS.n701 8.5005
R1122 VSS.n915 VSS.n322 8.5005
R1123 VSS.n915 VSS.n693 8.5005
R1124 VSS.n915 VSS.n692 8.5005
R1125 VSS.n915 VSS.n326 8.5005
R1126 VSS.n915 VSS.n691 8.5005
R1127 VSS.n915 VSS.n329 8.5005
R1128 VSS.n915 VSS.n685 8.5005
R1129 VSS.n915 VSS.n330 8.5005
R1130 VSS.n915 VSS.n683 8.5005
R1131 VSS.n915 VSS.n332 8.5005
R1132 VSS.n915 VSS.n675 8.5005
R1133 VSS.n915 VSS.n672 8.5005
R1134 VSS.n915 VSS.n334 8.5005
R1135 VSS.n915 VSS.n671 8.5005
R1136 VSS.n915 VSS.n337 8.5005
R1137 VSS.n915 VSS.n665 8.5005
R1138 VSS.n915 VSS.n338 8.5005
R1139 VSS.n915 VSS.n663 8.5005
R1140 VSS.n915 VSS.n341 8.5005
R1141 VSS.n915 VSS.n654 8.5005
R1142 VSS.n915 VSS.n652 8.5005
R1143 VSS.n915 VSS.n344 8.5005
R1144 VSS.n915 VSS.n651 8.5005
R1145 VSS.n915 VSS.n347 8.5005
R1146 VSS.n915 VSS.n645 8.5005
R1147 VSS.n915 VSS.n348 8.5005
R1148 VSS.n915 VSS.n643 8.5005
R1149 VSS.n915 VSS.n350 8.5005
R1150 VSS.n915 VSS.n634 8.5005
R1151 VSS.n915 VSS.n632 8.5005
R1152 VSS.n915 VSS.n353 8.5005
R1153 VSS.n915 VSS.n631 8.5005
R1154 VSS.n915 VSS.n356 8.5005
R1155 VSS.n915 VSS.n625 8.5005
R1156 VSS.n915 VSS.n357 8.5005
R1157 VSS.n915 VSS.n623 8.5005
R1158 VSS.n915 VSS.n359 8.5005
R1159 VSS.n915 VSS.n615 8.5005
R1160 VSS.n915 VSS.n613 8.5005
R1161 VSS.n915 VSS.n363 8.5005
R1162 VSS.n915 VSS.n612 8.5005
R1163 VSS.n915 VSS.n366 8.5005
R1164 VSS.n915 VSS.n606 8.5005
R1165 VSS.n915 VSS.n367 8.5005
R1166 VSS.n915 VSS.n605 8.5005
R1167 VSS.n915 VSS.n370 8.5005
R1168 VSS.n915 VSS.n597 8.5005
R1169 VSS.n915 VSS.n596 8.5005
R1170 VSS.n915 VSS.n375 8.5005
R1171 VSS.n915 VSS.n595 8.5005
R1172 VSS.n915 VSS.n378 8.5005
R1173 VSS.n915 VSS.n589 8.5005
R1174 VSS.n915 VSS.n379 8.5005
R1175 VSS.n915 VSS.n383 8.5005
R1176 VSS.n570 VSS.n30 8.49319
R1177 VSS.n552 VSS.n21 8.49319
R1178 VSS.n536 VSS.n45 8.49319
R1179 VSS.n513 VSS.n49 8.49319
R1180 VSS.n498 VSS.n18 8.49319
R1181 VSS.n482 VSS.n1 8.49319
R1182 VSS.n930 VSS.n915 8.47732
R1183 VSS.n915 VSS.n219 8.47732
R1184 VSS.n915 VSS.n884 8.47732
R1185 VSS.n915 VSS.n866 8.47732
R1186 VSS.n915 VSS.n846 8.47732
R1187 VSS.n915 VSS.n829 8.47732
R1188 VSS.n915 VSS.n812 8.47732
R1189 VSS.n915 VSS.n794 8.47732
R1190 VSS.n915 VSS.n777 8.47732
R1191 VSS.n915 VSS.n758 8.47732
R1192 VSS.n915 VSS.n738 8.47732
R1193 VSS.n915 VSS.n719 8.47732
R1194 VSS.n915 VSS.n700 8.47732
R1195 VSS.n915 VSS.n682 8.47732
R1196 VSS.n915 VSS.n662 8.47732
R1197 VSS.n915 VSS.n642 8.47732
R1198 VSS.n915 VSS.n622 8.47732
R1199 VSS.n915 VSS.n604 8.47732
R1200 VSS.n915 VSS.n94 8.47732
R1201 VSS.n915 VSS.n152 8.47732
R1202 VSS.n915 VSS.n150 8.47732
R1203 VSS.n389 VSS.n65 8.48044
R1204 VSS.n83 VSS.n572 0.176279
R1205 VSS.n563 VSS.n30 8.47732
R1206 VSS.n30 VSS.n81 4.21421
R1207 VSS.n80 VSS.n21 4.22409
R1208 VSS.n546 VSS.n23 8.47732
R1209 VSS.n23 VSS.n78 4.21421
R1210 VSS.n538 VSS.n77 0.176279
R1211 VSS.n530 VSS.n45 8.47732
R1212 VSS.n45 VSS.n75 4.21421
R1213 VSS.n515 VSS.n74 0.176279
R1214 VSS.n507 VSS.n49 8.47732
R1215 VSS.n49 VSS.n72 4.21421
R1216 VSS.n500 VSS.n71 0.176279
R1217 VSS.n492 VSS.n0 8.47732
R1218 VSS.n0 VSS.n69 4.21421
R1219 VSS.n68 VSS.n0 4.22409
R1220 VSS.n476 VSS.n1 8.47732
R1221 VSS.n1 VSS.n66 4.21421
R1222 VSS.n464 VSS.n14 8.47732
R1223 VSS.n386 VSS.t380 8.46888
R1224 VSS.n581 VSS.t376 8.46888
R1225 VSS.n586 VSS.t377 8.46631
R1226 VSS.n592 VSS.t500 8.46631
R1227 VSS.n601 VSS.t452 8.46631
R1228 VSS.n609 VSS.t464 8.46631
R1229 VSS.n619 VSS.t448 8.46631
R1230 VSS.n628 VSS.t498 8.46631
R1231 VSS.n639 VSS.t450 8.46631
R1232 VSS.n648 VSS.t446 8.46631
R1233 VSS.n659 VSS.t454 8.46631
R1234 VSS.n668 VSS.t466 8.46631
R1235 VSS.n679 VSS.t482 8.46631
R1236 VSS.n688 VSS.t496 8.46631
R1237 VSS.n697 VSS.t490 8.46631
R1238 VSS.n706 VSS.t494 8.46631
R1239 VSS.n716 VSS.t488 8.46631
R1240 VSS.n724 VSS.t492 8.46631
R1241 VSS.n735 VSS.t486 8.46631
R1242 VSS.n743 VSS.t480 8.46631
R1243 VSS.n755 VSS.t484 8.46631
R1244 VSS.n765 VSS.t478 8.46631
R1245 VSS.n774 VSS.t476 8.46631
R1246 VSS.n782 VSS.t440 8.46631
R1247 VSS.n791 VSS.t474 8.46631
R1248 VSS.n799 VSS.t472 8.46631
R1249 VSS.n809 VSS.t444 8.46631
R1250 VSS.n817 VSS.t470 8.46631
R1251 VSS.n826 VSS.t438 8.46631
R1252 VSS.n834 VSS.t468 8.46631
R1253 VSS.n843 VSS.t462 8.46631
R1254 VSS.n853 VSS.t460 8.46631
R1255 VSS.n863 VSS.t442 8.46631
R1256 VSS.n872 VSS.t458 8.46631
R1257 VSS.n882 VSS.t456 8.46631
R1258 VSS.n893 VSS.t373 8.46519
R1259 VSS.n888 VSS.t369 8.46519
R1260 VSS.n902 VSS.t370 8.46519
R1261 VSS.n933 VSS.n84 6.99673
R1262 VSS.n915 VSS.n390 5.63777
R1263 VSS.n922 VSS.n915 5.62581
R1264 VSS.n926 VSS.n915 5.62581
R1265 VSS.n932 VSS.n915 5.62581
R1266 VSS.n915 VSS.n880 5.62581
R1267 VSS.n915 VSS.n229 5.62581
R1268 VSS.n915 VSS.n861 5.62581
R1269 VSS.n915 VSS.n238 5.62581
R1270 VSS.n915 VSS.n841 5.62581
R1271 VSS.n915 VSS.n249 5.62581
R1272 VSS.n915 VSS.n824 5.62581
R1273 VSS.n915 VSS.n259 5.62581
R1274 VSS.n915 VSS.n806 5.62581
R1275 VSS.n915 VSS.n269 5.62581
R1276 VSS.n915 VSS.n789 5.62581
R1277 VSS.n915 VSS.n280 5.62581
R1278 VSS.n915 VSS.n772 5.62581
R1279 VSS.n915 VSS.n290 5.62581
R1280 VSS.n915 VSS.n752 5.62581
R1281 VSS.n915 VSS.n299 5.62581
R1282 VSS.n915 VSS.n732 5.62581
R1283 VSS.n915 VSS.n310 5.62581
R1284 VSS.n915 VSS.n714 5.62581
R1285 VSS.n915 VSS.n321 5.62581
R1286 VSS.n915 VSS.n695 5.62581
R1287 VSS.n915 VSS.n331 5.62581
R1288 VSS.n915 VSS.n677 5.62581
R1289 VSS.n915 VSS.n339 5.62581
R1290 VSS.n915 VSS.n656 5.62581
R1291 VSS.n915 VSS.n349 5.62581
R1292 VSS.n915 VSS.n636 5.62581
R1293 VSS.n915 VSS.n358 5.62581
R1294 VSS.n915 VSS.n617 5.62581
R1295 VSS.n915 VSS.n369 5.62581
R1296 VSS.n915 VSS.n599 5.62581
R1297 VSS.n915 VSS.n216 5.62581
R1298 VSS.n915 VSS.n214 5.62581
R1299 VSS.n915 VSS.n212 5.62581
R1300 VSS.n915 VSS.n210 5.62581
R1301 VSS.n915 VSS.n208 5.62581
R1302 VSS.n915 VSS.n206 5.62581
R1303 VSS.n915 VSS.n204 5.62581
R1304 VSS.n915 VSS.n202 5.62581
R1305 VSS.n915 VSS.n200 5.62581
R1306 VSS.n915 VSS.n198 5.62581
R1307 VSS.n915 VSS.n196 5.62581
R1308 VSS.n915 VSS.n194 5.62581
R1309 VSS.n915 VSS.n192 5.62581
R1310 VSS.n915 VSS.n190 5.62581
R1311 VSS.n915 VSS.n188 5.62581
R1312 VSS.n915 VSS.n186 5.62581
R1313 VSS.n915 VSS.n184 5.62581
R1314 VSS.n915 VSS.n182 5.62581
R1315 VSS.n915 VSS.n180 5.62581
R1316 VSS.n915 VSS.n178 5.62581
R1317 VSS.n915 VSS.n176 5.62581
R1318 VSS.n915 VSS.n174 5.62581
R1319 VSS.n915 VSS.n172 5.62581
R1320 VSS.n915 VSS.n170 5.62581
R1321 VSS.n915 VSS.n168 5.62581
R1322 VSS.n915 VSS.n166 5.62581
R1323 VSS.n915 VSS.n164 5.62581
R1324 VSS.n915 VSS.n162 5.62581
R1325 VSS.n915 VSS.n160 5.62581
R1326 VSS.n915 VSS.n158 5.62581
R1327 VSS.n915 VSS.n156 5.62581
R1328 VSS.n915 VSS.n154 5.62581
R1329 VSS.n915 VSS.n148 5.62581
R1330 VSS.n31 VSS.n573 5.62581
R1331 VSS.n568 VSS.n30 5.62581
R1332 VSS.n555 VSS.n21 5.62581
R1333 VSS.n21 VSS.n402 5.62581
R1334 VSS.n539 VSS.n23 5.62581
R1335 VSS.n45 VSS.n411 5.62581
R1336 VSS.n524 VSS.n35 5.62581
R1337 VSS.n516 VSS.n35 5.62581
R1338 VSS.n49 VSS.n422 5.62581
R1339 VSS.n501 VSS.n18 5.62581
R1340 VSS.n18 VSS.n430 5.62581
R1341 VSS.n485 VSS.n0 5.62581
R1342 VSS.n1 VSS.n439 5.62581
R1343 VSS.n470 VSS.n14 5.62581
R1344 VSS.n468 VSS.n14 5.62581
R1345 VSS.n460 VSS.n14 5.62581
R1346 VSS.n456 VSS.n14 5.62581
R1347 VSS.n450 VSS.n84 4.28471
R1348 VSS.n566 VSS.n30 4.21914
R1349 VSS.n21 VSS.n551 4.21914
R1350 VSS.n45 VSS.n535 4.21914
R1351 VSS.n49 VSS.n512 4.21914
R1352 VSS.n18 VSS.n497 4.21914
R1353 VSS.n1 VSS.n481 4.21914
R1354 VSS.n915 VSS.n149 4.20662
R1355 VSS.n918 VSS.n915 4.19244
R1356 VSS.n915 VSS.n897 4.19244
R1357 VSS.n452 VSS.n14 4.19244
R1358 VSS VSS.n84 3.80469
R1359 VSS.n885 VSS.t455 3.34498
R1360 VSS.n876 VSS.t457 3.34498
R1361 VSS.n867 VSS.t441 3.34498
R1362 VSS.n857 VSS.t459 3.34498
R1363 VSS.n847 VSS.t461 3.34498
R1364 VSS.n838 VSS.t467 3.34498
R1365 VSS.n830 VSS.t437 3.34498
R1366 VSS.n821 VSS.t469 3.34498
R1367 VSS.n813 VSS.t443 3.34498
R1368 VSS.n803 VSS.t471 3.34498
R1369 VSS.n795 VSS.t473 3.34498
R1370 VSS.n786 VSS.t439 3.34498
R1371 VSS.n778 VSS.t475 3.34498
R1372 VSS.n769 VSS.t477 3.34498
R1373 VSS.n759 VSS.t483 3.34498
R1374 VSS.n747 VSS.t479 3.34498
R1375 VSS.n739 VSS.t485 3.34498
R1376 VSS.n728 VSS.t491 3.34498
R1377 VSS.n720 VSS.t487 3.34498
R1378 VSS.n710 VSS.t493 3.34498
R1379 VSS.n701 VSS.t489 3.34498
R1380 VSS.n692 VSS.t495 3.34498
R1381 VSS.n683 VSS.t481 3.34498
R1382 VSS.n672 VSS.t465 3.34498
R1383 VSS.n663 VSS.t453 3.34498
R1384 VSS.n652 VSS.t445 3.34498
R1385 VSS.n643 VSS.t449 3.34498
R1386 VSS.n632 VSS.t497 3.34498
R1387 VSS.n623 VSS.t447 3.34498
R1388 VSS.n613 VSS.t463 3.34498
R1389 VSS.n605 VSS.t451 3.34498
R1390 VSS.n596 VSS.t499 3.34498
R1391 VSS.n924 VSS.n915 3.3265
R1392 VSS.n928 VSS.n915 3.3265
R1393 VSS.n915 VSS.n874 3.3265
R1394 VSS.n915 VSS.n855 3.3265
R1395 VSS.n915 VSS.n836 3.3265
R1396 VSS.n915 VSS.n819 3.3265
R1397 VSS.n915 VSS.n801 3.3265
R1398 VSS.n915 VSS.n784 3.3265
R1399 VSS.n915 VSS.n767 3.3265
R1400 VSS.n915 VSS.n745 3.3265
R1401 VSS.n915 VSS.n726 3.3265
R1402 VSS.n915 VSS.n708 3.3265
R1403 VSS.n915 VSS.n690 3.3265
R1404 VSS.n915 VSS.n670 3.3265
R1405 VSS.n915 VSS.n650 3.3265
R1406 VSS.n915 VSS.n630 3.3265
R1407 VSS.n915 VSS.n611 3.3265
R1408 VSS.n915 VSS.n594 3.3265
R1409 VSS.n559 VSS.n21 3.3265
R1410 VSS.n543 VSS.n23 3.3265
R1411 VSS.n528 VSS.n35 3.3265
R1412 VSS.n505 VSS.n18 3.3265
R1413 VSS.n489 VSS.n0 3.3265
R1414 VSS.n474 VSS.n14 3.3265
R1415 VSS.n466 VSS.n14 3.3265
R1416 VSS.n462 VSS.n14 3.3265
R1417 VSS.n458 VSS.n14 3.3265
R1418 VSS.n905 VSS 3.16675
R1419 VSS.n579 VSS.n578 2.9579
R1420 VSS.n915 VSS.n85 2.83376
R1421 VSS.n920 VSS.n915 2.74446
R1422 VSS.n915 VSS.n223 2.74446
R1423 VSS.n915 VSS.n232 2.74446
R1424 VSS.n915 VSS.n241 2.74446
R1425 VSS.n915 VSS.n252 2.74446
R1426 VSS.n915 VSS.n263 2.74446
R1427 VSS.n915 VSS.n272 2.74446
R1428 VSS.n915 VSS.n284 2.74446
R1429 VSS.n915 VSS.n292 2.74446
R1430 VSS.n915 VSS.n303 2.74446
R1431 VSS.n915 VSS.n314 2.74446
R1432 VSS.n915 VSS.n324 2.74446
R1433 VSS.n915 VSS.n333 2.74446
R1434 VSS.n915 VSS.n342 2.74446
R1435 VSS.n915 VSS.n351 2.74446
R1436 VSS.n915 VSS.n362 2.74446
R1437 VSS.n915 VSS.n373 2.74446
R1438 VSS.n915 VSS.n217 2.74446
R1439 VSS.n454 VSS.n14 2.74446
R1440 VSS.n915 VSS.n97 2.32483
R1441 VSS.n915 VSS.n99 2.32483
R1442 VSS.n915 VSS.n102 2.32483
R1443 VSS.n915 VSS.n103 2.32483
R1444 VSS.n915 VSS.n105 2.32483
R1445 VSS.n915 VSS.n106 2.32483
R1446 VSS.n915 VSS.n109 2.32483
R1447 VSS.n915 VSS.n110 2.32483
R1448 VSS.n915 VSS.n112 2.32483
R1449 VSS.n915 VSS.n114 2.32483
R1450 VSS.n915 VSS.n118 2.32483
R1451 VSS.n915 VSS.n119 2.32483
R1452 VSS.n915 VSS.n121 2.32483
R1453 VSS.n915 VSS.n123 2.32483
R1454 VSS.n915 VSS.n124 2.32483
R1455 VSS.n915 VSS.n125 2.32483
R1456 VSS.n915 VSS.n126 2.32483
R1457 VSS.n915 VSS.n127 2.32483
R1458 VSS.n915 VSS.n128 2.32483
R1459 VSS.n915 VSS.n129 2.32483
R1460 VSS.n915 VSS.n132 2.32483
R1461 VSS.n915 VSS.n133 2.32483
R1462 VSS.n915 VSS.n136 2.32483
R1463 VSS.n915 VSS.n137 2.32483
R1464 VSS.n915 VSS.n138 2.32483
R1465 VSS.n915 VSS.n139 2.32483
R1466 VSS.n915 VSS.n141 2.32483
R1467 VSS.n915 VSS.n142 2.32483
R1468 VSS.n915 VSS.n144 2.32483
R1469 VSS.n915 VSS.n145 2.32483
R1470 VSS.n915 VSS.n147 2.32483
R1471 VSS.n522 VSS.n35 2.00687
R1472 VSS.n915 VSS.n11 1.64417
R1473 VSS.n915 VSS.n912 1.64417
R1474 VSS.n915 VSS.n89 1.64417
R1475 VSS.n915 VSS.n91 1.64417
R1476 VSS.n915 VSS.n908 1.64417
R1477 VSS.n31 VSS.n576 1.56144
R1478 VSS.n557 VSS.n21 1.56144
R1479 VSS.n541 VSS.n23 1.56144
R1480 VSS.n518 VSS.n35 1.56144
R1481 VSS.n503 VSS.n18 1.56144
R1482 VSS.n487 VSS.n0 1.56144
R1483 VSS.n526 VSS.n35 1.12565
R1484 VSS.n472 VSS.n471 0.909006
R1485 VSS.n473 VSS.n472 0.898984
R1486 VSS.n578 VSS.n31 0.849178
R1487 VSS.n520 VSS.n35 0.849178
R1488 VSS.n520 VSS.n519 0.728316
R1489 VSS.n578 VSS.n391 0.728316
R1490 VSS.n521 VSS.n520 0.69965
R1491 VSS.n31 VSS.n29 0.613782
R1492 VSS.n410 VSS.n23 0.613782
R1493 VSS.n421 VSS.n35 0.613782
R1494 VSS.n438 VSS.n0 0.613782
R1495 VSS.n14 VSS.n5 0.613782
R1496 VSS.n14 VSS.n7 0.613782
R1497 VSS.n14 VSS.n13 0.613782
R1498 VSS.n14 VSS.n10 0.613782
R1499 VSS.n14 VSS.n12 0.315147
R1500 VSS.n526 VSS.n525 0.603496
R1501 VSS.n915 VSS.n65 0.00104694
R1502 VSS.n915 VSS.n93 0.556705
R1503 VSS.n527 VSS.n526 0.540438
R1504 VSS VSS.n933 0.48296
R1505 VSS.n587 VSS.n586 0.419816
R1506 VSS.n593 VSS.n592 0.419816
R1507 VSS.n602 VSS.n601 0.419816
R1508 VSS.n610 VSS.n609 0.419816
R1509 VSS.n620 VSS.n619 0.419816
R1510 VSS.n629 VSS.n628 0.419816
R1511 VSS.n640 VSS.n639 0.419816
R1512 VSS.n649 VSS.n648 0.419816
R1513 VSS.n660 VSS.n659 0.419816
R1514 VSS.n669 VSS.n668 0.419816
R1515 VSS.n680 VSS.n679 0.419816
R1516 VSS.n689 VSS.n688 0.419816
R1517 VSS.n698 VSS.n697 0.419816
R1518 VSS.n707 VSS.n706 0.419816
R1519 VSS.n717 VSS.n716 0.419816
R1520 VSS.n725 VSS.n724 0.419816
R1521 VSS.n736 VSS.n735 0.419816
R1522 VSS.n744 VSS.n743 0.419816
R1523 VSS.n756 VSS.n755 0.419816
R1524 VSS.n766 VSS.n765 0.419816
R1525 VSS.n775 VSS.n774 0.419816
R1526 VSS.n783 VSS.n782 0.419816
R1527 VSS.n792 VSS.n791 0.419816
R1528 VSS.n800 VSS.n799 0.419816
R1529 VSS.n810 VSS.n809 0.419816
R1530 VSS.n818 VSS.n817 0.419816
R1531 VSS.n827 VSS.n826 0.419816
R1532 VSS.n835 VSS.n834 0.419816
R1533 VSS.n844 VSS.n843 0.419816
R1534 VSS.n854 VSS.n853 0.419816
R1535 VSS.n864 VSS.n863 0.419816
R1536 VSS.n873 VSS.n872 0.419816
R1537 VSS.n883 VSS.n882 0.419816
R1538 VSS.n488 VSS.n487 0.413418
R1539 VSS.n504 VSS.n503 0.413418
R1540 VSS.n519 VSS.n518 0.413418
R1541 VSS.n542 VSS.n541 0.413418
R1542 VSS.n558 VSS.n557 0.413418
R1543 VSS.n576 VSS.n391 0.413418
R1544 VSS.n472 VSS.n14 0.405836
R1545 VSS.n893 VSS.n892 0.385697
R1546 VSS.n888 VSS.n887 0.385697
R1547 VSS.n586 VSS.n585 0.383459
R1548 VSS.n592 VSS.n591 0.383459
R1549 VSS.n601 VSS.n600 0.383459
R1550 VSS.n609 VSS.n608 0.383459
R1551 VSS.n619 VSS.n618 0.383459
R1552 VSS.n628 VSS.n627 0.383459
R1553 VSS.n639 VSS.n638 0.383459
R1554 VSS.n648 VSS.n647 0.383459
R1555 VSS.n659 VSS.n658 0.383459
R1556 VSS.n668 VSS.n667 0.383459
R1557 VSS.n679 VSS.n678 0.383459
R1558 VSS.n688 VSS.n687 0.383459
R1559 VSS.n697 VSS.n696 0.383459
R1560 VSS.n706 VSS.n705 0.383459
R1561 VSS.n716 VSS.n715 0.383459
R1562 VSS.n724 VSS.n723 0.383459
R1563 VSS.n735 VSS.n734 0.383459
R1564 VSS.n743 VSS.n742 0.383459
R1565 VSS.n755 VSS.n754 0.383459
R1566 VSS.n765 VSS.n764 0.383459
R1567 VSS.n774 VSS.n773 0.383459
R1568 VSS.n782 VSS.n781 0.383459
R1569 VSS.n791 VSS.n790 0.383459
R1570 VSS.n799 VSS.n798 0.383459
R1571 VSS.n809 VSS.n808 0.383459
R1572 VSS.n817 VSS.n816 0.383459
R1573 VSS.n826 VSS.n825 0.383459
R1574 VSS.n834 VSS.n833 0.383459
R1575 VSS.n843 VSS.n842 0.383459
R1576 VSS.n853 VSS.n852 0.383459
R1577 VSS.n863 VSS.n862 0.383459
R1578 VSS.n872 VSS.n871 0.383459
R1579 VSS.n882 VSS.n881 0.383459
R1580 VSS.n523 VSS.n522 0.380519
R1581 VSS.n903 VSS.n902 0.379351
R1582 VSS.n582 VSS.n581 0.37817
R1583 VSS.n522 VSS.n521 0.359515
R1584 VSS.n215 VSS.n97 0.351341
R1585 VSS.n213 VSS.n99 0.351341
R1586 VSS.n211 VSS.n102 0.351341
R1587 VSS.n209 VSS.n103 0.351341
R1588 VSS.n207 VSS.n105 0.351341
R1589 VSS.n205 VSS.n106 0.351341
R1590 VSS.n203 VSS.n109 0.351341
R1591 VSS.n201 VSS.n110 0.351341
R1592 VSS.n199 VSS.n112 0.351341
R1593 VSS.n197 VSS.n114 0.351341
R1594 VSS.n195 VSS.n118 0.351341
R1595 VSS.n193 VSS.n119 0.351341
R1596 VSS.n191 VSS.n121 0.351341
R1597 VSS.n189 VSS.n123 0.351341
R1598 VSS.n187 VSS.n124 0.351341
R1599 VSS.n185 VSS.n125 0.351341
R1600 VSS.n183 VSS.n126 0.351341
R1601 VSS.n181 VSS.n127 0.351341
R1602 VSS.n179 VSS.n128 0.351341
R1603 VSS.n177 VSS.n129 0.351341
R1604 VSS.n175 VSS.n132 0.351341
R1605 VSS.n173 VSS.n133 0.351341
R1606 VSS.n171 VSS.n136 0.351341
R1607 VSS.n169 VSS.n137 0.351341
R1608 VSS.n167 VSS.n138 0.351341
R1609 VSS.n165 VSS.n139 0.351341
R1610 VSS.n163 VSS.n141 0.351341
R1611 VSS.n161 VSS.n142 0.351341
R1612 VSS.n159 VSS.n144 0.351341
R1613 VSS.n157 VSS.n145 0.351341
R1614 VSS.n155 VSS.n147 0.351341
R1615 VSS.n386 VSS.n385 0.345929
R1616 VSS.n581 VSS.n580 0.345929
R1617 VSS.n576 VSS.n575 0.340858
R1618 VSS.n557 VSS.n556 0.340858
R1619 VSS.n541 VSS.n540 0.340858
R1620 VSS.n518 VSS.n517 0.340858
R1621 VSS.n503 VSS.n502 0.340858
R1622 VSS.n487 VSS.n486 0.340858
R1623 VSS.n921 VSS.n920 0.318018
R1624 VSS.n455 VSS.n454 0.316299
R1625 VSS.n871 VSS.n97 0.311066
R1626 VSS.n862 VSS.n99 0.311066
R1627 VSS.n852 VSS.n102 0.311066
R1628 VSS.n842 VSS.n103 0.311066
R1629 VSS.n833 VSS.n105 0.311066
R1630 VSS.n825 VSS.n106 0.311066
R1631 VSS.n816 VSS.n109 0.311066
R1632 VSS.n808 VSS.n110 0.311066
R1633 VSS.n798 VSS.n112 0.311066
R1634 VSS.n790 VSS.n114 0.311066
R1635 VSS.n781 VSS.n118 0.311066
R1636 VSS.n773 VSS.n119 0.311066
R1637 VSS.n764 VSS.n121 0.311066
R1638 VSS.n754 VSS.n123 0.311066
R1639 VSS.n742 VSS.n124 0.311066
R1640 VSS.n734 VSS.n125 0.311066
R1641 VSS.n723 VSS.n126 0.311066
R1642 VSS.n715 VSS.n127 0.311066
R1643 VSS.n705 VSS.n128 0.311066
R1644 VSS.n696 VSS.n129 0.311066
R1645 VSS.n687 VSS.n132 0.311066
R1646 VSS.n678 VSS.n133 0.311066
R1647 VSS.n667 VSS.n136 0.311066
R1648 VSS.n658 VSS.n137 0.311066
R1649 VSS.n647 VSS.n138 0.311066
R1650 VSS.n638 VSS.n139 0.311066
R1651 VSS.n627 VSS.n141 0.311066
R1652 VSS.n618 VSS.n142 0.311066
R1653 VSS.n608 VSS.n144 0.311066
R1654 VSS.n600 VSS.n145 0.311066
R1655 VSS.n591 VSS.n147 0.311066
R1656 VSS.n225 VSS.n223 0.284268
R1657 VSS.n234 VSS.n232 0.284268
R1658 VSS.n244 VSS.n241 0.284268
R1659 VSS.n255 VSS.n252 0.284268
R1660 VSS.n265 VSS.n263 0.284268
R1661 VSS.n275 VSS.n272 0.284268
R1662 VSS.n286 VSS.n284 0.284268
R1663 VSS.n294 VSS.n292 0.284268
R1664 VSS.n305 VSS.n303 0.284268
R1665 VSS.n317 VSS.n314 0.284268
R1666 VSS.n327 VSS.n324 0.284268
R1667 VSS.n335 VSS.n333 0.284268
R1668 VSS.n345 VSS.n342 0.284268
R1669 VSS.n354 VSS.n351 0.284268
R1670 VSS.n364 VSS.n362 0.284268
R1671 VSS.n376 VSS.n373 0.284268
R1672 VSS.n902 VSS.n901 0.279928
R1673 VSS.n454 VSS.n453 0.274268
R1674 VSS.n462 VSS.n461 0.274227
R1675 VSS.n474 VSS.n473 0.274227
R1676 VSS.n489 VSS.n488 0.274227
R1677 VSS.n505 VSS.n504 0.274227
R1678 VSS.n528 VSS.n527 0.274227
R1679 VSS.n543 VSS.n542 0.274227
R1680 VSS.n559 VSS.n558 0.274227
R1681 VSS.n928 VSS.n927 0.272997
R1682 VSS.n920 VSS.n919 0.272549
R1683 VSS.n892 VSS.n217 0.271299
R1684 VSS.n915 VSS.n907 0.267794
R1685 VSS.n915 VSS.n222 0.267794
R1686 VSS.n915 VSS.n868 0.267794
R1687 VSS.n915 VSS.n858 0.267794
R1688 VSS.n915 VSS.n849 0.267794
R1689 VSS.n915 VSS.n848 0.267794
R1690 VSS.n915 VSS.n242 0.267794
R1691 VSS.n915 VSS.n248 0.267794
R1692 VSS.n915 VSS.n253 0.267794
R1693 VSS.n915 VSS.n260 0.267794
R1694 VSS.n915 VSS.n807 0.267794
R1695 VSS.n915 VSS.n273 0.267794
R1696 VSS.n915 VSS.n279 0.267794
R1697 VSS.n915 VSS.n282 0.267794
R1698 VSS.n915 VSS.n761 0.267794
R1699 VSS.n915 VSS.n760 0.267794
R1700 VSS.n915 VSS.n753 0.267794
R1701 VSS.n915 VSS.n748 0.267794
R1702 VSS.n915 VSS.n298 0.267794
R1703 VSS.n915 VSS.n300 0.267794
R1704 VSS.n915 VSS.n733 0.267794
R1705 VSS.n915 VSS.n729 0.267794
R1706 VSS.n915 VSS.n309 0.267794
R1707 VSS.n915 VSS.n311 0.267794
R1708 VSS.n915 VSS.n313 0.267794
R1709 VSS.n915 VSS.n315 0.267794
R1710 VSS.n915 VSS.n702 0.267794
R1711 VSS.n915 VSS.n325 0.267794
R1712 VSS.n915 VSS.n684 0.267794
R1713 VSS.n915 VSS.n673 0.267794
R1714 VSS.n915 VSS.n664 0.267794
R1715 VSS.n915 VSS.n340 0.267794
R1716 VSS.n915 VSS.n657 0.267794
R1717 VSS.n915 VSS.n343 0.267794
R1718 VSS.n915 VSS.n644 0.267794
R1719 VSS.n915 VSS.n637 0.267794
R1720 VSS.n915 VSS.n352 0.267794
R1721 VSS.n915 VSS.n624 0.267794
R1722 VSS.n915 VSS.n360 0.267794
R1723 VSS.n915 VSS.n614 0.267794
R1724 VSS.n915 VSS.n368 0.267794
R1725 VSS.n915 VSS.n371 0.267794
R1726 VSS.n915 VSS.n374 0.267794
R1727 VSS.n915 VSS.n96 0.267794
R1728 VSS.n915 VSS.n98 0.267794
R1729 VSS.n915 VSS.n100 0.267794
R1730 VSS.n915 VSS.n101 0.267794
R1731 VSS.n915 VSS.n104 0.267794
R1732 VSS.n915 VSS.n107 0.267794
R1733 VSS.n915 VSS.n108 0.267794
R1734 VSS.n915 VSS.n111 0.267794
R1735 VSS.n915 VSS.n113 0.267794
R1736 VSS.n915 VSS.n115 0.267794
R1737 VSS.n915 VSS.n116 0.267794
R1738 VSS.n915 VSS.n117 0.267794
R1739 VSS.n915 VSS.n120 0.267794
R1740 VSS.n915 VSS.n122 0.267794
R1741 VSS.n915 VSS.n130 0.267794
R1742 VSS.n915 VSS.n131 0.267794
R1743 VSS.n915 VSS.n134 0.267794
R1744 VSS.n915 VSS.n135 0.267794
R1745 VSS.n915 VSS.n140 0.267794
R1746 VSS.n915 VSS.n143 0.267794
R1747 VSS.n915 VSS.n146 0.267794
R1748 VSS.n915 VSS.n151 0.267794
R1749 VSS.n881 VSS.n217 0.265518
R1750 VSS.n389 VSS.n149 0.259448
R1751 VSS.n387 VSS.n386 0.251101
R1752 VSS.n467 VSS.n466 0.245497
R1753 VSS.n874 VSS.n873 0.244247
R1754 VSS.n855 VSS.n854 0.244247
R1755 VSS.n836 VSS.n835 0.244247
R1756 VSS.n819 VSS.n818 0.244247
R1757 VSS.n801 VSS.n800 0.244247
R1758 VSS.n784 VSS.n783 0.244247
R1759 VSS.n767 VSS.n766 0.244247
R1760 VSS.n745 VSS.n744 0.244247
R1761 VSS.n726 VSS.n725 0.244247
R1762 VSS.n708 VSS.n707 0.244247
R1763 VSS.n690 VSS.n689 0.244247
R1764 VSS.n670 VSS.n669 0.244247
R1765 VSS.n650 VSS.n649 0.244247
R1766 VSS.n630 VSS.n629 0.244247
R1767 VSS.n611 VSS.n610 0.244247
R1768 VSS.n594 VSS.n593 0.244247
R1769 VSS.n879 VSS.n223 0.240049
R1770 VSS.n860 VSS.n232 0.240049
R1771 VSS.n840 VSS.n241 0.240049
R1772 VSS.n823 VSS.n252 0.240049
R1773 VSS.n805 VSS.n263 0.240049
R1774 VSS.n788 VSS.n272 0.240049
R1775 VSS.n771 VSS.n284 0.240049
R1776 VSS.n751 VSS.n292 0.240049
R1777 VSS.n731 VSS.n303 0.240049
R1778 VSS.n713 VSS.n314 0.240049
R1779 VSS.n694 VSS.n324 0.240049
R1780 VSS.n676 VSS.n333 0.240049
R1781 VSS.n655 VSS.n342 0.240049
R1782 VSS.n635 VSS.n351 0.240049
R1783 VSS.n616 VSS.n362 0.240049
R1784 VSS.n598 VSS.n373 0.240049
R1785 VSS.n475 VSS.n474 0.237997
R1786 VSS.n490 VSS.n489 0.237997
R1787 VSS.n506 VSS.n505 0.237997
R1788 VSS.n529 VSS.n528 0.237997
R1789 VSS.n544 VSS.n543 0.237997
R1790 VSS.n560 VSS.n559 0.237997
R1791 VSS.n458 VSS.n457 0.234227
R1792 VSS.n924 VSS.n923 0.232997
R1793 VSS.n925 VSS.n924 0.231727
R1794 VSS.n459 VSS.n458 0.230497
R1795 VSS.n874 VSS.n870 0.224227
R1796 VSS.n855 VSS.n851 0.224227
R1797 VSS.n836 VSS.n832 0.224227
R1798 VSS.n819 VSS.n815 0.224227
R1799 VSS.n801 VSS.n797 0.224227
R1800 VSS.n784 VSS.n780 0.224227
R1801 VSS.n767 VSS.n763 0.224227
R1802 VSS.n745 VSS.n741 0.224227
R1803 VSS.n726 VSS.n722 0.224227
R1804 VSS.n708 VSS.n704 0.224227
R1805 VSS.n690 VSS.n686 0.224227
R1806 VSS.n670 VSS.n666 0.224227
R1807 VSS.n650 VSS.n646 0.224227
R1808 VSS.n630 VSS.n626 0.224227
R1809 VSS.n611 VSS.n607 0.224227
R1810 VSS.n594 VSS.n590 0.224227
R1811 VSS.n466 VSS.n465 0.219227
R1812 VSS.n894 VSS.n893 0.21012
R1813 VSS.n890 VSS.n888 0.21012
R1814 VSS.n390 VSS.n389 0.206787
R1815 VSS.n919 VSS.n918 0.201058
R1816 VSS.n453 VSS.n452 0.200293
R1817 VSS.n929 VSS.n928 0.191727
R1818 VSS.n463 VSS.n462 0.190497
R1819 VSS.n880 VSS.n879 0.186138
R1820 VSS.n861 VSS.n860 0.186138
R1821 VSS.n841 VSS.n840 0.186138
R1822 VSS.n824 VSS.n823 0.186138
R1823 VSS.n806 VSS.n805 0.186138
R1824 VSS.n789 VSS.n788 0.186138
R1825 VSS.n772 VSS.n771 0.186138
R1826 VSS.n752 VSS.n751 0.186138
R1827 VSS.n732 VSS.n731 0.186138
R1828 VSS.n714 VSS.n713 0.186138
R1829 VSS.n695 VSS.n694 0.186138
R1830 VSS.n677 VSS.n676 0.186138
R1831 VSS.n656 VSS.n655 0.186138
R1832 VSS.n636 VSS.n635 0.186138
R1833 VSS.n617 VSS.n616 0.186138
R1834 VSS.n599 VSS.n598 0.186138
R1835 VSS.n471 VSS.n470 0.1833
R1836 VSS.n897 VSS.n896 0.179043
R1837 VSS.n385 VSS.n149 0.177116
R1838 VSS.n933 VSS.n932 0.167388
R1839 VSS.n153 VSS.n148 0.16705
R1840 VSS.n481 VSS.n480 0.166269
R1841 VSS.n497 VSS.n496 0.166269
R1842 VSS.n512 VSS.n511 0.166269
R1843 VSS.n535 VSS.n534 0.166269
R1844 VSS.n551 VSS.n550 0.166269
R1845 VSS.n567 VSS.n566 0.166269
R1846 VSS.n470 VSS.n469 0.164888
R1847 VSS.n881 VSS.n216 0.16205
R1848 VSS.n871 VSS.n214 0.16205
R1849 VSS.n862 VSS.n212 0.16205
R1850 VSS.n852 VSS.n210 0.16205
R1851 VSS.n842 VSS.n208 0.16205
R1852 VSS.n833 VSS.n206 0.16205
R1853 VSS.n825 VSS.n204 0.16205
R1854 VSS.n816 VSS.n202 0.16205
R1855 VSS.n808 VSS.n200 0.16205
R1856 VSS.n798 VSS.n198 0.16205
R1857 VSS.n790 VSS.n196 0.16205
R1858 VSS.n781 VSS.n194 0.16205
R1859 VSS.n773 VSS.n192 0.16205
R1860 VSS.n764 VSS.n190 0.16205
R1861 VSS.n754 VSS.n188 0.16205
R1862 VSS.n742 VSS.n186 0.16205
R1863 VSS.n734 VSS.n184 0.16205
R1864 VSS.n723 VSS.n182 0.16205
R1865 VSS.n715 VSS.n180 0.16205
R1866 VSS.n705 VSS.n178 0.16205
R1867 VSS.n696 VSS.n176 0.16205
R1868 VSS.n687 VSS.n174 0.16205
R1869 VSS.n678 VSS.n172 0.16205
R1870 VSS.n667 VSS.n170 0.16205
R1871 VSS.n658 VSS.n168 0.16205
R1872 VSS.n647 VSS.n166 0.16205
R1873 VSS.n638 VSS.n164 0.16205
R1874 VSS.n627 VSS.n162 0.16205
R1875 VSS.n618 VSS.n160 0.16205
R1876 VSS.n608 VSS.n158 0.16205
R1877 VSS.n600 VSS.n156 0.16205
R1878 VSS.n591 VSS.n154 0.16205
R1879 VSS.n915 VSS.n913 0.16137
R1880 VSS.n915 VSS.n90 0.16137
R1881 VSS.n915 VSS.n92 0.16137
R1882 VSS.n897 VSS.n886 0.161058
R1883 VSS.n452 VSS.n451 0.161058
R1884 VSS.n918 VSS.n917 0.160293
R1885 VSS.n870 VSS.n229 0.15705
R1886 VSS.n851 VSS.n238 0.15705
R1887 VSS.n832 VSS.n249 0.15705
R1888 VSS.n815 VSS.n259 0.15705
R1889 VSS.n797 VSS.n269 0.15705
R1890 VSS.n780 VSS.n280 0.15705
R1891 VSS.n763 VSS.n290 0.15705
R1892 VSS.n741 VSS.n299 0.15705
R1893 VSS.n722 VSS.n310 0.15705
R1894 VSS.n704 VSS.n321 0.15705
R1895 VSS.n686 VSS.n331 0.15705
R1896 VSS.n666 VSS.n339 0.15705
R1897 VSS.n646 VSS.n349 0.15705
R1898 VSS.n626 VSS.n358 0.15705
R1899 VSS.n607 VSS.n369 0.15705
R1900 VSS.n477 VSS.n440 0.155582
R1901 VSS.n437 VSS.n436 0.155582
R1902 VSS.n486 VSS.n434 0.155582
R1903 VSS.n493 VSS.n431 0.155582
R1904 VSS.n429 VSS.n428 0.155582
R1905 VSS.n502 VSS.n426 0.155582
R1906 VSS.n508 VSS.n423 0.155582
R1907 VSS.n419 VSS.n418 0.155582
R1908 VSS.n517 VSS.n416 0.155582
R1909 VSS.n531 VSS.n412 0.155582
R1910 VSS.n409 VSS.n408 0.155582
R1911 VSS.n540 VSS.n406 0.155582
R1912 VSS.n547 VSS.n403 0.155582
R1913 VSS.n401 VSS.n400 0.155582
R1914 VSS.n556 VSS.n398 0.155582
R1915 VSS.n564 VSS.n395 0.155582
R1916 VSS.n569 VSS.n393 0.155582
R1917 VSS.n575 VSS.n574 0.155582
R1918 VSS.n883 VSS.n880 0.1508
R1919 VSS.n864 VSS.n861 0.1508
R1920 VSS.n844 VSS.n841 0.1508
R1921 VSS.n827 VSS.n824 0.1508
R1922 VSS.n810 VSS.n806 0.1508
R1923 VSS.n792 VSS.n789 0.1508
R1924 VSS.n775 VSS.n772 0.1508
R1925 VSS.n756 VSS.n752 0.1508
R1926 VSS.n736 VSS.n732 0.1508
R1927 VSS.n717 VSS.n714 0.1508
R1928 VSS.n698 VSS.n695 0.1508
R1929 VSS.n680 VSS.n677 0.1508
R1930 VSS.n660 VSS.n656 0.1508
R1931 VSS.n640 VSS.n636 0.1508
R1932 VSS.n620 VSS.n617 0.1508
R1933 VSS.n602 VSS.n599 0.1508
R1934 VSS.n460 VSS.n459 0.149888
R1935 VSS.n926 VSS.n925 0.14955
R1936 VSS.n475 VSS.n449 0.149476
R1937 VSS.n479 VSS.n478 0.149476
R1938 VSS.n483 VSS.n435 0.149476
R1939 VSS.n490 VSS.n433 0.149476
R1940 VSS.n495 VSS.n494 0.149476
R1941 VSS.n499 VSS.n427 0.149476
R1942 VSS.n506 VSS.n425 0.149476
R1943 VSS.n510 VSS.n509 0.149476
R1944 VSS.n514 VSS.n417 0.149476
R1945 VSS.n529 VSS.n415 0.149476
R1946 VSS.n533 VSS.n532 0.149476
R1947 VSS.n537 VSS.n407 0.149476
R1948 VSS.n544 VSS.n405 0.149476
R1949 VSS.n549 VSS.n548 0.149476
R1950 VSS.n553 VSS.n399 0.149476
R1951 VSS.n560 VSS.n397 0.149476
R1952 VSS.n565 VSS.n394 0.149476
R1953 VSS.n571 VSS.n392 0.149476
R1954 VSS.n901 VSS.n900 0.148577
R1955 VSS.n923 VSS.n922 0.147388
R1956 VSS.n457 VSS.n456 0.14705
R1957 VSS.n930 VSS.n929 0.142118
R1958 VSS.n464 VSS.n463 0.142118
R1959 VSS.n390 VSS.n388 0.141022
R1960 VSS.n468 VSS.n467 0.134888
R1961 VSS.n524 VSS.n523 0.134888
R1962 VSS.n477 VSS.n476 0.129618
R1963 VSS.n493 VSS.n492 0.129618
R1964 VSS.n508 VSS.n507 0.129618
R1965 VSS.n531 VSS.n530 0.129618
R1966 VSS.n547 VSS.n546 0.129618
R1967 VSS.n564 VSS.n563 0.129618
R1968 VSS.n388 VSS.n387 0.127569
R1969 VSS.n480 VSS.n439 0.126138
R1970 VSS.n496 VSS.n430 0.126138
R1971 VSS.n511 VSS.n422 0.126138
R1972 VSS.n534 VSS.n411 0.126138
R1973 VSS.n550 VSS.n402 0.126138
R1974 VSS.n568 VSS.n567 0.126138
R1975 VSS.n886 VSS.n884 0.125868
R1976 VSS.n866 VSS.n865 0.125868
R1977 VSS.n846 VSS.n845 0.125868
R1978 VSS.n829 VSS.n828 0.125868
R1979 VSS.n812 VSS.n811 0.125868
R1980 VSS.n794 VSS.n793 0.125868
R1981 VSS.n777 VSS.n776 0.125868
R1982 VSS.n758 VSS.n757 0.125868
R1983 VSS.n738 VSS.n737 0.125868
R1984 VSS.n719 VSS.n718 0.125868
R1985 VSS.n700 VSS.n699 0.125868
R1986 VSS.n682 VSS.n681 0.125868
R1987 VSS.n662 VSS.n661 0.125868
R1988 VSS.n642 VSS.n641 0.125868
R1989 VSS.n622 VSS.n621 0.125868
R1990 VSS.n604 VSS.n603 0.125868
R1991 VSS.n66 VSS.n441 0.156005
R1992 VSS.n69 VSS.n432 0.156005
R1993 VSS.n72 VSS.n424 0.156005
R1994 VSS.n75 VSS.n413 0.156005
R1995 VSS.n78 VSS.n404 0.156005
R1996 VSS.n81 VSS.n396 0.156005
R1997 VSS.n585 VSS.n152 0.124618
R1998 VSS.n932 VSS.n931 0.12455
R1999 VSS.n580 VSS.n152 0.122118
R2000 VSS.n469 VSS.n468 0.12205
R2001 VSS.n486 VSS.n485 0.12205
R2002 VSS.n502 VSS.n501 0.12205
R2003 VSS.n517 VSS.n516 0.12205
R2004 VSS.n525 VSS.n524 0.12205
R2005 VSS.n540 VSS.n539 0.12205
R2006 VSS.n556 VSS.n555 0.12205
R2007 VSS.n575 VSS.n573 0.12205
R2008 VSS.n216 VSS.n215 0.119888
R2009 VSS.n214 VSS.n213 0.119888
R2010 VSS.n212 VSS.n211 0.119888
R2011 VSS.n210 VSS.n209 0.119888
R2012 VSS.n208 VSS.n207 0.119888
R2013 VSS.n206 VSS.n205 0.119888
R2014 VSS.n204 VSS.n203 0.119888
R2015 VSS.n202 VSS.n201 0.119888
R2016 VSS.n200 VSS.n199 0.119888
R2017 VSS.n198 VSS.n197 0.119888
R2018 VSS.n196 VSS.n195 0.119888
R2019 VSS.n194 VSS.n193 0.119888
R2020 VSS.n192 VSS.n191 0.119888
R2021 VSS.n190 VSS.n189 0.119888
R2022 VSS.n188 VSS.n187 0.119888
R2023 VSS.n186 VSS.n185 0.119888
R2024 VSS.n184 VSS.n183 0.119888
R2025 VSS.n182 VSS.n181 0.119888
R2026 VSS.n180 VSS.n179 0.119888
R2027 VSS.n178 VSS.n177 0.119888
R2028 VSS.n176 VSS.n175 0.119888
R2029 VSS.n174 VSS.n173 0.119888
R2030 VSS.n172 VSS.n171 0.119888
R2031 VSS.n170 VSS.n169 0.119888
R2032 VSS.n168 VSS.n167 0.119888
R2033 VSS.n166 VSS.n165 0.119888
R2034 VSS.n164 VSS.n163 0.119888
R2035 VSS.n162 VSS.n161 0.119888
R2036 VSS.n160 VSS.n159 0.119888
R2037 VSS.n158 VSS.n157 0.119888
R2038 VSS.n156 VSS.n155 0.119888
R2039 VSS.n154 VSS.n153 0.119888
R2040 VSS.n585 VSS.n148 0.114888
R2041 VSS.n931 VSS.n930 0.114618
R2042 VSS.n465 VSS.n464 0.114618
R2043 VSS.n865 VSS.n229 0.113638
R2044 VSS.n845 VSS.n238 0.113638
R2045 VSS.n828 VSS.n249 0.113638
R2046 VSS.n811 VSS.n259 0.113638
R2047 VSS.n793 VSS.n269 0.113638
R2048 VSS.n776 VSS.n280 0.113638
R2049 VSS.n757 VSS.n290 0.113638
R2050 VSS.n737 VSS.n299 0.113638
R2051 VSS.n718 VSS.n310 0.113638
R2052 VSS.n699 VSS.n321 0.113638
R2053 VSS.n681 VSS.n331 0.113638
R2054 VSS.n661 VSS.n339 0.113638
R2055 VSS.n641 VSS.n349 0.113638
R2056 VSS.n621 VSS.n358 0.113638
R2057 VSS.n603 VSS.n369 0.113638
R2058 VSS.n456 VSS.n455 0.109888
R2059 VSS.n922 VSS.n921 0.10955
R2060 VSS.n927 VSS.n926 0.107388
R2061 VSS.n461 VSS.n460 0.10705
R2062 VSS.n485 VSS.n484 0.106138
R2063 VSS.n501 VSS.n500 0.106138
R2064 VSS.n516 VSS.n515 0.106138
R2065 VSS.n539 VSS.n538 0.106138
R2066 VSS.n555 VSS.n554 0.106138
R2067 VSS.n573 VSS.n572 0.106138
R2068 VSS.n483 VSS.n482 0.105361
R2069 VSS.n499 VSS.n498 0.105361
R2070 VSS.n514 VSS.n513 0.105361
R2071 VSS.n537 VSS.n536 0.105361
R2072 VSS.n553 VSS.n552 0.105361
R2073 VSS.n571 VSS.n570 0.105361
R2074 VSS.n439 VSS.n437 0.10205
R2075 VSS.n430 VSS.n429 0.10205
R2076 VSS.n422 VSS.n419 0.10205
R2077 VSS.n411 VSS.n409 0.10205
R2078 VSS.n402 VSS.n401 0.10205
R2079 VSS.n569 VSS.n568 0.10205
R2080 VSS.n476 VSS.n441 0.0983676
R2081 VSS.n492 VSS.n432 0.0983676
R2082 VSS.n507 VSS.n424 0.0983676
R2083 VSS.n530 VSS.n413 0.0983676
R2084 VSS.n546 VSS.n404 0.0983676
R2085 VSS.n563 VSS.n396 0.0983676
R2086 VSS.n891 VSS.n890 0.094
R2087 VSS.n894 VSS.n891 0.094
R2088 VSS.n900 VSS.n218 0.08925
R2089 VSS.n884 VSS.n883 0.0883676
R2090 VSS.n866 VSS.n864 0.0883676
R2091 VSS.n846 VSS.n844 0.0883676
R2092 VSS.n829 VSS.n827 0.0883676
R2093 VSS.n812 VSS.n810 0.0883676
R2094 VSS.n794 VSS.n792 0.0883676
R2095 VSS.n777 VSS.n775 0.0883676
R2096 VSS.n758 VSS.n756 0.0883676
R2097 VSS.n738 VSS.n736 0.0883676
R2098 VSS.n719 VSS.n717 0.0883676
R2099 VSS.n700 VSS.n698 0.0883676
R2100 VSS.n682 VSS.n680 0.0883676
R2101 VSS.n662 VSS.n660 0.0883676
R2102 VSS.n642 VSS.n640 0.0883676
R2103 VSS.n622 VSS.n620 0.0883676
R2104 VSS.n604 VSS.n602 0.0883676
R2105 VSS.n588 VSS.n587 0.088
R2106 VSS.n484 VSS.n68 0.176279
R2107 VSS.n71 VSS.n499 0.0435295
R2108 VSS.n74 VSS.n514 0.0435295
R2109 VSS.n77 VSS.n537 0.0435295
R2110 VSS.n554 VSS.n80 0.176279
R2111 VSS.n571 VSS.n83 0.0435295
R2112 VSS.n890 VSS.n889 0.0851154
R2113 VSS.n896 VSS.n894 0.0851154
R2114 VSS.n583 VSS.n579 0.0805
R2115 VSS.n917 VSS.n916 0.078
R2116 VSS.n451 VSS.n450 0.078
R2117 VSS.n385 VSS.n150 0.0771176
R2118 VSS.n889 VSS.n219 0.0746176
R2119 VSS.n887 VSS.n94 0.0746176
R2120 VSS.n582 VSS.n382 0.07425
R2121 VSS.n580 VSS.n150 0.0696176
R2122 VSS.n889 VSS.n220 0.06925
R2123 VSS.n887 VSS.n95 0.06925
R2124 VSS.n479 VSS.n67 0.103847
R2125 VSS.n495 VSS.n70 0.103847
R2126 VSS.n510 VSS.n73 0.103847
R2127 VSS.n533 VSS.n76 0.103847
R2128 VSS.n549 VSS.n79 0.103847
R2129 VSS.n565 VSS.n82 0.103847
R2130 VSS.n590 VSS.n381 0.06175
R2131 VSS.n892 VSS.n95 0.05925
R2132 VSS.n906 VSS.n904 0.05675
R2133 VSS.n903 VSS.n219 0.0546176
R2134 VSS.n900 VSS.n94 0.0546176
R2135 VSS.n566 VSS.n565 0.0543074
R2136 VSS.n551 VSS.n549 0.0543074
R2137 VSS.n535 VSS.n533 0.0543074
R2138 VSS.n512 VSS.n510 0.0543074
R2139 VSS.n497 VSS.n495 0.0543074
R2140 VSS.n481 VSS.n479 0.0543074
R2141 VSS.n73 VSS.n508 0.0180497
R2142 VSS.n79 VSS.n547 0.0180497
R2143 VSS.n584 VSS.n382 0.04925
R2144 VSS.n226 VSS.n225 0.048
R2145 VSS.n235 VSS.n234 0.048
R2146 VSS.n245 VSS.n244 0.048
R2147 VSS.n256 VSS.n255 0.048
R2148 VSS.n266 VSS.n265 0.048
R2149 VSS.n276 VSS.n275 0.048
R2150 VSS.n287 VSS.n286 0.048
R2151 VSS.n295 VSS.n294 0.048
R2152 VSS.n306 VSS.n305 0.048
R2153 VSS.n318 VSS.n317 0.048
R2154 VSS.n328 VSS.n327 0.048
R2155 VSS.n336 VSS.n335 0.048
R2156 VSS.n346 VSS.n345 0.048
R2157 VSS.n355 VSS.n354 0.048
R2158 VSS.n365 VSS.n364 0.048
R2159 VSS.n377 VSS.n376 0.048
R2160 VSS.n588 VSS.n584 0.04675
R2161 VSS.n873 VSS.n226 0.0405
R2162 VSS.n854 VSS.n235 0.0405
R2163 VSS.n835 VSS.n245 0.0405
R2164 VSS.n818 VSS.n256 0.0405
R2165 VSS.n800 VSS.n266 0.0405
R2166 VSS.n783 VSS.n276 0.0405
R2167 VSS.n766 VSS.n287 0.0405
R2168 VSS.n744 VSS.n295 0.0405
R2169 VSS.n725 VSS.n306 0.0405
R2170 VSS.n707 VSS.n318 0.0405
R2171 VSS.n689 VSS.n328 0.0405
R2172 VSS.n669 VSS.n336 0.0405
R2173 VSS.n649 VSS.n346 0.0405
R2174 VSS.n629 VSS.n355 0.0405
R2175 VSS.n610 VSS.n365 0.0405
R2176 VSS.n593 VSS.n377 0.0405
R2177 VSS.n916 VSS 0.038
R2178 VSS.n904 VSS.n903 0.033
R2179 VSS.n896 VSS.n895 0.033
R2180 VSS.n388 VSS.n384 0.02925
R2181 VSS.n895 VSS.n220 0.02675
R2182 VSS.t249 VSS.n28 116.468
R2183 VSS.n55 VSS.n21 0.00760728
R2184 VSS.n56 VSS.n23 0.00760728
R2185 VSS.t175 VSS.n37 212.157
R2186 VSS.n58 VSS.n35 0.00588066
R2187 VSS.n57 VSS.n35 0.00760728
R2188 VSS.t237 VSS.n20 116.468
R2189 VSS.t20 VSS.n61 212.157
R2190 VSS.n60 VSS.n0 0.00760728
R2191 VSS.n34 VSS.t172 116.468
R2192 VSS.n14 VSS.n6 0.023135
R2193 VSS.n15 VSS.t45 384.904
R2194 VSS.n583 VSS.n582 0.02175
R2195 VSS.n915 VSS.n914 0.0166972
R2196 VSS.n915 VSS.n87 0.0166972
R2197 VSS.n570 VSS.n569 0.0166107
R2198 VSS.n552 VSS.n401 0.0166107
R2199 VSS.n536 VSS.n409 0.0166107
R2200 VSS.n513 VSS.n419 0.0166107
R2201 VSS.n498 VSS.n429 0.0166107
R2202 VSS.n482 VSS.n437 0.0166107
R2203 VSS.n579 VSS.n384 0.0155
R2204 VSS.n905 VSS.n85 0.0112403
R2205 VSS.n933 VSS.n85 0.0095322
R2206 VSS.n915 VSS.n251 0.00938635
R2207 VSS.n915 VSS.n271 0.00938635
R2208 VSS.n915 VSS.n302 0.00938635
R2209 VSS.n915 VSS.n323 0.00938635
R2210 VSS.n915 VSS.n898 0.00937856
R2211 VSS.n915 VSS.n877 0.00937856
R2212 VSS.n915 VSS.n240 0.00937856
R2213 VSS.n915 VSS.n262 0.00937856
R2214 VSS.n915 VSS.n711 0.00937856
R2215 VSS.n915 VSS.n674 0.00937856
R2216 VSS.n915 VSS.n653 0.00937856
R2217 VSS.n915 VSS.n380 0.00937856
R2218 VSS.n915 VSS.n231 0.00937856
R2219 VSS.n915 VSS.n283 0.00937856
R2220 VSS.n915 VSS.n749 0.00937856
R2221 VSS.n915 VSS.n633 0.00937856
R2222 VSS.n915 VSS.n361 0.00937856
R2223 VSS.n915 VSS.n372 0.00937856
R2224 VSS.n587 VSS.n381 0.008
R2225 VSS.n906 VSS.n905 0.00675
R2226 VSS.n905 VSS.n218 0.00675
R2227 VSS.n1 VSS.n0 0.0025
R2228 VSS.n0 VSS.n18 0.0025
R2229 VSS.n19 VSS.n18 0.00292781
R2230 VSS.n45 VSS.n35 0.00201811
R2231 VSS.n561 VSS.n30 0.00179957
R2232 VSS.n562 VSS.n30 0.00179957
R2233 VSS.t356 VSS.n39 402.185
R2234 VSS.n30 VSS.n38 0.00179957
R2235 VSS.n40 VSS.t344 229.441
R2236 VSS.n21 VSS.n26 0.00179957
R2237 VSS.n21 VSS.n27 0.00179957
R2238 VSS.n45 VSS.n44 0.00179957
R2239 VSS.n45 VSS.n43 0.00179957
R2240 VSS.n45 VSS.n42 0.00104691
R2241 VSS.n45 VSS.n41 0.00179957
R2242 VSS.n49 VSS.n48 0.00179957
R2243 VSS.n49 VSS.n47 0.00179957
R2244 VSS.n50 VSS.t311 402.185
R2245 VSS.n49 VSS.n46 0.00179957
R2246 VSS.n51 VSS.t299 229.441
R2247 VSS.n31 VSS.n30 0.00353618
R2248 VSS.n14 VSS.n9 0.00309914
R2249 VSS.n14 VSS.n8 0.00281833
R2250 VSS.n420 VSS.n35 0.00252007
R2251 VSS.n49 VSS.n35 0.0025
R2252 VSS.n45 VSS.n23 0.0025
R2253 VSS.n23 VSS.n21 0.0025
R2254 VSS.n1 VSS.n4 0.00249124
R2255 VSS.n23 VSS.n22 0.0022108
R2256 VSS.n30 VSS.n25 0.00107219
R2257 VSS.n40 VSS.n21 0.00203791
R2258 VSS.n51 VSS.n18 0.00203791
R2259 VSS.n18 VSS.n16 0.00179957
R2260 VSS.n18 VSS.n17 0.00179957
R2261 VSS.n0 VSS.n52 0.00179957
R2262 VSS.n2 VSS.n438 469.784
R2263 a_3747_311.n0 a_3747_311.t2 52.0388
R2264 a_3747_311.t1 a_3747_311.n0 35.4491
R2265 a_3747_311.n0 a_3747_311.t3 33.5891
R2266 a_3747_311.t0 a_3747_311.t1 5.61942
R2267 a_3171_311.n0 a_3171_311.t2 51.8377
R2268 a_3171_311.n0 a_3171_311.t3 33.3881
R2269 a_3171_311.t1 a_3171_311.n0 31.8923
R2270 a_3171_311.t0 a_3171_311.t1 5.61777
R2271 a_2595_311.n0 a_2595_311.t2 51.6367
R2272 a_2595_311.n0 a_2595_311.t3 33.187
R2273 a_2595_311.t1 a_2595_311.n0 27.993
R2274 a_2595_311.t0 a_2595_311.t1 5.73018
R2275 a_3747_1047.n0 a_3747_1047.t2 38.0081
R2276 a_3747_1047.n0 a_3747_1047.t3 33.3957
R2277 a_3747_1047.n1 a_3747_1047.t4 33.3957
R2278 a_3747_1047.n2 a_3747_1047.t5 33.3957
R2279 a_3747_1047.n3 a_3747_1047.t6 33.3957
R2280 a_3747_1047.n4 a_3747_1047.t7 33.3957
R2281 a_3747_1047.n5 a_3747_1047.t8 33.3957
R2282 a_3747_1047.n6 a_3747_1047.t9 33.3957
R2283 a_3747_1047.t1 a_3747_1047.n6 23.2419
R2284 a_3747_1047.t0 a_3747_1047.t1 5.61942
R2285 a_3747_1047.n6 a_3747_1047.n5 4.61291
R2286 a_3747_1047.n5 a_3747_1047.n4 4.61291
R2287 a_3747_1047.n4 a_3747_1047.n3 4.61291
R2288 a_3747_1047.n3 a_3747_1047.n2 4.61291
R2289 a_3747_1047.n2 a_3747_1047.n1 4.61291
R2290 a_3747_1047.n1 a_3747_1047.n0 4.61291
R2291 a_3171_1047.n0 a_3171_1047.t2 37.8054
R2292 a_3171_1047.n0 a_3171_1047.t3 33.193
R2293 a_3171_1047.n1 a_3171_1047.t4 33.193
R2294 a_3171_1047.n2 a_3171_1047.t5 33.193
R2295 a_3171_1047.n3 a_3171_1047.t6 33.193
R2296 a_3171_1047.n4 a_3171_1047.t7 33.193
R2297 a_3171_1047.n5 a_3171_1047.t8 33.193
R2298 a_3171_1047.n6 a_3171_1047.t9 33.193
R2299 a_3171_1047.t1 a_3171_1047.n6 23.0313
R2300 a_3171_1047.t0 a_3171_1047.t1 5.61777
R2301 a_3171_1047.n6 a_3171_1047.n5 4.61291
R2302 a_3171_1047.n5 a_3171_1047.n4 4.61291
R2303 a_3171_1047.n4 a_3171_1047.n3 4.61291
R2304 a_3171_1047.n3 a_3171_1047.n2 4.61291
R2305 a_3171_1047.n2 a_3171_1047.n1 4.61291
R2306 a_3171_1047.n1 a_3171_1047.n0 4.61291
R2307 a_2595_1047.n0 a_2595_1047.t2 37.7691
R2308 a_2595_1047.n0 a_2595_1047.t3 33.1567
R2309 a_2595_1047.n1 a_2595_1047.t4 33.1567
R2310 a_2595_1047.n2 a_2595_1047.t5 33.1567
R2311 a_2595_1047.n3 a_2595_1047.t6 33.1567
R2312 a_2595_1047.n4 a_2595_1047.t7 33.1567
R2313 a_2595_1047.n5 a_2595_1047.t8 33.1567
R2314 a_2595_1047.n6 a_2595_1047.t9 33.1567
R2315 a_2595_1047.t1 a_2595_1047.n6 22.7941
R2316 a_2595_1047.t0 a_2595_1047.t1 5.65522
R2317 a_2595_1047.n6 a_2595_1047.n5 4.61291
R2318 a_2595_1047.n5 a_2595_1047.n4 4.61291
R2319 a_2595_1047.n4 a_2595_1047.n3 4.61291
R2320 a_2595_1047.n3 a_2595_1047.n2 4.61291
R2321 a_2595_1047.n2 a_2595_1047.n1 4.61291
R2322 a_2595_1047.n1 a_2595_1047.n0 4.61291
R2323 a_2019_1047.n0 a_2019_1047.t2 37.9701
R2324 a_2019_1047.n0 a_2019_1047.t3 33.3577
R2325 a_2019_1047.n1 a_2019_1047.t4 33.3577
R2326 a_2019_1047.n2 a_2019_1047.t5 33.3577
R2327 a_2019_1047.n3 a_2019_1047.t6 33.3577
R2328 a_2019_1047.n4 a_2019_1047.t7 33.3577
R2329 a_2019_1047.n5 a_2019_1047.t8 33.3577
R2330 a_2019_1047.t1 a_2019_1047.t9 22.5945
R2331 a_2019_1047.t0 a_2019_1047.t1 5.62052
R2332 a_2019_1047.t9 a_2019_1047.n5 4.61291
R2333 a_2019_1047.n5 a_2019_1047.n4 4.61291
R2334 a_2019_1047.n4 a_2019_1047.n3 4.61291
R2335 a_2019_1047.n3 a_2019_1047.n2 4.61291
R2336 a_2019_1047.n2 a_2019_1047.n1 4.61291
R2337 a_2019_1047.n1 a_2019_1047.n0 4.61291
C1105 MUX_OUT VSS 3.24058f
C1106 MUX_SEL4 VSS 1.60778f
C1107 MUX_SEL3 VSS 0.90686f
C1108 MUX_SEL2 VSS 1.81137f
C1109 MUX_SEL1 VSS 0.95076f
C1110 MUX_SEL0 VSS 1.55166f
C1111 DELAY_VBIASN VSS 12.4102f
C1112 DELAY_OUT_LAST VSS 0.39284f
C1113 DELAY_VBIASP VSS 4.12851f
C1114 DELAY_IN VSS 1.91954f
C1115 VDD VSS 46.2941f
C1116 a_26985_519# VSS 0.17928f ; **FLOATING
C1117 a_23945_519# VSS 0.17928f ; **FLOATING
C1118 a_20905_519# VSS 0.17928f ; **FLOATING
C1119 a_17865_519# VSS 0.17593f ; **FLOATING
C1120 a_16851_309# VSS 0.38699f ; **FLOATING
C1121 a_16108_289# VSS 3.85084f ; **FLOATING
C1122 a_15964_289# VSS 0.17613f ; **FLOATING
C1123 a_15765_463# VSS 0.36132f ; **FLOATING
C1124 a_14825_519# VSS 0.17928f ; **FLOATING
C1125 a_11785_519# VSS 0.17928f ; **FLOATING
C1126 a_8745_519# VSS 0.17928f ; **FLOATING
C1127 a_5731_289# VSS 3.39133f ; **FLOATING
C1128 a_2019_311# VSS 1.61601f ; **FLOATING
C1129 a_5705_519# VSS 0.17638f ; **FLOATING
C1130 a_3449_331# VSS 0.18478f ; **FLOATING
C1131 a_2873_331# VSS 0.18321f ; **FLOATING
C1132 a_2297_331# VSS 0.18321f ; **FLOATING
C1133 a_1721_331# VSS 0.17001f ; **FLOATING
C1134 a_1544_289# VSS 0.30014f ; **FLOATING
C1135 a_1256_289# VSS 0.84266f ; **FLOATING
C1136 a_27991_1008# VSS 0.18706f ; **FLOATING
C1137 a_27915_1044# VSS 0.10926f ; **FLOATING
C1138 a_27124_1008# VSS 0.17878f ; **FLOATING
C1139 a_27048_1044# VSS 0.12122f ; **FLOATING
C1140 a_26471_1008# VSS 0.18175f ; **FLOATING
C1141 a_26395_1044# VSS 0.11073f ; **FLOATING
C1142 a_25604_1008# VSS 0.18087f ; **FLOATING
C1143 a_25630_1044# VSS 0.34139f ; **FLOATING
C1144 a_25528_1044# VSS 0.12433f ; **FLOATING
C1145 a_24951_1008# VSS 0.18335f ; **FLOATING
C1146 a_24875_1044# VSS 0.11016f ; **FLOATING
C1147 a_24084_1008# VSS 0.17878f ; **FLOATING
C1148 a_24008_1044# VSS 0.12122f ; **FLOATING
C1149 a_23431_1008# VSS 0.18175f ; **FLOATING
C1150 a_23355_1044# VSS 0.11073f ; **FLOATING
C1151 a_22564_1008# VSS 0.18087f ; **FLOATING
C1152 a_22590_1044# VSS 0.33314f ; **FLOATING
C1153 a_22488_1044# VSS 0.12433f ; **FLOATING
C1154 a_21911_1008# VSS 0.18335f ; **FLOATING
C1155 a_21835_1044# VSS 0.11016f ; **FLOATING
C1156 a_21044_1008# VSS 0.17878f ; **FLOATING
C1157 a_20968_1044# VSS 0.12122f ; **FLOATING
C1158 a_20391_1008# VSS 0.18175f ; **FLOATING
C1159 a_20315_1044# VSS 0.11073f ; **FLOATING
C1160 a_19524_1008# VSS 0.18087f ; **FLOATING
C1161 a_19550_1044# VSS 0.33563f ; **FLOATING
C1162 a_19448_1044# VSS 0.12433f ; **FLOATING
C1163 a_18871_1008# VSS 0.18335f ; **FLOATING
C1164 a_18795_1044# VSS 0.11016f ; **FLOATING
C1165 a_18004_1008# VSS 0.17878f ; **FLOATING
C1166 a_17928_1044# VSS 0.12122f ; **FLOATING
C1167 a_17351_1008# VSS 0.18022f ; **FLOATING
C1168 a_17275_1044# VSS 0.10926f ; **FLOATING
C1169 a_16484_1008# VSS 0.18023f ; **FLOATING
C1170 a_16510_1044# VSS 0.28935f ; **FLOATING
C1171 a_16408_1044# VSS 0.1229f ; **FLOATING
C1172 a_15831_1008# VSS 0.17846f ; **FLOATING
C1173 a_15755_1044# VSS 0.10926f ; **FLOATING
C1174 a_14964_1008# VSS 0.17878f ; **FLOATING
C1175 a_14888_1044# VSS 0.12122f ; **FLOATING
C1176 a_14311_1008# VSS 0.18175f ; **FLOATING
C1177 a_14235_1044# VSS 0.11073f ; **FLOATING
C1178 a_13444_1008# VSS 0.18087f ; **FLOATING
C1179 a_13470_1044# VSS 0.30333f ; **FLOATING
C1180 a_13368_1044# VSS 0.12433f ; **FLOATING
C1181 a_12791_1008# VSS 0.18335f ; **FLOATING
C1182 a_12715_1044# VSS 0.11016f ; **FLOATING
C1183 a_11924_1008# VSS 0.17878f ; **FLOATING
C1184 a_11848_1044# VSS 0.12122f ; **FLOATING
C1185 a_11271_1008# VSS 0.18175f ; **FLOATING
C1186 a_11195_1044# VSS 0.11073f ; **FLOATING
C1187 a_10404_1008# VSS 0.18087f ; **FLOATING
C1188 a_10430_1044# VSS 0.31665f ; **FLOATING
C1189 a_10328_1044# VSS 0.12433f ; **FLOATING
C1190 a_9751_1008# VSS 0.18335f ; **FLOATING
C1191 a_9675_1044# VSS 0.11016f ; **FLOATING
C1192 a_8884_1008# VSS 0.17878f ; **FLOATING
C1193 a_8808_1044# VSS 0.12122f ; **FLOATING
C1194 a_8231_1008# VSS 0.18175f ; **FLOATING
C1195 a_8155_1044# VSS 0.11073f ; **FLOATING
C1196 a_7364_1008# VSS 0.18087f ; **FLOATING
C1197 a_7390_1044# VSS 0.31357f ; **FLOATING
C1198 a_7288_1044# VSS 0.12433f ; **FLOATING
C1199 a_6711_1008# VSS 0.18335f ; **FLOATING
C1200 a_6635_1044# VSS 0.11016f ; **FLOATING
C1201 a_5844_1008# VSS 0.17878f ; **FLOATING
C1202 a_5768_1044# VSS 0.12122f ; **FLOATING
C1203 a_5191_1008# VSS 0.18022f ; **FLOATING
C1204 a_5115_1044# VSS 0.10926f ; **FLOATING
C1205 a_4324_1008# VSS 0.18023f ; **FLOATING
C1206 a_4350_1044# VSS 0.26655f ; **FLOATING
C1207 a_4248_1044# VSS 0.12443f ; **FLOATING
C1208 a_27705_1044# VSS 0.25296f ; **FLOATING
C1209 a_26185_1044# VSS 0.23475f ; **FLOATING
C1210 a_24665_1044# VSS 0.25432f ; **FLOATING
C1211 a_23145_1044# VSS 0.23475f ; **FLOATING
C1212 a_21625_1044# VSS 0.25432f ; **FLOATING
C1213 a_20105_1044# VSS 0.23475f ; **FLOATING
C1214 a_18585_1044# VSS 0.25432f ; **FLOATING
C1215 a_17065_1044# VSS 0.23385f ; **FLOATING
C1216 a_15545_1044# VSS 0.25296f ; **FLOATING
C1217 a_14025_1044# VSS 0.23475f ; **FLOATING
C1218 a_12505_1044# VSS 0.25432f ; **FLOATING
C1219 a_10985_1044# VSS 0.23475f ; **FLOATING
C1220 a_9465_1044# VSS 0.25432f ; **FLOATING
C1221 a_7945_1044# VSS 0.23475f ; **FLOATING
C1222 a_6425_1044# VSS 0.25432f ; **FLOATING
C1223 a_4905_1044# VSS 0.23549f ; **FLOATING
C1224 a_4157_1313# VSS 0.32875f ; **FLOATING
C1225 a_3449_1395# VSS 0.18629f ; **FLOATING
C1226 a_2873_1395# VSS 0.18349f ; **FLOATING
C1227 a_2297_1395# VSS 0.18349f ; **FLOATING
C1228 a_1721_1395# VSS 0.17029f ; **FLOATING
C1229 a_1544_1044# VSS 0.29829f ; **FLOATING
C1230 a_1256_1044# VSS 0.82978f ; **FLOATING
C1231 a_27671_1842# VSS 0.01336f ; **FLOATING
C1232 a_26911_1842# VSS 0.01336f ; **FLOATING
C1233 a_26151_1842# VSS 0.01336f ; **FLOATING
C1234 a_25391_1842# VSS 0.01336f ; **FLOATING
C1235 a_24631_1842# VSS 0.01336f ; **FLOATING
C1236 a_23871_1842# VSS 0.01336f ; **FLOATING
C1237 a_23111_1842# VSS 0.01336f ; **FLOATING
C1238 a_22351_1842# VSS 0.01336f ; **FLOATING
C1239 a_21591_1842# VSS 0.01336f ; **FLOATING
C1240 a_20831_1842# VSS 0.01336f ; **FLOATING
C1241 a_20071_1842# VSS 0.01336f ; **FLOATING
C1242 a_19311_1842# VSS 0.01336f ; **FLOATING
C1243 a_18551_1842# VSS 0.01336f ; **FLOATING
C1244 a_17791_1842# VSS 0.01336f ; **FLOATING
C1245 a_17031_1842# VSS 0.01336f ; **FLOATING
C1246 a_16271_1842# VSS 0.01336f ; **FLOATING
C1247 a_15511_1842# VSS 0.01336f ; **FLOATING
C1248 a_14751_1842# VSS 0.01336f ; **FLOATING
C1249 a_13991_1842# VSS 0.01336f ; **FLOATING
C1250 a_13231_1842# VSS 0.01336f ; **FLOATING
C1251 a_12471_1842# VSS 0.01336f ; **FLOATING
C1252 a_11711_1842# VSS 0.01336f ; **FLOATING
C1253 a_10951_1842# VSS 0.01336f ; **FLOATING
C1254 a_10191_1842# VSS 0.01336f ; **FLOATING
C1255 a_9431_1842# VSS 0.01336f ; **FLOATING
C1256 a_8671_1842# VSS 0.01336f ; **FLOATING
C1257 a_7911_1842# VSS 0.01336f ; **FLOATING
C1258 a_7151_1842# VSS 0.01336f ; **FLOATING
C1259 a_6391_1842# VSS 0.01336f ; **FLOATING
C1260 a_5631_1842# VSS 0.01336f ; **FLOATING
C1261 a_4871_1842# VSS 0.01336f ; **FLOATING
C1262 a_4111_1842# VSS 0.0139f ; **FLOATING
C1263 a_27563_1842# VSS 0.51284f ; **FLOATING
C1264 a_27997_1842# VSS 0.6533f ; **FLOATING
C1265 a_27433_1842# VSS 0.45843f ; **FLOATING
C1266 a_26803_1842# VSS 0.50902f ; **FLOATING
C1267 a_27237_1842# VSS 0.93747f ; **FLOATING
C1268 a_26673_1842# VSS 0.45994f ; **FLOATING
C1269 a_26043_1842# VSS 0.51137f ; **FLOATING
C1270 a_26477_1842# VSS 0.96549f ; **FLOATING
C1271 a_25913_1842# VSS 0.46292f ; **FLOATING
C1272 a_25283_1842# VSS 0.50906f ; **FLOATING
C1273 a_25717_1842# VSS 0.87619f ; **FLOATING
C1274 a_25153_1842# VSS 0.45997f ; **FLOATING
C1275 a_24523_1842# VSS 0.51043f ; **FLOATING
C1276 a_24957_1842# VSS 0.97121f ; **FLOATING
C1277 a_24393_1842# VSS 0.45843f ; **FLOATING
C1278 a_23763_1842# VSS 0.50902f ; **FLOATING
C1279 a_24197_1842# VSS 0.93322f ; **FLOATING
C1280 a_23633_1842# VSS 0.45994f ; **FLOATING
C1281 a_23003_1842# VSS 0.51137f ; **FLOATING
C1282 a_23437_1842# VSS 0.96549f ; **FLOATING
C1283 a_22873_1842# VSS 0.46292f ; **FLOATING
C1284 a_22243_1842# VSS 0.50906f ; **FLOATING
C1285 a_22677_1842# VSS 0.87619f ; **FLOATING
C1286 a_22113_1842# VSS 0.45997f ; **FLOATING
C1287 a_21483_1842# VSS 0.51043f ; **FLOATING
C1288 a_21917_1842# VSS 0.97121f ; **FLOATING
C1289 a_21353_1842# VSS 0.45843f ; **FLOATING
C1290 a_20723_1842# VSS 0.50902f ; **FLOATING
C1291 a_21157_1842# VSS 0.93322f ; **FLOATING
C1292 a_20593_1842# VSS 0.45994f ; **FLOATING
C1293 a_19963_1842# VSS 0.51137f ; **FLOATING
C1294 a_20397_1842# VSS 0.96549f ; **FLOATING
C1295 a_19833_1842# VSS 0.46292f ; **FLOATING
C1296 a_19203_1842# VSS 0.50906f ; **FLOATING
C1297 a_19637_1842# VSS 0.87619f ; **FLOATING
C1298 a_19073_1842# VSS 0.45997f ; **FLOATING
C1299 a_18443_1842# VSS 0.51043f ; **FLOATING
C1300 a_18877_1842# VSS 0.97121f ; **FLOATING
C1301 a_18313_1842# VSS 0.45843f ; **FLOATING
C1302 a_17683_1842# VSS 0.50902f ; **FLOATING
C1303 a_18117_1842# VSS 0.93322f ; **FLOATING
C1304 a_17553_1842# VSS 0.45994f ; **FLOATING
C1305 a_16923_1842# VSS 0.51133f ; **FLOATING
C1306 a_17357_1842# VSS 0.96549f ; **FLOATING
C1307 a_16793_1842# VSS 0.46262f ; **FLOATING
C1308 a_16163_1842# VSS 0.50902f ; **FLOATING
C1309 a_16597_1842# VSS 0.87137f ; **FLOATING
C1310 a_16033_1842# VSS 0.45859f ; **FLOATING
C1311 a_15403_1842# VSS 0.51041f ; **FLOATING
C1312 a_15837_1842# VSS 0.9618f ; **FLOATING
C1313 a_15273_1842# VSS 0.45843f ; **FLOATING
C1314 a_14643_1842# VSS 0.50902f ; **FLOATING
C1315 a_15077_1842# VSS 0.93209f ; **FLOATING
C1316 a_14513_1842# VSS 0.45994f ; **FLOATING
C1317 a_13883_1842# VSS 0.51137f ; **FLOATING
C1318 a_14317_1842# VSS 0.96549f ; **FLOATING
C1319 a_13753_1842# VSS 0.46292f ; **FLOATING
C1320 a_13123_1842# VSS 0.50904f ; **FLOATING
C1321 a_13557_1842# VSS 0.87619f ; **FLOATING
C1322 a_12993_1842# VSS 0.45997f ; **FLOATING
C1323 a_12363_1842# VSS 0.51043f ; **FLOATING
C1324 a_12797_1842# VSS 0.96954f ; **FLOATING
C1325 a_12233_1842# VSS 0.45843f ; **FLOATING
C1326 a_11603_1842# VSS 0.50902f ; **FLOATING
C1327 a_12037_1842# VSS 0.93322f ; **FLOATING
C1328 a_11473_1842# VSS 0.45994f ; **FLOATING
C1329 a_10843_1842# VSS 0.51137f ; **FLOATING
C1330 a_11277_1842# VSS 0.96549f ; **FLOATING
C1331 a_10713_1842# VSS 0.46292f ; **FLOATING
C1332 a_10083_1842# VSS 0.50904f ; **FLOATING
C1333 a_10517_1842# VSS 0.87619f ; **FLOATING
C1334 a_9953_1842# VSS 0.45997f ; **FLOATING
C1335 a_9323_1842# VSS 0.51043f ; **FLOATING
C1336 a_9757_1842# VSS 0.96954f ; **FLOATING
C1337 a_9193_1842# VSS 0.45843f ; **FLOATING
C1338 a_8563_1842# VSS 0.50902f ; **FLOATING
C1339 a_8997_1842# VSS 0.93322f ; **FLOATING
C1340 a_8433_1842# VSS 0.45994f ; **FLOATING
C1341 a_7803_1842# VSS 0.51137f ; **FLOATING
C1342 a_8237_1842# VSS 0.96549f ; **FLOATING
C1343 a_7673_1842# VSS 0.46292f ; **FLOATING
C1344 a_7043_1842# VSS 0.50904f ; **FLOATING
C1345 a_7477_1842# VSS 0.87619f ; **FLOATING
C1346 a_6913_1842# VSS 0.45997f ; **FLOATING
C1347 a_6283_1842# VSS 0.51043f ; **FLOATING
C1348 a_6717_1842# VSS 0.96895f ; **FLOATING
C1349 a_6153_1842# VSS 0.45843f ; **FLOATING
C1350 a_5523_1842# VSS 0.50902f ; **FLOATING
C1351 a_5957_1842# VSS 0.93322f ; **FLOATING
C1352 a_5393_1842# VSS 0.45994f ; **FLOATING
C1353 a_4763_1842# VSS 0.51133f ; **FLOATING
C1354 a_5197_1842# VSS 0.96549f ; **FLOATING
C1355 a_4633_1842# VSS 0.4629f ; **FLOATING
C1356 a_4003_1842# VSS 0.58899f ; **FLOATING
C1357 a_4437_1842# VSS 0.87666f ; **FLOATING
C1358 a_2019_1047.t2 VSS 0.93017f ; **FLOATING
C1359 a_2019_1047.t3 VSS 0.70616f ; **FLOATING
C1360 a_2019_1047.n0 VSS 5.0083f ; **FLOATING
C1361 a_2019_1047.t4 VSS 0.70616f ; **FLOATING
C1362 a_2019_1047.n1 VSS 3.38825f ; **FLOATING
C1363 a_2019_1047.t5 VSS 0.70616f ; **FLOATING
C1364 a_2019_1047.n2 VSS 3.38825f ; **FLOATING
C1365 a_2019_1047.t6 VSS 0.70616f ; **FLOATING
C1366 a_2019_1047.n3 VSS 3.38825f ; **FLOATING
C1367 a_2019_1047.t7 VSS 0.70616f ; **FLOATING
C1368 a_2019_1047.n4 VSS 3.38825f ; **FLOATING
C1369 a_2019_1047.t8 VSS 0.70616f ; **FLOATING
C1370 a_2019_1047.n5 VSS 3.38825f ; **FLOATING
C1371 a_2019_1047.t9 VSS 5.45426f ; **FLOATING
C1372 a_2019_1047.t1 VSS 1.07246f ; **FLOATING
C1373 a_2019_1047.t0 VSS 0.30482f ; **FLOATING
C1374 a_2595_1047.t2 VSS 1.36702f ; **FLOATING
C1375 a_2595_1047.t3 VSS 1.02093f ; **FLOATING
C1376 a_2595_1047.n0 VSS 7.7612f ; **FLOATING
C1377 a_2595_1047.t4 VSS 1.02093f ; **FLOATING
C1378 a_2595_1047.n1 VSS 5.27337f ; **FLOATING
C1379 a_2595_1047.t5 VSS 1.02093f ; **FLOATING
C1380 a_2595_1047.n2 VSS 5.27337f ; **FLOATING
C1381 a_2595_1047.t6 VSS 1.02093f ; **FLOATING
C1382 a_2595_1047.n3 VSS 5.27337f ; **FLOATING
C1383 a_2595_1047.t7 VSS 1.02093f ; **FLOATING
C1384 a_2595_1047.n4 VSS 5.27337f ; **FLOATING
C1385 a_2595_1047.t8 VSS 1.02093f ; **FLOATING
C1386 a_2595_1047.n5 VSS 5.27337f ; **FLOATING
C1387 a_2595_1047.t9 VSS 1.02093f ; **FLOATING
C1388 a_2595_1047.n6 VSS 7.58543f ; **FLOATING
C1389 a_2595_1047.t1 VSS 1.75118f ; **FLOATING
C1390 a_2595_1047.t0 VSS 0.48227f ; **FLOATING
C1391 a_3171_1047.t2 VSS 1.38442f ; **FLOATING
C1392 a_3171_1047.t3 VSS 1.03733f ; **FLOATING
C1393 a_3171_1047.n0 VSS 7.77854f ; **FLOATING
C1394 a_3171_1047.t4 VSS 1.03733f ; **FLOATING
C1395 a_3171_1047.n1 VSS 5.28082f ; **FLOATING
C1396 a_3171_1047.t5 VSS 1.03733f ; **FLOATING
C1397 a_3171_1047.n2 VSS 5.28082f ; **FLOATING
C1398 a_3171_1047.t6 VSS 1.03733f ; **FLOATING
C1399 a_3171_1047.n3 VSS 5.28082f ; **FLOATING
C1400 a_3171_1047.t7 VSS 1.03733f ; **FLOATING
C1401 a_3171_1047.n4 VSS 5.28082f ; **FLOATING
C1402 a_3171_1047.t8 VSS 1.03733f ; **FLOATING
C1403 a_3171_1047.n5 VSS 5.28082f ; **FLOATING
C1404 a_3171_1047.t9 VSS 1.03733f ; **FLOATING
C1405 a_3171_1047.n6 VSS 7.68345f ; **FLOATING
C1406 a_3171_1047.t1 VSS 1.77026f ; **FLOATING
C1407 a_3171_1047.t0 VSS 0.48084f ; **FLOATING
C1408 a_3747_1047.t2 VSS 0.96886f ; **FLOATING
C1409 a_3747_1047.t3 VSS 0.73761f ; **FLOATING
C1410 a_3747_1047.n0 VSS 5.16753f ; **FLOATING
C1411 a_3747_1047.t4 VSS 0.73761f ; **FLOATING
C1412 a_3747_1047.n1 VSS 3.49318f ; **FLOATING
C1413 a_3747_1047.t5 VSS 0.73761f ; **FLOATING
C1414 a_3747_1047.n2 VSS 3.49318f ; **FLOATING
C1415 a_3747_1047.t6 VSS 0.73761f ; **FLOATING
C1416 a_3747_1047.n3 VSS 3.49318f ; **FLOATING
C1417 a_3747_1047.t7 VSS 0.73761f ; **FLOATING
C1418 a_3747_1047.n4 VSS 3.49318f ; **FLOATING
C1419 a_3747_1047.t8 VSS 0.73761f ; **FLOATING
C1420 a_3747_1047.n5 VSS 3.49318f ; **FLOATING
C1421 a_3747_1047.t9 VSS 0.73761f ; **FLOATING
C1422 a_3747_1047.n6 VSS 5.18697f ; **FLOATING
C1423 a_3747_1047.t1 VSS 1.18537f ; **FLOATING
C1424 a_3747_1047.t0 VSS 0.31338f ; **FLOATING
C1425 a_2595_311.t1 VSS 3.27037f ; **FLOATING
C1426 a_2595_311.t2 VSS 5.04145f ; **FLOATING
C1427 a_2595_311.t3 VSS 1.20632f ; **FLOATING
C1428 a_2595_311.n0 VSS 26.8668f ; **FLOATING
C1429 a_2595_311.t0 VSS 0.49572f ; **FLOATING
C1430 a_3171_311.t2 VSS 5.05009f ; **FLOATING
C1431 a_3171_311.t3 VSS 1.21149f ; **FLOATING
C1432 a_3171_311.n0 VSS 29.8499f ; **FLOATING
C1433 a_3171_311.t1 VSS 4.61154f ; **FLOATING
C1434 a_3171_311.t0 VSS 0.4973f ; **FLOATING
C1435 a_3747_311.t2 VSS 3.09213f ; **FLOATING
C1436 a_3747_311.t3 VSS 0.74425f ; **FLOATING
C1437 a_3747_311.n0 VSS 19.8892f ; **FLOATING
C1438 a_3747_311.t1 VSS 3.68905f ; **FLOATING
C1439 a_3747_311.t0 VSS 0.30538f ; **FLOATING
C1440 DELAY_VBIASP.n0 VSS 0.14472f ; **FLOATING
C1441 DELAY_VBIASP.t31 VSS 0.37059f ; **FLOATING
C1442 DELAY_VBIASP.t30 VSS 0.3623f ; **FLOATING
C1443 DELAY_VBIASP.n1 VSS 0.64924f ; **FLOATING
C1444 DELAY_VBIASP.t29 VSS 0.3623f ; **FLOATING
C1445 DELAY_VBIASP.n2 VSS 0.44929f ; **FLOATING
C1446 DELAY_VBIASP.t28 VSS 0.3623f ; **FLOATING
C1447 DELAY_VBIASP.n3 VSS 0.44929f ; **FLOATING
C1448 DELAY_VBIASP.t27 VSS 0.3623f ; **FLOATING
C1449 DELAY_VBIASP.n4 VSS 0.44929f ; **FLOATING
C1450 DELAY_VBIASP.t26 VSS 0.3623f ; **FLOATING
C1451 DELAY_VBIASP.n5 VSS 0.44929f ; **FLOATING
C1452 DELAY_VBIASP.t25 VSS 0.3623f ; **FLOATING
C1453 DELAY_VBIASP.n6 VSS 0.44929f ; **FLOATING
C1454 DELAY_VBIASP.t24 VSS 0.3623f ; **FLOATING
C1455 DELAY_VBIASP.n7 VSS 0.44929f ; **FLOATING
C1456 DELAY_VBIASP.t23 VSS 0.3623f ; **FLOATING
C1457 DELAY_VBIASP.n8 VSS 0.44929f ; **FLOATING
C1458 DELAY_VBIASP.t22 VSS 0.3623f ; **FLOATING
C1459 DELAY_VBIASP.n9 VSS 0.44929f ; **FLOATING
C1460 DELAY_VBIASP.t21 VSS 0.3623f ; **FLOATING
C1461 DELAY_VBIASP.n10 VSS 0.44929f ; **FLOATING
C1462 DELAY_VBIASP.t20 VSS 0.3623f ; **FLOATING
C1463 DELAY_VBIASP.n11 VSS 0.44929f ; **FLOATING
C1464 DELAY_VBIASP.t19 VSS 0.3623f ; **FLOATING
C1465 DELAY_VBIASP.n12 VSS 0.44929f ; **FLOATING
C1466 DELAY_VBIASP.t18 VSS 0.3623f ; **FLOATING
C1467 DELAY_VBIASP.n13 VSS 0.44929f ; **FLOATING
C1468 DELAY_VBIASP.t17 VSS 0.3623f ; **FLOATING
C1469 DELAY_VBIASP.n14 VSS 0.44929f ; **FLOATING
C1470 DELAY_VBIASP.t16 VSS 0.3623f ; **FLOATING
C1471 DELAY_VBIASP.n15 VSS 0.44929f ; **FLOATING
C1472 DELAY_VBIASP.t15 VSS 0.3623f ; **FLOATING
C1473 DELAY_VBIASP.n16 VSS 0.44929f ; **FLOATING
C1474 DELAY_VBIASP.t14 VSS 0.3623f ; **FLOATING
C1475 DELAY_VBIASP.n17 VSS 0.44929f ; **FLOATING
C1476 DELAY_VBIASP.t13 VSS 0.3623f ; **FLOATING
C1477 DELAY_VBIASP.n18 VSS 0.44929f ; **FLOATING
C1478 DELAY_VBIASP.t12 VSS 0.3623f ; **FLOATING
C1479 DELAY_VBIASP.n19 VSS 0.44929f ; **FLOATING
C1480 DELAY_VBIASP.t11 VSS 0.3623f ; **FLOATING
C1481 DELAY_VBIASP.n20 VSS 0.44929f ; **FLOATING
C1482 DELAY_VBIASP.t10 VSS 0.3623f ; **FLOATING
C1483 DELAY_VBIASP.n21 VSS 0.44929f ; **FLOATING
C1484 DELAY_VBIASP.t9 VSS 0.3623f ; **FLOATING
C1485 DELAY_VBIASP.n22 VSS 0.44929f ; **FLOATING
C1486 DELAY_VBIASP.t8 VSS 0.3623f ; **FLOATING
C1487 DELAY_VBIASP.n23 VSS 0.44929f ; **FLOATING
C1488 DELAY_VBIASP.t7 VSS 0.3623f ; **FLOATING
C1489 DELAY_VBIASP.n24 VSS 0.44929f ; **FLOATING
C1490 DELAY_VBIASP.t6 VSS 0.3623f ; **FLOATING
C1491 DELAY_VBIASP.n25 VSS 0.44929f ; **FLOATING
C1492 DELAY_VBIASP.t5 VSS 0.3623f ; **FLOATING
C1493 DELAY_VBIASP.n26 VSS 0.44929f ; **FLOATING
C1494 DELAY_VBIASP.t4 VSS 0.3623f ; **FLOATING
C1495 DELAY_VBIASP.n27 VSS 0.44929f ; **FLOATING
C1496 DELAY_VBIASP.t3 VSS 0.3623f ; **FLOATING
C1497 DELAY_VBIASP.n28 VSS 0.44929f ; **FLOATING
C1498 DELAY_VBIASP.t2 VSS 0.3623f ; **FLOATING
C1499 DELAY_VBIASP.n29 VSS 0.44929f ; **FLOATING
C1500 DELAY_VBIASP.t1 VSS 0.3623f ; **FLOATING
C1501 DELAY_VBIASP.n30 VSS 0.44929f ; **FLOATING
C1502 DELAY_VBIASP.t0 VSS 0.3623f ; **FLOATING
C1503 DELAY_VBIASN.n0 VSS 0.37704f ; **FLOATING
C1504 DELAY_VBIASN.t31 VSS 0.22493f ; **FLOATING
C1505 DELAY_VBIASN.t30 VSS 0.21834f ; **FLOATING
C1506 DELAY_VBIASN.n1 VSS 0.5167f ; **FLOATING
C1507 DELAY_VBIASN.t29 VSS 0.21834f ; **FLOATING
C1508 DELAY_VBIASN.n2 VSS 0.3584f ; **FLOATING
C1509 DELAY_VBIASN.t28 VSS 0.21834f ; **FLOATING
C1510 DELAY_VBIASN.n3 VSS 0.3584f ; **FLOATING
C1511 DELAY_VBIASN.t27 VSS 0.21834f ; **FLOATING
C1512 DELAY_VBIASN.n4 VSS 0.3584f ; **FLOATING
C1513 DELAY_VBIASN.t26 VSS 0.21834f ; **FLOATING
C1514 DELAY_VBIASN.n5 VSS 0.3584f ; **FLOATING
C1515 DELAY_VBIASN.t25 VSS 0.21834f ; **FLOATING
C1516 DELAY_VBIASN.n6 VSS 0.3584f ; **FLOATING
C1517 DELAY_VBIASN.t24 VSS 0.21834f ; **FLOATING
C1518 DELAY_VBIASN.n7 VSS 0.3584f ; **FLOATING
C1519 DELAY_VBIASN.t23 VSS 0.21834f ; **FLOATING
C1520 DELAY_VBIASN.n8 VSS 0.3584f ; **FLOATING
C1521 DELAY_VBIASN.t22 VSS 0.21834f ; **FLOATING
C1522 DELAY_VBIASN.n9 VSS 0.3584f ; **FLOATING
C1523 DELAY_VBIASN.t21 VSS 0.21834f ; **FLOATING
C1524 DELAY_VBIASN.n10 VSS 0.3584f ; **FLOATING
C1525 DELAY_VBIASN.t20 VSS 0.21834f ; **FLOATING
C1526 DELAY_VBIASN.n11 VSS 0.3584f ; **FLOATING
C1527 DELAY_VBIASN.t19 VSS 0.21834f ; **FLOATING
C1528 DELAY_VBIASN.n12 VSS 0.3584f ; **FLOATING
C1529 DELAY_VBIASN.t18 VSS 0.21834f ; **FLOATING
C1530 DELAY_VBIASN.n13 VSS 0.3584f ; **FLOATING
C1531 DELAY_VBIASN.t17 VSS 0.21834f ; **FLOATING
C1532 DELAY_VBIASN.n14 VSS 0.3584f ; **FLOATING
C1533 DELAY_VBIASN.t16 VSS 0.21834f ; **FLOATING
C1534 DELAY_VBIASN.n15 VSS 0.3584f ; **FLOATING
C1535 DELAY_VBIASN.t15 VSS 0.21834f ; **FLOATING
C1536 DELAY_VBIASN.n16 VSS 0.3584f ; **FLOATING
C1537 DELAY_VBIASN.t14 VSS 0.21834f ; **FLOATING
C1538 DELAY_VBIASN.n17 VSS 0.3584f ; **FLOATING
C1539 DELAY_VBIASN.t13 VSS 0.21834f ; **FLOATING
C1540 DELAY_VBIASN.n18 VSS 0.3584f ; **FLOATING
C1541 DELAY_VBIASN.t12 VSS 0.21834f ; **FLOATING
C1542 DELAY_VBIASN.n19 VSS 0.3584f ; **FLOATING
C1543 DELAY_VBIASN.t11 VSS 0.21834f ; **FLOATING
C1544 DELAY_VBIASN.n20 VSS 0.3584f ; **FLOATING
C1545 DELAY_VBIASN.t10 VSS 0.21834f ; **FLOATING
C1546 DELAY_VBIASN.n21 VSS 0.3584f ; **FLOATING
C1547 DELAY_VBIASN.t9 VSS 0.21834f ; **FLOATING
C1548 DELAY_VBIASN.n22 VSS 0.3584f ; **FLOATING
C1549 DELAY_VBIASN.t8 VSS 0.21834f ; **FLOATING
C1550 DELAY_VBIASN.n23 VSS 0.3584f ; **FLOATING
C1551 DELAY_VBIASN.t7 VSS 0.21834f ; **FLOATING
C1552 DELAY_VBIASN.n24 VSS 0.3584f ; **FLOATING
C1553 DELAY_VBIASN.t6 VSS 0.21834f ; **FLOATING
C1554 DELAY_VBIASN.n25 VSS 0.3584f ; **FLOATING
C1555 DELAY_VBIASN.t5 VSS 0.21834f ; **FLOATING
C1556 DELAY_VBIASN.n26 VSS 0.3584f ; **FLOATING
C1557 DELAY_VBIASN.t4 VSS 0.21834f ; **FLOATING
C1558 DELAY_VBIASN.n27 VSS 0.3584f ; **FLOATING
C1559 DELAY_VBIASN.t3 VSS 0.21834f ; **FLOATING
C1560 DELAY_VBIASN.n28 VSS 0.3584f ; **FLOATING
C1561 DELAY_VBIASN.t2 VSS 0.21834f ; **FLOATING
C1562 DELAY_VBIASN.n29 VSS 0.3584f ; **FLOATING
C1563 DELAY_VBIASN.t1 VSS 0.21834f ; **FLOATING
C1564 DELAY_VBIASN.n30 VSS 0.3584f ; **FLOATING
C1565 DELAY_VBIASN.t0 VSS 0.21834f ; **FLOATING
.ends
