* NGSPICE file created from hx_delay_line_with_mux.ext - technology: ihp-sg13g2

.subckt hx_delay_line_with_mux VSS VDD DELAY_OUT_LAST DELAY_IN MUX_SEL0 MUX_SEL1 MUX_OUT
+ MUX_SEL4 MUX_SEL2 MUX_SEL3 DELAY_VBIASN DELAY_VBIASP
X0 VDD a_4003_1842# a_4437_1842# VDD sg13_lv_pmos ad=0.2128p pd=1.5u as=0.3808p ps=2.92u w=1.12u l=0.13u
X1 VSS.t240 a_15077_1842# a_15545_1044# VSS.t515 sg13_lv_nmos ad=0.1665p pd=1.19u as=0.2516p ps=2.16u w=0.74u l=0.13u
X2 a_27915_1044# a_27705_1044# VDD VDD sg13_lv_pmos ad=0.2128p pd=1.5u as=0.252p ps=1.57u w=1.12u l=0.13u
X3 VSS.t293 VDD VSS.t291 VSS.t292 sg13_lv_nmos ad=79.8f pd=0.8u as=0 ps=0 w=0.42u l=1u
X4 a_10951_2470# a_10713_1842# a_10843_1842# VDD sg13_lv_pmos ad=0.2128p pd=1.5u as=0.3808p ps=2.92u w=1.12u l=0.2u
X5 VSS.t150 a_3171_1047.t7 a_11924_1008# VSS.t149 sg13_lv_nmos ad=0.2516p pd=2.16u as=0.2516p ps=2.16u w=0.74u l=0.13u
X6 VDD VSS.t572 VDD VDD sg13_lv_pmos ad=0.34p pd=2.68u as=0.30484n ps=1.54979m w=1u l=1u
X7 VSS.t25 a_1256_1044# a_2967_1395# VSS.t24 sg13_lv_nmos ad=0.1331p pd=1.12u as=0.1216p ps=1.02u w=0.64u l=0.13u
X8 VSS.t296 VDD VSS.t295 VSS.t294 sg13_lv_nmos ad=0.1428p pd=1.52u as=0 ps=0 w=0.42u l=1u
X9 a_25153_1842# a_24957_1842# VSS.t278 VSS.t538 sg13_lv_nmos ad=0.2516p pd=2.16u as=0.1406p ps=1.12u w=0.74u l=0.13u
X10 VDD VSS.t586 VDD VDD sg13_lv_pmos ad=0.34p pd=2.68u as=0 ps=0 w=1u l=1u
X11 a_25630_1044# a_2019_1047.t2 a_25528_1044# VSS.t199 sg13_lv_nmos ad=0.2516p pd=2.16u as=0.1406p ps=1.12u w=0.74u l=0.13u
X12 VDD DELAY_VBIASP.t11 a_19311_2470# VDD sg13_lv_pmos ad=0.3808p pd=2.92u as=0.2128p ps=1.5u w=1.12u l=0.6u
X13 a_16108_289# a_2019_311# a_16510_1044# VSS.t184 sg13_lv_nmos ad=0.2516p pd=2.16u as=0.2516p ps=2.16u w=0.74u l=0.13u
X14 VDD DELAY_VBIASP.t24 a_9431_2470# VDD sg13_lv_pmos ad=0.3808p pd=2.92u as=0.2128p ps=1.5u w=1.12u l=0.6u
X15 VSS.t361 VDD VSS.t360 VSS.t359 sg13_lv_nmos ad=0.1428p pd=1.52u as=0 ps=0 w=0.42u l=1u
X16 VDD DELAY_VBIASP.t6 a_23111_2470# VDD sg13_lv_pmos ad=0.3808p pd=2.92u as=0.2128p ps=1.5u w=1.12u l=0.6u
X17 a_7390_1044# a_8231_1008# a_8155_1044# VDD sg13_lv_pmos ad=0.3808p pd=2.92u as=0.2128p ps=1.5u w=1.12u l=0.13u
X18 VSS.t33 a_2595_311.t3 a_8745_519# VSS.t32 sg13_lv_nmos ad=0.2516p pd=2.16u as=0.2516p ps=2.16u w=0.74u l=0.13u
X19 a_17791_1842# a_17553_1842# a_17683_1842# VSS.t400 sg13_lv_nmos ad=0.1406p pd=1.12u as=0.2516p ps=2.16u w=0.74u l=0.2u
X20 VDD a_12037_1842# a_12505_1044# VDD sg13_lv_pmos ad=0.252p pd=1.57u as=0.3808p ps=2.92u w=1.12u l=0.13u
X21 a_16510_1044# a_2019_1047.t5 a_16408_1044# VSS.t113 sg13_lv_nmos ad=0.2516p pd=2.16u as=0.1406p ps=1.12u w=0.74u l=0.13u
X22 a_21591_1842# a_21353_1842# a_21483_1842# VSS.t428 sg13_lv_nmos ad=0.1406p pd=1.12u as=0.2516p ps=2.16u w=0.74u l=0.2u
X23 a_6153_1842# a_5957_1842# VSS.t403 VSS.t525 sg13_lv_nmos ad=0.2516p pd=2.16u as=0.1406p ps=1.12u w=0.74u l=0.13u
X24 VSS.t80 a_16163_1842# a_16597_1842# VSS.t226 sg13_lv_nmos ad=0.1406p pd=1.12u as=0.2516p ps=2.16u w=0.74u l=0.13u
X25 VSS.t141 a_3171_1047.t2 a_27124_1008# VSS.t140 sg13_lv_nmos ad=0.2516p pd=2.16u as=0.2516p ps=2.16u w=0.74u l=0.13u
X26 VDD a_11603_1842# a_12037_1842# VDD sg13_lv_pmos ad=0.2128p pd=1.5u as=0.3808p ps=2.92u w=1.12u l=0.13u
X27 VDD a_3171_311.t3 a_11785_519# VDD sg13_lv_pmos ad=0.3808p pd=2.92u as=0.3808p ps=2.92u w=1.12u l=0.13u
X28 a_24393_1842# a_24197_1842# VDD VDD sg13_lv_pmos ad=0.3808p pd=2.92u as=0.2128p ps=1.5u w=1.12u l=0.13u
X29 a_5731_289# a_2595_311.t3 a_7390_1044# VSS.t31 sg13_lv_nmos ad=0.2516p pd=2.16u as=0.2516p ps=2.16u w=0.74u l=0.13u
X30 a_10430_1044# a_2595_1047.t7 a_11195_1044# VSS.t58 sg13_lv_nmos ad=0.2516p pd=2.16u as=0.1406p ps=1.12u w=0.74u l=0.13u
X31 a_23355_1044# a_23145_1044# VSS.t198 VSS.t543 sg13_lv_nmos ad=0.1406p pd=1.12u as=0.1665p ps=1.19u w=0.74u l=0.13u
X32 VDD DELAY_VBIASP.t17 a_14751_2470# VDD sg13_lv_pmos ad=0.3808p pd=2.92u as=0.2128p ps=1.5u w=1.12u l=0.6u
X33 VSS.t438 DELAY_VBIASN.t23 a_10191_1842# VSS.t437 sg13_lv_nmos ad=0.2516p pd=2.16u as=0.1406p ps=1.12u w=0.74u l=0.6u
X34 VSS.t230 a_3747_1047.t4 a_21911_1008# VSS.t229 sg13_lv_nmos ad=0.2516p pd=2.16u as=0.2516p ps=2.16u w=0.74u l=0.13u
X35 VSS.t54 a_19963_1842# a_20397_1842# VSS.t425 sg13_lv_nmos ad=0.1406p pd=1.12u as=0.2516p ps=2.16u w=0.74u l=0.13u
X36 VDD DELAY_VBIASP.t31 a_4111_2470# VDD sg13_lv_pmos ad=0.3808p pd=2.92u as=0.2128p ps=1.5u w=1.12u l=0.6u
X37 a_10328_1044# a_9757_1842# VDD VDD sg13_lv_pmos ad=0.2128p pd=1.5u as=0.3808p ps=2.92u w=1.12u l=0.13u
X38 a_20968_1044# a_20397_1842# VSS.t52 VSS.t51 sg13_lv_nmos ad=0.1406p pd=1.12u as=0.2516p ps=2.16u w=0.74u l=0.13u
X39 a_22590_1044# a_22564_1008# a_22488_1044# VDD sg13_lv_pmos ad=0.3808p pd=2.92u as=0.2128p ps=1.5u w=1.12u l=0.13u
X40 VDD VSS.t589 VDD VDD sg13_lv_pmos ad=0.19p pd=1.38u as=0 ps=0 w=1u l=1u
X41 a_8808_1044# a_8237_1842# VDD VDD sg13_lv_pmos ad=0.2128p pd=1.5u as=0.3808p ps=2.92u w=1.12u l=0.13u
X42 a_4157_1313# DELAY_IN VDD VDD sg13_lv_pmos ad=0.3808p pd=2.92u as=0.3808p ps=2.92u w=1.12u l=0.13u
X43 a_17031_2470# a_16793_1842# a_16923_1842# VDD sg13_lv_pmos ad=0.2128p pd=1.5u as=0.3808p ps=2.92u w=1.12u l=0.2u
X44 a_11473_1842# a_11277_1842# VSS.t191 VSS.t190 sg13_lv_nmos ad=0.2516p pd=2.16u as=0.1406p ps=1.12u w=0.74u l=0.13u
X45 VSS.t353 VDD VSS.t351 VSS.t352 sg13_lv_nmos ad=79.8f pd=0.8u as=0 ps=0 w=0.42u l=1u
X46 a_19448_1044# a_18877_1842# VSS.t129 VSS.t128 sg13_lv_nmos ad=0.1406p pd=1.12u as=0.2516p ps=2.16u w=0.74u l=0.13u
X47 a_10430_1044# a_3171_1047.t7 a_11848_1044# VSS.t148 sg13_lv_nmos ad=0.2516p pd=2.16u as=0.1406p ps=1.12u w=0.74u l=0.13u
X48 a_20831_2470# a_20593_1842# a_20723_1842# VDD sg13_lv_pmos ad=0.2128p pd=1.5u as=0.3808p ps=2.92u w=1.12u l=0.2u
X49 VSS.t318 VDD VSS.t316 VSS.t317 sg13_lv_nmos ad=79.8f pd=0.8u as=0 ps=0 w=0.42u l=1u
X50 VDD a_27237_1842# a_27705_1044# VDD sg13_lv_pmos ad=0.252p pd=1.57u as=0.3808p ps=2.92u w=1.12u l=0.13u
X51 a_5393_1842# a_5197_1842# VDD VDD sg13_lv_pmos ad=0.3808p pd=2.92u as=0.2128p ps=1.5u w=1.12u l=0.13u
X52 VDD DELAY_VBIASP.t14 a_17031_2470# VDD sg13_lv_pmos ad=0.3808p pd=2.92u as=0.2128p ps=1.5u w=1.12u l=0.6u
X53 VDD a_26803_1842# a_27237_1842# VDD sg13_lv_pmos ad=0.2128p pd=1.5u as=0.3808p ps=2.92u w=1.12u l=0.13u
X54 VDD MUX_SEL1 a_3449_1395# VDD sg13_lv_pmos ad=0.1918p pd=1.5u as=0.1596p ps=1.22u w=0.84u l=0.13u
X55 a_25630_1044# a_2595_1047.t2 a_26395_1044# VSS.t249 sg13_lv_nmos ad=0.2516p pd=2.16u as=0.1406p ps=1.12u w=0.74u l=0.13u
X56 VSS.t442 DELAY_VBIASN.t3 a_25391_1842# VSS.t441 sg13_lv_nmos ad=0.2516p pd=2.16u as=0.1406p ps=1.12u w=0.74u l=0.6u
X57 a_6635_1044# a_6425_1044# VDD VDD sg13_lv_pmos ad=0.2128p pd=1.5u as=0.252p ps=1.57u w=1.12u l=0.13u
X58 a_20315_1044# a_20105_1044# VDD VDD sg13_lv_pmos ad=0.2128p pd=1.5u as=0.252p ps=1.57u w=1.12u l=0.13u
X59 VDD a_2595_1047.t9 a_5191_1008# VDD sg13_lv_pmos ad=0.3808p pd=2.92u as=0.3808p ps=2.92u w=1.12u l=0.13u
X60 a_19311_2470# a_19073_1842# a_19203_1842# VDD sg13_lv_pmos ad=0.2128p pd=1.5u as=0.3808p ps=2.92u w=1.12u l=0.2u
X61 VSS.t22 a_1721_1395# a_2019_1047.t1 VSS.t21 sg13_lv_nmos ad=0.2812p pd=2.24u as=0.1406p ps=1.12u w=0.74u l=0.13u
X62 a_25528_1044# a_24957_1842# VDD VDD sg13_lv_pmos ad=0.2128p pd=1.5u as=0.3808p ps=2.92u w=1.12u l=0.13u
X63 VSS.t161 a_5957_1842# a_6425_1044# VSS.t524 sg13_lv_nmos ad=0.1665p pd=1.19u as=0.2516p ps=2.16u w=0.74u l=0.13u
X64 VSS.t255 a_2019_1047.t6 a_13444_1008# VSS.t254 sg13_lv_nmos ad=0.2516p pd=2.16u as=0.2516p ps=2.16u w=0.74u l=0.13u
X65 a_23111_2470# a_22873_1842# a_23003_1842# VDD sg13_lv_pmos ad=0.2128p pd=1.5u as=0.3808p ps=2.92u w=1.12u l=0.2u
X66 VSS.t291 VDD VSS.t290 VSS.t289 sg13_lv_nmos ad=0.1428p pd=1.52u as=0 ps=0 w=0.42u l=1u
X67 VSS.t117 a_15964_289# a_16851_309# VSS.t116 sg13_lv_nmos ad=0.1371p pd=1.12u as=0.2176p ps=1.96u w=0.64u l=0.13u
X68 a_10713_1842# a_10517_1842# VDD VDD sg13_lv_pmos ad=0.3808p pd=2.92u as=0.2128p ps=1.5u w=1.12u l=0.13u
X69 VDD a_17683_1842# a_18117_1842# VDD sg13_lv_pmos ad=0.2128p pd=1.5u as=0.3808p ps=2.92u w=1.12u l=0.13u
X70 a_16108_289# a_17865_519# a_16510_1044# VDD sg13_lv_pmos ad=0.3808p pd=2.92u as=0.3808p ps=2.92u w=1.12u l=0.13u
X71 a_26673_1842# a_26477_1842# VSS.t204 VSS.t219 sg13_lv_nmos ad=0.2516p pd=2.16u as=0.1406p ps=1.12u w=0.74u l=0.13u
X72 VDD a_7803_1842# a_8237_1842# VDD sg13_lv_pmos ad=0.2128p pd=1.5u as=0.3808p ps=2.92u w=1.12u l=0.13u
X73 a_4248_1044# a_4157_1313# VSS.t235 VSS.t234 sg13_lv_nmos ad=0.1406p pd=1.12u as=0.2516p ps=2.16u w=0.74u l=0.13u
X74 a_16108_289# a_3171_311.t2 a_22590_1044# VSS.t165 sg13_lv_nmos ad=0.2516p pd=2.16u as=0.2516p ps=2.16u w=0.74u l=0.13u
X75 VSS.t454 DELAY_VBIASN.t28 a_6391_1842# VSS.t453 sg13_lv_nmos ad=0.2516p pd=2.16u as=0.1406p ps=1.12u w=0.74u l=0.6u
X76 a_16408_1044# a_15837_1842# VDD VDD sg13_lv_pmos ad=0.2128p pd=1.5u as=0.3808p ps=2.92u w=1.12u l=0.13u
X77 a_19550_1044# a_3747_1047.t4 a_21835_1044# VSS.t228 sg13_lv_nmos ad=0.2516p pd=2.16u as=0.1406p ps=1.12u w=0.74u l=0.13u
X78 VSS.t476 DELAY_VBIASN.t9 a_20831_1842# VSS.t475 sg13_lv_nmos ad=0.2516p pd=2.16u as=0.1406p ps=1.12u w=0.74u l=0.6u
X79 a_3171_311.t0 a_2873_331# VDD VDD sg13_lv_pmos ad=0.2128p pd=1.5u as=0.1918p ps=1.5u w=1.12u l=0.13u
X80 a_3747_311.t0 a_3449_331# VDD VDD sg13_lv_pmos ad=0.2128p pd=1.5u as=0.1918p ps=1.5u w=1.12u l=0.13u
X81 a_7390_1044# a_9751_1008# a_9675_1044# VDD sg13_lv_pmos ad=0.3808p pd=2.92u as=0.2128p ps=1.5u w=1.12u l=0.13u
X82 a_10191_1842# a_9953_1842# a_10083_1842# VSS.t526 sg13_lv_nmos ad=0.1406p pd=1.12u as=0.2516p ps=2.16u w=0.74u l=0.2u
X83 VSS.t198 a_22677_1842# a_23145_1044# VSS.t197 sg13_lv_nmos ad=0.1665p pd=1.19u as=0.2516p ps=2.16u w=0.74u l=0.13u
X84 a_14751_2470# a_14513_1842# a_14643_1842# VDD sg13_lv_pmos ad=0.2128p pd=1.5u as=0.3808p ps=2.92u w=1.12u l=0.2u
X85 a_5731_289# a_8745_519# a_7390_1044# VDD sg13_lv_pmos ad=0.3808p pd=2.92u as=0.3808p ps=2.92u w=1.12u l=0.13u
X86 VDD VDD VDD VDD sg13_lv_pmos ad=0.2128p pd=1.5u as=0 ps=0 w=1.12u l=0.13u
X87 a_4111_2470# DELAY_IN a_4003_1842# VDD sg13_lv_pmos ad=0.2128p pd=1.5u as=0.3808p ps=2.92u w=1.12u l=0.2u
X88 a_7673_1842# a_7477_1842# VSS.t222 VSS.t221 sg13_lv_nmos ad=0.2516p pd=2.16u as=0.1406p ps=1.12u w=0.74u l=0.13u
X89 VDD a_3171_1047.t5 a_18004_1008# VDD sg13_lv_pmos ad=0.3808p pd=2.92u as=0.3808p ps=2.92u w=1.12u l=0.13u
X90 VDD a_13123_1842# a_13557_1842# VDD sg13_lv_pmos ad=0.2128p pd=1.5u as=0.3808p ps=2.92u w=1.12u l=0.13u
X91 VDD a_3747_311.t2 a_26985_519# VDD sg13_lv_pmos ad=0.3808p pd=2.92u as=0.3808p ps=2.92u w=1.12u l=0.13u
X92 a_25913_1842# a_25717_1842# VDD VDD sg13_lv_pmos ad=0.3808p pd=2.92u as=0.2128p ps=1.5u w=1.12u l=0.13u
X93 a_10430_1044# a_3747_1047.t7 a_12715_1044# VSS.t157 sg13_lv_nmos ad=0.2516p pd=2.16u as=0.1406p ps=1.12u w=0.74u l=0.13u
X94 a_14235_1044# a_14025_1044# VDD VDD sg13_lv_pmos ad=0.2128p pd=1.5u as=0.252p ps=1.57u w=1.12u l=0.13u
X95 a_24875_1044# a_24665_1044# VSS.t91 VSS.t162 sg13_lv_nmos ad=0.1406p pd=1.12u as=0.1665p ps=1.19u w=0.74u l=0.13u
X96 VSS.t468 DELAY_VBIASN.t21 a_11711_1842# VSS.t467 sg13_lv_nmos ad=0.2516p pd=2.16u as=0.1406p ps=1.12u w=0.74u l=0.6u
X97 VDD a_3747_1047.t7 a_12791_1008# VDD sg13_lv_pmos ad=0.3808p pd=2.92u as=0.3808p ps=2.92u w=1.12u l=0.13u
X98 VSS.t30 a_2595_1047.t3 a_23431_1008# VSS.t29 sg13_lv_nmos ad=0.2516p pd=2.16u as=0.2516p ps=2.16u w=0.74u l=0.13u
X99 VSS.t42 a_21483_1842# a_21917_1842# VSS.t41 sg13_lv_nmos ad=0.1406p pd=1.12u as=0.2516p ps=2.16u w=0.74u l=0.13u
X100 VSS.t134 a_13557_1842# a_14025_1044# VSS.t406 sg13_lv_nmos ad=0.1665p pd=1.19u as=0.2516p ps=2.16u w=0.74u l=0.13u
X101 a_11848_1044# a_11277_1842# VDD VDD sg13_lv_pmos ad=0.2128p pd=1.5u as=0.3808p ps=2.92u w=1.12u l=0.13u
X102 VDD VSS.t565 VDD VDD sg13_lv_pmos ad=0.19p pd=1.38u as=0 ps=0 w=1u l=1u
X103 a_25391_1842# a_25153_1842# a_25283_1842# VSS.t65 sg13_lv_nmos ad=0.1406p pd=1.12u as=0.2516p ps=2.16u w=0.74u l=0.2u
X104 a_12993_1842# a_12797_1842# VSS.t50 VSS.t520 sg13_lv_nmos ad=0.2516p pd=2.16u as=0.1406p ps=1.12u w=0.74u l=0.13u
X105 DELAY_OUT_LAST a_27997_1842# VDD VDD sg13_lv_pmos ad=0.3808p pd=2.92u as=0.2128p ps=1.5u w=1.12u l=0.13u
X106 VDD VSS.t564 VDD VDD sg13_lv_pmos ad=0.34p pd=2.68u as=0 ps=0 w=1u l=1u
X107 VDD a_19637_1842# a_20105_1044# VDD sg13_lv_pmos ad=0.252p pd=1.57u as=0.3808p ps=2.92u w=1.12u l=0.13u
X108 VSS.t472 DELAY_VBIASN.t18 a_13991_1842# VSS.t471 sg13_lv_nmos ad=0.2516p pd=2.16u as=0.1406p ps=1.12u w=0.74u l=0.6u
X109 VSS.t351 VDD VSS.t350 VSS.t349 sg13_lv_nmos ad=0.1428p pd=1.52u as=0 ps=0 w=0.42u l=1u
X110 a_22590_1044# a_3171_1047.t3 a_24008_1044# VSS.t0 sg13_lv_nmos ad=0.2516p pd=2.16u as=0.1406p ps=1.12u w=0.74u l=0.13u
X111 a_6913_1842# a_6717_1842# VDD VDD sg13_lv_pmos ad=0.3808p pd=2.92u as=0.2128p ps=1.5u w=1.12u l=0.13u
X112 VDD DELAY_VBIASP.t12 a_18551_2470# VDD sg13_lv_pmos ad=0.3808p pd=2.92u as=0.2128p ps=1.5u w=1.12u l=0.6u
X113 VSS.t93 a_23763_1842# a_24197_1842# VSS.t560 sg13_lv_nmos ad=0.1406p pd=1.12u as=0.2516p ps=2.16u w=0.74u l=0.13u
X114 VSS.t316 VDD VSS.t315 VSS.t314 sg13_lv_nmos ad=0.1428p pd=1.52u as=0 ps=0 w=0.42u l=1u
X115 VDD a_1256_1044# a_2873_1395# VDD sg13_lv_pmos ad=0.1918p pd=1.5u as=0.1596p ps=1.22u w=0.84u l=0.13u
X116 a_3171_311.t1 a_2873_331# VSS.t40 VSS.t178 sg13_lv_nmos ad=0.1406p pd=1.12u as=0.1331p ps=1.12u w=0.74u l=0.13u
X117 VDD a_2873_331# a_3171_311.t0 VDD sg13_lv_pmos ad=0.4256p pd=3u as=0.2128p ps=1.5u w=1.12u l=0.13u
X118 a_16510_1044# a_17351_1008# a_17275_1044# VDD sg13_lv_pmos ad=0.3808p pd=2.92u as=0.2128p ps=1.5u w=1.12u l=0.13u
X119 a_25630_1044# a_3747_1047.t2 a_27915_1044# VSS.t154 sg13_lv_nmos ad=0.2516p pd=2.16u as=0.1406p ps=1.12u w=0.74u l=0.13u
X120 VSS.t446 DELAY_VBIASN.t1 a_26911_1842# VSS.t445 sg13_lv_nmos ad=0.2516p pd=2.16u as=0.1406p ps=1.12u w=0.74u l=0.6u
X121 a_3747_311.t1 a_3449_331# VSS.t73 VSS.t72 sg13_lv_nmos ad=0.1406p pd=1.12u as=0.1331p ps=1.12u w=0.74u l=0.13u
X122 VDD a_3449_331# a_3747_311.t0 VDD sg13_lv_pmos ad=0.4256p pd=3u as=0.2128p ps=1.5u w=1.12u l=0.13u
X123 VDD DELAY_VBIASP.t7 a_22351_2470# VDD sg13_lv_pmos ad=0.3808p pd=2.92u as=0.2128p ps=1.5u w=1.12u l=0.6u
X124 VDD a_3747_1047.t2 a_27991_1008# VDD sg13_lv_pmos ad=0.3808p pd=2.92u as=0.3808p ps=2.92u w=1.12u l=0.13u
X125 VDD VSS.t597 VDD VDD sg13_lv_pmos ad=0.19p pd=1.38u as=0 ps=0 w=1u l=1u
X126 VDD a_3747_1047.t9 a_6711_1008# VDD sg13_lv_pmos ad=0.3808p pd=2.92u as=0.3808p ps=2.92u w=1.12u l=0.13u
X127 a_6391_1842# a_6153_1842# a_6283_1842# VSS.t504 sg13_lv_nmos ad=0.1406p pd=1.12u as=0.2516p ps=2.16u w=0.74u l=0.2u
X128 a_15273_1842# a_15077_1842# VSS.t517 VSS.t516 sg13_lv_nmos ad=0.2516p pd=2.16u as=0.1406p ps=1.12u w=0.74u l=0.13u
X129 a_19833_1842# a_19637_1842# VDD VDD sg13_lv_pmos ad=0.3808p pd=2.92u as=0.2128p ps=1.5u w=1.12u l=0.13u
X130 a_16108_289# a_23945_519# a_22590_1044# VDD sg13_lv_pmos ad=0.3808p pd=2.92u as=0.3808p ps=2.92u w=1.12u l=0.13u
X131 a_9193_1842# a_8997_1842# VDD VDD sg13_lv_pmos ad=0.3808p pd=2.92u as=0.2128p ps=1.5u w=1.12u l=0.13u
X132 a_24631_2470# a_24393_1842# a_24523_1842# VDD sg13_lv_pmos ad=0.2128p pd=1.5u as=0.3808p ps=2.92u w=1.12u l=0.2u
X133 VSS.t276 a_15403_1842# a_15837_1842# VSS.t552 sg13_lv_nmos ad=0.1406p pd=1.12u as=0.2516p ps=2.16u w=0.74u l=0.13u
X134 a_8155_1044# a_7945_1044# VSS.t71 VSS.t70 sg13_lv_nmos ad=0.1406p pd=1.12u as=0.1665p ps=1.19u w=0.74u l=0.13u
X135 a_23633_1842# a_23437_1842# VDD VDD sg13_lv_pmos ad=0.3808p pd=2.92u as=0.2128p ps=1.5u w=1.12u l=0.13u
X136 VSS.t64 a_4763_1842# a_5197_1842# VSS.t63 sg13_lv_nmos ad=0.1406p pd=1.12u as=0.2516p ps=2.16u w=0.74u l=0.13u
X137 a_27048_1044# a_26477_1842# VSS.t218 VSS.t217 sg13_lv_nmos ad=0.1406p pd=1.12u as=0.2516p ps=2.16u w=0.74u l=0.13u
X138 VDD a_9323_1842# a_9757_1842# VDD sg13_lv_pmos ad=0.2128p pd=1.5u as=0.3808p ps=2.92u w=1.12u l=0.13u
X139 a_5768_1044# a_5197_1842# VSS.t498 VSS.t497 sg13_lv_nmos ad=0.1406p pd=1.12u as=0.2516p ps=2.16u w=0.74u l=0.13u
X140 a_7390_1044# a_7364_1008# a_7288_1044# VDD sg13_lv_pmos ad=0.3808p pd=2.92u as=0.2128p ps=1.5u w=1.12u l=0.13u
X141 VSS.t462 DELAY_VBIASN.t26 a_7911_1842# VSS.t461 sg13_lv_nmos ad=0.2516p pd=2.16u as=0.1406p ps=1.12u w=0.74u l=0.6u
X142 VDD VSS.t581 VDD VDD sg13_lv_pmos ad=0.19p pd=1.38u as=0 ps=0 w=1u l=1u
X143 a_11711_1842# a_11473_1842# a_11603_1842# VSS.t213 sg13_lv_nmos ad=0.1406p pd=1.12u as=0.2516p ps=2.16u w=0.74u l=0.2u
X144 VSS.t91 a_24197_1842# a_24665_1044# VSS.t90 sg13_lv_nmos ad=0.1665p pd=1.19u as=0.2516p ps=2.16u w=0.74u l=0.13u
X145 a_16510_1044# a_3171_1047.t5 a_17928_1044# VSS.t136 sg13_lv_nmos ad=0.2516p pd=2.16u as=0.1406p ps=1.12u w=0.74u l=0.13u
X146 VSS.t308 VDD VSS.t306 VSS.t307 sg13_lv_nmos ad=79.8f pd=0.8u as=0 ps=0 w=0.42u l=1u
X147 a_5631_2470# a_5393_1842# a_5523_1842# VDD sg13_lv_pmos ad=0.2128p pd=1.5u as=0.3808p ps=2.92u w=1.12u l=0.2u
X148 a_14513_1842# a_14317_1842# VDD VDD sg13_lv_pmos ad=0.3808p pd=2.92u as=0.2128p ps=1.5u w=1.12u l=0.13u
X149 a_4633_1842# a_4437_1842# VDD VDD sg13_lv_pmos ad=0.3808p pd=2.92u as=0.2128p ps=1.5u w=1.12u l=0.13u
X150 VSS.t393 a_10083_1842# a_10517_1842# VSS.t429 sg13_lv_nmos ad=0.1406p pd=1.12u as=0.2516p ps=2.16u w=0.74u l=0.13u
X151 VDD a_2019_1047.t4 a_19524_1008# VDD sg13_lv_pmos ad=0.3808p pd=2.92u as=0.3808p ps=2.92u w=1.12u l=0.13u
X152 VSS.t550 a_3171_1047.t4 a_21044_1008# VSS.t549 sg13_lv_nmos ad=0.2516p pd=2.16u as=0.2516p ps=2.16u w=0.74u l=0.13u
X153 VSS.t180 a_2873_331# a_3171_311.t1 VSS.t179 sg13_lv_nmos ad=0.2812p pd=2.24u as=0.1406p ps=1.12u w=0.74u l=0.13u
X154 VSS.t75 a_3449_331# a_3747_311.t1 VSS.t74 sg13_lv_nmos ad=0.2812p pd=2.24u as=0.1406p ps=1.12u w=0.74u l=0.13u
X155 a_15755_1044# a_15545_1044# VDD VDD sg13_lv_pmos ad=0.2128p pd=1.5u as=0.252p ps=1.57u w=1.12u l=0.13u
X156 VDD a_2595_1047.t6 a_14311_1008# VDD sg13_lv_pmos ad=0.3808p pd=2.92u as=0.3808p ps=2.92u w=1.12u l=0.13u
X157 VSS.t492 DELAY_VBIASN.t4 a_24631_1842# VSS.t491 sg13_lv_nmos ad=0.2516p pd=2.16u as=0.1406p ps=1.12u w=0.74u l=0.6u
X158 a_5115_1044# a_4905_1044# VDD VDD sg13_lv_pmos ad=0.2128p pd=1.5u as=0.252p ps=1.57u w=1.12u l=0.13u
X159 a_18551_2470# a_18313_1842# a_18443_1842# VDD sg13_lv_pmos ad=0.2128p pd=1.5u as=0.3808p ps=2.92u w=1.12u l=0.2u
X160 VDD VSS.t573 VDD VDD sg13_lv_pmos ad=0.19p pd=1.38u as=0 ps=0 w=1u l=1u
X161 a_3171_1047.t1 a_2873_1395# VSS.t25 VSS.t236 sg13_lv_nmos ad=0.1406p pd=1.12u as=0.1331p ps=1.12u w=0.74u l=0.13u
X162 VSS.t18 a_2297_1395# a_2595_1047.t1 VSS.t17 sg13_lv_nmos ad=0.2812p pd=2.24u as=0.1406p ps=1.12u w=0.74u l=0.13u
X163 a_22351_2470# a_22113_1842# a_22243_1842# VDD sg13_lv_pmos ad=0.2128p pd=1.5u as=0.3808p ps=2.92u w=1.12u l=0.2u
X164 VSS.t377 VSS.t374 VSS.t376 VSS.t375 sg13_lv_nmos ad=0.2516p pd=2.16u as=0 ps=0 w=0.74u l=0.13u
X165 a_26911_1842# a_26673_1842# a_26803_1842# VSS.t557 sg13_lv_nmos ad=0.1406p pd=1.12u as=0.2516p ps=2.16u w=0.74u l=0.2u
X166 VSS.t144 a_3171_311.t3 a_11785_519# VSS.t143 sg13_lv_nmos ad=0.2516p pd=2.16u as=0.2516p ps=2.16u w=0.74u l=0.13u
X167 VDD a_1721_1395# a_2019_1047.t0 VDD sg13_lv_pmos ad=0.4256p pd=3u as=0.2128p ps=1.5u w=1.12u l=0.13u
X168 VDD a_16923_1842# a_17357_1842# VDD sg13_lv_pmos ad=0.2128p pd=1.5u as=0.3808p ps=2.92u w=1.12u l=0.13u
X169 a_2391_1395# MUX_SEL0 a_2297_1395# VSS.t502 sg13_lv_nmos ad=0.1216p pd=1.02u as=0.2176p ps=1.96u w=0.64u l=0.13u
X170 VSS.t20 a_1544_1044# a_1815_1395# VSS.t542 sg13_lv_nmos ad=0.1331p pd=1.12u as=0.1216p ps=1.02u w=0.64u l=0.13u
X171 a_13368_1044# a_12797_1842# VSS.t519 VSS.t518 sg13_lv_nmos ad=0.1406p pd=1.12u as=0.2516p ps=2.16u w=0.74u l=0.13u
X172 a_5731_289# a_3171_311.t3 a_10430_1044# VSS.t142 sg13_lv_nmos ad=0.2516p pd=2.16u as=0.2516p ps=2.16u w=0.74u l=0.13u
X173 VDD a_21157_1842# a_21625_1044# VDD sg13_lv_pmos ad=0.252p pd=1.57u as=0.3808p ps=2.92u w=1.12u l=0.13u
X174 VDD DELAY_VBIASP.t22 a_10951_2470# VDD sg13_lv_pmos ad=0.3808p pd=2.92u as=0.2128p ps=1.5u w=1.12u l=0.6u
X175 VSS.t474 DELAY_VBIASN.t16 a_15511_1842# VSS.t473 sg13_lv_nmos ad=0.2516p pd=2.16u as=0.1406p ps=1.12u w=0.74u l=0.6u
X176 VDD a_20723_1842# a_21157_1842# VDD sg13_lv_pmos ad=0.2128p pd=1.5u as=0.3808p ps=2.92u w=1.12u l=0.13u
X177 VSS.t44 a_25283_1842# a_25717_1842# VSS.t43 sg13_lv_nmos ad=0.1406p pd=1.12u as=0.2516p ps=2.16u w=0.74u l=0.13u
X178 a_4350_1044# a_3747_1047.t9 a_6635_1044# VSS.t130 sg13_lv_nmos ad=0.2516p pd=2.16u as=0.1406p ps=1.12u w=0.74u l=0.13u
X179 VSS.t436 DELAY_VBIASN.t29 a_5631_1842# VSS.t435 sg13_lv_nmos ad=0.2516p pd=2.16u as=0.1406p ps=1.12u w=0.74u l=0.6u
X180 VDD a_2019_1047.t9 a_4324_1008# VDD sg13_lv_pmos ad=0.3808p pd=2.92u as=0.3808p ps=2.92u w=1.12u l=0.13u
X181 a_16510_1044# a_18871_1008# a_18795_1044# VDD sg13_lv_pmos ad=0.3808p pd=2.92u as=0.2128p ps=1.5u w=1.12u l=0.13u
X182 a_19550_1044# a_2595_1047.t4 a_20315_1044# VSS.t265 sg13_lv_nmos ad=0.2516p pd=2.16u as=0.1406p ps=1.12u w=0.74u l=0.13u
X183 VDD DELAY_VBIASP.t5 a_23871_2470# VDD sg13_lv_pmos ad=0.3808p pd=2.92u as=0.2128p ps=1.5u w=1.12u l=0.6u
X184 VSS.t71 a_7477_1842# a_7945_1044# VSS.t220 sg13_lv_nmos ad=0.1665p pd=1.19u as=0.2516p ps=2.16u w=0.74u l=0.13u
X185 a_13231_2470# a_12993_1842# a_13123_1842# VDD sg13_lv_pmos ad=0.2128p pd=1.5u as=0.3808p ps=2.92u w=1.12u l=0.2u
X186 VDD VSS.t598 VDD VDD sg13_lv_pmos ad=0.34p pd=2.68u as=0 ps=0 w=1u l=1u
X187 a_12233_1842# a_12037_1842# VDD VDD sg13_lv_pmos ad=0.3808p pd=2.92u as=0.2128p ps=1.5u w=1.12u l=0.13u
X188 a_7911_1842# a_7673_1842# a_7803_1842# VSS.t108 sg13_lv_nmos ad=0.1406p pd=1.12u as=0.2516p ps=2.16u w=0.74u l=0.2u
X189 a_16793_1842# a_16597_1842# VSS.t80 VSS.t79 sg13_lv_nmos ad=0.2516p pd=2.16u as=0.1406p ps=1.12u w=0.74u l=0.13u
X190 VDD a_3747_311.t3 a_14825_519# VDD sg13_lv_pmos ad=0.3808p pd=2.92u as=0.3808p ps=2.92u w=1.12u l=0.13u
X191 VSS.t62 a_27563_1842# a_27997_1842# VSS.t61 sg13_lv_nmos ad=0.1406p pd=1.12u as=0.2516p ps=2.16u w=0.74u l=0.13u
X192 a_9675_1044# a_9465_1044# VSS.t103 VSS.t102 sg13_lv_nmos ad=0.1406p pd=1.12u as=0.1665p ps=1.19u w=0.74u l=0.13u
X193 a_20593_1842# a_20397_1842# VSS.t54 VSS.t53 sg13_lv_nmos ad=0.2516p pd=2.16u as=0.1406p ps=1.12u w=0.74u l=0.13u
X194 VSS.t14 a_2595_1047.t8 a_8231_1008# VSS.t13 sg13_lv_nmos ad=0.2516p pd=2.16u as=0.2516p ps=2.16u w=0.74u l=0.13u
X195 VSS.t411 a_6283_1842# a_6717_1842# VSS.t410 sg13_lv_nmos ad=0.1406p pd=1.12u as=0.2516p ps=2.16u w=0.74u l=0.13u
X196 a_10430_1044# a_10404_1008# a_10328_1044# VDD sg13_lv_pmos ad=0.3808p pd=2.92u as=0.2128p ps=1.5u w=1.12u l=0.13u
X197 VDD DELAY_VBIASP.t2 a_26151_2470# VDD sg13_lv_pmos ad=0.3808p pd=2.92u as=0.2128p ps=1.5u w=1.12u l=0.6u
X198 a_7390_1044# a_8884_1008# a_8808_1044# VDD sg13_lv_pmos ad=0.3808p pd=2.92u as=0.2128p ps=1.5u w=1.12u l=0.13u
X199 VDD DELAY_VBIASP.t30 a_4871_2470# VDD sg13_lv_pmos ad=0.3808p pd=2.92u as=0.2128p ps=1.5u w=1.12u l=0.6u
X200 a_3449_331# MUX_SEL2 VDD VDD sg13_lv_pmos ad=0.1596p pd=1.22u as=0.2856p ps=2.36u w=0.84u l=0.13u
X201 VDD VSS.t575 VDD VDD sg13_lv_pmos ad=0.19p pd=1.38u as=0 ps=0 w=1u l=1u
X202 a_19073_1842# a_18877_1842# VSS.t127 VSS.t126 sg13_lv_nmos ad=0.2516p pd=2.16u as=0.1406p ps=1.12u w=0.74u l=0.13u
X203 VDD a_15077_1842# a_15545_1044# VDD sg13_lv_pmos ad=0.252p pd=1.57u as=0.3808p ps=2.92u w=1.12u l=0.13u
X204 a_19550_1044# a_2019_1047.t4 a_19448_1044# VSS.t262 sg13_lv_nmos ad=0.2516p pd=2.16u as=0.1406p ps=1.12u w=0.74u l=0.13u
X205 VDD VDD VDD VDD sg13_lv_pmos ad=0.3808p pd=2.92u as=0 ps=0 w=1.12u l=0.6u
X206 VSS.t368 VDD VSS.t366 VSS.t367 sg13_lv_nmos ad=79.8f pd=0.8u as=0 ps=0 w=0.42u l=1u
X207 VSS.t280 a_19203_1842# a_19637_1842# VSS.t279 sg13_lv_nmos ad=0.1406p pd=1.12u as=0.2516p ps=2.16u w=0.74u l=0.13u
X208 VDD VSS.t577 VDD VDD sg13_lv_pmos ad=0.19p pd=1.38u as=0 ps=0 w=1u l=1u
X209 VDD VSS.t588 VDD VDD sg13_lv_pmos ad=0.34p pd=2.68u as=0 ps=0 w=1u l=1u
X210 a_27433_1842# a_27237_1842# VDD VDD sg13_lv_pmos ad=0.3808p pd=2.92u as=0.2128p ps=1.5u w=1.12u l=0.13u
X211 VDD a_1256_289# a_2873_331# VDD sg13_lv_pmos ad=0.1918p pd=1.5u as=0.1596p ps=1.22u w=0.84u l=0.13u
X212 a_13470_1044# a_2595_1047.t6 a_14235_1044# VSS.t151 sg13_lv_nmos ad=0.2516p pd=2.16u as=0.1406p ps=1.12u w=0.74u l=0.13u
X213 VSS.t225 a_8563_1842# a_8997_1842# VSS.t224 sg13_lv_nmos ad=0.1406p pd=1.12u as=0.2516p ps=2.16u w=0.74u l=0.13u
X214 VSS.t470 DELAY_VBIASN.t19 a_13231_1842# VSS.t469 sg13_lv_nmos ad=0.2516p pd=2.16u as=0.1406p ps=1.12u w=0.74u l=0.6u
X215 VDD a_3171_1047.t7 a_11924_1008# VDD sg13_lv_pmos ad=0.3808p pd=2.92u as=0.3808p ps=2.92u w=1.12u l=0.13u
X216 VSS.t258 a_2019_1047.t3 a_22564_1008# VSS.t257 sg13_lv_nmos ad=0.2516p pd=2.16u as=0.2516p ps=2.16u w=0.74u l=0.13u
X217 VSS.t112 a_23003_1842# a_23437_1842# VSS.t208 sg13_lv_nmos ad=0.1406p pd=1.12u as=0.2516p ps=2.16u w=0.74u l=0.13u
X218 VSS.t371 VDD VSS.t370 VSS.t369 sg13_lv_nmos ad=0.1428p pd=1.52u as=0 ps=0 w=0.42u l=1u
X219 VDD DELAY_VBIASP.t27 a_7151_2470# VDD sg13_lv_pmos ad=0.3808p pd=2.92u as=0.2128p ps=1.5u w=1.12u l=0.6u
X220 a_25630_1044# a_25604_1008# a_25528_1044# VDD sg13_lv_pmos ad=0.3808p pd=2.92u as=0.2128p ps=1.5u w=1.12u l=0.13u
X221 a_15511_1842# a_15273_1842# a_15403_1842# VSS.t412 sg13_lv_nmos ad=0.1406p pd=1.12u as=0.2516p ps=2.16u w=0.74u l=0.2u
X222 a_18313_1842# a_18117_1842# VDD VDD sg13_lv_pmos ad=0.3808p pd=2.92u as=0.2128p ps=1.5u w=1.12u l=0.13u
X223 a_5731_289# a_11785_519# a_10430_1044# VDD sg13_lv_pmos ad=0.3808p pd=2.92u as=0.3808p ps=2.92u w=1.12u l=0.13u
X224 VSS.t288 VDD VSS.t286 VSS.t287 sg13_lv_nmos ad=79.8f pd=0.8u as=0 ps=0 w=0.42u l=1u
X225 a_9431_2470# a_9193_1842# a_9323_1842# VDD sg13_lv_pmos ad=0.2128p pd=1.5u as=0.3808p ps=2.92u w=1.12u l=0.2u
X226 a_17275_1044# a_17065_1044# VSS.t78 VSS.t246 sg13_lv_nmos ad=0.1406p pd=1.12u as=0.1665p ps=1.19u w=0.74u l=0.13u
X227 VDD VSS.t574 VDD VDD sg13_lv_pmos ad=0.34p pd=2.68u as=0 ps=0 w=1u l=1u
X228 VSS.t5 a_3747_1047.t6 a_15831_1008# VSS.t4 sg13_lv_nmos ad=0.2516p pd=2.16u as=0.2516p ps=2.16u w=0.74u l=0.13u
X229 a_23871_2470# a_23633_1842# a_23763_1842# VDD sg13_lv_pmos ad=0.2128p pd=1.5u as=0.3808p ps=2.92u w=1.12u l=0.2u
X230 VSS.t420 a_13883_1842# a_14317_1842# VSS.t544 sg13_lv_nmos ad=0.1406p pd=1.12u as=0.2516p ps=2.16u w=0.74u l=0.13u
X231 VSS.t83 a_3747_311.t2 a_26985_519# VSS.t82 sg13_lv_nmos ad=0.2516p pd=2.16u as=0.2516p ps=2.16u w=0.74u l=0.13u
X232 a_8433_1842# a_8237_1842# VDD VDD sg13_lv_pmos ad=0.3808p pd=2.92u as=0.2128p ps=1.5u w=1.12u l=0.13u
X233 VDD a_18443_1842# a_18877_1842# VDD sg13_lv_pmos ad=0.2128p pd=1.5u as=0.3808p ps=2.92u w=1.12u l=0.13u
X234 a_22113_1842# a_21917_1842# VDD VDD sg13_lv_pmos ad=0.3808p pd=2.92u as=0.2128p ps=1.5u w=1.12u l=0.13u
X235 a_4350_1044# a_2019_1047.t9 a_4248_1044# VSS.t545 sg13_lv_nmos ad=0.2516p pd=2.16u as=0.1406p ps=1.12u w=0.74u l=0.13u
X236 a_14888_1044# a_14317_1842# VSS.t418 VSS.t417 sg13_lv_nmos ad=0.1406p pd=1.12u as=0.2516p ps=2.16u w=0.74u l=0.13u
X237 a_16108_289# a_3747_311.t2 a_25630_1044# VSS.t81 sg13_lv_nmos ad=0.2516p pd=2.16u as=0.2516p ps=2.16u w=0.74u l=0.13u
X238 VDD DELAY_VBIASP.t20 a_12471_2470# VDD sg13_lv_pmos ad=0.3808p pd=2.92u as=0.2128p ps=1.5u w=1.12u l=0.6u
X239 VSS.t207 a_4003_1842# a_4437_1842# VSS.t223 sg13_lv_nmos ad=0.1406p pd=1.12u as=0.2516p ps=2.16u w=0.74u l=0.13u
X240 a_16510_1044# a_16484_1008# a_16408_1044# VDD sg13_lv_pmos ad=0.3808p pd=2.92u as=0.2128p ps=1.5u w=1.12u l=0.13u
X241 VDD a_22243_1842# a_22677_1842# VDD sg13_lv_pmos ad=0.2128p pd=1.5u as=0.3808p ps=2.92u w=1.12u l=0.13u
X242 VDD a_3171_1047.t2 a_27124_1008# VDD sg13_lv_pmos ad=0.3808p pd=2.92u as=0.3808p ps=2.92u w=1.12u l=0.13u
X243 VDD MUX_SEL3 a_3449_331# VDD sg13_lv_pmos ad=0.1918p pd=1.5u as=0.1596p ps=1.22u w=0.84u l=0.13u
X244 a_2595_311.t0 a_2297_331# VDD VDD sg13_lv_pmos ad=0.2128p pd=1.5u as=0.1918p ps=1.5u w=1.12u l=0.13u
X245 a_10430_1044# a_11271_1008# a_11195_1044# VDD sg13_lv_pmos ad=0.3808p pd=2.92u as=0.2128p ps=1.5u w=1.12u l=0.13u
X246 a_23355_1044# a_23145_1044# VDD VDD sg13_lv_pmos ad=0.2128p pd=1.5u as=0.252p ps=1.57u w=1.12u l=0.13u
X247 VDD a_3747_1047.t4 a_21911_1008# VDD sg13_lv_pmos ad=0.3808p pd=2.92u as=0.3808p ps=2.92u w=1.12u l=0.13u
X248 VSS.t103 a_8997_1842# a_9465_1044# VSS.t535 sg13_lv_nmos ad=0.1665p pd=1.19u as=0.2516p ps=2.16u w=0.74u l=0.13u
X249 a_20968_1044# a_20397_1842# VDD VDD sg13_lv_pmos ad=0.2128p pd=1.5u as=0.3808p ps=2.92u w=1.12u l=0.13u
X250 a_10951_1842# a_10713_1842# a_10843_1842# VSS.t505 sg13_lv_nmos ad=0.1406p pd=1.12u as=0.2516p ps=2.16u w=0.74u l=0.2u
X251 VSS.t115 a_2019_1047.t5 a_16484_1008# VSS.t114 sg13_lv_nmos ad=0.2516p pd=2.16u as=0.2516p ps=2.16u w=0.74u l=0.13u
X252 a_26151_2470# a_25913_1842# a_26043_1842# VDD sg13_lv_pmos ad=0.2128p pd=1.5u as=0.3808p ps=2.92u w=1.12u l=0.2u
X253 a_13753_1842# a_13557_1842# VDD VDD sg13_lv_pmos ad=0.3808p pd=2.92u as=0.2128p ps=1.5u w=1.12u l=0.13u
X254 VDD a_1721_331# a_2019_311# VDD sg13_lv_pmos ad=0.4256p pd=3u as=0.2128p ps=1.5u w=1.12u l=0.13u
X255 a_4871_2470# a_4633_1842# a_4763_1842# VDD sg13_lv_pmos ad=0.2128p pd=1.5u as=0.3808p ps=2.92u w=1.12u l=0.2u
X256 VSS.t97 a_3171_1047.t9 a_5844_1008# VSS.t96 sg13_lv_nmos ad=0.2516p pd=2.16u as=0.2516p ps=2.16u w=0.74u l=0.13u
X257 VSS.t328 VDD VSS.t326 VSS.t327 sg13_lv_nmos ad=79.8f pd=0.8u as=0 ps=0 w=0.42u l=1u
X258 VDD a_2595_311.t2 a_20905_519# VDD sg13_lv_pmos ad=0.3808p pd=2.92u as=0.3808p ps=2.92u w=1.12u l=0.13u
X259 VDD a_2297_331# a_2595_311.t0 VDD sg13_lv_pmos ad=0.4256p pd=3u as=0.2128p ps=1.5u w=1.12u l=0.13u
X260 VSS.t60 a_2595_1047.t7 a_11271_1008# VSS.t59 sg13_lv_nmos ad=0.2516p pd=2.16u as=0.2516p ps=2.16u w=0.74u l=0.13u
X261 VSS.t484 DELAY_VBIASN.t11 a_19311_1842# VSS.t483 sg13_lv_nmos ad=0.2516p pd=2.16u as=0.1406p ps=1.12u w=0.74u l=0.6u
X262 VDD a_24523_1842# a_24957_1842# VDD sg13_lv_pmos ad=0.2128p pd=1.5u as=0.3808p ps=2.92u w=1.12u l=0.13u
X263 VSS.t270 a_3747_1047.t8 a_9751_1008# VSS.t269 sg13_lv_nmos ad=0.2516p pd=2.16u as=0.2516p ps=2.16u w=0.74u l=0.13u
X264 VSS.t464 DELAY_VBIASN.t24 a_9431_1842# VSS.t463 sg13_lv_nmos ad=0.2516p pd=2.16u as=0.1406p ps=1.12u w=0.74u l=0.6u
X265 a_19448_1044# a_18877_1842# VDD VDD sg13_lv_pmos ad=0.2128p pd=1.5u as=0.3808p ps=2.92u w=1.12u l=0.13u
X266 VSS.t440 DELAY_VBIASN.t6 a_23111_1842# VSS.t439 sg13_lv_nmos ad=0.2516p pd=2.16u as=0.1406p ps=1.12u w=0.74u l=0.6u
X267 a_10430_1044# a_11924_1008# a_11848_1044# VDD sg13_lv_pmos ad=0.3808p pd=2.92u as=0.2128p ps=1.5u w=1.12u l=0.13u
X268 VDD DELAY_VBIASP.t0 a_27671_2470# VDD sg13_lv_pmos ad=0.3808p pd=2.92u as=0.2128p ps=1.5u w=1.12u l=0.6u
X269 a_25630_1044# a_26471_1008# a_26395_1044# VDD sg13_lv_pmos ad=0.3808p pd=2.92u as=0.2128p ps=1.5u w=1.12u l=0.13u
X270 a_7151_2470# a_6913_1842# a_7043_1842# VDD sg13_lv_pmos ad=0.2128p pd=1.5u as=0.3808p ps=2.92u w=1.12u l=0.2u
X271 a_16033_1842# a_15837_1842# VDD VDD sg13_lv_pmos ad=0.3808p pd=2.92u as=0.2128p ps=1.5u w=1.12u l=0.13u
X272 VDD a_15964_289# a_16851_309# VDD sg13_lv_pmos ad=0.2086p pd=1.5u as=0.34p ps=2.68u w=1u l=0.13u
X273 VDD VSS.t576 VDD VDD sg13_lv_pmos ad=0.34p pd=2.68u as=0 ps=0 w=1u l=1u
X274 VSS.t511 a_11603_1842# a_12037_1842# VSS.t522 sg13_lv_nmos ad=0.1406p pd=1.12u as=0.2516p ps=2.16u w=0.74u l=0.13u
X275 VSS.t348 VDD VSS.t346 VSS.t347 sg13_lv_nmos ad=79.8f pd=0.8u as=0 ps=0 w=0.42u l=1u
X276 VDD VSS.t590 VDD VDD sg13_lv_pmos ad=0.34p pd=2.68u as=0 ps=0 w=1u l=1u
X277 VDD a_5957_1842# a_6425_1044# VDD sg13_lv_pmos ad=0.252p pd=1.57u as=0.3808p ps=2.92u w=1.12u l=0.13u
X278 a_24393_1842# a_24197_1842# VSS.t93 VSS.t92 sg13_lv_nmos ad=0.2516p pd=2.16u as=0.1406p ps=1.12u w=0.74u l=0.13u
X279 a_3747_1047.t1 a_3449_1395# VSS.t99 VSS.t98 sg13_lv_nmos ad=0.1406p pd=1.12u as=0.1331p ps=1.12u w=0.74u l=0.13u
X280 a_1544_1044# MUX_SEL1 VSS.t528 VSS.t527 sg13_lv_nmos ad=0.2516p pd=2.16u as=0.2516p ps=2.16u w=0.74u l=0.13u
X281 VDD VSS.t578 VDD VDD sg13_lv_pmos ad=0.34p pd=2.68u as=0 ps=0 w=1u l=1u
X282 a_3171_1047.t0 a_2873_1395# VDD VDD sg13_lv_pmos ad=0.2128p pd=1.5u as=0.1918p ps=1.5u w=1.12u l=0.13u
X283 a_13470_1044# a_3747_1047.t6 a_15755_1044# VSS.t3 sg13_lv_nmos ad=0.2516p pd=2.16u as=0.1406p ps=1.12u w=0.74u l=0.13u
X284 VDD a_5523_1842# a_5957_1842# VDD sg13_lv_pmos ad=0.2128p pd=1.5u as=0.3808p ps=2.92u w=1.12u l=0.13u
X285 VDD a_2297_1395# a_2595_1047.t0 VDD sg13_lv_pmos ad=0.4256p pd=3u as=0.2128p ps=1.5u w=1.12u l=0.13u
X286 VSS.t478 DELAY_VBIASN.t17 a_14751_1842# VSS.t477 sg13_lv_nmos ad=0.2516p pd=2.16u as=0.1406p ps=1.12u w=0.74u l=0.6u
X287 a_2967_1395# MUX_SEL1 a_2873_1395# VSS.t529 sg13_lv_nmos ad=0.1216p pd=1.02u as=0.2176p ps=1.96u w=0.64u l=0.13u
X288 a_4350_1044# a_2595_1047.t9 a_5115_1044# VSS.t104 sg13_lv_nmos ad=0.2516p pd=2.16u as=0.1406p ps=1.12u w=0.74u l=0.13u
X289 VDD a_2019_1047.t6 a_13444_1008# VDD sg13_lv_pmos ad=0.3808p pd=2.92u as=0.3808p ps=2.92u w=1.12u l=0.13u
X290 VSS.t251 a_2595_1047.t2 a_26471_1008# VSS.t250 sg13_lv_nmos ad=0.2516p pd=2.16u as=0.2516p ps=2.16u w=0.74u l=0.13u
X291 a_2595_311.t1 a_2297_331# VSS.t169 VSS.t168 sg13_lv_nmos ad=0.1406p pd=1.12u as=0.1331p ps=1.12u w=0.74u l=0.13u
X292 VSS.t450 DELAY_VBIASN.t31 a_4111_1842# VSS.t449 sg13_lv_nmos ad=0.2516p pd=2.16u as=0.1406p ps=1.12u w=0.74u l=0.6u
X293 a_2297_1395# MUX_SEL0 VDD VDD sg13_lv_pmos ad=0.1596p pd=1.22u as=0.2856p ps=2.36u w=0.84u l=0.13u
X294 VSS.t78 a_16597_1842# a_17065_1044# VSS.t77 sg13_lv_nmos ad=0.1665p pd=1.19u as=0.2516p ps=2.16u w=0.74u l=0.13u
X295 VDD DELAY_VBIASP.t25 a_8671_2470# VDD sg13_lv_pmos ad=0.3808p pd=2.92u as=0.2128p ps=1.5u w=1.12u l=0.6u
X296 VDD VSS.t591 VDD VDD sg13_lv_pmos ad=0.19p pd=1.38u as=0 ps=0 w=1u l=1u
X297 VDD a_1544_1044# a_1721_1395# VDD sg13_lv_pmos ad=0.1918p pd=1.5u as=0.1596p ps=1.22u w=0.84u l=0.13u
X298 a_4248_1044# a_4157_1313# VDD VDD sg13_lv_pmos ad=0.2128p pd=1.5u as=0.3808p ps=2.92u w=1.12u l=0.13u
X299 a_12471_2470# a_12233_1842# a_12363_1842# VDD sg13_lv_pmos ad=0.2128p pd=1.5u as=0.3808p ps=2.92u w=1.12u l=0.2u
X300 a_17031_1842# a_16793_1842# a_16923_1842# VSS.t398 sg13_lv_nmos ad=0.1406p pd=1.12u as=0.2516p ps=2.16u w=0.74u l=0.2u
X301 VSS.t175 a_1721_331# a_2019_311# VSS.t174 sg13_lv_nmos ad=0.2812p pd=2.24u as=0.1406p ps=1.12u w=0.74u l=0.13u
X302 a_19550_1044# a_21911_1008# a_21835_1044# VDD sg13_lv_pmos ad=0.3808p pd=2.92u as=0.2128p ps=1.5u w=1.12u l=0.13u
X303 a_16108_289# a_26985_519# a_25630_1044# VDD sg13_lv_pmos ad=0.3808p pd=2.92u as=0.3808p ps=2.92u w=1.12u l=0.13u
X304 VSS.t171 a_2297_331# a_2595_311.t1 VSS.t170 sg13_lv_nmos ad=0.2812p pd=2.24u as=0.1406p ps=1.12u w=0.74u l=0.13u
X305 a_18795_1044# a_18585_1044# VSS.t48 VSS.t531 sg13_lv_nmos ad=0.1406p pd=1.12u as=0.1665p ps=1.19u w=0.74u l=0.13u
X306 a_20831_1842# a_20593_1842# a_20723_1842# VSS.t553 sg13_lv_nmos ad=0.1406p pd=1.12u as=0.2516p ps=2.16u w=0.74u l=0.2u
X307 VSS.t286 VDD VSS.t285 VSS.t284 sg13_lv_nmos ad=0.1428p pd=1.52u as=0 ps=0 w=0.42u l=1u
X308 VDD a_22677_1842# a_23145_1044# VDD sg13_lv_pmos ad=0.252p pd=1.57u as=0.3808p ps=2.92u w=1.12u l=0.13u
X309 VSS.t11 a_2595_1047.t5 a_17351_1008# VSS.t10 sg13_lv_nmos ad=0.2516p pd=2.16u as=0.2516p ps=2.16u w=0.74u l=0.13u
X310 a_5393_1842# a_5197_1842# VSS.t64 VSS.t499 sg13_lv_nmos ad=0.2516p pd=2.16u as=0.1406p ps=1.12u w=0.74u l=0.13u
X311 VSS.t486 DELAY_VBIASN.t14 a_17031_1842# VSS.t485 sg13_lv_nmos ad=0.2516p pd=2.16u as=0.1406p ps=1.12u w=0.74u l=0.6u
X312 a_25630_1044# a_3171_1047.t2 a_27048_1044# VSS.t139 sg13_lv_nmos ad=0.2516p pd=2.16u as=0.1406p ps=1.12u w=0.74u l=0.13u
X313 a_9953_1842# a_9757_1842# VDD VDD sg13_lv_pmos ad=0.3808p pd=2.92u as=0.2128p ps=1.5u w=1.12u l=0.13u
X314 VDD a_10843_1842# a_11277_1842# VDD sg13_lv_pmos ad=0.2128p pd=1.5u as=0.3808p ps=2.92u w=1.12u l=0.13u
X315 VSS.t123 a_26803_1842# a_27237_1842# VSS.t202 sg13_lv_nmos ad=0.1406p pd=1.12u as=0.2516p ps=2.16u w=0.74u l=0.13u
X316 a_4350_1044# a_3171_1047.t9 a_5768_1044# VSS.t95 sg13_lv_nmos ad=0.2516p pd=2.16u as=0.1406p ps=1.12u w=0.74u l=0.13u
X317 a_10430_1044# a_12791_1008# a_12715_1044# VDD sg13_lv_pmos ad=0.3808p pd=2.92u as=0.2128p ps=1.5u w=1.12u l=0.13u
X318 a_19311_1842# a_19073_1842# a_19203_1842# VSS.t496 sg13_lv_nmos ad=0.1406p pd=1.12u as=0.2516p ps=2.16u w=0.74u l=0.2u
X319 a_24875_1044# a_24665_1044# VDD VDD sg13_lv_pmos ad=0.2128p pd=1.5u as=0.252p ps=1.57u w=1.12u l=0.13u
X320 VDD a_2595_1047.t3 a_23431_1008# VDD sg13_lv_pmos ad=0.3808p pd=2.92u as=0.3808p ps=2.92u w=1.12u l=0.13u
X321 VDD a_13557_1842# a_14025_1044# VDD sg13_lv_pmos ad=0.252p pd=1.57u as=0.3808p ps=2.92u w=1.12u l=0.13u
X322 a_23111_1842# a_22873_1842# a_23003_1842# VSS.t76 sg13_lv_nmos ad=0.1406p pd=1.12u as=0.2516p ps=2.16u w=0.74u l=0.2u
X323 a_27671_2470# a_27433_1842# a_27563_1842# VDD sg13_lv_pmos ad=0.2128p pd=1.5u as=0.3808p ps=2.92u w=1.12u l=0.2u
X324 VSS.t46 a_17683_1842# a_18117_1842# VSS.t121 sg13_lv_nmos ad=0.1406p pd=1.12u as=0.2516p ps=2.16u w=0.74u l=0.13u
X325 VSS.t343 VDD VSS.t341 VSS.t342 sg13_lv_nmos ad=79.8f pd=0.8u as=0 ps=0 w=0.42u l=1u
X326 a_10713_1842# a_10517_1842# VSS.t393 VSS.t392 sg13_lv_nmos ad=0.2516p pd=2.16u as=0.1406p ps=1.12u w=0.74u l=0.13u
X327 VSS.t245 a_2019_1047.t8 a_7364_1008# VSS.t244 sg13_lv_nmos ad=0.2516p pd=2.16u as=0.2516p ps=2.16u w=0.74u l=0.13u
X328 VSS.t424 a_7803_1842# a_8237_1842# VSS.t555 sg13_lv_nmos ad=0.1406p pd=1.12u as=0.2516p ps=2.16u w=0.74u l=0.13u
X329 VDD DELAY_VBIASP.t15 a_16271_2470# VDD sg13_lv_pmos ad=0.3808p pd=2.92u as=0.2128p ps=1.5u w=1.12u l=0.6u
X330 VSS.t338 VDD VSS.t336 VSS.t337 sg13_lv_nmos ad=79.8f pd=0.8u as=0 ps=0 w=0.42u l=1u
X331 VSS.t311 VDD VSS.t310 VSS.t309 sg13_lv_nmos ad=0.1428p pd=1.52u as=0 ps=0 w=0.42u l=1u
X332 VDD a_26043_1842# a_26477_1842# VDD sg13_lv_pmos ad=0.2128p pd=1.5u as=0.3808p ps=2.92u w=1.12u l=0.13u
X333 a_3543_331# MUX_SEL2 a_3449_331# VSS.t397 sg13_lv_nmos ad=0.1216p pd=1.02u as=0.2176p ps=1.96u w=0.64u l=0.13u
X334 a_22488_1044# a_21917_1842# VSS.t88 VSS.t87 sg13_lv_nmos ad=0.1406p pd=1.12u as=0.2516p ps=2.16u w=0.74u l=0.13u
X335 VDD VSS.t593 VDD VDD sg13_lv_pmos ad=0.19p pd=1.38u as=0 ps=0 w=1u l=1u
X336 a_22590_1044# a_24084_1008# a_24008_1044# VDD sg13_lv_pmos ad=0.3808p pd=2.92u as=0.2128p ps=1.5u w=1.12u l=0.13u
X337 VDD DELAY_VBIASP.t10 a_20071_2470# VDD sg13_lv_pmos ad=0.3808p pd=2.92u as=0.2128p ps=1.5u w=1.12u l=0.6u
X338 a_14751_1842# a_14513_1842# a_14643_1842# VSS.t430 sg13_lv_nmos ad=0.1406p pd=1.12u as=0.2516p ps=2.16u w=0.74u l=0.2u
X339 VSS.t238 a_2873_1395# a_3171_1047.t1 VSS.t237 sg13_lv_nmos ad=0.2812p pd=2.24u as=0.1406p ps=1.12u w=0.74u l=0.13u
X340 VDD VSS.t567 VDD VDD sg13_lv_pmos ad=0.19p pd=1.38u as=0 ps=0 w=1u l=1u
X341 a_25630_1044# a_27991_1008# a_27915_1044# VDD sg13_lv_pmos ad=0.3808p pd=2.92u as=0.2128p ps=1.5u w=1.12u l=0.13u
X342 VSS.t380 VSS.t378 VSS.t376 VSS.t379 sg13_lv_nmos ad=0.1406p pd=1.12u as=0 ps=0 w=0.74u l=0.13u
X343 a_4111_1842# DELAY_IN a_4003_1842# VSS.t281 sg13_lv_nmos ad=0.1406p pd=1.12u as=0.2516p ps=2.16u w=0.74u l=0.2u
X344 a_8671_2470# a_8433_1842# a_8563_1842# VDD sg13_lv_pmos ad=0.2128p pd=1.5u as=0.3808p ps=2.92u w=1.12u l=0.2u
X345 a_17553_1842# a_17357_1842# VDD VDD sg13_lv_pmos ad=0.3808p pd=2.92u as=0.2128p ps=1.5u w=1.12u l=0.13u
X346 VSS.t16 a_1544_1044# a_2391_1395# VSS.t541 sg13_lv_nmos ad=0.1331p pd=1.12u as=0.1216p ps=1.02u w=0.64u l=0.13u
X347 VSS.t211 a_3747_311.t3 a_14825_519# VSS.t210 sg13_lv_nmos ad=0.2516p pd=2.16u as=0.2516p ps=2.16u w=0.74u l=0.13u
X348 VSS.t40 a_1256_289# a_2967_331# VSS.t39 sg13_lv_nmos ad=0.1331p pd=1.12u as=0.1216p ps=1.02u w=0.64u l=0.13u
X349 a_2019_1047.t1 a_1721_1395# VSS.t20 VSS.t19 sg13_lv_nmos ad=0.1406p pd=1.12u as=0.1331p ps=1.12u w=0.74u l=0.13u
X350 a_15964_289# a_15765_463# a_5731_289# VSS.t551 sg13_lv_nmos ad=0.2183p pd=1.33u as=0.2516p ps=2.16u w=0.74u l=0.13u
X351 a_13470_1044# a_2019_1047.t6 a_13368_1044# VSS.t253 sg13_lv_nmos ad=0.2516p pd=2.16u as=0.1406p ps=1.12u w=0.74u l=0.13u
X352 VSS.t408 a_13123_1842# a_13557_1842# VSS.t554 sg13_lv_nmos ad=0.1406p pd=1.12u as=0.2516p ps=2.16u w=0.74u l=0.13u
X353 VDD VSS.t566 VDD VDD sg13_lv_pmos ad=0.34p pd=2.68u as=0 ps=0 w=1u l=1u
X354 VSS.t2 a_3171_1047.t3 a_24084_1008# VSS.t1 sg13_lv_nmos ad=0.2516p pd=2.16u as=0.2516p ps=2.16u w=0.74u l=0.13u
X355 a_25913_1842# a_25717_1842# VSS.t44 VSS.t272 sg13_lv_nmos ad=0.2516p pd=2.16u as=0.1406p ps=1.12u w=0.74u l=0.13u
X356 a_21353_1842# a_21157_1842# VDD VDD sg13_lv_pmos ad=0.3808p pd=2.92u as=0.2128p ps=1.5u w=1.12u l=0.13u
X357 VSS.t346 VDD VSS.t345 VSS.t344 sg13_lv_nmos ad=0.1428p pd=1.52u as=0 ps=0 w=0.42u l=1u
X358 a_2297_331# MUX_SEL2 VDD VDD sg13_lv_pmos ad=0.1596p pd=1.22u as=0.2856p ps=2.36u w=0.84u l=0.13u
X359 VDD a_7043_1842# a_7477_1842# VDD sg13_lv_pmos ad=0.2128p pd=1.5u as=0.3808p ps=2.92u w=1.12u l=0.13u
X360 a_2873_331# MUX_SEL3 VDD VDD sg13_lv_pmos ad=0.1596p pd=1.22u as=0.2856p ps=2.36u w=0.84u l=0.13u
X361 a_8155_1044# a_7945_1044# VDD VDD sg13_lv_pmos ad=0.2128p pd=1.5u as=0.252p ps=1.57u w=1.12u l=0.13u
X362 VSS.t48 a_18117_1842# a_18585_1044# VSS.t47 sg13_lv_nmos ad=0.1665p pd=1.19u as=0.2516p ps=2.16u w=0.74u l=0.13u
X363 a_27048_1044# a_26477_1842# VDD VDD sg13_lv_pmos ad=0.2128p pd=1.5u as=0.3808p ps=2.92u w=1.12u l=0.13u
X364 a_5768_1044# a_5197_1842# VDD VDD sg13_lv_pmos ad=0.2128p pd=1.5u as=0.3808p ps=2.92u w=1.12u l=0.13u
X365 a_13991_2470# a_13753_1842# a_13883_1842# VDD sg13_lv_pmos ad=0.2128p pd=1.5u as=0.3808p ps=2.92u w=1.12u l=0.2u
X366 VSS.t86 a_3171_1047.t6 a_14964_1008# VSS.t85 sg13_lv_nmos ad=0.2516p pd=2.16u as=0.2516p ps=2.16u w=0.74u l=0.13u
X367 VDD a_2019_311# a_17865_519# VDD sg13_lv_pmos ad=0.3808p pd=2.92u as=0.3808p ps=2.92u w=1.12u l=0.13u
X368 DELAY_OUT_LAST a_27997_1842# VSS.t62 VSS.t534 sg13_lv_nmos ad=0.2516p pd=2.16u as=0.1406p ps=1.12u w=0.74u l=0.13u
X369 a_11195_1044# a_10985_1044# VSS.t242 VSS.t241 sg13_lv_nmos ad=0.1406p pd=1.12u as=0.1665p ps=1.19u w=0.74u l=0.13u
X370 VDD a_24197_1842# a_24665_1044# VDD sg13_lv_pmos ad=0.252p pd=1.57u as=0.3808p ps=2.92u w=1.12u l=0.13u
X371 a_6913_1842# a_6717_1842# VSS.t411 VSS.t506 sg13_lv_nmos ad=0.2516p pd=2.16u as=0.1406p ps=1.12u w=0.74u l=0.13u
X372 VSS.t488 DELAY_VBIASN.t12 a_18551_1842# VSS.t487 sg13_lv_nmos ad=0.2516p pd=2.16u as=0.1406p ps=1.12u w=0.74u l=0.6u
X373 a_16510_1044# a_18004_1008# a_17928_1044# VDD sg13_lv_pmos ad=0.3808p pd=2.92u as=0.2128p ps=1.5u w=1.12u l=0.13u
X374 VDD a_12363_1842# a_12797_1842# VDD sg13_lv_pmos ad=0.2128p pd=1.5u as=0.3808p ps=2.92u w=1.12u l=0.13u
X375 VSS.t73 MUX_SEL3 a_3543_331# VSS.t416 sg13_lv_nmos ad=0.1331p pd=1.12u as=0.1216p ps=1.02u w=0.64u l=0.13u
X376 a_22590_1044# a_2595_1047.t3 a_23355_1044# VSS.t28 sg13_lv_nmos ad=0.2516p pd=2.16u as=0.1406p ps=1.12u w=0.74u l=0.13u
X377 VSS.t448 DELAY_VBIASN.t7 a_22351_1842# VSS.t447 sg13_lv_nmos ad=0.2516p pd=2.16u as=0.1406p ps=1.12u w=0.74u l=0.6u
X378 VDD a_3171_1047.t4 a_21044_1008# VDD sg13_lv_pmos ad=0.3808p pd=2.92u as=0.3808p ps=2.92u w=1.12u l=0.13u
X379 VDD VSS.t569 VDD VDD sg13_lv_pmos ad=0.19p pd=1.38u as=0 ps=0 w=1u l=1u
X380 a_16271_2470# a_16033_1842# a_16163_1842# VDD sg13_lv_pmos ad=0.2128p pd=1.5u as=0.3808p ps=2.92u w=1.12u l=0.2u
X381 VDD VSS.t583 VDD VDD sg13_lv_pmos ad=0.19p pd=1.38u as=0 ps=0 w=1u l=1u
X382 a_19833_1842# a_19637_1842# VSS.t280 VSS.t405 sg13_lv_nmos ad=0.2516p pd=2.16u as=0.1406p ps=1.12u w=0.74u l=0.13u
X383 VDD a_2019_311# a_5705_519# VDD sg13_lv_pmos ad=0.3808p pd=2.92u as=0.3808p ps=2.92u w=1.12u l=0.13u
X384 a_20071_2470# a_19833_1842# a_19963_1842# VDD sg13_lv_pmos ad=0.2128p pd=1.5u as=0.3808p ps=2.92u w=1.12u l=0.2u
X385 a_9193_1842# a_8997_1842# VSS.t225 VSS.t536 sg13_lv_nmos ad=0.2516p pd=2.16u as=0.1406p ps=1.12u w=0.74u l=0.13u
X386 a_24631_1842# a_24393_1842# a_24523_1842# VSS.t214 sg13_lv_nmos ad=0.1406p pd=1.12u as=0.2516p ps=2.16u w=0.74u l=0.2u
X387 VDD VSS.t582 VDD VDD sg13_lv_pmos ad=0.34p pd=2.68u as=0 ps=0 w=1u l=1u
X388 VSS.t120 a_2019_1047.t7 a_10404_1008# VSS.t119 sg13_lv_nmos ad=0.2516p pd=2.16u as=0.2516p ps=2.16u w=0.74u l=0.13u
X389 VDD a_14643_1842# a_15077_1842# VDD sg13_lv_pmos ad=0.2128p pd=1.5u as=0.3808p ps=2.92u w=1.12u l=0.13u
X390 VDD a_1544_289# a_2297_331# VDD sg13_lv_pmos ad=0.1918p pd=1.5u as=0.1596p ps=1.22u w=0.84u l=0.13u
X391 a_23633_1842# a_23437_1842# VSS.t112 VSS.t111 sg13_lv_nmos ad=0.2516p pd=2.16u as=0.1406p ps=1.12u w=0.74u l=0.13u
X392 VSS.t341 VDD VSS.t340 VSS.t339 sg13_lv_nmos ad=0.1428p pd=1.52u as=0 ps=0 w=0.42u l=1u
X393 a_2019_311# a_1721_331# VDD VDD sg13_lv_pmos ad=0.2128p pd=1.5u as=0.1918p ps=1.5u w=1.12u l=0.13u
X394 VSS.t67 a_9323_1842# a_9757_1842# VSS.t252 sg13_lv_nmos ad=0.1406p pd=1.12u as=0.2516p ps=2.16u w=0.74u l=0.13u
X395 a_26395_1044# a_26185_1044# VSS.t37 VSS.t36 sg13_lv_nmos ad=0.1406p pd=1.12u as=0.1665p ps=1.19u w=0.74u l=0.13u
X396 VDD DELAY_VBIASP.t13 a_17791_2470# VDD sg13_lv_pmos ad=0.3808p pd=2.92u as=0.2128p ps=1.5u w=1.12u l=0.6u
X397 VSS.t8 a_3747_1047.t3 a_24951_1008# VSS.t7 sg13_lv_nmos ad=0.2516p pd=2.16u as=0.2516p ps=2.16u w=0.74u l=0.13u
X398 VSS.t306 VDD VSS.t305 VSS.t304 sg13_lv_nmos ad=0.1428p pd=1.52u as=0 ps=0 w=0.42u l=1u
X399 VSS.t336 VDD VSS.t335 VSS.t334 sg13_lv_nmos ad=0.1428p pd=1.52u as=0 ps=0 w=0.42u l=1u
X400 a_3747_1047.t0 a_3449_1395# VDD VDD sg13_lv_pmos ad=0.2128p pd=1.5u as=0.1918p ps=1.5u w=1.12u l=0.13u
X401 a_13368_1044# a_12797_1842# VDD VDD sg13_lv_pmos ad=0.2128p pd=1.5u as=0.3808p ps=2.92u w=1.12u l=0.13u
X402 a_24008_1044# a_23437_1842# VSS.t110 VSS.t109 sg13_lv_nmos ad=0.1406p pd=1.12u as=0.2516p ps=2.16u w=0.74u l=0.13u
X403 VDD DELAY_VBIASP.t8 a_21591_2470# VDD sg13_lv_pmos ad=0.3808p pd=2.92u as=0.2128p ps=1.5u w=1.12u l=0.6u
X404 a_15964_289# MUX_SEL4 a_5731_289# VDD sg13_lv_pmos ad=0.3304p pd=1.71u as=0.3808p ps=2.92u w=1.12u l=0.13u
X405 a_4350_1044# a_6711_1008# a_6635_1044# VDD sg13_lv_pmos ad=0.3808p pd=2.92u as=0.2128p ps=1.5u w=1.12u l=0.13u
X406 a_2873_1395# MUX_SEL1 VDD VDD sg13_lv_pmos ad=0.1596p pd=1.22u as=0.2856p ps=2.36u w=0.84u l=0.13u
X407 a_1256_1044# MUX_SEL0 VSS.t501 VSS.t500 sg13_lv_nmos ad=0.2516p pd=2.16u as=0.2516p ps=2.16u w=0.74u l=0.13u
X408 VSS.t303 VDD VSS.t301 VSS.t302 sg13_lv_nmos ad=79.8f pd=0.8u as=0 ps=0 w=0.42u l=1u
X409 a_19550_1044# a_20391_1008# a_20315_1044# VDD sg13_lv_pmos ad=0.3808p pd=2.92u as=0.2128p ps=1.5u w=1.12u l=0.13u
X410 VDD VDD VDD VDD sg13_lv_pmos ad=0.2128p pd=1.5u as=0 ps=0 w=1.12u l=0.2u
X411 a_5631_1842# a_5393_1842# a_5523_1842# VSS.t401 sg13_lv_nmos ad=0.1406p pd=1.12u as=0.2516p ps=2.16u w=0.74u l=0.2u
X412 a_14513_1842# a_14317_1842# VSS.t420 VSS.t419 sg13_lv_nmos ad=0.2516p pd=2.16u as=0.1406p ps=1.12u w=0.74u l=0.13u
X413 VSS.t261 a_2595_311.t2 a_20905_519# VSS.t260 sg13_lv_nmos ad=0.2516p pd=2.16u as=0.2516p ps=2.16u w=0.74u l=0.13u
X414 VDD a_7477_1842# a_7945_1044# VDD sg13_lv_pmos ad=0.252p pd=1.57u as=0.3808p ps=2.92u w=1.12u l=0.13u
X415 a_13470_1044# a_3171_1047.t6 a_14888_1044# VSS.t84 sg13_lv_nmos ad=0.2516p pd=2.16u as=0.1406p ps=1.12u w=0.74u l=0.13u
X416 a_4633_1842# a_4437_1842# VSS.t207 VSS.t206 sg13_lv_nmos ad=0.2516p pd=2.16u as=0.1406p ps=1.12u w=0.74u l=0.13u
X417 a_1256_289# MUX_SEL2 VSS.t395 VSS.t394 sg13_lv_nmos ad=0.2516p pd=2.16u as=0.2516p ps=2.16u w=0.74u l=0.13u
X418 VSS.t201 a_2019_1047.t2 a_25604_1008# VSS.t200 sg13_lv_nmos ad=0.2516p pd=2.16u as=0.2516p ps=2.16u w=0.74u l=0.13u
X419 a_16108_289# MUX_SEL4 a_15964_289# VSS.t55 sg13_lv_nmos ad=0.2516p pd=2.16u as=0.2183p ps=1.33u w=0.74u l=0.13u
X420 a_22873_1842# a_22677_1842# VDD VDD sg13_lv_pmos ad=0.3808p pd=2.92u as=0.2128p ps=1.5u w=1.12u l=0.13u
X421 a_21835_1044# a_21625_1044# VSS.t248 VSS.t247 sg13_lv_nmos ad=0.1406p pd=1.12u as=0.1665p ps=1.19u w=0.74u l=0.13u
X422 VSS.t267 a_2595_1047.t4 a_20391_1008# VSS.t266 sg13_lv_nmos ad=0.2516p pd=2.16u as=0.2516p ps=2.16u w=0.74u l=0.13u
X423 a_9675_1044# a_9465_1044# VDD VDD sg13_lv_pmos ad=0.2128p pd=1.5u as=0.252p ps=1.57u w=1.12u l=0.13u
X424 VSS.t242 a_10517_1842# a_10985_1044# VSS.t391 sg13_lv_nmos ad=0.1665p pd=1.19u as=0.2516p ps=2.16u w=0.74u l=0.13u
X425 VDD a_2595_1047.t8 a_8231_1008# VDD sg13_lv_pmos ad=0.3808p pd=2.92u as=0.3808p ps=2.92u w=1.12u l=0.13u
X426 a_18551_1842# a_18313_1842# a_18443_1842# VSS.t399 sg13_lv_nmos ad=0.1406p pd=1.12u as=0.2516p ps=2.16u w=0.74u l=0.2u
X427 a_22351_1842# a_22113_1842# a_22243_1842# VSS.t559 sg13_lv_nmos ad=0.1406p pd=1.12u as=0.2516p ps=2.16u w=0.74u l=0.2u
X428 VSS.t233 a_3747_1047.t5 a_18871_1008# VSS.t232 sg13_lv_nmos ad=0.2516p pd=2.16u as=0.2516p ps=2.16u w=0.74u l=0.13u
X429 VSS.t427 a_16923_1842# a_17357_1842# VSS.t426 sg13_lv_nmos ad=0.1406p pd=1.12u as=0.2516p ps=2.16u w=0.74u l=0.13u
X430 VDD a_3171_311.t2 a_23945_519# VDD sg13_lv_pmos ad=0.3808p pd=2.92u as=0.3808p ps=2.92u w=1.12u l=0.13u
X431 a_2019_311# a_1721_331# VSS.t173 VSS.t172 sg13_lv_nmos ad=0.1406p pd=1.12u as=0.1331p ps=1.12u w=0.74u l=0.13u
X432 a_25153_1842# a_24957_1842# VDD VDD sg13_lv_pmos ad=0.3808p pd=2.92u as=0.2128p ps=1.5u w=1.12u l=0.13u
X433 a_17928_1044# a_17357_1842# VSS.t514 VSS.t513 sg13_lv_nmos ad=0.1406p pd=1.12u as=0.2516p ps=2.16u w=0.74u l=0.13u
X434 a_12715_1044# a_12505_1044# VSS.t35 VSS.t34 sg13_lv_nmos ad=0.1406p pd=1.12u as=0.1665p ps=1.19u w=0.74u l=0.13u
X435 VDD MUX_SEL4 a_15765_463# VDD sg13_lv_pmos ad=0.3808p pd=2.92u as=0.3808p ps=2.92u w=1.12u l=0.13u
X436 a_19550_1044# a_3171_1047.t4 a_20968_1044# VSS.t548 sg13_lv_nmos ad=0.2516p pd=2.16u as=0.1406p ps=1.12u w=0.74u l=0.13u
X437 VSS.t466 DELAY_VBIASN.t22 a_10951_1842# VSS.t465 sg13_lv_nmos ad=0.2516p pd=2.16u as=0.1406p ps=1.12u w=0.74u l=0.6u
X438 a_19550_1044# a_19524_1008# a_19448_1044# VDD sg13_lv_pmos ad=0.3808p pd=2.92u as=0.2128p ps=1.5u w=1.12u l=0.13u
X439 a_7288_1044# a_6717_1842# VSS.t508 VSS.t507 sg13_lv_nmos ad=0.1406p pd=1.12u as=0.2516p ps=2.16u w=0.74u l=0.13u
X440 VSS.t216 a_20723_1842# a_21157_1842# VSS.t215 sg13_lv_nmos ad=0.1406p pd=1.12u as=0.2516p ps=2.16u w=0.74u l=0.13u
X441 a_1544_289# MUX_SEL3 VSS.t414 VSS.t413 sg13_lv_nmos ad=0.2516p pd=2.16u as=0.2516p ps=2.16u w=0.74u l=0.13u
X442 a_13470_1044# a_14311_1008# a_14235_1044# VDD sg13_lv_pmos ad=0.3808p pd=2.92u as=0.2128p ps=1.5u w=1.12u l=0.13u
X443 a_22590_1044# a_3747_1047.t3 a_24875_1044# VSS.t6 sg13_lv_nmos ad=0.2516p pd=2.16u as=0.1406p ps=1.12u w=0.74u l=0.13u
X444 VSS.t444 DELAY_VBIASN.t5 a_23871_1842# VSS.t443 sg13_lv_nmos ad=0.2516p pd=2.16u as=0.1406p ps=1.12u w=0.74u l=0.6u
X445 VDD a_2019_1047.t3 a_22564_1008# VDD sg13_lv_pmos ad=0.3808p pd=2.92u as=0.3808p ps=2.92u w=1.12u l=0.13u
X446 VSS.t37 a_25717_1842# a_26185_1044# VSS.t271 sg13_lv_nmos ad=0.1665p pd=1.19u as=0.2516p ps=2.16u w=0.74u l=0.13u
X447 a_13231_1842# a_12993_1842# a_13123_1842# VSS.t558 sg13_lv_nmos ad=0.1406p pd=1.12u as=0.2516p ps=2.16u w=0.74u l=0.2u
X448 VSS.t298 VDD VSS.t296 VSS.t297 sg13_lv_nmos ad=79.8f pd=0.8u as=0 ps=0 w=0.42u l=1u
X449 a_17791_2470# a_17553_1842# a_17683_1842# VDD sg13_lv_pmos ad=0.2128p pd=1.5u as=0.3808p ps=2.92u w=1.12u l=0.2u
X450 VSS.t27 a_4437_1842# a_4905_1044# VSS.t205 sg13_lv_nmos ad=0.1665p pd=1.19u as=0.2516p ps=2.16u w=0.74u l=0.13u
X451 VDD VSS.t570 VDD VDD sg13_lv_pmos ad=0.34p pd=2.68u as=0 ps=0 w=1u l=1u
X452 a_12233_1842# a_12037_1842# VSS.t511 VSS.t510 sg13_lv_nmos ad=0.2516p pd=2.16u as=0.1406p ps=1.12u w=0.74u l=0.13u
X453 VSS.t101 a_3449_1395# a_3747_1047.t1 VSS.t100 sg13_lv_nmos ad=0.2812p pd=2.24u as=0.1406p ps=1.12u w=0.74u l=0.13u
X454 VDD VSS.t584 VDD VDD sg13_lv_pmos ad=0.34p pd=2.68u as=0 ps=0 w=1u l=1u
X455 VDD VSS.t579 VDD VDD sg13_lv_pmos ad=0.19p pd=1.38u as=0 ps=0 w=1u l=1u
X456 VSS.t363 VDD VSS.t361 VSS.t362 sg13_lv_nmos ad=79.8f pd=0.8u as=0 ps=0 w=0.42u l=1u
X457 VSS.t147 a_3171_1047.t8 a_8884_1008# VSS.t146 sg13_lv_nmos ad=0.2516p pd=2.16u as=0.2516p ps=2.16u w=0.74u l=0.13u
X458 a_21591_2470# a_21353_1842# a_21483_1842# VDD sg13_lv_pmos ad=0.2128p pd=1.5u as=0.3808p ps=2.92u w=1.12u l=0.2u
X459 VDD a_2873_1395# a_3171_1047.t0 VDD sg13_lv_pmos ad=0.4256p pd=3u as=0.2128p ps=1.5u w=1.12u l=0.13u
X460 a_6153_1842# a_5957_1842# VDD VDD sg13_lv_pmos ad=0.3808p pd=2.92u as=0.2128p ps=1.5u w=1.12u l=0.13u
X461 VDD a_16163_1842# a_16597_1842# VDD sg13_lv_pmos ad=0.2128p pd=1.5u as=0.3808p ps=2.92u w=1.12u l=0.13u
X462 a_3543_1395# MUX_SEL0 a_3449_1395# VSS.t503 sg13_lv_nmos ad=0.1216p pd=1.02u as=0.2176p ps=1.96u w=0.64u l=0.13u
X463 VDD a_1544_1044# a_2297_1395# VDD sg13_lv_pmos ad=0.1918p pd=1.5u as=0.1596p ps=1.22u w=0.84u l=0.13u
X464 VDD DELAY_VBIASP.t23 a_10191_2470# VDD sg13_lv_pmos ad=0.3808p pd=2.92u as=0.2128p ps=1.5u w=1.12u l=0.6u
X465 a_17275_1044# a_17065_1044# VDD VDD sg13_lv_pmos ad=0.2128p pd=1.5u as=0.252p ps=1.57u w=1.12u l=0.13u
X466 a_2019_1047.t0 a_1721_1395# VDD VDD sg13_lv_pmos ad=0.2128p pd=1.5u as=0.1918p ps=1.5u w=1.12u l=0.13u
X467 a_27915_1044# a_27705_1044# VSS.t125 VSS.t135 sg13_lv_nmos ad=0.1406p pd=1.12u as=0.1665p ps=1.19u w=0.74u l=0.13u
X468 VSS.t458 DELAY_VBIASN.t2 a_26151_1842# VSS.t457 sg13_lv_nmos ad=0.2516p pd=2.16u as=0.1406p ps=1.12u w=0.74u l=0.6u
X469 VDD a_3747_1047.t6 a_15831_1008# VDD sg13_lv_pmos ad=0.3808p pd=2.92u as=0.3808p ps=2.92u w=1.12u l=0.13u
X470 VDD a_19963_1842# a_20397_1842# VDD sg13_lv_pmos ad=0.2128p pd=1.5u as=0.3808p ps=2.92u w=1.12u l=0.13u
X471 VSS.t366 VDD VSS.t365 VSS.t364 sg13_lv_nmos ad=0.1428p pd=1.52u as=0 ps=0 w=0.42u l=1u
X472 VSS.t452 DELAY_VBIASN.t30 a_4871_1842# VSS.t451 sg13_lv_nmos ad=0.2516p pd=2.16u as=0.1406p ps=1.12u w=0.74u l=0.6u
X473 a_14888_1044# a_14317_1842# VDD VDD sg13_lv_pmos ad=0.2128p pd=1.5u as=0.3808p ps=2.92u w=1.12u l=0.13u
X474 a_4350_1044# a_4324_1008# a_4248_1044# VDD sg13_lv_pmos ad=0.3808p pd=2.92u as=0.2128p ps=1.5u w=1.12u l=0.13u
X475 a_1256_289# MUX_SEL2 VDD VDD sg13_lv_pmos ad=0.3808p pd=2.92u as=0.3808p ps=2.92u w=1.12u l=0.13u
X476 VSS.t384 VSS.t381 VSS.t383 VSS.t382 sg13_lv_nmos ad=0.2516p pd=2.16u as=0 ps=0 w=0.74u l=0.6u
X477 a_16108_289# a_15765_463# a_15964_289# VDD sg13_lv_pmos ad=0.3808p pd=2.92u as=0.3304p ps=1.71u w=1.12u l=0.13u
X478 a_11473_1842# a_11277_1842# VDD VDD sg13_lv_pmos ad=0.3808p pd=2.92u as=0.2128p ps=1.5u w=1.12u l=0.13u
X479 VDD a_8997_1842# a_9465_1044# VDD sg13_lv_pmos ad=0.252p pd=1.57u as=0.3808p ps=2.92u w=1.12u l=0.13u
X480 a_27433_1842# a_27237_1842# VSS.t123 VSS.t122 sg13_lv_nmos ad=0.2516p pd=2.16u as=0.1406p ps=1.12u w=0.74u l=0.13u
X481 a_2391_331# MUX_SEL2 a_2297_331# VSS.t396 sg13_lv_nmos ad=0.1216p pd=1.02u as=0.2176p ps=1.96u w=0.64u l=0.13u
X482 a_2967_331# MUX_SEL3 a_2873_331# VSS.t415 sg13_lv_nmos ad=0.1216p pd=1.02u as=0.2176p ps=1.96u w=0.64u l=0.13u
X483 VDD a_2019_1047.t5 a_16484_1008# VDD sg13_lv_pmos ad=0.3808p pd=2.92u as=0.3808p ps=2.92u w=1.12u l=0.13u
X484 a_7390_1044# a_2595_1047.t8 a_8155_1044# VSS.t12 sg13_lv_nmos ad=0.2516p pd=2.16u as=0.1406p ps=1.12u w=0.74u l=0.13u
X485 VSS.t456 DELAY_VBIASN.t27 a_7151_1842# VSS.t455 sg13_lv_nmos ad=0.2516p pd=2.16u as=0.1406p ps=1.12u w=0.74u l=0.6u
X486 VDD a_3171_1047.t9 a_5844_1008# VDD sg13_lv_pmos ad=0.3808p pd=2.92u as=0.3808p ps=2.92u w=1.12u l=0.13u
X487 VDD DELAY_VBIASP.t3 a_25391_2470# VDD sg13_lv_pmos ad=0.3808p pd=2.92u as=0.2128p ps=1.5u w=1.12u l=0.6u
X488 VDD a_2595_1047.t7 a_11271_1008# VDD sg13_lv_pmos ad=0.3808p pd=2.92u as=0.3808p ps=2.92u w=1.12u l=0.13u
X489 VDD VSS.t587 VDD VDD sg13_lv_pmos ad=0.19p pd=1.38u as=0 ps=0 w=1u l=1u
X490 VSS.t35 a_12037_1842# a_12505_1044# VSS.t509 sg13_lv_nmos ad=0.1665p pd=1.19u as=0.2516p ps=2.16u w=0.74u l=0.13u
X491 VDD a_3747_1047.t8 a_9751_1008# VDD sg13_lv_pmos ad=0.3808p pd=2.92u as=0.3808p ps=2.92u w=1.12u l=0.13u
X492 a_9431_1842# a_9193_1842# a_9323_1842# VSS.t495 sg13_lv_nmos ad=0.1406p pd=1.12u as=0.2516p ps=2.16u w=0.74u l=0.2u
X493 a_18313_1842# a_18117_1842# VSS.t46 VSS.t45 sg13_lv_nmos ad=0.2516p pd=2.16u as=0.1406p ps=1.12u w=0.74u l=0.13u
X494 MUX_OUT a_16851_309# VSS.t117 VSS.t187 sg13_lv_nmos ad=0.1406p pd=1.12u as=0.1371p ps=1.12u w=0.74u l=0.13u
X495 VSS.t358 VDD VSS.t356 VSS.t357 sg13_lv_nmos ad=79.8f pd=0.8u as=0 ps=0 w=0.42u l=1u
X496 a_23871_1842# a_23633_1842# a_23763_1842# VSS.t176 sg13_lv_nmos ad=0.1406p pd=1.12u as=0.2516p ps=2.16u w=0.74u l=0.2u
X497 a_8433_1842# a_8237_1842# VSS.t424 VSS.t423 sg13_lv_nmos ad=0.2516p pd=2.16u as=0.1406p ps=1.12u w=0.74u l=0.13u
X498 VSS.t127 a_18443_1842# a_18877_1842# VSS.t409 sg13_lv_nmos ad=0.1406p pd=1.12u as=0.2516p ps=2.16u w=0.74u l=0.13u
X499 VSS.t323 VDD VSS.t321 VSS.t322 sg13_lv_nmos ad=79.8f pd=0.8u as=0 ps=0 w=0.42u l=1u
X500 a_22113_1842# a_21917_1842# VSS.t42 VSS.t89 sg13_lv_nmos ad=0.2516p pd=2.16u as=0.1406p ps=1.12u w=0.74u l=0.13u
X501 a_1544_289# MUX_SEL3 VDD VDD sg13_lv_pmos ad=0.3808p pd=2.92u as=0.3808p ps=2.92u w=1.12u l=0.13u
X502 a_26673_1842# a_26477_1842# VDD VDD sg13_lv_pmos ad=0.3808p pd=2.92u as=0.2128p ps=1.5u w=1.12u l=0.13u
X503 a_10328_1044# a_9757_1842# VSS.t69 VSS.t68 sg13_lv_nmos ad=0.1406p pd=1.12u as=0.2516p ps=2.16u w=0.74u l=0.13u
X504 VSS.t326 VDD VSS.t325 VSS.t324 sg13_lv_nmos ad=0.1428p pd=1.52u as=0 ps=0 w=0.42u l=1u
X505 a_22590_1044# a_2019_1047.t3 a_22488_1044# VSS.t256 sg13_lv_nmos ad=0.2516p pd=2.16u as=0.1406p ps=1.12u w=0.74u l=0.13u
X506 VSS.t434 DELAY_VBIASN.t20 a_12471_1842# VSS.t433 sg13_lv_nmos ad=0.2516p pd=2.16u as=0.1406p ps=1.12u w=0.74u l=0.6u
X507 a_8808_1044# a_8237_1842# VSS.t422 VSS.t421 sg13_lv_nmos ad=0.1406p pd=1.12u as=0.2516p ps=2.16u w=0.74u l=0.13u
X508 VSS.t196 a_22243_1842# a_22677_1842# VSS.t212 sg13_lv_nmos ad=0.1406p pd=1.12u as=0.2516p ps=2.16u w=0.74u l=0.13u
X509 VDD DELAY_VBIASP.t28 a_6391_2470# VDD sg13_lv_pmos ad=0.3808p pd=2.92u as=0.2128p ps=1.5u w=1.12u l=0.6u
X510 a_13470_1044# a_15831_1008# a_15755_1044# VDD sg13_lv_pmos ad=0.3808p pd=2.92u as=0.2128p ps=1.5u w=1.12u l=0.13u
X511 a_1544_1044# MUX_SEL1 VDD VDD sg13_lv_pmos ad=0.3808p pd=2.92u as=0.3808p ps=2.92u w=1.12u l=0.13u
X512 VDD DELAY_VBIASP.t9 a_20831_2470# VDD sg13_lv_pmos ad=0.3808p pd=2.92u as=0.2128p ps=1.5u w=1.12u l=0.6u
X513 VDD a_2595_1047.t2 a_26471_1008# VDD sg13_lv_pmos ad=0.3808p pd=2.92u as=0.3808p ps=2.92u w=1.12u l=0.13u
X514 a_4350_1044# a_5191_1008# a_5115_1044# VDD sg13_lv_pmos ad=0.3808p pd=2.92u as=0.2128p ps=1.5u w=1.12u l=0.13u
X515 VDD a_16597_1842# a_17065_1044# VDD sg13_lv_pmos ad=0.252p pd=1.57u as=0.3808p ps=2.92u w=1.12u l=0.13u
X516 VSS.t125 a_27237_1842# a_27705_1044# VSS.t124 sg13_lv_nmos ad=0.1665p pd=1.19u as=0.2516p ps=2.16u w=0.74u l=0.13u
X517 a_10191_2470# a_9953_1842# a_10083_1842# VDD sg13_lv_pmos ad=0.2128p pd=1.5u as=0.3808p ps=2.92u w=1.12u l=0.2u
X518 a_2595_1047.t1 a_2297_1395# VSS.t16 VSS.t15 sg13_lv_nmos ad=0.1406p pd=1.12u as=0.1331p ps=1.12u w=0.74u l=0.13u
X519 a_26151_1842# a_25913_1842# a_26043_1842# VSS.t388 sg13_lv_nmos ad=0.1406p pd=1.12u as=0.2516p ps=2.16u w=0.74u l=0.2u
X520 VSS.t186 a_2019_311# a_17865_519# VSS.t185 sg13_lv_nmos ad=0.2516p pd=2.16u as=0.2516p ps=2.16u w=0.74u l=0.13u
X521 VSS.t169 a_1544_289# a_2391_331# VSS.t562 sg13_lv_nmos ad=0.1331p pd=1.12u as=0.1216p ps=1.02u w=0.64u l=0.13u
X522 a_4871_1842# a_4633_1842# a_4763_1842# VSS.t523 sg13_lv_nmos ad=0.1406p pd=1.12u as=0.2516p ps=2.16u w=0.74u l=0.2u
X523 a_13753_1842# a_13557_1842# VSS.t408 VSS.t407 sg13_lv_nmos ad=0.2516p pd=2.16u as=0.1406p ps=1.12u w=0.74u l=0.13u
X524 a_1815_1395# a_1256_1044# a_1721_1395# VSS.t23 sg13_lv_nmos ad=0.1216p pd=1.02u as=0.2176p ps=1.96u w=0.64u l=0.13u
X525 a_7673_1842# a_7477_1842# VDD VDD sg13_lv_pmos ad=0.3808p pd=2.92u as=0.2128p ps=1.5u w=1.12u l=0.13u
X526 VDD VSS.t580 VDD VDD sg13_lv_pmos ad=0.34p pd=2.68u as=0 ps=0 w=1u l=1u
X527 a_1721_331# a_1256_289# VDD VDD sg13_lv_pmos ad=0.1596p pd=1.22u as=0.2856p ps=2.36u w=0.84u l=0.13u
X528 VSS.t278 a_24523_1842# a_24957_1842# VSS.t277 sg13_lv_nmos ad=0.1406p pd=1.12u as=0.2516p ps=2.16u w=0.74u l=0.13u
X529 a_6635_1044# a_6425_1044# VSS.t161 VSS.t160 sg13_lv_nmos ad=0.1406p pd=1.12u as=0.1665p ps=1.19u w=0.74u l=0.13u
X530 VSS.t106 a_2595_1047.t9 a_5191_1008# VSS.t105 sg13_lv_nmos ad=0.2516p pd=2.16u as=0.2516p ps=2.16u w=0.74u l=0.13u
X531 a_20315_1044# a_20105_1044# VSS.t164 VSS.t163 sg13_lv_nmos ad=0.1406p pd=1.12u as=0.1665p ps=1.19u w=0.74u l=0.13u
X532 VDD DELAY_VBIASP.t21 a_11711_2470# VDD sg13_lv_pmos ad=0.3808p pd=2.92u as=0.2128p ps=1.5u w=1.12u l=0.6u
X533 a_18795_1044# a_18585_1044# VDD VDD sg13_lv_pmos ad=0.2128p pd=1.5u as=0.252p ps=1.57u w=1.12u l=0.13u
X534 a_25528_1044# a_24957_1842# VSS.t540 VSS.t539 sg13_lv_nmos ad=0.1406p pd=1.12u as=0.2516p ps=2.16u w=0.74u l=0.13u
X535 VSS.t494 DELAY_VBIASN.t0 a_27671_1842# VSS.t493 sg13_lv_nmos ad=0.2516p pd=2.16u as=0.1406p ps=1.12u w=0.74u l=0.6u
X536 a_5731_289# a_3747_311.t3 a_13470_1044# VSS.t209 sg13_lv_nmos ad=0.2516p pd=2.16u as=0.2516p ps=2.16u w=0.74u l=0.13u
X537 a_25630_1044# a_27124_1008# a_27048_1044# VDD sg13_lv_pmos ad=0.3808p pd=2.92u as=0.2128p ps=1.5u w=1.12u l=0.13u
X538 VDD a_2595_1047.t5 a_17351_1008# VDD sg13_lv_pmos ad=0.3808p pd=2.92u as=0.3808p ps=2.92u w=1.12u l=0.13u
X539 VDD a_21483_1842# a_21917_1842# VDD sg13_lv_pmos ad=0.2128p pd=1.5u as=0.3808p ps=2.92u w=1.12u l=0.13u
X540 a_4350_1044# a_5844_1008# a_5768_1044# VDD sg13_lv_pmos ad=0.3808p pd=2.92u as=0.2128p ps=1.5u w=1.12u l=0.13u
X541 VSS.t189 a_16851_309# MUX_OUT VSS.t188 sg13_lv_nmos ad=0.2516p pd=2.16u as=0.1406p ps=1.12u w=0.74u l=0.13u
X542 VSS.t183 a_2019_311# a_5705_519# VSS.t182 sg13_lv_nmos ad=0.2516p pd=2.16u as=0.2516p ps=2.16u w=0.74u l=0.13u
X543 VDD a_1544_289# a_1721_331# VDD sg13_lv_pmos ad=0.1918p pd=1.5u as=0.1596p ps=1.22u w=0.84u l=0.13u
X544 a_7151_1842# a_6913_1842# a_7043_1842# VSS.t94 sg13_lv_nmos ad=0.1406p pd=1.12u as=0.2516p ps=2.16u w=0.74u l=0.2u
X545 a_16033_1842# a_15837_1842# VSS.t276 VSS.t275 sg13_lv_nmos ad=0.2516p pd=2.16u as=0.1406p ps=1.12u w=0.74u l=0.13u
X546 MUX_OUT a_16851_309# VDD VDD sg13_lv_pmos ad=0.2128p pd=1.5u as=0.2086p ps=1.5u w=1.12u l=0.13u
X547 a_25391_2470# a_25153_1842# a_25283_1842# VDD sg13_lv_pmos ad=0.2128p pd=1.5u as=0.3808p ps=2.92u w=1.12u l=0.2u
X548 VDD VSS.t592 VDD VDD sg13_lv_pmos ad=0.34p pd=2.68u as=0 ps=0 w=1u l=1u
X549 a_12993_1842# a_12797_1842# VDD VDD sg13_lv_pmos ad=0.3808p pd=2.92u as=0.2128p ps=1.5u w=1.12u l=0.13u
X550 a_16408_1044# a_15837_1842# VSS.t274 VSS.t273 sg13_lv_nmos ad=0.1406p pd=1.12u as=0.2516p ps=2.16u w=0.74u l=0.13u
X551 VSS.t403 a_5523_1842# a_5957_1842# VSS.t402 sg13_lv_nmos ad=0.1406p pd=1.12u as=0.2516p ps=2.16u w=0.74u l=0.13u
X552 VDD DELAY_VBIASP.t18 a_13991_2470# VDD sg13_lv_pmos ad=0.3808p pd=2.92u as=0.2128p ps=1.5u w=1.12u l=0.6u
X553 a_5731_289# a_2019_311# a_4350_1044# VSS.t181 sg13_lv_nmos ad=0.2516p pd=2.16u as=0.2516p ps=2.16u w=0.74u l=0.13u
X554 a_7390_1044# a_3747_1047.t8 a_9675_1044# VSS.t268 sg13_lv_nmos ad=0.2516p pd=2.16u as=0.1406p ps=1.12u w=0.74u l=0.13u
X555 VDD a_23763_1842# a_24197_1842# VDD sg13_lv_pmos ad=0.2128p pd=1.5u as=0.3808p ps=2.92u w=1.12u l=0.13u
X556 VSS.t432 DELAY_VBIASN.t25 a_8671_1842# VSS.t431 sg13_lv_nmos ad=0.2516p pd=2.16u as=0.1406p ps=1.12u w=0.74u l=0.6u
X557 VDD a_2019_1047.t8 a_7364_1008# VDD sg13_lv_pmos ad=0.3808p pd=2.92u as=0.3808p ps=2.92u w=1.12u l=0.13u
X558 VDD DELAY_VBIASP.t1 a_26911_2470# VDD sg13_lv_pmos ad=0.3808p pd=2.92u as=0.2128p ps=1.5u w=1.12u l=0.6u
X559 VDD VSS.t563 VDD VDD sg13_lv_pmos ad=0.19p pd=1.38u as=0 ps=0 w=1u l=1u
X560 a_12471_1842# a_12233_1842# a_12363_1842# VSS.t194 sg13_lv_nmos ad=0.1406p pd=1.12u as=0.2516p ps=2.16u w=0.74u l=0.2u
X561 a_22488_1044# a_21917_1842# VDD VDD sg13_lv_pmos ad=0.2128p pd=1.5u as=0.3808p ps=2.92u w=1.12u l=0.13u
X562 VDD a_2595_311.t3 a_8745_519# VDD sg13_lv_pmos ad=0.3808p pd=2.92u as=0.3808p ps=2.92u w=1.12u l=0.13u
X563 VSS.t138 a_3171_1047.t5 a_18004_1008# VSS.t137 sg13_lv_nmos ad=0.2516p pd=2.16u as=0.2516p ps=2.16u w=0.74u l=0.13u
X564 a_6391_2470# a_6153_1842# a_6283_1842# VDD sg13_lv_pmos ad=0.2128p pd=1.5u as=0.3808p ps=2.92u w=1.12u l=0.2u
X565 a_15273_1842# a_15077_1842# VDD VDD sg13_lv_pmos ad=0.3808p pd=2.92u as=0.2128p ps=1.5u w=1.12u l=0.13u
X566 a_14235_1044# a_14025_1044# VSS.t134 VSS.t133 sg13_lv_nmos ad=0.1406p pd=1.12u as=0.1665p ps=1.19u w=0.74u l=0.13u
X567 VSS.t159 a_3747_1047.t7 a_12791_1008# VSS.t158 sg13_lv_nmos ad=0.2516p pd=2.16u as=0.2516p ps=2.16u w=0.74u l=0.13u
X568 a_9953_1842# a_9757_1842# VSS.t67 VSS.t66 sg13_lv_nmos ad=0.2516p pd=2.16u as=0.1406p ps=1.12u w=0.74u l=0.13u
X569 VSS.t191 a_10843_1842# a_11277_1842# VSS.t389 sg13_lv_nmos ad=0.1406p pd=1.12u as=0.2516p ps=2.16u w=0.74u l=0.13u
X570 VSS.t356 VDD VSS.t355 VSS.t354 sg13_lv_nmos ad=0.1428p pd=1.52u as=0 ps=0 w=0.42u l=1u
X571 VDD a_15403_1842# a_15837_1842# VDD sg13_lv_pmos ad=0.2128p pd=1.5u as=0.3808p ps=2.92u w=1.12u l=0.13u
X572 VSS.t321 VDD VSS.t320 VSS.t319 sg13_lv_nmos ad=0.1428p pd=1.52u as=0 ps=0 w=0.42u l=1u
X573 a_11848_1044# a_11277_1842# VSS.t193 VSS.t192 sg13_lv_nmos ad=0.1406p pd=1.12u as=0.2516p ps=2.16u w=0.74u l=0.13u
X574 VDD a_4763_1842# a_5197_1842# VDD sg13_lv_pmos ad=0.2128p pd=1.5u as=0.3808p ps=2.92u w=1.12u l=0.13u
X575 VSS.t333 VDD VSS.t331 VSS.t332 sg13_lv_nmos ad=79.8f pd=0.8u as=0 ps=0 w=0.42u l=1u
X576 a_13470_1044# a_13444_1008# a_13368_1044# VDD sg13_lv_pmos ad=0.3808p pd=2.92u as=0.2128p ps=1.5u w=1.12u l=0.13u
X577 VDD a_3449_1395# a_3747_1047.t0 VDD sg13_lv_pmos ad=0.4256p pd=3u as=0.2128p ps=1.5u w=1.12u l=0.13u
X578 VDD a_3171_1047.t3 a_24084_1008# VDD sg13_lv_pmos ad=0.3808p pd=2.92u as=0.3808p ps=2.92u w=1.12u l=0.13u
X579 a_3449_1395# MUX_SEL0 VDD VDD sg13_lv_pmos ad=0.1596p pd=1.22u as=0.2856p ps=2.36u w=0.84u l=0.13u
X580 VDD DELAY_VBIASP.t26 a_7911_2470# VDD sg13_lv_pmos ad=0.3808p pd=2.92u as=0.2128p ps=1.5u w=1.12u l=0.6u
X581 VDD VSS.t595 VDD VDD sg13_lv_pmos ad=0.19p pd=1.38u as=0 ps=0 w=1u l=1u
X582 VDD VSS.t594 VDD VDD sg13_lv_pmos ad=0.34p pd=2.68u as=0 ps=0 w=1u l=1u
X583 VDD a_16851_309# MUX_OUT VDD sg13_lv_pmos ad=0.7336p pd=3.55u as=0.2128p ps=1.5u w=1.12u l=0.13u
X584 VSS.t167 a_3171_311.t2 a_23945_519# VSS.t166 sg13_lv_nmos ad=0.2516p pd=2.16u as=0.2516p ps=2.16u w=0.74u l=0.13u
X585 VDD a_18117_1842# a_18585_1044# VDD sg13_lv_pmos ad=0.252p pd=1.57u as=0.3808p ps=2.92u w=1.12u l=0.13u
X586 VSS.t164 a_19637_1842# a_20105_1044# VSS.t404 sg13_lv_nmos ad=0.1665p pd=1.19u as=0.2516p ps=2.16u w=0.74u l=0.13u
X587 a_11711_2470# a_11473_1842# a_11603_1842# VDD sg13_lv_pmos ad=0.2128p pd=1.5u as=0.3808p ps=2.92u w=1.12u l=0.2u
X588 a_27671_1842# a_27433_1842# a_27563_1842# VSS.t107 sg13_lv_nmos ad=0.1406p pd=1.12u as=0.2516p ps=2.16u w=0.74u l=0.2u
X589 VSS.t57 MUX_SEL4 a_15765_463# VSS.t56 sg13_lv_nmos ad=0.2516p pd=2.16u as=0.2516p ps=2.16u w=0.74u l=0.13u
X590 a_5731_289# a_14825_519# a_13470_1044# VDD sg13_lv_pmos ad=0.3808p pd=2.92u as=0.3808p ps=2.92u w=1.12u l=0.13u
X591 a_16510_1044# a_2595_1047.t5 a_17275_1044# VSS.t9 sg13_lv_nmos ad=0.2516p pd=2.16u as=0.1406p ps=1.12u w=0.74u l=0.13u
X592 VSS.t480 DELAY_VBIASN.t15 a_16271_1842# VSS.t479 sg13_lv_nmos ad=0.2516p pd=2.16u as=0.1406p ps=1.12u w=0.74u l=0.6u
X593 VDD VSS.t568 VDD VDD sg13_lv_pmos ad=0.34p pd=2.68u as=0 ps=0 w=1u l=1u
X594 VDD a_3171_1047.t6 a_14964_1008# VDD sg13_lv_pmos ad=0.3808p pd=2.92u as=0.3808p ps=2.92u w=1.12u l=0.13u
X595 VDD a_10083_1842# a_10517_1842# VDD sg13_lv_pmos ad=0.2128p pd=1.5u as=0.3808p ps=2.92u w=1.12u l=0.13u
X596 VSS.t156 a_3747_1047.t2 a_27991_1008# VSS.t155 sg13_lv_nmos ad=0.2516p pd=2.16u as=0.2516p ps=2.16u w=0.74u l=0.13u
X597 VSS.t204 a_26043_1842# a_26477_1842# VSS.t203 sg13_lv_nmos ad=0.1406p pd=1.12u as=0.2516p ps=2.16u w=0.74u l=0.13u
X598 a_11195_1044# a_10985_1044# VDD VDD sg13_lv_pmos ad=0.2128p pd=1.5u as=0.252p ps=1.57u w=1.12u l=0.13u
X599 VSS.t132 a_3747_1047.t9 a_6711_1008# VSS.t131 sg13_lv_nmos ad=0.2516p pd=2.16u as=0.2516p ps=2.16u w=0.74u l=0.13u
X600 a_16108_289# a_2595_311.t2 a_19550_1044# VSS.t259 sg13_lv_nmos ad=0.2516p pd=2.16u as=0.2516p ps=2.16u w=0.74u l=0.13u
X601 VSS.t490 DELAY_VBIASN.t10 a_20071_1842# VSS.t489 sg13_lv_nmos ad=0.2516p pd=2.16u as=0.1406p ps=1.12u w=0.74u l=0.6u
X602 VDD DELAY_VBIASP.t4 a_24631_2470# VDD sg13_lv_pmos ad=0.3808p pd=2.92u as=0.2128p ps=1.5u w=1.12u l=0.6u
X603 a_22590_1044# a_23431_1008# a_23355_1044# VDD sg13_lv_pmos ad=0.3808p pd=2.92u as=0.2128p ps=1.5u w=1.12u l=0.13u
X604 VSS.t313 VDD VSS.t311 VSS.t312 sg13_lv_nmos ad=79.8f pd=0.8u as=0 ps=0 w=0.42u l=1u
X605 a_8671_1842# a_8433_1842# a_8563_1842# VSS.t556 sg13_lv_nmos ad=0.1406p pd=1.12u as=0.2516p ps=2.16u w=0.74u l=0.2u
X606 a_17553_1842# a_17357_1842# VSS.t427 VSS.t512 sg13_lv_nmos ad=0.2516p pd=2.16u as=0.1406p ps=1.12u w=0.74u l=0.13u
X607 a_5731_289# a_5705_519# a_4350_1044# VDD sg13_lv_pmos ad=0.3808p pd=2.92u as=0.3808p ps=2.92u w=1.12u l=0.13u
X608 VDD VDD VDD VDD sg13_lv_pmos ad=0.3808p pd=2.92u as=0 ps=0 w=1.12u l=0.13u
X609 a_26911_2470# a_26673_1842# a_26803_1842# VDD sg13_lv_pmos ad=0.2128p pd=1.5u as=0.3808p ps=2.92u w=1.12u l=0.2u
X610 a_7390_1044# a_2019_1047.t8 a_7288_1044# VSS.t243 sg13_lv_nmos ad=0.2516p pd=2.16u as=0.1406p ps=1.12u w=0.74u l=0.13u
X611 a_21353_1842# a_21157_1842# VSS.t216 VSS.t533 sg13_lv_nmos ad=0.2516p pd=2.16u as=0.1406p ps=1.12u w=0.74u l=0.13u
X612 VSS.t222 a_7043_1842# a_7477_1842# VSS.t521 sg13_lv_nmos ad=0.1406p pd=1.12u as=0.2516p ps=2.16u w=0.74u l=0.13u
X613 VDD DELAY_VBIASP.t16 a_15511_2470# VDD sg13_lv_pmos ad=0.3808p pd=2.92u as=0.2128p ps=1.5u w=1.12u l=0.6u
X614 VDD a_2019_1047.t7 a_10404_1008# VDD sg13_lv_pmos ad=0.3808p pd=2.92u as=0.3808p ps=2.92u w=1.12u l=0.13u
X615 VDD a_25283_1842# a_25717_1842# VDD sg13_lv_pmos ad=0.2128p pd=1.5u as=0.3808p ps=2.92u w=1.12u l=0.13u
X616 VDD DELAY_VBIASP.t29 a_5631_2470# VDD sg13_lv_pmos ad=0.3808p pd=2.92u as=0.2128p ps=1.5u w=1.12u l=0.6u
X617 a_26395_1044# a_26185_1044# VDD VDD sg13_lv_pmos ad=0.2128p pd=1.5u as=0.252p ps=1.57u w=1.12u l=0.13u
X618 VDD a_3747_1047.t3 a_24951_1008# VDD sg13_lv_pmos ad=0.3808p pd=2.92u as=0.3808p ps=2.92u w=1.12u l=0.13u
X619 VDD VSS.t571 VDD VDD sg13_lv_pmos ad=0.19p pd=1.38u as=0 ps=0 w=1u l=1u
X620 a_13991_1842# a_13753_1842# a_13883_1842# VSS.t177 sg13_lv_nmos ad=0.1406p pd=1.12u as=0.2516p ps=2.16u w=0.74u l=0.2u
X621 a_24008_1044# a_23437_1842# VDD VDD sg13_lv_pmos ad=0.2128p pd=1.5u as=0.3808p ps=2.92u w=1.12u l=0.13u
X622 VDD VSS.t585 VDD VDD sg13_lv_pmos ad=0.19p pd=1.38u as=0 ps=0 w=1u l=1u
X623 VSS.t264 a_2019_1047.t4 a_19524_1008# VSS.t263 sg13_lv_nmos ad=0.2516p pd=2.16u as=0.2516p ps=2.16u w=0.74u l=0.13u
X624 a_7911_2470# a_7673_1842# a_7803_1842# VDD sg13_lv_pmos ad=0.2128p pd=1.5u as=0.3808p ps=2.92u w=1.12u l=0.2u
X625 a_16793_1842# a_16597_1842# VDD VDD sg13_lv_pmos ad=0.3808p pd=2.92u as=0.2128p ps=1.5u w=1.12u l=0.13u
X626 VSS.t99 MUX_SEL1 a_3543_1395# VSS.t530 sg13_lv_nmos ad=0.1331p pd=1.12u as=0.1216p ps=1.02u w=0.64u l=0.13u
X627 a_15755_1044# a_15545_1044# VSS.t240 VSS.t239 sg13_lv_nmos ad=0.1406p pd=1.12u as=0.1665p ps=1.19u w=0.74u l=0.13u
X628 a_2595_1047.t0 a_2297_1395# VDD VDD sg13_lv_pmos ad=0.2128p pd=1.5u as=0.1918p ps=1.5u w=1.12u l=0.13u
X629 VSS.t153 a_2595_1047.t6 a_14311_1008# VSS.t152 sg13_lv_nmos ad=0.2516p pd=2.16u as=0.2516p ps=2.16u w=0.74u l=0.13u
X630 VSS.t50 a_12363_1842# a_12797_1842# VSS.t49 sg13_lv_nmos ad=0.1406p pd=1.12u as=0.2516p ps=2.16u w=0.74u l=0.13u
X631 a_5115_1044# a_4905_1044# VSS.t27 VSS.t26 sg13_lv_nmos ad=0.1406p pd=1.12u as=0.1665p ps=1.19u w=0.74u l=0.13u
X632 a_1256_1044# MUX_SEL0 VDD VDD sg13_lv_pmos ad=0.3808p pd=2.92u as=0.3808p ps=2.92u w=1.12u l=0.13u
X633 VDD a_27563_1842# a_27997_1842# VDD sg13_lv_pmos ad=0.2128p pd=1.5u as=0.3808p ps=2.92u w=1.12u l=0.13u
X634 a_20593_1842# a_20397_1842# VDD VDD sg13_lv_pmos ad=0.3808p pd=2.92u as=0.2128p ps=1.5u w=1.12u l=0.13u
X635 a_1721_1395# a_1256_1044# VDD VDD sg13_lv_pmos ad=0.1596p pd=1.22u as=0.2856p ps=2.36u w=0.84u l=0.13u
X636 VDD a_6283_1842# a_6717_1842# VDD sg13_lv_pmos ad=0.2128p pd=1.5u as=0.3808p ps=2.92u w=1.12u l=0.13u
X637 a_13470_1044# a_14964_1008# a_14888_1044# VDD sg13_lv_pmos ad=0.3808p pd=2.92u as=0.2128p ps=1.5u w=1.12u l=0.13u
X638 VSS.t331 VDD VSS.t330 VSS.t329 sg13_lv_nmos ad=0.1428p pd=1.52u as=0 ps=0 w=0.42u l=1u
X639 VDD a_2019_1047.t2 a_25604_1008# VDD sg13_lv_pmos ad=0.3808p pd=2.92u as=0.3808p ps=2.92u w=1.12u l=0.13u
X640 a_16271_1842# a_16033_1842# a_16163_1842# VSS.t390 sg13_lv_nmos ad=0.1406p pd=1.12u as=0.2516p ps=2.16u w=0.74u l=0.2u
X641 a_21835_1044# a_21625_1044# VDD VDD sg13_lv_pmos ad=0.2128p pd=1.5u as=0.252p ps=1.57u w=1.12u l=0.13u
X642 VDD VSS.t596 VDD VDD sg13_lv_pmos ad=0.34p pd=2.68u as=0 ps=0 w=1u l=1u
X643 VDD a_2595_1047.t4 a_20391_1008# VDD sg13_lv_pmos ad=0.3808p pd=2.92u as=0.3808p ps=2.92u w=1.12u l=0.13u
X644 a_19073_1842# a_18877_1842# VDD VDD sg13_lv_pmos ad=0.3808p pd=2.92u as=0.2128p ps=1.5u w=1.12u l=0.13u
X645 VDD a_10517_1842# a_10985_1044# VDD sg13_lv_pmos ad=0.252p pd=1.57u as=0.3808p ps=2.92u w=1.12u l=0.13u
X646 VSS.t248 a_21157_1842# a_21625_1044# VSS.t532 sg13_lv_nmos ad=0.1665p pd=1.19u as=0.2516p ps=2.16u w=0.74u l=0.13u
X647 a_20071_1842# a_19833_1842# a_19963_1842# VSS.t227 sg13_lv_nmos ad=0.1406p pd=1.12u as=0.2516p ps=2.16u w=0.74u l=0.2u
X648 VSS.t517 a_14643_1842# a_15077_1842# VSS.t537 sg13_lv_nmos ad=0.1406p pd=1.12u as=0.2516p ps=2.16u w=0.74u l=0.13u
X649 a_1815_331# a_1256_289# a_1721_331# VSS.t38 sg13_lv_nmos ad=0.1216p pd=1.02u as=0.2176p ps=1.96u w=0.64u l=0.13u
X650 VDD a_19203_1842# a_19637_1842# VDD sg13_lv_pmos ad=0.2128p pd=1.5u as=0.3808p ps=2.92u w=1.12u l=0.13u
X651 VSS.t547 a_2019_1047.t9 a_4324_1008# VSS.t546 sg13_lv_nmos ad=0.2516p pd=2.16u as=0.2516p ps=2.16u w=0.74u l=0.13u
X652 a_16108_289# a_20905_519# a_19550_1044# VDD sg13_lv_pmos ad=0.3808p pd=2.92u as=0.3808p ps=2.92u w=1.12u l=0.13u
X653 a_16510_1044# a_3747_1047.t5 a_18795_1044# VSS.t231 sg13_lv_nmos ad=0.2516p pd=2.16u as=0.1406p ps=1.12u w=0.74u l=0.13u
X654 VDD a_8563_1842# a_8997_1842# VDD sg13_lv_pmos ad=0.2128p pd=1.5u as=0.3808p ps=2.92u w=1.12u l=0.13u
X655 VDD DELAY_VBIASP.t19 a_13231_2470# VDD sg13_lv_pmos ad=0.3808p pd=2.92u as=0.2128p ps=1.5u w=1.12u l=0.6u
X656 VSS.t482 DELAY_VBIASN.t13 a_17791_1842# VSS.t481 sg13_lv_nmos ad=0.2516p pd=2.16u as=0.1406p ps=1.12u w=0.74u l=0.6u
X657 VSS.t301 VDD VSS.t300 VSS.t299 sg13_lv_nmos ad=0.1428p pd=1.52u as=0 ps=0 w=0.42u l=1u
X658 VDD a_3747_1047.t5 a_18871_1008# VDD sg13_lv_pmos ad=0.3808p pd=2.92u as=0.3808p ps=2.92u w=1.12u l=0.13u
X659 VDD a_23003_1842# a_23437_1842# VDD sg13_lv_pmos ad=0.2128p pd=1.5u as=0.3808p ps=2.92u w=1.12u l=0.13u
X660 a_12715_1044# a_12505_1044# VDD VDD sg13_lv_pmos ad=0.2128p pd=1.5u as=0.252p ps=1.57u w=1.12u l=0.13u
X661 a_19550_1044# a_21044_1008# a_20968_1044# VDD sg13_lv_pmos ad=0.3808p pd=2.92u as=0.2128p ps=1.5u w=1.12u l=0.13u
X662 a_17928_1044# a_17357_1842# VDD VDD sg13_lv_pmos ad=0.2128p pd=1.5u as=0.3808p ps=2.92u w=1.12u l=0.13u
X663 VSS.t460 DELAY_VBIASN.t8 a_21591_1842# VSS.t459 sg13_lv_nmos ad=0.2516p pd=2.16u as=0.1406p ps=1.12u w=0.74u l=0.6u
X664 VSS.t173 a_1544_289# a_1815_331# VSS.t561 sg13_lv_nmos ad=0.1331p pd=1.12u as=0.1216p ps=1.02u w=0.64u l=0.13u
X665 a_7288_1044# a_6717_1842# VDD VDD sg13_lv_pmos ad=0.2128p pd=1.5u as=0.3808p ps=2.92u w=1.12u l=0.13u
X666 a_15511_2470# a_15273_1842# a_15403_1842# VDD sg13_lv_pmos ad=0.2128p pd=1.5u as=0.3808p ps=2.92u w=1.12u l=0.2u
X667 VSS.t383 VSS.t385 VSS.t387 VSS.t386 sg13_lv_nmos ad=0.1406p pd=1.12u as=0 ps=0 w=0.74u l=0.2u
X668 a_22590_1044# a_24951_1008# a_24875_1044# VDD sg13_lv_pmos ad=0.3808p pd=2.92u as=0.2128p ps=1.5u w=1.12u l=0.13u
X669 VSS.t373 VDD VSS.t371 VSS.t372 sg13_lv_nmos ad=79.8f pd=0.8u as=0 ps=0 w=0.42u l=1u
X670 a_10430_1044# a_2019_1047.t7 a_10328_1044# VSS.t118 sg13_lv_nmos ad=0.2516p pd=2.16u as=0.1406p ps=1.12u w=0.74u l=0.13u
X671 VDD a_25717_1842# a_26185_1044# VDD sg13_lv_pmos ad=0.252p pd=1.57u as=0.3808p ps=2.92u w=1.12u l=0.13u
X672 VDD a_13883_1842# a_14317_1842# VDD sg13_lv_pmos ad=0.2128p pd=1.5u as=0.3808p ps=2.92u w=1.12u l=0.13u
X673 VDD a_4437_1842# a_4905_1044# VDD sg13_lv_pmos ad=0.252p pd=1.57u as=0.3808p ps=2.92u w=1.12u l=0.13u
X674 a_4157_1313# DELAY_IN VSS.t283 VSS.t282 sg13_lv_nmos ad=0.2516p pd=2.16u as=0.2553p ps=2.17u w=0.74u l=0.13u
X675 a_7390_1044# a_3171_1047.t8 a_8808_1044# VSS.t145 sg13_lv_nmos ad=0.2516p pd=2.16u as=0.1406p ps=1.12u w=0.74u l=0.13u
X676 a_22873_1842# a_22677_1842# VSS.t196 VSS.t195 sg13_lv_nmos ad=0.2516p pd=2.16u as=0.1406p ps=1.12u w=0.74u l=0.13u
X677 VDD a_3171_1047.t8 a_8884_1008# VDD sg13_lv_pmos ad=0.3808p pd=2.92u as=0.3808p ps=2.92u w=1.12u l=0.13u
C0 a_6711_1008# a_4350_1044# 0.26208f
C1 a_10517_1842# a_10404_1008# 0.05157f
C2 a_15545_1044# a_15077_1842# 0.2079f
C3 VDD a_12363_1842# 0.4973f
C4 a_6391_2470# a_6283_1842# 0.01697f
C5 MUX_SEL2 a_1544_289# 0.07405f
C6 a_4437_1842# DELAY_VBIASN 0.08375f
C7 a_4633_1842# DELAY_VBIASP 0.11222f
C8 MUX_SEL3 a_1256_289# 1.41161f
C9 a_22590_1044# a_24008_1044# 0.38994f
C10 a_23111_2470# VDD 0.01806f
C11 a_7477_1842# DELAY_VBIASP 0.0414f
C12 MUX_OUT VDD 0.35871f
C13 a_12505_1044# a_12791_1008# 0.01885f
C14 VDD a_13557_1842# 0.86707f
C15 a_4905_1044# a_5115_1044# 0.09424f
C16 VDD a_20593_1842# 0.49417f
C17 a_25630_1044# a_26185_1044# 0.03209f
C18 VDD a_5393_1842# 0.49417f
C19 a_8155_1044# a_8231_1008# 0.01194f
C20 a_7390_1044# a_8884_1008# 0.28279f
C21 a_18443_1842# DELAY_VBIASN 0.07254f
C22 a_4871_2470# a_4763_1842# 0.01697f
C23 a_20105_1044# a_19637_1842# 0.19203f
C24 a_17683_1842# a_17791_2470# 0.01697f
C25 a_18877_1842# a_18443_1842# 0.6972f
C26 a_7288_1044# a_6717_1842# 0.10864f
C27 a_16408_1044# a_15837_1842# 0.10864f
C28 a_13470_1044# DELAY_VBIASN 0.02115f
C29 a_23145_1044# a_22590_1044# 0.03209f
C30 a_19550_1044# a_21483_1842# 0.01012f
C31 a_5705_519# MUX_SEL4 0.03556f
C32 a_15964_289# MUX_SEL4 0.5544f
C33 a_4350_1044# a_5191_1008# 0.28268f
C34 a_16923_1842# DELAY_VBIASP 0.06627f
C35 a_17553_1842# a_18117_1842# 0.0114f
C36 VDD a_22488_1044# 0.17274f
C37 a_16033_1842# a_16163_1842# 0.70845f
C38 a_5631_1842# a_5523_1842# 0.01163f
C39 a_24197_1842# a_22590_1044# 0.05231f
C40 a_23437_1842# a_23431_1008# 0.02349f
C41 a_14235_1044# VDD 0.15389f
C42 a_13368_1044# a_13470_1044# 0.37183f
C43 a_16408_1044# a_16510_1044# 0.37183f
C44 MUX_OUT MUX_SEL2 0.08497f
C45 MUX_SEL4 MUX_SEL3 0.75489f
C46 VDD a_15837_1842# 0.87963f
C47 a_24957_1842# VDD 0.87825f
C48 DELAY_VBIASN a_14317_1842# 0.09974f
C49 DELAY_VBIASP a_14513_1842# 0.11222f
C50 a_5631_2470# VDD 0.01806f
C51 a_18877_1842# a_19448_1044# 0.10864f
C52 DELAY_VBIASP a_6283_1842# 0.06627f
C53 DELAY_VBIASN a_6153_1842# 0.0961f
C54 a_11848_1044# a_11924_1008# 0.01176f
C55 a_15545_1044# VDD 0.29918f
C56 a_22564_1008# a_22677_1842# 0.05157f
C57 DELAY_VBIASP a_11603_1842# 0.06627f
C58 a_18877_1842# a_16108_289# 0.0157f
C59 DELAY_VBIASN a_11473_1842# 0.0961f
C60 VDD a_25153_1842# 0.49426f
C61 a_10713_1842# VDD 0.49294f
C62 a_20071_1842# a_19963_1842# 0.01163f
C63 a_11848_1044# a_10430_1044# 0.38994f
C64 a_26803_1842# a_26477_1842# 0.01427f
C65 a_10328_1044# a_10430_1044# 0.37183f
C66 a_16510_1044# VDD 0.8795f
C67 DELAY_VBIASP a_19833_1842# 0.11222f
C68 DELAY_VBIASN a_19637_1842# 0.08375f
C69 a_10517_1842# a_10713_1842# 0.73897f
C70 a_19550_1044# a_21044_1008# 0.28279f
C71 a_16510_1044# a_18795_1044# 0.39036f
C72 a_20315_1044# a_20391_1008# 0.01194f
C73 a_2019_311# VDD 1.43004f
C74 a_23437_1842# a_23633_1842# 0.76914f
C75 a_18877_1842# a_19637_1842# 0.06198f
C76 a_6635_1044# VDD 0.15406f
C77 VDD a_26471_1008# 0.28336f
C78 VDD a_10191_2470# 0.01806f
C79 a_8808_1044# a_8884_1008# 0.01176f
C80 a_24957_1842# a_25604_1008# 0.02011f
C81 a_25630_1044# a_25717_1842# 0.1088f
C82 a_24523_1842# a_24631_1842# 0.01163f
C83 VDD a_21353_1842# 0.49285f
C84 a_7673_1842# VDD 0.49294f
C85 a_7288_1044# a_7364_1008# 0.01176f
C86 a_9757_1842# a_7390_1044# 0.02479f
C87 a_9193_1842# a_9323_1842# 0.70845f
C88 a_26911_2470# VDD 0.01806f
C89 a_12233_1842# a_12797_1842# 0.0114f
C90 a_1256_1044# a_2297_1395# 0.04619f
C91 a_23437_1842# a_22677_1842# 0.01669f
C92 a_6425_1044# VDD 0.29722f
C93 a_19550_1044# a_21157_1842# 0.05231f
C94 a_27671_2470# a_27563_1842# 0.01697f
C95 a_20391_1008# a_20397_1842# 0.02349f
C96 MUX_SEL0 a_3449_1395# 0.10753f
C97 DELAY_VBIASN a_16597_1842# 0.08375f
C98 a_13753_1842# a_14317_1842# 0.0114f
C99 DELAY_VBIASP a_16793_1842# 0.11222f
C100 a_2019_311# a_15765_463# 0.05969f
C101 a_27671_1842# a_27563_1842# 0.01163f
C102 a_3449_331# a_2019_311# 0.01176f
C103 a_9193_1842# a_8997_1842# 0.77122f
C104 a_13470_1044# a_14888_1044# 0.38994f
C105 VDD a_1256_289# 0.40292f
C106 a_9465_1044# a_7390_1044# 0.03208f
C107 a_5957_1842# a_6717_1842# 0.02912f
C108 DELAY_VBIASP a_26043_1842# 0.06627f
C109 DELAY_VBIASN a_25913_1842# 0.0961f
C110 a_23003_1842# a_23111_1842# 0.01163f
C111 a_25630_1044# a_27048_1044# 0.38994f
C112 a_11277_1842# a_12037_1842# 0.03319f
C113 VDD DELAY_IN 1.33375f
C114 a_21917_1842# a_22243_1842# 0.01427f
C115 VDD a_5115_1044# 0.15389f
C116 a_24197_1842# DELAY_VBIASP 0.04141f
C117 a_2019_311# a_4157_1313# 0.01018f
C118 a_27997_1842# DELAY_OUT_LAST 0.70955f
C119 a_20397_1842# a_19963_1842# 0.6972f
C120 VDD a_13231_2470# 0.01806f
C121 a_27563_1842# DELAY_VBIASP 0.06629f
C122 a_27433_1842# DELAY_VBIASN 0.0961f
C123 a_18117_1842# VDD 0.85848f
C124 a_23003_1842# DELAY_VBIASN 0.07254f
C125 a_1256_1044# a_1721_1395# 0.13421f
C126 a_13991_1842# a_13883_1842# 0.01163f
C127 a_5197_1842# a_4763_1842# 0.6972f
C128 a_9757_1842# DELAY_VBIASN 0.09992f
C129 a_9953_1842# DELAY_VBIASP 0.11222f
C130 a_7390_1044# DELAY_VBIASN 0.02115f
C131 a_11924_1008# VDD 0.28225f
C132 a_7477_1842# a_7673_1842# 0.73897f
C133 a_14888_1044# a_14317_1842# 0.10863f
C134 a_27048_1044# a_27124_1008# 0.01176f
C135 VDD a_10430_1044# 0.88416f
C136 a_19073_1842# a_19637_1842# 0.0114f
C137 DELAY_VBIASN a_22113_1842# 0.0961f
C138 DELAY_VBIASP a_22243_1842# 0.06627f
C139 a_8433_1842# DELAY_VBIASN 0.0961f
C140 a_20391_1008# VDD 0.28336f
C141 a_3449_331# DELAY_IN 0.01017f
C142 a_16923_1842# a_16510_1044# 0.01012f
C143 a_2019_311# a_4350_1044# 0.02042f
C144 a_1256_1044# MUX_SEL0 0.3314f
C145 a_15273_1842# a_15077_1842# 0.77122f
C146 a_23945_519# VDD 0.29292f
C147 a_25630_1044# DELAY_VBIASP 0.01522f
C148 a_6635_1044# a_4350_1044# 0.39036f
C149 a_10517_1842# a_10430_1044# 0.1088f
C150 VDD a_12797_1842# 0.87771f
C151 a_21625_1044# a_21157_1842# 0.2079f
C152 MUX_SEL2 a_1256_289# 0.33134f
C153 a_4003_1842# DELAY_VBIASP 0.05992f
C154 a_22351_2470# VDD 0.01806f
C155 a_6913_1842# DELAY_VBIASP 0.11222f
C156 a_22590_1044# a_23431_1008# 0.28268f
C157 MUX_SEL4 VDD 2.63176f
C158 a_12505_1044# a_12715_1044# 0.09424f
C159 a_4157_1313# DELAY_IN 0.50642f
C160 VDD a_12993_1842# 0.49426f
C161 a_6425_1044# a_4350_1044# 0.03208f
C162 VDD a_19963_1842# 0.4973f
C163 VDD a_4763_1842# 0.4973f
C164 a_12471_1842# a_12363_1842# 0.01163f
C165 a_7390_1044# a_8808_1044# 0.38994f
C166 a_14888_1044# a_14964_1008# 0.01176f
C167 a_18877_1842# DELAY_VBIASN 0.09992f
C168 a_16510_1044# a_17865_519# 0.02165f
C169 a_2019_311# a_17865_519# 0.13959f
C170 a_18313_1842# a_18443_1842# 0.70845f
C171 a_26985_519# a_25630_1044# 0.02165f
C172 a_6711_1008# a_6717_1842# 0.02354f
C173 a_15831_1008# a_15837_1842# 0.02354f
C174 a_19550_1044# a_21917_1842# 0.02479f
C175 a_3449_331# MUX_SEL4 0.05166f
C176 a_4350_1044# a_5115_1044# 0.39037f
C177 a_15765_463# MUX_SEL4 0.65508f
C178 a_15545_1044# a_15831_1008# 0.01885f
C179 a_10951_1842# a_10843_1842# 0.01163f
C180 a_17357_1842# DELAY_VBIASP 0.0414f
C181 a_17357_1842# a_17683_1842# 0.01427f
C182 a_16033_1842# a_16597_1842# 0.0114f
C183 VDD a_21911_1008# 0.2822f
C184 a_26673_1842# a_27237_1842# 0.0114f
C185 a_5844_1008# a_5197_1842# 0.02312f
C186 a_13444_1008# VDD 0.28633f
C187 VDD a_27237_1842# 0.85969f
C188 a_4633_1842# a_4763_1842# 0.70845f
C189 a_4157_1313# MUX_SEL4 0.08229f
C190 a_20723_1842# a_20397_1842# 0.01427f
C191 MUX_OUT MUX_SEL1 0.09357f
C192 MUX_SEL4 MUX_SEL2 0.01978f
C193 VDD a_2873_1395# 0.46517f
C194 VDD a_15273_1842# 0.49285f
C195 a_25717_1842# a_26477_1842# 0.01669f
C196 DELAY_VBIASP a_13883_1842# 0.06627f
C197 a_18871_1008# VDD 0.2822f
C198 DELAY_VBIASN a_13753_1842# 0.0961f
C199 a_24393_1842# VDD 0.49285f
C200 a_4871_2470# VDD 0.01806f
C201 DELAY_VBIASN a_5523_1842# 0.07254f
C202 a_14025_1044# VDD 0.30409f
C203 a_18795_1044# a_18871_1008# 0.01194f
C204 DELAY_VBIASP a_6717_1842# 0.0414f
C205 a_24197_1842# a_24957_1842# 0.02912f
C206 a_13991_2470# a_13883_1842# 0.01697f
C207 a_22590_1044# a_22677_1842# 0.1088f
C208 DELAY_VBIASP a_12037_1842# 0.04141f
C209 DELAY_VBIASN a_10843_1842# 0.07254f
C210 a_10083_1842# VDD 0.49727f
C211 a_11271_1008# a_10430_1044# 0.28268f
C212 MUX_SEL4 a_4350_1044# 0.31434f
C213 DELAY_VBIASN a_19073_1842# 0.0961f
C214 DELAY_VBIASP a_19203_1842# 0.06627f
C215 a_27048_1044# a_26477_1842# 0.10863f
C216 a_10517_1842# a_10083_1842# 0.69698f
C217 a_5705_519# VDD 0.29556f
C218 a_23437_1842# a_23003_1842# 0.6972f
C219 a_17275_1044# a_17351_1008# 0.01194f
C220 a_15964_289# VDD 0.31312f
C221 a_19550_1044# a_20968_1044# 0.38994f
C222 a_16510_1044# a_18004_1008# 0.28279f
C223 a_18877_1842# a_19073_1842# 0.76914f
C224 a_4763_1842# a_4350_1044# 0.01012f
C225 VDD a_26395_1044# 0.15389f
C226 a_5844_1008# VDD 0.28225f
C227 VDD a_9431_2470# 0.01806f
C228 a_7288_1044# a_7390_1044# 0.37183f
C229 a_9193_1842# a_9757_1842# 0.0114f
C230 a_7043_1842# VDD 0.49723f
C231 VDD a_20723_1842# 0.49671f
C232 a_26151_2470# VDD 0.01806f
C233 a_4905_1044# VDD 0.30126f
C234 a_9323_1842# a_9431_1842# 0.01163f
C235 VDD MUX_SEL3 0.4053f
C236 DELAY_VBIASN a_16033_1842# 0.0961f
C237 DELAY_VBIASP a_16163_1842# 0.06627f
C238 MUX_OUT a_16851_309# 0.45865f
C239 a_15765_463# a_15964_289# 0.061f
C240 VDD a_18551_2470# 0.01806f
C241 a_13470_1044# a_14311_1008# 0.28268f
C242 a_8563_1842# a_8997_1842# 0.6972f
C243 a_7803_1842# a_7390_1044# 0.01012f
C244 VDD a_27991_1008# 0.28201f
C245 a_7945_1044# a_7390_1044# 0.03209f
C246 DELAY_VBIASP a_26477_1842# 0.04144f
C247 DELAY_VBIASN a_25283_1842# 0.07254f
C248 a_5957_1842# a_6153_1842# 0.77122f
C249 a_5768_1044# a_5844_1008# 0.01176f
C250 a_25630_1044# a_26471_1008# 0.28268f
C251 a_11277_1842# a_11473_1842# 0.76914f
C252 a_8237_1842# a_8997_1842# 0.03319f
C253 a_13470_1044# a_15403_1842# 0.01012f
C254 a_21917_1842# a_22677_1842# 0.06198f
C255 VDD a_4324_1008# 0.28597f
C256 a_23633_1842# DELAY_VBIASP 0.11222f
C257 a_23437_1842# DELAY_VBIASN 0.09974f
C258 a_27997_1842# DELAY_VBIASP 0.04001f
C259 a_17553_1842# VDD 0.49417f
C260 a_19833_1842# a_19963_1842# 0.70845f
C261 a_26803_1842# DELAY_VBIASN 0.07254f
C262 a_1256_1044# a_1544_1044# 1.26509f
C263 a_3449_331# MUX_SEL3 0.28429f
C264 a_18117_1842# a_18004_1008# 0.02055f
C265 a_7043_1842# a_7151_1842# 0.01163f
C266 a_9193_1842# DELAY_VBIASN 0.0961f
C267 a_9323_1842# DELAY_VBIASP 0.06627f
C268 a_24875_1044# a_24951_1008# 0.01194f
C269 a_16108_289# a_22590_1044# 0.58202f
C270 a_11848_1044# VDD 0.17499f
C271 a_7477_1842# a_7043_1842# 0.69698f
C272 a_14311_1008# a_14317_1842# 0.02349f
C273 VDD a_10328_1044# 0.17274f
C274 a_8997_1842# DELAY_VBIASP 0.04141f
C275 a_7803_1842# DELAY_VBIASN 0.07254f
C276 DELAY_VBIASP a_22677_1842# 0.0414f
C277 DELAY_VBIASN a_21483_1842# 0.07254f
C278 a_20315_1044# VDD 0.15389f
C279 a_5705_519# a_4350_1044# 0.02005f
C280 a_17357_1842# a_16510_1044# 0.08038f
C281 VDD a_15077_1842# 0.85963f
C282 a_14643_1842# a_15077_1842# 0.6972f
C283 MUX_SEL2 MUX_SEL3 3.21891f
C284 a_20905_519# VDD 0.29292f
C285 a_5844_1008# a_4350_1044# 0.28279f
C286 VDD a_12233_1842# 0.49285f
C287 a_4003_1842# DELAY_IN 0.54998f
C288 a_4437_1842# DELAY_VBIASP 0.0414f
C289 a_21591_2470# VDD 0.01806f
C290 a_22590_1044# a_23355_1044# 0.39037f
C291 a_27915_1044# a_27991_1008# 0.01194f
C292 DELAY_IN MUX_SEL1 0.01858f
C293 VDD a_20397_1842# 0.86909f
C294 DELAY_OUT_LAST DELAY_VBIASN 0.04786f
C295 a_12505_1044# a_10430_1044# 0.03208f
C296 a_4157_1313# a_4324_1008# 0.02463f
C297 a_4905_1044# a_4350_1044# 0.03209f
C298 a_5731_289# MUX_OUT 1.04829f
C299 VDD a_5197_1842# 0.86909f
C300 a_8745_519# MUX_SEL4 0.04472f
C301 a_18443_1842# DELAY_VBIASP 0.06627f
C302 a_18313_1842# DELAY_VBIASN 0.0961f
C303 a_7390_1044# a_8231_1008# 0.28268f
C304 a_16510_1044# a_16851_309# 0.02131f
C305 a_15511_1842# a_15403_1842# 0.01163f
C306 a_2019_311# a_16851_309# 0.01299f
C307 a_18313_1842# a_18877_1842# 0.0114f
C308 VDD a_24084_1008# 0.28225f
C309 a_16408_1044# VDD 0.17274f
C310 a_8237_1842# a_8884_1008# 0.02312f
C311 a_22351_2470# a_22243_1842# 0.01697f
C312 a_14825_519# MUX_SEL4 0.03307f
C313 a_4350_1044# a_4324_1008# 0.277f
C314 a_15545_1044# a_15755_1044# 0.09424f
C315 a_16108_289# a_21917_1842# 0.0157f
C316 a_17357_1842# a_18117_1842# 0.03319f
C317 a_15837_1842# a_16163_1842# 0.01427f
C318 a_23003_1842# a_22590_1044# 0.01012f
C319 a_24665_1044# VDD 0.29722f
C320 a_5768_1044# a_5197_1842# 0.10863f
C321 a_17065_1044# a_16597_1842# 0.19203f
C322 a_20831_2470# a_20723_1842# 0.01697f
C323 VDD a_26673_1842# 0.49417f
C324 a_4633_1842# a_5197_1842# 0.0114f
C325 MUX_SEL4 MUX_SEL1 0.03574f
C326 VDD a_14643_1842# 0.49671f
C327 DELAY_VBIASP a_14317_1842# 0.0414f
C328 a_25717_1842# a_25913_1842# 0.73897f
C329 DELAY_VBIASN a_13123_1842# 0.07254f
C330 DELAY_VBIASN a_21157_1842# 0.09156f
C331 a_4111_2470# VDD 0.01866f
C332 a_23763_1842# VDD 0.49671f
C333 a_18795_1044# VDD 0.15406f
C334 a_16484_1008# a_16597_1842# 0.05157f
C335 DELAY_VBIASP a_6153_1842# 0.11222f
C336 DELAY_VBIASN a_5957_1842# 0.09156f
C337 a_24197_1842# a_24393_1842# 0.77122f
C338 DELAY_VBIASP a_11473_1842# 0.11222f
C339 DELAY_VBIASN a_11277_1842# 0.09974f
C340 a_17065_1044# a_17351_1008# 0.01885f
C341 a_10517_1842# VDD 0.86707f
C342 a_11195_1044# a_10430_1044# 0.39037f
C343 a_24951_1008# a_22590_1044# 0.26208f
C344 a_13470_1044# a_13557_1842# 0.1088f
C345 DELAY_VBIASP a_19637_1842# 0.0414f
C346 a_25630_1044# a_27237_1842# 0.05253f
C347 a_9953_1842# a_10083_1842# 0.70845f
C348 a_26471_1008# a_26477_1842# 0.02349f
C349 a_3449_331# VDD 0.46596f
C350 a_19550_1044# a_20391_1008# 0.28268f
C351 VDD a_22873_1842# 0.49294f
C352 a_15765_463# VDD 0.35368f
C353 a_16510_1044# a_17928_1044# 0.38994f
C354 a_11924_1008# a_12037_1842# 0.02055f
C355 a_5197_1842# a_4350_1044# 0.08038f
C356 a_10430_1044# a_12037_1842# 0.05231f
C357 a_2019_311# a_5731_289# 1.15781f
C358 a_5768_1044# VDD 0.17499f
C359 VDD a_25604_1008# 0.28633f
C360 a_22590_1044# DELAY_VBIASN 0.02115f
C361 a_14513_1842# a_15077_1842# 0.0114f
C362 a_24957_1842# a_25528_1044# 0.10864f
C363 VDD a_8671_2470# 0.01806f
C364 a_26151_2470# a_26043_1842# 0.01697f
C365 a_16108_289# a_26985_519# 0.2906f
C366 a_26151_1842# a_26043_1842# 0.01163f
C367 a_4633_1842# VDD 0.49285f
C368 a_7477_1842# VDD 0.86707f
C369 a_25391_2470# VDD 0.01806f
C370 a_4157_1313# VDD 0.48935f
C371 a_12037_1842# a_12797_1842# 0.02912f
C372 VDD MUX_SEL2 0.50938f
C373 a_19550_1044# a_19963_1842# 0.01012f
C374 MUX_SEL1 a_2873_1395# 0.13092f
C375 DELAY_VBIASN a_15403_1842# 0.07254f
C376 DELAY_VBIASP a_16597_1842# 0.0414f
C377 a_27124_1008# a_27237_1842# 0.02055f
C378 a_13557_1842# a_14317_1842# 0.01669f
C379 MUX_OUT a_16108_289# 0.24265f
C380 MUX_SEL4 a_6717_1842# 0.0195f
C381 a_24523_1842# DELAY_VBIASN 0.07254f
C382 VDD a_17791_2470# 0.01806f
C383 a_13470_1044# a_14235_1044# 0.39037f
C384 a_8563_1842# a_8433_1842# 0.70845f
C385 a_15511_2470# a_15403_1842# 0.01697f
C386 a_8237_1842# a_7390_1044# 0.08038f
C387 VDD a_27915_1044# 0.15389f
C388 a_5957_1842# a_5523_1842# 0.6972f
C389 DELAY_VBIASP a_25913_1842# 0.11222f
C390 DELAY_VBIASN a_25717_1842# 0.08411f
C391 a_25630_1044# a_26395_1044# 0.39037f
C392 a_20071_2470# a_19963_1842# 0.01697f
C393 a_11277_1842# a_10843_1842# 0.6972f
C394 a_13470_1044# a_15837_1842# 0.02479f
C395 a_8237_1842# a_8433_1842# 0.76914f
C396 a_21917_1842# a_22113_1842# 0.76914f
C397 VDD a_4350_1044# 0.87635f
C398 a_23003_1842# DELAY_VBIASP 0.06627f
C399 a_27433_1842# DELAY_VBIASP 0.11222f
C400 a_16923_1842# VDD 0.4973f
C401 a_19833_1842# a_20397_1842# 0.0114f
C402 a_15545_1044# a_13470_1044# 0.03208f
C403 a_3449_331# MUX_SEL2 0.10741f
C404 a_18443_1842# a_16510_1044# 0.01012f
C405 a_19550_1044# a_21911_1008# 0.26208f
C406 a_9757_1842# DELAY_VBIASP 0.0414f
C407 a_8563_1842# DELAY_VBIASN 0.07254f
C408 a_11271_1008# VDD 0.28336f
C409 a_6913_1842# a_7043_1842# 0.70845f
C410 VDD a_9751_1008# 0.2822f
C411 a_25630_1044# a_27991_1008# 0.26208f
C412 a_8237_1842# DELAY_VBIASN 0.09974f
C413 a_8433_1842# DELAY_VBIASP 0.11222f
C414 DELAY_VBIASP a_22113_1842# 0.11222f
C415 a_24008_1044# a_24084_1008# 0.01176f
C416 DELAY_VBIASN a_21917_1842# 0.09992f
C417 a_19524_1008# VDD 0.28633f
C418 a_24631_2470# a_24523_1842# 0.01697f
C419 a_5731_289# a_10430_1044# 0.41176f
C420 VDD a_14513_1842# 0.49417f
C421 a_1256_289# a_2873_331# 0.27926f
C422 a_1544_289# a_2297_331# 0.27303f
C423 a_14643_1842# a_14513_1842# 0.70845f
C424 a_17865_519# VDD 0.29444f
C425 a_5768_1044# a_4350_1044# 0.38994f
C426 VDD a_6283_1842# 0.4973f
C427 a_9757_1842# a_10404_1008# 0.02011f
C428 a_24957_1842# a_16108_289# 0.0157f
C429 VDD a_11603_1842# 0.49671f
C430 a_4437_1842# DELAY_IN 0.05007f
C431 a_20831_2470# VDD 0.01806f
C432 a_22590_1044# a_22564_1008# 0.277f
C433 a_23111_2470# a_23003_1842# 0.01697f
C434 a_11785_519# a_10430_1044# 0.02058f
C435 a_4157_1313# a_4350_1044# 0.04624f
C436 DELAY_IN MUX_SEL0 0.14089f
C437 VDD a_19833_1842# 0.49294f
C438 DELAY_VBIASP DELAY_VBIASN 3.50557f
C439 a_10985_1044# a_10430_1044# 0.03209f
C440 a_5731_289# MUX_SEL4 4.60702f
C441 a_12471_2470# a_12363_1842# 0.01697f
C442 a_18877_1842# DELAY_VBIASP 0.0414f
C443 a_17683_1842# DELAY_VBIASN 0.07254f
C444 a_16510_1044# a_16108_289# 0.56108f
C445 a_2019_311# a_16108_289# 0.33889f
C446 a_15964_289# a_16851_309# 0.16757f
C447 VDD a_24008_1044# 0.17499f
C448 a_24197_1842# a_24084_1008# 0.02055f
C449 a_15831_1008# VDD 0.2816f
C450 a_8237_1842# a_8808_1044# 0.10863f
C451 a_21625_1044# a_21911_1008# 0.01885f
C452 a_7945_1044# a_8231_1008# 0.01885f
C453 a_4248_1044# a_4324_1008# 0.01176f
C454 a_10951_2470# a_10843_1842# 0.01697f
C455 a_11785_519# MUX_SEL4 0.03255f
C456 a_1544_1044# MUX_OUT 0.04258f
C457 a_7043_1842# a_6717_1842# 0.01427f
C458 a_17357_1842# a_17553_1842# 0.76914f
C459 VDD a_16793_1842# 0.49277f
C460 a_26477_1842# a_27237_1842# 0.03319f
C461 a_15837_1842# a_16597_1842# 0.06198f
C462 a_23437_1842# a_22590_1044# 0.08038f
C463 a_23145_1044# VDD 0.30409f
C464 MUX_OUT a_2297_331# 0.01179f
C465 MUX_SEL4 a_2873_331# 0.04916f
C466 DELAY_VBIASN a_12363_1842# 0.07254f
C467 VDD a_26043_1842# 0.4973f
C468 a_24197_1842# a_24665_1044# 0.2079f
C469 DELAY_VBIASP a_13753_1842# 0.11222f
C470 a_25717_1842# a_25283_1842# 0.69698f
C471 DELAY_VBIASN a_13557_1842# 0.08375f
C472 a_27563_1842# VDD 0.49811f
C473 a_24197_1842# VDD 0.85848f
C474 a_18004_1008# VDD 0.28225f
C475 DELAY_VBIASN a_20593_1842# 0.0961f
C476 a_16510_1044# a_16597_1842# 0.1088f
C477 a_8745_519# VDD 0.29292f
C478 DELAY_VBIASP a_5523_1842# 0.06627f
C479 DELAY_VBIASN a_5393_1842# 0.0961f
C480 a_24197_1842# a_23763_1842# 0.6972f
C481 a_22564_1008# a_21917_1842# 0.02011f
C482 a_6283_1842# a_4350_1044# 0.01012f
C483 DELAY_VBIASP a_10843_1842# 0.06627f
C484 a_17065_1044# a_17275_1044# 0.09424f
C485 a_9953_1842# VDD 0.49426f
C486 a_8155_1044# VDD 0.15389f
C487 a_18443_1842# a_18551_1842# 0.01163f
C488 a_24875_1044# a_22590_1044# 0.39036f
C489 a_13470_1044# MUX_SEL4 0.256f
C490 DELAY_VBIASP a_19073_1842# 0.11222f
C491 a_9953_1842# a_10517_1842# 0.0114f
C492 VDD a_22243_1842# 0.49737f
C493 a_19550_1044# a_20315_1044# 0.39037f
C494 a_14825_519# VDD 0.29292f
C495 a_16510_1044# a_17351_1008# 0.28268f
C496 a_12505_1044# VDD 0.29722f
C497 a_21044_1008# a_21157_1842# 0.02055f
C498 VDD a_25630_1044# 0.89531f
C499 a_19550_1044# a_20905_519# 0.02165f
C500 a_5705_519# a_5731_289# 0.28954f
C501 a_5731_289# a_15964_289# 0.2778f
C502 a_16923_1842# a_17031_1842# 0.01163f
C503 VDD a_7911_2470# 0.01806f
C504 a_24957_1842# a_24951_1008# 0.02354f
C505 a_16108_289# a_23945_519# 0.2906f
C506 a_4003_1842# VDD 0.61559f
C507 a_6913_1842# VDD 0.49426f
C508 a_4003_1842# a_4111_2470# 0.01697f
C509 a_12037_1842# a_12233_1842# 0.77122f
C510 a_9323_1842# a_9431_2470# 0.01697f
C511 VDD MUX_SEL1 0.50267f
C512 a_19550_1044# a_20397_1842# 0.08038f
C513 MUX_SEL0 a_2873_1395# 0.01504f
C514 DELAY_VBIASN a_15837_1842# 0.09992f
C515 DELAY_VBIASP a_16033_1842# 0.11222f
C516 a_13557_1842# a_13753_1842# 0.73897f
C517 MUX_SEL4 a_16108_289# 0.1283f
C518 a_24957_1842# DELAY_VBIASN 0.09992f
C519 VDD a_17031_2470# 0.01806f
C520 a_16923_1842# a_16793_1842# 0.70845f
C521 a_13470_1044# a_13444_1008# 0.277f
C522 VDD a_27124_1008# 0.28225f
C523 a_5393_1842# a_5523_1842# 0.70845f
C524 DELAY_VBIASP a_25283_1842# 0.06627f
C525 DELAY_VBIASN a_25153_1842# 0.0961f
C526 a_10713_1842# DELAY_VBIASN 0.0961f
C527 a_25630_1044# a_25604_1008# 0.277f
C528 a_2019_311# a_2297_331# 0.04011f
C529 a_8237_1842# a_7803_1842# 0.6972f
C530 a_21917_1842# a_21483_1842# 0.6972f
C531 VDD a_4248_1044# 0.17587f
C532 a_16510_1044# DELAY_VBIASN 0.02115f
C533 a_23437_1842# DELAY_VBIASP 0.0414f
C534 a_26803_1842# DELAY_VBIASP 0.06627f
C535 a_17357_1842# VDD 0.86909f
C536 a_14025_1044# a_13470_1044# 0.03209f
C537 a_18877_1842# a_16510_1044# 0.02479f
C538 a_7043_1842# a_7151_2470# 0.01697f
C539 a_9193_1842# DELAY_VBIASP 0.11222f
C540 a_21591_1842# a_21483_1842# 0.01163f
C541 a_26185_1044# a_25717_1842# 0.19203f
C542 a_20105_1044# a_20391_1008# 0.01885f
C543 a_11195_1044# VDD 0.15389f
C544 a_4905_1044# a_4437_1842# 0.19203f
C545 a_6913_1842# a_7477_1842# 0.0114f
C546 MUX_SEL3 a_2873_331# 0.12606f
C547 a_25630_1044# a_27915_1044# 0.39036f
C548 VDD a_9675_1044# 0.15406f
C549 DELAY_VBIASP a_21483_1842# 0.06627f
C550 DELAY_VBIASN a_21353_1842# 0.0961f
C551 a_7673_1842# DELAY_VBIASN 0.0961f
C552 a_7803_1842# DELAY_VBIASP 0.06627f
C553 a_19550_1044# VDD 0.89766f
C554 a_1256_289# a_2297_331# 0.04261f
C555 a_1544_289# a_1721_331# 0.36963f
C556 VDD a_13883_1842# 0.4973f
C557 a_16851_309# VDD 0.51536f
C558 VDD a_6717_1842# 0.87726f
C559 VDD a_12037_1842# 0.85848f
C560 a_5631_2470# a_5523_1842# 0.01697f
C561 a_18443_1842# a_18551_2470# 0.01697f
C562 a_4437_1842# a_4324_1008# 0.05157f
C563 a_20071_2470# VDD 0.01806f
C564 a_22488_1044# a_22564_1008# 0.01176f
C565 DELAY_VBIASP DELAY_OUT_LAST 0.21225f
C566 DELAY_IN DELAY_VBIASN 0.07156f
C567 a_4157_1313# a_4248_1044# 0.11672f
C568 a_10713_1842# a_10843_1842# 0.70845f
C569 VDD a_19203_1842# 0.49737f
C570 a_18117_1842# DELAY_VBIASN 0.09156f
C571 a_18313_1842# DELAY_VBIASP 0.11222f
C572 a_15964_289# a_16108_289# 0.42202f
C573 a_9757_1842# MUX_SEL4 0.01829f
C574 a_6391_1842# a_6283_1842# 0.01163f
C575 a_18117_1842# a_18877_1842# 0.02912f
C576 a_16923_1842# a_17031_2470# 0.01697f
C577 MUX_SEL4 a_7390_1044# 0.34655f
C578 VDD a_23431_1008# 0.28336f
C579 a_24523_1842# a_22590_1044# 0.01012f
C580 a_15755_1044# VDD 0.15389f
C581 a_8237_1842# a_8231_1008# 0.02349f
C582 a_10430_1044# DELAY_VBIASN 0.02115f
C583 a_4248_1044# a_4350_1044# 0.37183f
C584 a_1256_1044# MUX_OUT 0.02466f
C585 a_21917_1842# a_21157_1842# 0.02912f
C586 a_1544_1044# MUX_SEL4 0.03407f
C587 a_7477_1842# a_6717_1842# 0.06198f
C588 VDD a_16163_1842# 0.4973f
C589 a_17357_1842# a_16923_1842# 0.6972f
C590 a_4871_1842# a_4763_1842# 0.01163f
C591 a_26477_1842# a_26673_1842# 0.76914f
C592 a_15837_1842# a_16033_1842# 0.76914f
C593 a_21625_1044# VDD 0.29722f
C594 a_12715_1044# a_12791_1008# 0.01194f
C595 MUX_SEL4 a_2297_331# 0.04338f
C596 VDD a_26477_1842# 0.86909f
C597 DELAY_VBIASN a_12797_1842# 0.09992f
C598 a_24957_1842# a_25283_1842# 0.01427f
C599 a_4437_1842# a_5197_1842# 0.01669f
C600 a_27433_1842# a_27237_1842# 0.77122f
C601 VDD a_2297_1395# 0.46536f
C602 a_13470_1044# a_15077_1842# 0.05231f
C603 a_25153_1842# a_25283_1842# 0.70845f
C604 DELAY_VBIASN a_12993_1842# 0.0961f
C605 DELAY_VBIASP a_13123_1842# 0.06627f
C606 DELAY_VBIASN a_19963_1842# 0.07254f
C607 a_17928_1044# VDD 0.17499f
C608 DELAY_VBIASP a_21157_1842# 0.04141f
C609 a_23633_1842# VDD 0.49417f
C610 a_27997_1842# VDD 0.76025f
C611 DELAY_VBIASN a_4763_1842# 0.07254f
C612 a_20968_1044# a_21044_1008# 0.01176f
C613 DELAY_VBIASP a_5957_1842# 0.04141f
C614 a_5731_289# VDD 0.6143f
C615 a_13368_1044# a_12797_1842# 0.10864f
C616 a_11195_1044# a_11271_1008# 0.01194f
C617 a_23633_1842# a_23763_1842# 0.70845f
C618 a_6717_1842# a_4350_1044# 0.02479f
C619 a_18585_1044# a_16510_1044# 0.03208f
C620 DELAY_VBIASP a_11277_1842# 0.0414f
C621 a_9323_1842# VDD 0.4973f
C622 a_7364_1008# VDD 0.28633f
C623 a_19311_1842# a_19203_1842# 0.01163f
C624 a_9675_1044# a_9751_1008# 0.01194f
C625 a_9757_1842# a_10083_1842# 0.01427f
C626 a_8997_1842# VDD 0.85848f
C627 a_25630_1044# a_26043_1842# 0.01012f
C628 a_19550_1044# a_19524_1008# 0.277f
C629 VDD a_22677_1842# 0.86707f
C630 a_16510_1044# a_17275_1044# 0.39037f
C631 a_11785_519# VDD 0.29292f
C632 a_1721_1395# VDD 0.4533f
C633 a_10985_1044# VDD 0.30409f
C634 VDD a_25528_1044# 0.17274f
C635 a_10430_1044# a_10843_1842# 0.01012f
C636 a_14317_1842# a_15077_1842# 0.03319f
C637 a_5731_289# a_15765_463# 0.23301f
C638 VDD a_7151_2470# 0.01806f
C639 a_27563_1842# a_25630_1044# 0.01024f
C640 a_16108_289# a_20905_519# 0.2906f
C641 a_4437_1842# VDD 0.86998f
C642 VDD a_2873_331# 0.46491f
C643 a_10985_1044# a_10517_1842# 0.19203f
C644 a_6717_1842# a_6283_1842# 0.6972f
C645 DELAY_VBIASN a_27237_1842# 0.09456f
C646 a_23763_1842# a_23871_1842# 0.01163f
C647 a_12037_1842# a_11603_1842# 0.6972f
C648 a_26911_2470# a_26803_1842# 0.01697f
C649 DELAY_IN a_3449_1395# 0.01058f
C650 a_22677_1842# a_22873_1842# 0.73897f
C651 VDD MUX_SEL0 0.56365f
C652 DELAY_VBIASP a_15403_1842# 0.06627f
C653 DELAY_VBIASN a_15273_1842# 0.0961f
C654 a_26911_1842# a_26803_1842# 0.01163f
C655 a_13557_1842# a_13123_1842# 0.69698f
C656 a_24393_1842# DELAY_VBIASN 0.0961f
C657 a_24523_1842# DELAY_VBIASP 0.06627f
C658 VDD a_16271_2470# 0.01806f
C659 a_20593_1842# a_21157_1842# 0.0114f
C660 a_18443_1842# VDD 0.4973f
C661 a_13368_1044# a_13444_1008# 0.01176f
C662 a_8563_1842# a_8237_1842# 0.01427f
C663 a_7477_1842# a_7364_1008# 0.05157f
C664 a_17357_1842# a_16793_1842# 0.0114f
C665 a_18877_1842# a_18871_1008# 0.02354f
C666 a_21835_1044# a_21911_1008# 0.01194f
C667 a_5393_1842# a_5957_1842# 0.0114f
C668 DELAY_VBIASP a_25717_1842# 0.0414f
C669 a_18117_1842# a_18585_1044# 0.2079f
C670 a_10083_1842# DELAY_VBIASN 0.07254f
C671 a_27705_1044# a_27237_1842# 0.2079f
C672 a_25528_1044# a_25604_1008# 0.01176f
C673 a_2019_311# a_1721_331# 0.18452f
C674 a_13470_1044# VDD 0.87936f
C675 a_14964_1008# a_15077_1842# 0.02055f
C676 a_7673_1842# a_7803_1842# 0.70845f
C677 a_21353_1842# a_21483_1842# 0.70845f
C678 a_19637_1842# a_20397_1842# 0.01669f
C679 a_5731_289# a_4350_1044# 0.41099f
C680 a_13231_1842# a_13123_1842# 0.01163f
C681 a_17357_1842# a_18004_1008# 0.02312f
C682 a_4437_1842# a_4633_1842# 0.73897f
C683 a_8563_1842# DELAY_VBIASP 0.06627f
C684 a_20105_1044# a_20315_1044# 0.09424f
C685 a_4157_1313# a_4437_1842# 0.01771f
C686 MUX_SEL3 a_2297_331# 0.01595f
C687 MUX_SEL2 a_2873_331# 0.01422f
C688 a_25630_1044# a_27124_1008# 0.28279f
C689 VDD a_8884_1008# 0.28225f
C690 DELAY_VBIASP a_21917_1842# 0.0414f
C691 a_7043_1842# DELAY_VBIASN 0.07254f
C692 a_8237_1842# DELAY_VBIASP 0.0414f
C693 DELAY_VBIASN a_20723_1842# 0.07254f
C694 a_19448_1044# VDD 0.17274f
C695 MUX_SEL0 MUX_SEL2 0.01204f
C696 a_1256_289# a_1721_331# 0.13421f
C697 VDD a_14317_1842# 0.86909f
C698 a_16108_289# VDD 1.25759f
C699 a_14643_1842# a_14317_1842# 0.01427f
C700 a_9757_1842# a_10328_1044# 0.10864f
C701 VDD a_6153_1842# 0.49285f
C702 a_26471_1008# a_26185_1044# 0.01885f
C703 a_15755_1044# a_15831_1008# 0.01194f
C704 VDD a_11473_1842# 0.49417f
C705 a_4437_1842# a_4350_1044# 0.1088f
C706 a_19311_2470# VDD 0.01806f
C707 a_22488_1044# a_22590_1044# 0.37183f
C708 a_10985_1044# a_11271_1008# 0.01885f
C709 a_23145_1044# a_23431_1008# 0.01885f
C710 a_10713_1842# a_11277_1842# 0.0114f
C711 VDD a_19637_1842# 0.86707f
C712 a_11711_1842# a_11603_1842# 0.01163f
C713 a_14235_1044# a_14311_1008# 0.01194f
C714 a_17683_1842# DELAY_VBIASP 0.06627f
C715 a_17553_1842# DELAY_VBIASN 0.0961f
C716 a_15765_463# a_16108_289# 0.42004f
C717 a_18117_1842# a_18313_1842# 0.77122f
C718 VDD a_23355_1044# 0.15389f
C719 a_27705_1044# a_27991_1008# 0.01885f
C720 a_24957_1842# a_22590_1044# 0.02479f
C721 a_14964_1008# VDD 0.28225f
C722 a_12505_1044# a_12037_1842# 0.2079f
C723 a_21353_1842# a_21157_1842# 0.77122f
C724 a_1256_1044# MUX_SEL4 0.04908f
C725 a_6913_1842# a_6717_1842# 0.76914f
C726 VDD a_16597_1842# 0.86876f
C727 a_15837_1842# a_15403_1842# 0.6972f
C728 DELAY_VBIASN a_15077_1842# 0.09156f
C729 a_26477_1842# a_26043_1842# 0.6972f
C730 a_6425_1044# a_5957_1842# 0.2079f
C731 a_20105_1044# VDD 0.30409f
C732 a_24957_1842# a_24523_1842# 0.6972f
C733 MUX_OUT a_1544_289# 0.69943f
C734 MUX_SEL4 a_1721_331# 0.05813f
C735 DELAY_VBIASP a_12363_1842# 0.06627f
C736 a_18585_1044# a_18871_1008# 0.01885f
C737 VDD a_25913_1842# 0.49294f
C738 DELAY_VBIASN a_12233_1842# 0.0961f
C739 a_12791_1008# a_10430_1044# 0.26208f
C740 a_24957_1842# a_25717_1842# 0.06198f
C741 a_26803_1842# a_27237_1842# 0.6972f
C742 a_25153_1842# a_25717_1842# 0.0114f
C743 DELAY_VBIASP a_13557_1842# 0.0414f
C744 DELAY_VBIASP a_20593_1842# 0.11222f
C745 a_17351_1008# VDD 0.28565f
C746 DELAY_VBIASN a_20397_1842# 0.09974f
C747 a_27433_1842# VDD 0.49285f
C748 a_23003_1842# VDD 0.4973f
C749 a_16484_1008# a_15837_1842# 0.02011f
C750 DELAY_VBIASN a_5197_1842# 0.09974f
C751 DELAY_VBIASP a_5393_1842# 0.11222f
C752 a_22488_1044# a_21917_1842# 0.10864f
C753 a_27997_1842# a_27563_1842# 0.69646f
C754 a_17928_1044# a_18004_1008# 0.01176f
C755 a_12791_1008# a_12797_1842# 0.02354f
C756 a_23633_1842# a_24197_1842# 0.0114f
C757 a_13231_2470# a_13123_1842# 0.01697f
C758 a_17065_1044# a_16510_1044# 0.03209f
C759 a_9757_1842# VDD 0.87771f
C760 a_23145_1044# a_22677_1842# 0.19203f
C761 a_5731_289# a_8745_519# 0.28635f
C762 a_7390_1044# VDD 0.8686f
C763 VDD a_12471_2470# 0.01806f
C764 a_24665_1044# a_24951_1008# 0.01885f
C765 a_25630_1044# a_26477_1842# 0.08038f
C766 a_8433_1842# VDD 0.49417f
C767 a_9757_1842# a_10517_1842# 0.06198f
C768 VDD a_22113_1842# 0.49426f
C769 a_19448_1044# a_19524_1008# 0.01176f
C770 a_16510_1044# a_16484_1008# 0.277f
C771 a_1256_1044# a_2873_1395# 0.28892f
C772 a_11924_1008# a_11277_1842# 0.02312f
C773 a_10083_1842# a_10191_1842# 0.01163f
C774 a_23003_1842# a_22873_1842# 0.70845f
C775 a_9465_1044# VDD 0.29722f
C776 a_1544_1044# VDD 0.45079f
C777 VDD a_24951_1008# 0.2822f
C778 a_10430_1044# a_11277_1842# 0.08038f
C779 a_14317_1842# a_14513_1842# 0.76914f
C780 a_5731_289# a_14825_519# 0.28056f
C781 a_16108_289# a_17865_519# 0.29564f
C782 a_13470_1044# a_15831_1008# 0.26208f
C783 VDD a_2297_331# 0.46496f
C784 a_12797_1842# a_13123_1842# 0.01427f
C785 a_6153_1842# a_6283_1842# 0.70845f
C786 DELAY_VBIASN a_26673_1842# 0.0961f
C787 a_6635_1044# a_6711_1008# 0.01194f
C788 a_8563_1842# a_8671_1842# 0.01163f
C789 a_11473_1842# a_11603_1842# 0.70845f
C790 MUX_SEL1 a_2297_1395# 0.01995f
C791 a_22677_1842# a_22243_1842# 0.69698f
C792 VDD DELAY_VBIASN 0.9333f
C793 a_19524_1008# a_19637_1842# 0.05157f
C794 DELAY_VBIASN a_14643_1842# 0.07254f
C795 a_27124_1008# a_26477_1842# 0.02312f
C796 DELAY_VBIASP a_15837_1842# 0.0414f
C797 a_12993_1842# a_13123_1842# 0.70845f
C798 a_24957_1842# DELAY_VBIASP 0.0414f
C799 a_23763_1842# DELAY_VBIASN 0.07254f
C800 a_18877_1842# VDD 0.87825f
C801 VDD a_15511_2470# 0.01806f
C802 a_7477_1842# a_7390_1044# 0.1088f
C803 a_7803_1842# a_7911_1842# 0.01163f
C804 a_5197_1842# a_5523_1842# 0.01427f
C805 a_6425_1044# a_6711_1008# 0.01885f
C806 DELAY_VBIASP a_25153_1842# 0.11222f
C807 a_10517_1842# DELAY_VBIASN 0.08375f
C808 a_10713_1842# DELAY_VBIASP 0.11222f
C809 a_25528_1044# a_25630_1044# 0.37183f
C810 a_2019_311# a_1544_289# 0.01747f
C811 a_23945_519# a_22590_1044# 0.02165f
C812 a_13368_1044# VDD 0.17274f
C813 a_7673_1842# a_8237_1842# 0.0114f
C814 a_21353_1842# a_21917_1842# 0.0114f
C815 VDD a_27705_1044# 0.29918f
C816 a_19637_1842# a_19833_1842# 0.73897f
C817 DELAY_VBIASN a_22873_1842# 0.0961f
C818 a_21835_1044# VDD 0.15406f
C819 a_17357_1842# a_17928_1044# 0.10863f
C820 a_4437_1842# a_4003_1842# 0.69698f
C821 a_21625_1044# a_19550_1044# 0.03208f
C822 a_4633_1842# DELAY_VBIASN 0.0961f
C823 MUX_SEL2 a_2297_331# 0.10655f
C824 VDD a_8808_1044# 0.17499f
C825 a_7477_1842# DELAY_VBIASN 0.08375f
C826 a_7673_1842# DELAY_VBIASP 0.11222f
C827 a_24631_2470# VDD 0.01806f
C828 a_14825_519# a_13470_1044# 0.02058f
C829 DELAY_VBIASP a_21353_1842# 0.11222f
C830 a_4157_1313# DELAY_VBIASN 0.01202f
C831 a_1256_289# a_1544_289# 1.25711f
C832 VDD a_13753_1842# 0.49294f
C833 MUX_SEL0 MUX_SEL1 3.14917f
C834 VDD a_5523_1842# 0.49671f
C835 a_9757_1842# a_9751_1008# 0.02354f
C836 a_26395_1044# a_26185_1044# 0.09424f
C837 a_7390_1044# a_9751_1008# 0.26208f
C838 VDD a_10843_1842# 0.4973f
C839 a_16271_1842# a_16163_1842# 0.01163f
C840 a_10985_1044# a_11195_1044# 0.09424f
C841 a_7364_1008# a_6717_1842# 0.02011f
C842 a_23145_1044# a_23355_1044# 0.09424f
C843 DELAY_IN DELAY_VBIASP 0.07719f
C844 VDD a_19073_1842# 0.49426f
C845 a_9465_1044# a_9751_1008# 0.01885f
C846 DELAY_VBIASN a_4350_1044# 0.02115f
C847 a_2019_311# MUX_OUT 8.45486f
C848 a_18117_1842# DELAY_VBIASP 0.04141f
C849 a_16923_1842# DELAY_VBIASN 0.07254f
C850 a_5115_1044# a_5191_1008# 0.01194f
C851 a_14751_1842# a_14643_1842# 0.01163f
C852 a_18117_1842# a_17683_1842# 0.6972f
C853 a_27705_1044# a_27915_1044# 0.09424f
C854 a_16597_1842# a_16793_1842# 0.73897f
C855 VDD a_22564_1008# 0.28633f
C856 a_23437_1842# a_24084_1008# 0.02312f
C857 a_14888_1044# VDD 0.17499f
C858 a_16108_289# a_25630_1044# 0.55833f
C859 a_5844_1008# a_5957_1842# 0.02055f
C860 a_21591_2470# a_21483_1842# 0.01697f
C861 a_14025_1044# a_14311_1008# 0.01885f
C862 a_20723_1842# a_21157_1842# 0.6972f
C863 VDD a_3449_1395# 0.46731f
C864 VDD a_16033_1842# 0.49413f
C865 a_25913_1842# a_26043_1842# 0.70845f
C866 DELAY_VBIASN a_14513_1842# 0.0961f
C867 a_15273_1842# a_15403_1842# 0.70845f
C868 a_18877_1842# a_19524_1008# 0.02011f
C869 a_18585_1044# VDD 0.29722f
C870 DELAY_VBIASN a_6283_1842# 0.07254f
C871 a_24393_1842# a_24523_1842# 0.70845f
C872 DELAY_VBIASP a_12797_1842# 0.0414f
C873 MUX_OUT a_1256_289# 0.1134f
C874 MUX_SEL4 a_1544_289# 0.47529f
C875 DELAY_VBIASN a_11603_1842# 0.07254f
C876 a_18585_1044# a_18795_1044# 0.09424f
C877 VDD a_25283_1842# 0.49737f
C878 a_12715_1044# a_10430_1044# 0.39036f
C879 a_24957_1842# a_25153_1842# 0.76914f
C880 a_26803_1842# a_26673_1842# 0.70845f
C881 a_10430_1044# a_10404_1008# 0.277f
C882 a_13470_1044# a_13883_1842# 0.01012f
C883 DELAY_VBIASP a_12993_1842# 0.11222f
C884 a_23437_1842# VDD 0.86909f
C885 DELAY_VBIASN a_19833_1842# 0.0961f
C886 a_26803_1842# VDD 0.49671f
C887 a_17275_1044# VDD 0.15389f
C888 DELAY_VBIASP a_19963_1842# 0.06627f
C889 DELAY_VBIASP a_4763_1842# 0.06627f
C890 a_23437_1842# a_23763_1842# 0.01427f
C891 a_27433_1842# a_27563_1842# 0.70845f
C892 a_21911_1008# a_21917_1842# 0.02354f
C893 a_9193_1842# VDD 0.49285f
C894 a_7288_1044# VDD 0.17274f
C895 a_10430_1044# a_12363_1842# 0.01012f
C896 VDD a_11711_2470# 0.01806f
C897 a_24665_1044# a_24875_1044# 0.09424f
C898 a_8745_519# a_7390_1044# 0.01756f
C899 a_7803_1842# VDD 0.4973f
C900 VDD a_21483_1842# 0.4973f
C901 a_9757_1842# a_9953_1842# 0.76914f
C902 a_7390_1044# a_8155_1044# 0.39037f
C903 a_19448_1044# a_19550_1044# 0.37183f
C904 a_11848_1044# a_11277_1842# 0.10863f
C905 a_1256_1044# VDD 0.475f
C906 a_12797_1842# a_12363_1842# 0.6972f
C907 a_7945_1044# VDD 0.30409f
C908 a_23437_1842# a_22873_1842# 0.0114f
C909 a_2019_311# a_16510_1044# 0.03139f
C910 a_21044_1008# a_20397_1842# 0.02312f
C911 a_19550_1044# a_16108_289# 0.58202f
C912 VDD a_24875_1044# 0.15406f
C913 DELAY_VBIASN a_16793_1842# 0.0961f
C914 a_14317_1842# a_13883_1842# 0.6972f
C915 a_5731_289# a_11785_519# 0.28056f
C916 a_25391_2470# a_25283_1842# 0.01697f
C917 a_13470_1044# a_15755_1044# 0.39036f
C918 a_16108_289# a_16851_309# 0.06181f
C919 a_16271_2470# a_16163_1842# 0.01697f
C920 a_25391_1842# a_25283_1842# 0.01163f
C921 VDD a_1721_331# 0.45259f
C922 a_12797_1842# a_13557_1842# 0.06198f
C923 DELAY_VBIASP a_27237_1842# 0.06189f
C924 a_6153_1842# a_6717_1842# 0.0114f
C925 DELAY_VBIASN a_26043_1842# 0.07254f
C926 MUX_SEL4 MUX_OUT 0.91933f
C927 a_11473_1842# a_12037_1842# 0.0114f
C928 MUX_SEL0 a_2297_1395# 0.10655f
C929 a_22113_1842# a_22243_1842# 0.70845f
C930 VDD DELAY_OUT_LAST 0.46312f
C931 a_19550_1044# a_19637_1842# 0.1088f
C932 DELAY_VBIASP a_15273_1842# 0.11222f
C933 a_12993_1842# a_13557_1842# 0.0114f
C934 a_27563_1842# DELAY_VBIASN 0.07259f
C935 a_20397_1842# a_21157_1842# 0.03319f
C936 a_24393_1842# DELAY_VBIASP 0.11222f
C937 VDD a_14751_2470# 0.01806f
C938 a_24197_1842# DELAY_VBIASN 0.09156f
C939 a_18313_1842# VDD 0.49285f
C940 a_14751_2470# a_14643_1842# 0.01697f
C941 a_17357_1842# a_16597_1842# 0.01669f
C942 a_6425_1044# a_6635_1044# 0.09424f
C943 a_5197_1842# a_5957_1842# 0.03319f
C944 a_9953_1842# DELAY_VBIASN 0.0961f
C945 a_10083_1842# DELAY_VBIASP 0.06627f
C946 a_2019_311# a_1256_289# 0.02904f
C947 a_19311_2470# a_19203_1842# 0.01697f
C948 a_12791_1008# VDD 0.2822f
C949 a_7945_1044# a_7477_1842# 0.19203f
C950 VDD a_26185_1044# 0.30409f
C951 a_19637_1842# a_19203_1842# 0.69698f
C952 a_5731_289# a_13470_1044# 0.41365f
C953 DELAY_VBIASN a_22243_1842# 0.07254f
C954 a_21044_1008# VDD 0.28225f
C955 a_1721_1395# MUX_SEL0 0.01315f
C956 a_18117_1842# a_16510_1044# 0.05231f
C957 a_17357_1842# a_17351_1008# 0.02349f
C958 a_1544_1044# MUX_SEL1 0.1672f
C959 a_25630_1044# DELAY_VBIASN 0.02756f
C960 a_20105_1044# a_19550_1044# 0.03209f
C961 a_13444_1008# a_13557_1842# 0.05157f
C962 a_4003_1842# DELAY_VBIASN 0.06486f
C963 MUX_SEL3 a_1544_289# 0.15976f
C964 MUX_SEL2 a_1721_331# 0.01315f
C965 VDD a_8231_1008# 0.28336f
C966 a_6913_1842# DELAY_VBIASN 0.0961f
C967 a_23355_1044# a_23431_1008# 0.01194f
C968 a_22590_1044# a_24084_1008# 0.28279f
C969 a_23871_2470# VDD 0.01806f
C970 a_7043_1842# DELAY_VBIASP 0.06627f
C971 DELAY_VBIASP a_20723_1842# 0.06627f
C972 a_23871_2470# a_23763_1842# 0.01697f
C973 VDD a_13123_1842# 0.49727f
C974 VDD a_21157_1842# 0.85848f
C975 a_4905_1044# a_5191_1008# 0.01885f
C976 VDD a_5957_1842# 0.85848f
C977 a_7390_1044# a_9675_1044# 0.39036f
C978 a_25630_1044# a_27705_1044# 0.03208f
C979 a_14025_1044# a_13557_1842# 0.19203f
C980 VDD a_11277_1842# 0.86909f
C981 a_5731_289# a_16108_289# 0.01334f
C982 a_8997_1842# a_8884_1008# 0.02055f
C983 a_24665_1044# a_22590_1044# 0.03208f
C984 a_10517_1842# a_11277_1842# 0.01669f
C985 a_9465_1044# a_9675_1044# 0.09424f
C986 a_15964_289# MUX_OUT 0.01307f
C987 a_11711_2470# a_11603_1842# 0.01697f
C988 a_2019_311# MUX_SEL4 0.90276f
C989 a_17357_1842# DELAY_VBIASN 0.09974f
C990 a_17553_1842# DELAY_VBIASP 0.11222f
C991 a_17553_1842# a_17683_1842# 0.70845f
C992 VDD a_22590_1044# 0.89557f
C993 a_16597_1842# a_16163_1842# 0.69698f
C994 a_23437_1842# a_24008_1044# 0.10863f
C995 a_14311_1008# VDD 0.28336f
C996 a_16408_1044# a_16484_1008# 0.01176f
C997 a_14025_1044# a_14235_1044# 0.09424f
C998 a_20723_1842# a_20593_1842# 0.70845f
C999 a_19550_1044# DELAY_VBIASN 0.02115f
C1000 VDD a_15403_1842# 0.4973f
C1001 MUX_OUT MUX_SEL3 0.79533f
C1002 a_25913_1842# a_26477_1842# 0.0114f
C1003 a_24523_1842# VDD 0.4973f
C1004 DELAY_VBIASN a_13883_1842# 0.07254f
C1005 a_15273_1842# a_15837_1842# 0.0114f
C1006 DELAY_VBIASP a_15077_1842# 0.04141f
C1007 a_6391_2470# VDD 0.01806f
C1008 DELAY_VBIASN a_6717_1842# 0.09992f
C1009 a_17065_1044# VDD 0.30218f
C1010 a_24393_1842# a_24957_1842# 0.0114f
C1011 DELAY_VBIASN a_12037_1842# 0.09156f
C1012 MUX_SEL4 a_1256_289# 0.65005f
C1013 DELAY_VBIASP a_12233_1842# 0.11222f
C1014 VDD a_25717_1842# 0.86707f
C1015 a_11924_1008# a_10430_1044# 0.28279f
C1016 a_10328_1044# a_10404_1008# 0.01176f
C1017 MUX_SEL4 DELAY_IN 0.0663f
C1018 a_13470_1044# a_14317_1842# 0.08038f
C1019 a_16484_1008# VDD 0.28597f
C1020 DELAY_VBIASP a_20397_1842# 0.0414f
C1021 DELAY_VBIASN a_19203_1842# 0.07254f
C1022 a_19550_1044# a_21835_1044# 0.39036f
C1023 a_16510_1044# a_18871_1008# 0.26208f
C1024 DELAY_VBIASP a_5197_1842# 0.0414f
C1025 a_18877_1842# a_19203_1842# 0.01427f
C1026 a_27433_1842# a_27997_1842# 0.0114f
C1027 a_15964_289# a_15837_1842# 0.02f
C1028 a_23437_1842# a_24197_1842# 0.03319f
C1029 a_5197_1842# a_5191_1008# 0.02349f
C1030 a_5957_1842# a_4350_1044# 0.05231f
C1031 a_8563_1842# VDD 0.49671f
C1032 a_6711_1008# VDD 0.2822f
C1033 a_10430_1044# a_12797_1842# 0.02479f
C1034 VDD a_27048_1044# 0.17499f
C1035 a_17683_1842# a_17791_1842# 0.01163f
C1036 VDD a_10951_2470# 0.01806f
C1037 a_5731_289# a_7390_1044# 0.41331f
C1038 MUX_SEL4 a_10430_1044# 0.24983f
C1039 a_25604_1008# a_25717_1842# 0.05157f
C1040 a_7390_1044# a_7364_1008# 0.277f
C1041 a_9323_1842# a_7390_1044# 0.01012f
C1042 a_9757_1842# a_9323_1842# 0.6972f
C1043 VDD a_21917_1842# 0.87825f
C1044 a_8237_1842# VDD 0.86909f
C1045 a_27671_2470# VDD 0.01806f
C1046 a_1544_1044# a_2297_1395# 0.28651f
C1047 a_11271_1008# a_11277_1842# 0.02349f
C1048 a_10083_1842# a_10191_2470# 0.01697f
C1049 a_12233_1842# a_12363_1842# 0.70845f
C1050 a_15964_289# a_16510_1044# 0.05416f
C1051 MUX_SEL1 a_3449_1395# 0.29404f
C1052 a_20968_1044# a_20397_1842# 0.10863f
C1053 a_13753_1842# a_13883_1842# 0.70845f
C1054 a_2019_311# a_15964_289# 0.02413f
C1055 DELAY_VBIASN a_16163_1842# 0.07254f
C1056 a_5705_519# a_2019_311# 0.13872f
C1057 a_13470_1044# a_14964_1008# 0.28279f
C1058 a_8997_1842# a_7390_1044# 0.05231f
C1059 a_9757_1842# a_8997_1842# 0.02912f
C1060 MUX_SEL4 a_12797_1842# 0.01829f
C1061 VDD a_1544_289# 0.39113f
C1062 a_12797_1842# a_12993_1842# 0.76914f
C1063 a_7945_1044# a_8155_1044# 0.09424f
C1064 DELAY_VBIASN a_26477_1842# 0.10224f
C1065 DELAY_VBIASP a_26673_1842# 0.11222f
C1066 a_26395_1044# a_26471_1008# 0.01194f
C1067 a_11277_1842# a_11603_1842# 0.01427f
C1068 a_8563_1842# a_8671_2470# 0.01697f
C1069 a_8433_1842# a_8997_1842# 0.0114f
C1070 VDD DELAY_VBIASP 13.3418f
C1071 a_22113_1842# a_22677_1842# 0.0114f
C1072 DELAY_VBIASP a_14643_1842# 0.06627f
C1073 a_9465_1044# a_8997_1842# 0.2079f
C1074 VDD a_5191_1008# 0.28565f
C1075 a_27997_1842# DELAY_VBIASN 0.04176f
C1076 VDD a_13991_2470# 0.01806f
C1077 a_23763_1842# DELAY_VBIASP 0.06627f
C1078 a_23633_1842# DELAY_VBIASN 0.0961f
C1079 a_17683_1842# VDD 0.49671f
C1080 a_20397_1842# a_20593_1842# 0.76914f
C1081 a_2019_311# MUX_SEL3 0.06209f
C1082 a_1544_1044# a_1721_1395# 0.38063f
C1083 a_7803_1842# a_7911_2470# 0.01697f
C1084 a_5197_1842# a_5393_1842# 0.76914f
C1085 a_10517_1842# DELAY_VBIASP 0.0414f
C1086 a_9323_1842# DELAY_VBIASN 0.07254f
C1087 a_21625_1044# a_21835_1044# 0.09424f
C1088 a_22351_1842# a_22243_1842# 0.01163f
C1089 a_4111_1842# a_4003_1842# 0.01163f
C1090 a_12715_1044# VDD 0.15406f
C1091 a_7477_1842# a_8237_1842# 0.01669f
C1092 a_14964_1008# a_14317_1842# 0.02312f
C1093 VDD a_10404_1008# 0.28633f
C1094 a_19073_1842# a_19203_1842# 0.70845f
C1095 DELAY_VBIASP a_22873_1842# 0.11222f
C1096 DELAY_VBIASN a_22677_1842# 0.08375f
C1097 a_8997_1842# DELAY_VBIASN 0.09156f
C1098 a_13444_1008# a_12797_1842# 0.02011f
C1099 a_20968_1044# VDD 0.17499f
C1100 a_1256_1044# MUX_SEL1 1.44243f
C1101 a_1544_1044# MUX_SEL0 0.07603f
C1102 a_15837_1842# a_15077_1842# 0.02912f
C1103 a_26985_519# VDD 0.29292f
C1104 a_20831_1842# a_20723_1842# 0.01163f
R0 DELAY_VBIASN.n1 DELAY_VBIASN.t31 34.3755
R1 DELAY_VBIASN.n1 DELAY_VBIASN.t30 33.0005
R2 DELAY_VBIASN.n2 DELAY_VBIASN.t29 33.0005
R3 DELAY_VBIASN.n3 DELAY_VBIASN.t28 33.0005
R4 DELAY_VBIASN.n4 DELAY_VBIASN.t27 33.0005
R5 DELAY_VBIASN.n5 DELAY_VBIASN.t26 33.0005
R6 DELAY_VBIASN.n6 DELAY_VBIASN.t25 33.0005
R7 DELAY_VBIASN.n7 DELAY_VBIASN.t24 33.0005
R8 DELAY_VBIASN.n8 DELAY_VBIASN.t23 33.0005
R9 DELAY_VBIASN.n9 DELAY_VBIASN.t22 33.0005
R10 DELAY_VBIASN.n10 DELAY_VBIASN.t21 33.0005
R11 DELAY_VBIASN.n11 DELAY_VBIASN.t20 33.0005
R12 DELAY_VBIASN.n12 DELAY_VBIASN.t19 33.0005
R13 DELAY_VBIASN.n13 DELAY_VBIASN.t18 33.0005
R14 DELAY_VBIASN.n14 DELAY_VBIASN.t17 33.0005
R15 DELAY_VBIASN.n15 DELAY_VBIASN.t16 33.0005
R16 DELAY_VBIASN.n16 DELAY_VBIASN.t15 33.0005
R17 DELAY_VBIASN.n17 DELAY_VBIASN.t14 33.0005
R18 DELAY_VBIASN.n18 DELAY_VBIASN.t13 33.0005
R19 DELAY_VBIASN.n19 DELAY_VBIASN.t12 33.0005
R20 DELAY_VBIASN.n20 DELAY_VBIASN.t11 33.0005
R21 DELAY_VBIASN.n21 DELAY_VBIASN.t10 33.0005
R22 DELAY_VBIASN.n22 DELAY_VBIASN.t9 33.0005
R23 DELAY_VBIASN.n23 DELAY_VBIASN.t8 33.0005
R24 DELAY_VBIASN.n24 DELAY_VBIASN.t7 33.0005
R25 DELAY_VBIASN.n25 DELAY_VBIASN.t6 33.0005
R26 DELAY_VBIASN.n26 DELAY_VBIASN.t5 33.0005
R27 DELAY_VBIASN.n27 DELAY_VBIASN.t4 33.0005
R28 DELAY_VBIASN.n28 DELAY_VBIASN.t3 33.0005
R29 DELAY_VBIASN.n29 DELAY_VBIASN.t2 33.0005
R30 DELAY_VBIASN.n30 DELAY_VBIASN.t1 33.0005
R31 DELAY_VBIASN.n0 DELAY_VBIASN.t0 33.0005
R32 DELAY_VBIASN DELAY_VBIASN.n0 1.55517
R33 DELAY_VBIASN.n0 DELAY_VBIASN.n30 1.3755
R34 DELAY_VBIASN.n30 DELAY_VBIASN.n29 1.3755
R35 DELAY_VBIASN.n29 DELAY_VBIASN.n28 1.3755
R36 DELAY_VBIASN.n28 DELAY_VBIASN.n27 1.3755
R37 DELAY_VBIASN.n27 DELAY_VBIASN.n26 1.3755
R38 DELAY_VBIASN.n26 DELAY_VBIASN.n25 1.3755
R39 DELAY_VBIASN.n25 DELAY_VBIASN.n24 1.3755
R40 DELAY_VBIASN.n24 DELAY_VBIASN.n23 1.3755
R41 DELAY_VBIASN.n23 DELAY_VBIASN.n22 1.3755
R42 DELAY_VBIASN.n22 DELAY_VBIASN.n21 1.3755
R43 DELAY_VBIASN.n21 DELAY_VBIASN.n20 1.3755
R44 DELAY_VBIASN.n20 DELAY_VBIASN.n19 1.3755
R45 DELAY_VBIASN.n19 DELAY_VBIASN.n18 1.3755
R46 DELAY_VBIASN.n18 DELAY_VBIASN.n17 1.3755
R47 DELAY_VBIASN.n17 DELAY_VBIASN.n16 1.3755
R48 DELAY_VBIASN.n16 DELAY_VBIASN.n15 1.3755
R49 DELAY_VBIASN.n15 DELAY_VBIASN.n14 1.3755
R50 DELAY_VBIASN.n14 DELAY_VBIASN.n13 1.3755
R51 DELAY_VBIASN.n13 DELAY_VBIASN.n12 1.3755
R52 DELAY_VBIASN.n12 DELAY_VBIASN.n11 1.3755
R53 DELAY_VBIASN.n11 DELAY_VBIASN.n10 1.3755
R54 DELAY_VBIASN.n10 DELAY_VBIASN.n9 1.3755
R55 DELAY_VBIASN.n9 DELAY_VBIASN.n8 1.3755
R56 DELAY_VBIASN.n8 DELAY_VBIASN.n7 1.3755
R57 DELAY_VBIASN.n7 DELAY_VBIASN.n6 1.3755
R58 DELAY_VBIASN.n6 DELAY_VBIASN.n5 1.3755
R59 DELAY_VBIASN.n5 DELAY_VBIASN.n4 1.3755
R60 DELAY_VBIASN.n4 DELAY_VBIASN.n3 1.3755
R61 DELAY_VBIASN.n3 DELAY_VBIASN.n2 1.3755
R62 DELAY_VBIASN.n2 DELAY_VBIASN.n1 1.3755
R63 DELAY_VBIASP.n1 DELAY_VBIASP.t31 34.3685
R64 DELAY_VBIASP.n1 DELAY_VBIASP.t30 33.0005
R65 DELAY_VBIASP.n2 DELAY_VBIASP.t29 33.0005
R66 DELAY_VBIASP.n3 DELAY_VBIASP.t28 33.0005
R67 DELAY_VBIASP.n4 DELAY_VBIASP.t27 33.0005
R68 DELAY_VBIASP.n5 DELAY_VBIASP.t26 33.0005
R69 DELAY_VBIASP.n6 DELAY_VBIASP.t25 33.0005
R70 DELAY_VBIASP.n7 DELAY_VBIASP.t24 33.0005
R71 DELAY_VBIASP.n8 DELAY_VBIASP.t23 33.0005
R72 DELAY_VBIASP.n9 DELAY_VBIASP.t22 33.0005
R73 DELAY_VBIASP.n10 DELAY_VBIASP.t21 33.0005
R74 DELAY_VBIASP.n11 DELAY_VBIASP.t20 33.0005
R75 DELAY_VBIASP.n12 DELAY_VBIASP.t19 33.0005
R76 DELAY_VBIASP.n13 DELAY_VBIASP.t18 33.0005
R77 DELAY_VBIASP.n14 DELAY_VBIASP.t17 33.0005
R78 DELAY_VBIASP.n15 DELAY_VBIASP.t16 33.0005
R79 DELAY_VBIASP.n16 DELAY_VBIASP.t15 33.0005
R80 DELAY_VBIASP.n17 DELAY_VBIASP.t14 33.0005
R81 DELAY_VBIASP.n18 DELAY_VBIASP.t13 33.0005
R82 DELAY_VBIASP.n19 DELAY_VBIASP.t12 33.0005
R83 DELAY_VBIASP.n20 DELAY_VBIASP.t11 33.0005
R84 DELAY_VBIASP.n21 DELAY_VBIASP.t10 33.0005
R85 DELAY_VBIASP.n22 DELAY_VBIASP.t9 33.0005
R86 DELAY_VBIASP.n23 DELAY_VBIASP.t8 33.0005
R87 DELAY_VBIASP.n24 DELAY_VBIASP.t7 33.0005
R88 DELAY_VBIASP.n25 DELAY_VBIASP.t6 33.0005
R89 DELAY_VBIASP.n26 DELAY_VBIASP.t5 33.0005
R90 DELAY_VBIASP.n27 DELAY_VBIASP.t4 33.0005
R91 DELAY_VBIASP.n28 DELAY_VBIASP.t3 33.0005
R92 DELAY_VBIASP.n29 DELAY_VBIASP.t2 33.0005
R93 DELAY_VBIASP.n30 DELAY_VBIASP.t1 33.0005
R94 DELAY_VBIASP.n0 DELAY_VBIASP.t0 33.0005
R95 DELAY_VBIASP DELAY_VBIASP.n0 1.70586
R96 DELAY_VBIASP.n0 DELAY_VBIASP.n30 1.36852
R97 DELAY_VBIASP.n30 DELAY_VBIASP.n29 1.36852
R98 DELAY_VBIASP.n29 DELAY_VBIASP.n28 1.36852
R99 DELAY_VBIASP.n28 DELAY_VBIASP.n27 1.36852
R100 DELAY_VBIASP.n27 DELAY_VBIASP.n26 1.36852
R101 DELAY_VBIASP.n26 DELAY_VBIASP.n25 1.36852
R102 DELAY_VBIASP.n25 DELAY_VBIASP.n24 1.36852
R103 DELAY_VBIASP.n24 DELAY_VBIASP.n23 1.36852
R104 DELAY_VBIASP.n23 DELAY_VBIASP.n22 1.36852
R105 DELAY_VBIASP.n22 DELAY_VBIASP.n21 1.36852
R106 DELAY_VBIASP.n21 DELAY_VBIASP.n20 1.36852
R107 DELAY_VBIASP.n20 DELAY_VBIASP.n19 1.36852
R108 DELAY_VBIASP.n19 DELAY_VBIASP.n18 1.36852
R109 DELAY_VBIASP.n18 DELAY_VBIASP.n17 1.36852
R110 DELAY_VBIASP.n17 DELAY_VBIASP.n16 1.36852
R111 DELAY_VBIASP.n16 DELAY_VBIASP.n15 1.36852
R112 DELAY_VBIASP.n15 DELAY_VBIASP.n14 1.36852
R113 DELAY_VBIASP.n14 DELAY_VBIASP.n13 1.36852
R114 DELAY_VBIASP.n13 DELAY_VBIASP.n12 1.36852
R115 DELAY_VBIASP.n12 DELAY_VBIASP.n11 1.36852
R116 DELAY_VBIASP.n11 DELAY_VBIASP.n10 1.36852
R117 DELAY_VBIASP.n10 DELAY_VBIASP.n9 1.36852
R118 DELAY_VBIASP.n9 DELAY_VBIASP.n8 1.36852
R119 DELAY_VBIASP.n8 DELAY_VBIASP.n7 1.36852
R120 DELAY_VBIASP.n7 DELAY_VBIASP.n6 1.36852
R121 DELAY_VBIASP.n6 DELAY_VBIASP.n5 1.36852
R122 DELAY_VBIASP.n5 DELAY_VBIASP.n4 1.36852
R123 DELAY_VBIASP.n4 DELAY_VBIASP.n3 1.36852
R124 DELAY_VBIASP.n3 DELAY_VBIASP.n2 1.36852
R125 DELAY_VBIASP.n2 DELAY_VBIASP.n1 1.36852
R126 VSS.n0 VSS.n397 7907.02
R127 VSS.n18 VSS.n96 4666.08
R128 VSS.n56 VSS.n448 469.783
R129 VSS.n65 VSS.n439 469.783
R130 VSS.n79 VSS.n422 469.783
R131 VSS.n88 VSS.n413 469.783
R132 VSS.n486 VSS.n54 454.007
R133 VSS.n502 VSS.n63 454.007
R134 VSS.n518 VSS.n7 454.007
R135 VSS.n542 VSS.n77 454.007
R136 VSS.n558 VSS.n86 454.007
R137 VSS.n574 VSS.n4 454.007
R138 VSS.n22 VSS.n11 0.00196391
R139 VSS.n33 VSS.n1 0.00296271
R140 VSS.n46 VSS.t56 21.1052
R141 VSS.t179 VSS.n13 442.469
R142 VSS.t415 VSS.n452 437.62
R143 VSS.n9 VSS.n47 0.547872
R144 VSS.n3 VSS.t369 413.695
R145 VSS.t354 VSS.n40 413.695
R146 VSS.t339 VSS.n41 413.695
R147 VSS.t324 VSS.n42 413.695
R148 VSS.t309 VSS.n44 413.695
R149 VSS.t294 VSS.n45 413.695
R150 VSS.n458 VSS.t416 403.072
R151 VSS.n54 VSS.t289 402.185
R152 VSS.n63 VSS.t304 402.185
R153 VSS.n7 VSS.t319 402.185
R154 VSS.n77 VSS.t334 402.185
R155 VSS.n86 VSS.t349 402.185
R156 VSS.n4 VSS.t364 402.185
R157 VSS.n48 VSS.t55 412.901
R158 VSS.n456 VSS.t168 391.555
R159 VSS.n20 VSS.t38 384.887
R160 VSS.n455 VSS.t174 380.038
R161 VSS.t561 VSS.n454 357.007
R162 VSS.t562 VSS.n453 333.974
R163 VSS.n20 VSS.t413 333.065
R164 VSS.n45 VSS.t297 97.2238
R165 VSS.n42 VSS.t327 97.2238
R166 VSS.n40 VSS.t357 97.2238
R167 VSS.n486 VSS.t287 305.183
R168 VSS.n502 VSS.t302 305.183
R169 VSS.n518 VSS.t317 305.183
R170 VSS.n542 VSS.t332 305.183
R171 VSS.n558 VSS.t347 305.183
R172 VSS.n574 VSS.t362 305.183
R173 VSS.n457 VSS.t178 299.425
R174 VSS.t284 VSS.n11 310.053
R175 VSS.t299 VSS.n25 310.053
R176 VSS.t314 VSS.n28 310.053
R177 VSS.t329 VSS.n36 310.053
R178 VSS.t344 VSS.n32 310.053
R179 VSS.n2 VSS.n1 0.00223459
R180 VSS.n38 VSS.t81 110.546
R181 VSS.t165 VSS.n34 110.547
R182 VSS.n31 VSS.t260 116.468
R183 VSS.n35 VSS.t185 116.468
R184 VSS.t209 VSS.n43 110.546
R185 VSS.t142 VSS.n29 110.547
R186 VSS.t31 VSS.n26 110.547
R187 VSS.t181 VSS.n37 110.547
R188 VSS.n457 VSS.t39 287.909
R189 VSS.n22 VSS.t282 114.148
R190 VSS.t397 VSS.n13 269.724
R191 VSS.n23 VSS.t72 332.017
R192 VSS.t187 VSS.n39 332.017
R193 VSS.t82 VSS.n38 116.469
R194 VSS.n22 VSS.n37 0.00596635
R195 VSS.n26 VSS.n24 0.00596633
R196 VSS.n29 VSS.n27 0.00596633
R197 VSS.n35 VSS.n9 0.00596635
R198 VSS.n31 VSS.n30 0.00596633
R199 VSS.t166 VSS.n34 116.468
R200 VSS.t170 VSS.n15 258.231
R201 VSS.t396 VSS.n453 253.359
R202 VSS.t108 VSS.n253 252.375
R203 VSS.t281 VSS.n229 252.375
R204 VSS.t523 VSS.n233 252.375
R205 VSS.t504 VSS.n244 252.375
R206 VSS.n835 VSS.t495 252.375
R207 VSS.n817 VSS.t505 252.375
R208 VSS.n796 VSS.t194 252.375
R209 VSS.n776 VSS.t177 252.375
R210 VSS.n758 VSS.t412 252.375
R211 VSS.t398 VSS.n310 252.375
R212 VSS.n719 VSS.t399 252.375
R213 VSS.t227 VSS.n329 252.375
R214 VSS.n341 VSS.t428 252.375
R215 VSS.t76 VSS.n351 252.375
R216 VSS.n645 VSS.t214 252.375
R217 VSS.n626 VSS.t388 252.375
R218 VSS.n606 VSS.t107 252.375
R219 VSS.n269 VSS.t526 252.117
R220 VSS.t390 VSS.n307 252.117
R221 VSS.n318 VSS.t400 252.117
R222 VSS.n348 VSS.t559 252.117
R223 VSS.n367 VSS.t65 252.117
R224 VSS.n882 VSS.t401 252.115
R225 VSS.t94 VSS.n112 252.115
R226 VSS.t556 VSS.n117 252.115
R227 VSS.n807 VSS.t213 252.115
R228 VSS.n787 VSS.t558 252.115
R229 VSS.t430 VSS.n131 252.115
R230 VSS.t496 VSS.n140 252.115
R231 VSS.n691 VSS.t553 252.115
R232 VSS.t176 VSS.n149 252.115
R233 VSS.n617 VSS.t557 252.115
R234 VSS.t449 VSS.n232 250.837
R235 VSS.t451 VSS.n236 250.837
R236 VSS.t435 VSS.n242 250.837
R237 VSS.t453 VSS.n246 250.837
R238 VSS.t455 VSS.n252 250.837
R239 VSS.t461 VSS.n255 250.837
R240 VSS.t431 VSS.n262 250.837
R241 VSS.t463 VSS.n264 250.837
R242 VSS.t437 VSS.n271 250.837
R243 VSS.t465 VSS.n274 250.837
R244 VSS.t467 VSS.n280 250.837
R245 VSS.t433 VSS.n282 250.837
R246 VSS.t469 VSS.n289 250.837
R247 VSS.t471 VSS.n292 250.837
R248 VSS.t477 VSS.n299 250.837
R249 VSS.t473 VSS.n302 250.837
R250 VSS.t479 VSS.n309 250.837
R251 VSS.t485 VSS.n313 250.837
R252 VSS.t481 VSS.n320 250.837
R253 VSS.t487 VSS.n322 250.837
R254 VSS.t483 VSS.n328 250.837
R255 VSS.t489 VSS.n332 250.837
R256 VSS.t475 VSS.n339 250.837
R257 VSS.t459 VSS.n343 250.837
R258 VSS.t447 VSS.n350 250.837
R259 VSS.t439 VSS.n353 250.837
R260 VSS.t443 VSS.n360 250.837
R261 VSS.t491 VSS.n362 250.837
R262 VSS.t441 VSS.n369 250.837
R263 VSS.t457 VSS.n372 250.837
R264 VSS.t445 VSS.n379 250.837
R265 VSS.t493 VSS.n381 250.837
R266 VSS.n19 VSS.t394 240.956
R267 VSS.n55 VSS.t292 240.956
R268 VSS.n64 VSS.t307 240.956
R269 VSS.n8 VSS.t322 240.956
R270 VSS.n78 VSS.t337 240.956
R271 VSS.n87 VSS.t352 240.956
R272 VSS.n5 VSS.t367 240.956
R273 VSS.n883 VSS.t499 234.114
R274 VSS.n863 VSS.t506 234.114
R275 VSS.n845 VSS.t423 234.114
R276 VSS.n827 VSS.t66 234.114
R277 VSS.n808 VSS.t190 234.114
R278 VSS.n788 VSS.t520 234.114
R279 VSS.n768 VSS.t419 234.114
R280 VSS.n749 VSS.t275 234.114
R281 VSS.n730 VSS.t512 234.114
R282 VSS.n711 VSS.t126 234.114
R283 VSS.n692 VSS.t53 234.114
R284 VSS.n674 VSS.t89 234.114
R285 VSS.n655 VSS.t111 234.114
R286 VSS.n637 VSS.t538 234.114
R287 VSS.n618 VSS.t219 234.114
R288 VSS.n597 VSS.t534 234.114
R289 VSS.t172 VSS.n454 230.327
R290 VSS.t292 VSS.n56 229.44
R291 VSS.t307 VSS.n65 229.44
R292 VSS.t337 VSS.n79 229.44
R293 VSS.t352 VSS.n88 229.44
R294 VSS.t367 VSS.n6 229.441
R295 VSS.t394 VSS.n18 228.827
R296 VSS.t234 VSS.n231 225.361
R297 VSS.t421 VSS.n261 225.361
R298 VSS.t518 VSS.n288 225.361
R299 VSS.t417 VSS.n298 225.361
R300 VSS.t51 VSS.n338 225.361
R301 VSS.t109 VSS.n359 225.361
R302 VSS.t217 VSS.n378 225.361
R303 VSS.n881 VSS.t497 225.359
R304 VSS.t507 VSS.n113 225.359
R305 VSS.t68 VSS.n122 225.359
R306 VSS.n806 VSS.t192 225.359
R307 VSS.n748 VSS.t273 225.359
R308 VSS.t513 VSS.n136 225.359
R309 VSS.n710 VSS.t128 225.359
R310 VSS.t87 VSS.n146 225.359
R311 VSS.t539 VSS.n154 225.359
R312 VSS.n43 VSS.t210 116.469
R313 VSS.t545 VSS.n107 211.982
R314 VSS.t243 VSS.n114 211.982
R315 VSS.t145 VSS.n118 211.982
R316 VSS.t148 VSS.n125 211.982
R317 VSS.t0 VSS.n150 211.982
R318 VSS.n780 VSS.t253 211.982
R319 VSS.n741 VSS.t113 211.982
R320 VSS.n723 VSS.t136 211.982
R321 VSS.n703 VSS.t262 211.982
R322 VSS.n667 VSS.t256 211.982
R323 VSS.n630 VSS.t199 211.982
R324 VSS.n610 VSS.t139 211.982
R325 VSS.n243 VSS.t95 211.982
R326 VSS.n272 VSS.t118 211.982
R327 VSS.n300 VSS.t84 211.982
R328 VSS.n340 VSS.t548 211.982
R329 VSS.n455 VSS.t172 207.294
R330 VSS.n16 VSS.t396 200.649
R331 VSS.n456 VSS.t170 195.778
R332 VSS.t205 VSS.n235 195.26
R333 VSS.t406 VSS.n291 195.26
R334 VSS.t77 VSS.n312 195.26
R335 VSS.t404 VSS.n331 195.26
R336 VSS.t271 VSS.n371 195.26
R337 VSS.n871 VSS.t524 195.26
R338 VSS.n853 VSS.t220 195.26
R339 VSS.t535 VSS.n120 195.26
R340 VSS.n816 VSS.t391 195.26
R341 VSS.t509 VSS.n127 195.26
R342 VSS.n757 VSS.t515 195.26
R343 VSS.t47 VSS.n138 195.26
R344 VSS.t532 VSS.n144 195.26
R345 VSS.n663 VSS.t197 195.26
R346 VSS.t90 VSS.n152 195.26
R347 VSS.n605 VSS.t124 195.26
R348 VSS.t188 VSS.n39 106.362
R349 VSS.n23 VSS.t74 106.362
R350 VSS.n889 VSS.t26 187.292
R351 VSS.n869 VSS.t160 187.292
R352 VSS.n851 VSS.t70 187.292
R353 VSS.n833 VSS.t102 187.292
R354 VSS.n814 VSS.t241 187.292
R355 VSS.n794 VSS.t34 187.292
R356 VSS.n774 VSS.t133 187.292
R357 VSS.n755 VSS.t239 187.292
R358 VSS.n736 VSS.t246 187.292
R359 VSS.n717 VSS.t531 187.292
R360 VSS.n698 VSS.t163 187.292
R361 VSS.n680 VSS.t247 187.292
R362 VSS.n661 VSS.t543 187.292
R363 VSS.n643 VSS.t162 187.292
R364 VSS.n624 VSS.t36 187.292
R365 VSS.n603 VSS.t135 187.292
R366 VSS.n458 VSS.t397 184.262
R367 VSS.n35 VSS.t184 110.547
R368 VSS.n9 VSS.n43 0.00588066
R369 VSS.n31 VSS.t259 110.547
R370 VSS.n33 VSS.n34 0.00596633
R371 VSS.n38 VSS.n0 0.00588067
R372 VSS.t105 VSS.n240 173.913
R373 VSS.n250 VSS.t131 173.913
R374 VSS.n259 VSS.t13 173.913
R375 VSS.t269 VSS.n268 173.913
R376 VSS.t59 VSS.n278 173.913
R377 VSS.t158 VSS.n286 173.913
R378 VSS.n296 VSS.t152 173.913
R379 VSS.t4 VSS.n306 173.913
R380 VSS.t10 VSS.n317 173.913
R381 VSS.n326 VSS.t232 173.913
R382 VSS.t266 VSS.n336 173.913
R383 VSS.t229 VSS.n347 173.913
R384 VSS.n357 VSS.t29 173.913
R385 VSS.t7 VSS.n366 173.913
R386 VSS.t250 VSS.n376 173.913
R387 VSS.t155 VSS.n385 173.913
R388 VSS.n397 VSS.n388 173.913
R389 VSS.t546 VSS.t206 163.881
R390 VSS.t96 VSS.t525 163.881
R391 VSS.t244 VSS.t221 163.881
R392 VSS.t146 VSS.t536 163.881
R393 VSS.t119 VSS.t392 163.881
R394 VSS.t149 VSS.t510 163.881
R395 VSS.t254 VSS.t407 163.881
R396 VSS.t85 VSS.t516 163.881
R397 VSS.t114 VSS.t79 163.881
R398 VSS.t137 VSS.t45 163.881
R399 VSS.t263 VSS.t405 163.881
R400 VSS.t549 VSS.t533 163.881
R401 VSS.t257 VSS.t195 163.881
R402 VSS.t1 VSS.t92 163.881
R403 VSS.t200 VSS.t272 163.881
R404 VSS.t140 VSS.t122 163.881
R405 VSS.n51 VSS.t284 160.341
R406 VSS.n60 VSS.t299 160.341
R407 VSS.n68 VSS.t314 160.341
R408 VSS.n74 VSS.t329 160.341
R409 VSS.n83 VSS.t344 160.341
R410 VSS.n2 VSS.t359 105.686
R411 VSS.t529 VSS.n101 157.062
R412 VSS.t503 VSS.n103 156.429
R413 VSS.t402 VSS.n243 155.126
R414 VSS.t429 VSS.n272 155.126
R415 VSS.t537 VSS.n300 155.126
R416 VSS.t215 VSS.n340 155.126
R417 VSS.t223 VSS.n107 155.125
R418 VSS.t521 VSS.n114 155.125
R419 VSS.t224 VSS.n118 155.125
R420 VSS.t522 VSS.n125 155.125
R421 VSS.n780 VSS.t554 155.125
R422 VSS.n741 VSS.t226 155.125
R423 VSS.n723 VSS.t121 155.125
R424 VSS.n703 VSS.t279 155.125
R425 VSS.n667 VSS.t212 155.125
R426 VSS.t560 VSS.n150 155.125
R427 VSS.n630 VSS.t43 155.125
R428 VSS.n610 VSS.t202 155.125
R429 VSS.t178 VSS.n14 153.971
R430 VSS.n911 VSS.t100 153.846
R431 VSS.n889 VSS.t104 153.846
R432 VSS.n869 VSS.t130 153.846
R433 VSS.n851 VSS.t12 153.846
R434 VSS.n833 VSS.t268 153.846
R435 VSS.n814 VSS.t58 153.846
R436 VSS.n794 VSS.t157 153.846
R437 VSS.n774 VSS.t151 153.846
R438 VSS.n755 VSS.t3 153.846
R439 VSS.n736 VSS.t9 153.846
R440 VSS.n717 VSS.t231 153.846
R441 VSS.n698 VSS.t265 153.846
R442 VSS.n680 VSS.t228 153.846
R443 VSS.n661 VSS.t28 153.846
R444 VSS.n643 VSS.t6 153.846
R445 VSS.n624 VSS.t249 153.846
R446 VSS.n603 VSS.t154 153.846
R447 VSS.t237 VSS.n103 153.327
R448 VSS.t530 VSS.n104 153.236
R449 VSS.t39 VSS.n452 149.713
R450 VSS.t287 VSS.n51 148.826
R451 VSS.t302 VSS.n60 148.826
R452 VSS.t317 VSS.n68 148.826
R453 VSS.t332 VSS.n74 148.826
R454 VSS.t347 VSS.n83 148.826
R455 VSS.t63 VSS.n239 147.157
R456 VSS.t410 VSS.n249 147.157
R457 VSS.t555 VSS.n258 147.157
R458 VSS.t252 VSS.n267 147.157
R459 VSS.t389 VSS.n277 147.157
R460 VSS.t49 VSS.n285 147.157
R461 VSS.t544 VSS.n295 147.157
R462 VSS.t552 VSS.n305 147.157
R463 VSS.t426 VSS.n316 147.157
R464 VSS.t409 VSS.n325 147.157
R465 VSS.t425 VSS.n335 147.157
R466 VSS.t41 VSS.n346 147.157
R467 VSS.t208 VSS.n356 147.157
R468 VSS.t277 VSS.n365 147.157
R469 VSS.t203 VSS.n375 147.157
R470 VSS.t61 VSS.n384 147.157
R471 VSS.n590 VSS.t386 145.093
R472 VSS.t382 VSS.n590 138.404
R473 VSS.t372 VSS.n3 97.2238
R474 VSS.n40 VSS.n33 0.00760728
R475 VSS.t342 VSS.n41 97.2238
R476 VSS.n42 VSS.n9 0.00760728
R477 VSS.t312 VSS.n44 97.2238
R478 VSS.n45 VSS.n24 0.00760728
R479 VSS.t413 VSS.n19 137.309
R480 VSS.n925 VSS.t23 134.661
R481 VSS.n596 VSS.t382 131.974
R482 VSS.n12 VSS.t72 130.939
R483 VSS.n47 VSS.t187 131.005
R484 VSS.n922 VSS.t15 126.945
R485 VSS.n923 VSS.t21 123.212
R486 VSS.n104 VSS.t503 120.691
R487 VSS.n21 VSS.t562 119.422
R488 VSS.t527 VSS.n925 117.858
R489 VSS.t386 VSS.n388 117.058
R490 VSS.t542 VSS.n97 115.745
R491 VSS.t541 VSS.n99 108.276
R492 VSS.n891 VSS.t223 107.023
R493 VSS.n883 VSS.t63 107.023
R494 VSS.n872 VSS.t402 107.023
R495 VSS.n863 VSS.t410 107.023
R496 VSS.n854 VSS.t521 107.023
R497 VSS.n845 VSS.t555 107.023
R498 VSS.n836 VSS.t224 107.023
R499 VSS.n827 VSS.t252 107.023
R500 VSS.n818 VSS.t429 107.023
R501 VSS.n808 VSS.t389 107.023
R502 VSS.n797 VSS.t522 107.023
R503 VSS.n788 VSS.t49 107.023
R504 VSS.t554 VSS.n777 107.023
R505 VSS.n768 VSS.t544 107.023
R506 VSS.n759 VSS.t537 107.023
R507 VSS.n749 VSS.t552 107.023
R508 VSS.t226 VSS.n738 107.023
R509 VSS.n730 VSS.t426 107.023
R510 VSS.t121 VSS.n720 107.023
R511 VSS.n711 VSS.t409 107.023
R512 VSS.t279 VSS.n700 107.023
R513 VSS.n692 VSS.t425 107.023
R514 VSS.n682 VSS.t215 107.023
R515 VSS.n674 VSS.t41 107.023
R516 VSS.t212 VSS.n664 107.023
R517 VSS.n655 VSS.t208 107.023
R518 VSS.n646 VSS.t560 107.023
R519 VSS.n637 VSS.t277 107.023
R520 VSS.t43 VSS.n627 107.023
R521 VSS.n618 VSS.t203 107.023
R522 VSS.t202 VSS.n607 107.023
R523 VSS.n597 VSS.t61 107.023
R524 VSS.t375 VSS.n911 100.335
R525 VSS.t104 VSS.n239 100.335
R526 VSS.t130 VSS.n249 100.335
R527 VSS.t12 VSS.n258 100.335
R528 VSS.t268 VSS.n267 100.335
R529 VSS.t58 VSS.n277 100.335
R530 VSS.t157 VSS.n285 100.335
R531 VSS.t151 VSS.n295 100.335
R532 VSS.t3 VSS.n305 100.335
R533 VSS.t9 VSS.n316 100.335
R534 VSS.t231 VSS.n325 100.335
R535 VSS.t265 VSS.n335 100.335
R536 VSS.t228 VSS.n346 100.335
R537 VSS.t28 VSS.n356 100.335
R538 VSS.t6 VSS.n365 100.335
R539 VSS.t249 VSS.n375 100.335
R540 VSS.t154 VSS.n384 100.335
R541 VSS.n921 VSS.t236 97.0758
R542 VSS.n17 VSS.t561 96.3896
R543 VSS.t17 VSS.n101 93.5889
R544 VSS.n921 VSS.t24 93.3421
R545 VSS.n596 VSS.t155 88.4945
R546 VSS.t131 VSS.n112 88.2366
R547 VSS.t13 VSS.n117 88.2366
R548 VSS.t152 VSS.n131 88.2366
R549 VSS.t232 VSS.n140 88.2366
R550 VSS.t29 VSS.n149 88.2366
R551 VSS.n882 VSS.t105 88.2366
R552 VSS.n807 VSS.t59 88.2366
R553 VSS.n787 VSS.t158 88.2366
R554 VSS.n691 VSS.t266 88.2366
R555 VSS.n617 VSS.t250 88.2366
R556 VSS.n269 VSS.t269 88.2359
R557 VSS.n307 VSS.t4 88.2359
R558 VSS.n318 VSS.t10 88.2359
R559 VSS.n348 VSS.t229 88.2359
R560 VSS.n367 VSS.t7 88.2359
R561 VSS.n926 VSS.t500 88.133
R562 VSS.n397 VSS.n49 88.4708
R563 VSS.t98 VSS.t375 86.957
R564 VSS.t100 VSS.t379 86.957
R565 VSS.t38 VSS.n17 84.8733
R566 VSS.t500 VSS.n96 82.7875
R567 VSS.n99 VSS.t502 82.1411
R568 VSS.t502 VSS.n98 75.0671
R569 VSS.n919 VSS.t98 74.8579
R570 VSS.t19 VSS.n97 74.6738
R571 VSS.t174 VSS.n16 73.9692
R572 VSS.n891 VSS.t546 70.2346
R573 VSS.n872 VSS.t96 70.2346
R574 VSS.n854 VSS.t244 70.2346
R575 VSS.n836 VSS.t146 70.2346
R576 VSS.n818 VSS.t119 70.2346
R577 VSS.n797 VSS.t149 70.2346
R578 VSS.n777 VSS.t254 70.2346
R579 VSS.n759 VSS.t85 70.2346
R580 VSS.n738 VSS.t114 70.2346
R581 VSS.n720 VSS.t137 70.2346
R582 VSS.n700 VSS.t263 70.2346
R583 VSS.n682 VSS.t549 70.2346
R584 VSS.n664 VSS.t257 70.2346
R585 VSS.n646 VSS.t1 70.2346
R586 VSS.n627 VSS.t200 70.2346
R587 VSS.n607 VSS.t140 70.2346
R588 VSS.t289 VSS.n55 68.211
R589 VSS.t304 VSS.n64 68.211
R590 VSS.t319 VSS.n8 68.211
R591 VSS.t334 VSS.n78 68.211
R592 VSS.t349 VSS.n87 68.211
R593 VSS.t364 VSS.n5 68.211
R594 VSS.n923 VSS.t19 67.2065
R595 VSS.n890 VSS.t205 66.8901
R596 VSS.t26 VSS.n236 66.8901
R597 VSS.t524 VSS.n870 66.8901
R598 VSS.t160 VSS.n246 66.8901
R599 VSS.t220 VSS.n852 66.8901
R600 VSS.t70 VSS.n255 66.8901
R601 VSS.n834 VSS.t535 66.8901
R602 VSS.t102 VSS.n264 66.8901
R603 VSS.t391 VSS.n815 66.8901
R604 VSS.t241 VSS.n274 66.8901
R605 VSS.n795 VSS.t509 66.8901
R606 VSS.t34 VSS.n282 66.8901
R607 VSS.n775 VSS.t406 66.8901
R608 VSS.t133 VSS.n292 66.8901
R609 VSS.t515 VSS.n756 66.8901
R610 VSS.t239 VSS.n302 66.8901
R611 VSS.n737 VSS.t77 66.8901
R612 VSS.t246 VSS.n313 66.8901
R613 VSS.n718 VSS.t47 66.8901
R614 VSS.t531 VSS.n322 66.8901
R615 VSS.n699 VSS.t404 66.8901
R616 VSS.t163 VSS.n332 66.8901
R617 VSS.n681 VSS.t532 66.8901
R618 VSS.t247 VSS.n343 66.8901
R619 VSS.t197 VSS.n662 66.8901
R620 VSS.t543 VSS.n353 66.8901
R621 VSS.n644 VSS.t90 66.8901
R622 VSS.t162 VSS.n362 66.8901
R623 VSS.n625 VSS.t271 66.8901
R624 VSS.t36 VSS.n372 66.8901
R625 VSS.t124 VSS.n604 66.8901
R626 VSS.t135 VSS.n381 66.8901
R627 VSS.n922 VSS.t17 63.4728
R628 VSS.t24 VSS.n102 62.2523
R629 VSS.t168 VSS.n21 61.8407
R630 VSS.t236 VSS.n920 58.5186
R631 VSS.t55 VSS.n46 56.6955
R632 VSS.n448 VSS.t294 56.0825
R633 VSS.n439 VSS.t309 56.0825
R634 VSS.n10 VSS.t324 56.6955
R635 VSS.n422 VSS.t339 56.0825
R636 VSS.n413 VSS.t354 56.0825
R637 VSS.t369 VSS.n6 56.6955
R638 VSS.n926 VSS.t527 54.532
R639 VSS.t416 VSS.n12 50.3244
R640 VSS.t116 VSS.n47 44.8755
R641 VSS.n232 VSS.t545 50.1677
R642 VSS.t95 VSS.n242 50.1677
R643 VSS.n252 VSS.t243 50.1677
R644 VSS.n262 VSS.t145 50.1677
R645 VSS.t118 VSS.n271 50.1677
R646 VSS.n280 VSS.t148 50.1677
R647 VSS.t253 VSS.n289 50.1677
R648 VSS.t84 VSS.n299 50.1677
R649 VSS.t113 VSS.n309 50.1677
R650 VSS.t136 VSS.n320 50.1677
R651 VSS.t262 VSS.n328 50.1677
R652 VSS.t548 VSS.n339 50.1677
R653 VSS.t256 VSS.n350 50.1677
R654 VSS.n360 VSS.t0 50.1677
R655 VSS.t199 VSS.n369 50.1677
R656 VSS.t139 VSS.n379 50.1677
R657 VSS.n100 VSS.t541 47.3176
R658 VSS.n924 VSS.t542 39.8503
R659 VSS.n898 VSS.t234 36.7898
R660 VSS.t497 VSS.n880 36.7898
R661 VSS.n862 VSS.t507 36.7898
R662 VSS.n844 VSS.t421 36.7898
R663 VSS.n826 VSS.t68 36.7898
R664 VSS.t192 VSS.n805 36.7898
R665 VSS.n786 VSS.t518 36.7898
R666 VSS.n767 VSS.t417 36.7898
R667 VSS.t273 VSS.n747 36.7898
R668 VSS.n729 VSS.t513 36.7898
R669 VSS.t128 VSS.n709 36.7898
R670 VSS.n690 VSS.t51 36.7898
R671 VSS.n673 VSS.t87 36.7898
R672 VSS.n654 VSS.t109 36.7898
R673 VSS.n636 VSS.t539 36.7898
R674 VSS.n616 VSS.t217 36.7898
R675 VSS.t23 VSS.n924 36.1166
R676 VSS.t21 VSS.n98 33.9948
R677 VSS.t15 VSS.n100 28.6493
R678 VSS.t206 VSS.n233 28.2938
R679 VSS.t525 VSS.n244 28.2938
R680 VSS.t536 VSS.n835 28.2938
R681 VSS.t392 VSS.n817 28.2938
R682 VSS.t510 VSS.n796 28.2938
R683 VSS.t407 VSS.n776 28.2938
R684 VSS.t516 VSS.n758 28.2938
R685 VSS.t79 VSS.n310 28.2938
R686 VSS.t45 VSS.n719 28.2938
R687 VSS.t405 VSS.n329 28.2938
R688 VSS.t533 VSS.n341 28.2938
R689 VSS.t195 VSS.n351 28.2938
R690 VSS.t92 VSS.n645 28.2938
R691 VSS.t272 VSS.n626 28.2938
R692 VSS.t122 VSS.n606 28.2938
R693 VSS.t221 VSS.n253 28.2928
R694 VSS.n919 VSS.t530 28.0359
R695 VSS.n14 VSS.t179 27.2918
R696 VSS.n46 VSS.n9 0.00206574
R697 VSS.n48 VSS.t551 20.3065
R698 VSS.t379 VSS.n229 21.6048
R699 VSS.t499 VSS.n240 20.0674
R700 VSS.t506 VSS.n250 20.0674
R701 VSS.t423 VSS.n259 20.0674
R702 VSS.t66 VSS.n268 20.0674
R703 VSS.t190 VSS.n278 20.0674
R704 VSS.t520 VSS.n286 20.0674
R705 VSS.t419 VSS.n296 20.0674
R706 VSS.t275 VSS.n306 20.0674
R707 VSS.t512 VSS.n317 20.0674
R708 VSS.t126 VSS.n326 20.0674
R709 VSS.t53 VSS.n336 20.0674
R710 VSS.t89 VSS.n347 20.0674
R711 VSS.t111 VSS.n357 20.0674
R712 VSS.t538 VSS.n366 20.0674
R713 VSS.t219 VSS.n376 20.0674
R714 VSS.t534 VSS.n385 20.0674
R715 VSS.n113 VSS.t94 18.0025
R716 VSS.t495 VSS.n120 18.0025
R717 VSS.t526 VSS.n122 18.0025
R718 VSS.t194 VSS.n127 18.0025
R719 VSS.t400 VSS.n136 18.0025
R720 VSS.t399 VSS.n138 18.0025
R721 VSS.t428 VSS.n144 18.0025
R722 VSS.t559 VSS.n146 18.0025
R723 VSS.t214 VSS.n152 18.0025
R724 VSS.t65 VSS.n154 18.0025
R725 VSS.t401 VSS.n881 18.0025
R726 VSS.n871 VSS.t504 18.0025
R727 VSS.n853 VSS.t108 18.0025
R728 VSS.t505 VSS.n816 18.0025
R729 VSS.t213 VSS.n806 18.0025
R730 VSS.t412 VSS.n757 18.0025
R731 VSS.n748 VSS.t390 18.0025
R732 VSS.n710 VSS.t496 18.0025
R733 VSS.n663 VSS.t76 18.0025
R734 VSS.t107 VSS.n605 18.0025
R735 VSS.n231 VSS.t281 18.0017
R736 VSS.n235 VSS.t523 18.0017
R737 VSS.n261 VSS.t556 18.0017
R738 VSS.t558 VSS.n288 18.0017
R739 VSS.t177 VSS.n291 18.0017
R740 VSS.n298 VSS.t430 18.0017
R741 VSS.n312 VSS.t398 18.0017
R742 VSS.n331 VSS.t227 18.0017
R743 VSS.t553 VSS.n338 18.0017
R744 VSS.n359 VSS.t176 18.0017
R745 VSS.t388 VSS.n371 18.0017
R746 VSS.t557 VSS.n378 18.0017
R747 VSS.n920 VSS.t237 17.4483
R748 VSS.n941 VSS.t25 17.3368
R749 VSS.n937 VSS.t16 17.3368
R750 VSS.n933 VSS.t20 17.3368
R751 VSS.n465 VSS.t173 17.3368
R752 VSS.n469 VSS.t169 17.3368
R753 VSS.n473 VSS.t40 17.3368
R754 VSS.n477 VSS.t73 17.3368
R755 VSS.n916 VSS.t99 17.3368
R756 VSS.n535 VSS.t117 17.2607
R757 VSS.n451 VSS.t286 17.2313
R758 VSS.n491 VSS.t291 17.2313
R759 VSS.n495 VSS.t296 17.2313
R760 VSS.n442 VSS.t301 17.2313
R761 VSS.n507 VSS.t306 17.2313
R762 VSS.n511 VSS.t311 17.2313
R763 VSS.n433 VSS.t316 17.2313
R764 VSS.n523 VSS.t321 17.2313
R765 VSS.n527 VSS.t326 17.2313
R766 VSS.n425 VSS.t331 17.2313
R767 VSS.n547 VSS.t336 17.2313
R768 VSS.n551 VSS.t341 17.2313
R769 VSS.n416 VSS.t346 17.2313
R770 VSS.n563 VSS.t351 17.2313
R771 VSS.n567 VSS.t356 17.2313
R772 VSS.n407 VSS.t361 17.2313
R773 VSS.n579 VSS.t366 17.2313
R774 VSS.n583 VSS.t371 17.2313
R775 VSS.n928 VSS.n927 17.0005
R776 VSS.n927 VSS.n97 17.0005
R777 VSS.n927 VSS.n923 17.0005
R778 VSS.n927 VSS.n99 17.0005
R779 VSS.n927 VSS.n922 17.0005
R780 VSS.n927 VSS.n921 17.0005
R781 VSS.n927 VSS.n918 17.0005
R782 VSS.n927 VSS.n230 17.0005
R783 VSS.n927 VSS.n238 17.0005
R784 VSS.n927 VSS.n248 17.0005
R785 VSS.n927 VSS.n257 17.0005
R786 VSS.n927 VSS.n266 17.0005
R787 VSS.n927 VSS.n276 17.0005
R788 VSS.n927 VSS.n284 17.0005
R789 VSS.n927 VSS.n294 17.0005
R790 VSS.n927 VSS.n304 17.0005
R791 VSS.n927 VSS.n315 17.0005
R792 VSS.n927 VSS.n324 17.0005
R793 VSS.n927 VSS.n334 17.0005
R794 VSS.n927 VSS.n345 17.0005
R795 VSS.n927 VSS.n355 17.0005
R796 VSS.n927 VSS.n364 17.0005
R797 VSS.n927 VSS.n374 17.0005
R798 VSS.n927 VSS.n383 17.0005
R799 VSS.n927 VSS.n386 17.0005
R800 VSS.n927 VSS.n595 17.0005
R801 VSS.n927 VSS.n387 17.0005
R802 VSS.n927 VSS.n589 17.0005
R803 VSS.n927 VSS.n389 17.0005
R804 VSS.n927 VSS.n227 17.0005
R805 VSS.n927 VSS.n106 17.0005
R806 VSS.n1 VSS.n574 17.0005
R807 VSS.n82 VSS.n89 5.65652
R808 VSS.n84 VSS.n558 17.0005
R809 VSS.n84 VSS.n32 0.00107349
R810 VSS.n75 VSS.n542 17.0005
R811 VSS.n75 VSS.n36 0.00109156
R812 VSS.n39 VSS.n9 6.82739
R813 VSS.n48 VSS.n9 0.800314
R814 VSS.n69 VSS.n518 17.0005
R815 VSS.n69 VSS.n28 0.00107349
R816 VSS.n61 VSS.n502 17.0005
R817 VSS.n61 VSS.n25 0.00107349
R818 VSS.n52 VSS.n486 17.0005
R819 VSS.n22 VSS.n23 6.82737
R820 VSS.n22 VSS.n458 17.0005
R821 VSS.n22 VSS.n457 17.0005
R822 VSS.n22 VSS.n452 17.0005
R823 VSS.n22 VSS.n456 17.0005
R824 VSS.n22 VSS.n453 17.0005
R825 VSS.n22 VSS.n455 17.0005
R826 VSS.n22 VSS.n454 17.0005
R827 VSS.n460 VSS.n22 17.0005
R828 VSS.n459 VSS.t285 17.0005
R829 VSS.n450 VSS.t288 17.0005
R830 VSS.n489 VSS.t290 17.0005
R831 VSS.n446 VSS.t293 17.0005
R832 VSS.n445 VSS.t295 17.0005
R833 VSS.n444 VSS.t298 17.0005
R834 VSS.n443 VSS.t300 17.0005
R835 VSS.n441 VSS.t303 17.0005
R836 VSS.n505 VSS.t305 17.0005
R837 VSS.n437 VSS.t308 17.0005
R838 VSS.n436 VSS.t310 17.0005
R839 VSS.n435 VSS.t313 17.0005
R840 VSS.n434 VSS.t315 17.0005
R841 VSS.n432 VSS.t318 17.0005
R842 VSS.n521 VSS.t320 17.0005
R843 VSS.n429 VSS.t323 17.0005
R844 VSS.n428 VSS.t325 17.0005
R845 VSS.n427 VSS.t328 17.0005
R846 VSS.n426 VSS.t330 17.0005
R847 VSS.n424 VSS.t333 17.0005
R848 VSS.n545 VSS.t335 17.0005
R849 VSS.n420 VSS.t338 17.0005
R850 VSS.n419 VSS.t340 17.0005
R851 VSS.n418 VSS.t343 17.0005
R852 VSS.n417 VSS.t345 17.0005
R853 VSS.n415 VSS.t348 17.0005
R854 VSS.n561 VSS.t350 17.0005
R855 VSS.n411 VSS.t353 17.0005
R856 VSS.n410 VSS.t355 17.0005
R857 VSS.n409 VSS.t358 17.0005
R858 VSS.n408 VSS.t360 17.0005
R859 VSS.n406 VSS.t363 17.0005
R860 VSS.n577 VSS.t365 17.0005
R861 VSS.n403 VSS.t368 17.0005
R862 VSS.n402 VSS.t370 17.0005
R863 VSS.n399 VSS.t373 17.0005
R864 VSS.n15 VSS.t415 16.3876
R865 VSS.n450 VSS.t597 15.3099
R866 VSS.n446 VSS.t595 15.3099
R867 VSS.n444 VSS.t593 15.3099
R868 VSS.n441 VSS.t591 15.3099
R869 VSS.n437 VSS.t589 15.3099
R870 VSS.n435 VSS.t587 15.3099
R871 VSS.n432 VSS.t585 15.3099
R872 VSS.n429 VSS.t583 15.3099
R873 VSS.n427 VSS.t581 15.3099
R874 VSS.n424 VSS.t579 15.3099
R875 VSS.n420 VSS.t577 15.3099
R876 VSS.n418 VSS.t575 15.3099
R877 VSS.n415 VSS.t573 15.3099
R878 VSS.n411 VSS.t571 15.3099
R879 VSS.n409 VSS.t569 15.3099
R880 VSS.n406 VSS.t567 15.3099
R881 VSS.n403 VSS.t565 15.3099
R882 VSS.n399 VSS.t563 15.3099
R883 VSS.n459 VSS.t598 15.2696
R884 VSS.n489 VSS.t596 15.2696
R885 VSS.n445 VSS.t594 15.2696
R886 VSS.n443 VSS.t592 15.2696
R887 VSS.n505 VSS.t590 15.2696
R888 VSS.n436 VSS.t588 15.2696
R889 VSS.n434 VSS.t586 15.2696
R890 VSS.n521 VSS.t584 15.2696
R891 VSS.n428 VSS.t582 15.2696
R892 VSS.n426 VSS.t580 15.2696
R893 VSS.n545 VSS.t578 15.2696
R894 VSS.n419 VSS.t576 15.2696
R895 VSS.n417 VSS.t574 15.2696
R896 VSS.n561 VSS.t572 15.2696
R897 VSS.n410 VSS.t570 15.2696
R898 VSS.n408 VSS.t568 15.2696
R899 VSS.n577 VSS.t566 15.2696
R900 VSS.n402 VSS.t564 15.2696
R901 VSS.n591 VSS.t381 15.1276
R902 VSS.n392 VSS.t385 15.0005
R903 VSS.n904 VSS.t378 15.0005
R904 VSS.n913 VSS.t374 15.0005
R905 VSS.n102 VSS.t529 13.7147
R906 VSS.n162 VSS.t62 8.85039
R907 VSS.n164 VSS.t123 8.85039
R908 VSS.n166 VSS.t204 8.85039
R909 VSS.n168 VSS.t44 8.85039
R910 VSS.n170 VSS.t278 8.85039
R911 VSS.n172 VSS.t93 8.85039
R912 VSS.n174 VSS.t112 8.85039
R913 VSS.n176 VSS.t196 8.85039
R914 VSS.n178 VSS.t42 8.85039
R915 VSS.n180 VSS.t216 8.85039
R916 VSS.n182 VSS.t54 8.85039
R917 VSS.n184 VSS.t280 8.85039
R918 VSS.n186 VSS.t127 8.85039
R919 VSS.n188 VSS.t46 8.85039
R920 VSS.n190 VSS.t427 8.85039
R921 VSS.n192 VSS.t80 8.85039
R922 VSS.n194 VSS.t276 8.85039
R923 VSS.n196 VSS.t517 8.85039
R924 VSS.n198 VSS.t420 8.85039
R925 VSS.n200 VSS.t408 8.85039
R926 VSS.n202 VSS.t50 8.85039
R927 VSS.n204 VSS.t511 8.85039
R928 VSS.n206 VSS.t191 8.85039
R929 VSS.n208 VSS.t393 8.85039
R930 VSS.n210 VSS.t67 8.85039
R931 VSS.n212 VSS.t225 8.85039
R932 VSS.n214 VSS.t424 8.85039
R933 VSS.n216 VSS.t222 8.85039
R934 VSS.n218 VSS.t411 8.85039
R935 VSS.n220 VSS.t403 8.85039
R936 VSS.n222 VSS.t64 8.85039
R937 VSS.n224 VSS.t207 8.85039
R938 VSS.n943 VSS.t238 8.80385
R939 VSS.n939 VSS.t18 8.80385
R940 VSS.n935 VSS.t22 8.80385
R941 VSS.n908 VSS.t101 8.80385
R942 VSS.n467 VSS.t175 8.80285
R943 VSS.n471 VSS.t171 8.80285
R944 VSS.n475 VSS.t180 8.80285
R945 VSS.n479 VSS.t75 8.80285
R946 VSS.n598 VSS.t156 8.77423
R947 VSS.n382 VSS.t125 8.77423
R948 VSS.n608 VSS.t141 8.77423
R949 VSS.n614 VSS.t218 8.77423
R950 VSS.n619 VSS.t251 8.77423
R951 VSS.n373 VSS.t37 8.77423
R952 VSS.n628 VSS.t201 8.77423
R953 VSS.n634 VSS.t540 8.77423
R954 VSS.n638 VSS.t8 8.77423
R955 VSS.n363 VSS.t91 8.77423
R956 VSS.n647 VSS.t2 8.77423
R957 VSS.n652 VSS.t110 8.77423
R958 VSS.n656 VSS.t30 8.77423
R959 VSS.n354 VSS.t198 8.77423
R960 VSS.n665 VSS.t258 8.77423
R961 VSS.n671 VSS.t88 8.77423
R962 VSS.n675 VSS.t230 8.77423
R963 VSS.n344 VSS.t248 8.77423
R964 VSS.n683 VSS.t550 8.77423
R965 VSS.n688 VSS.t52 8.77423
R966 VSS.n693 VSS.t267 8.77423
R967 VSS.n333 VSS.t164 8.77423
R968 VSS.n701 VSS.t264 8.77423
R969 VSS.n707 VSS.t129 8.77423
R970 VSS.n712 VSS.t233 8.77423
R971 VSS.n323 VSS.t48 8.77423
R972 VSS.n721 VSS.t138 8.77423
R973 VSS.n727 VSS.t514 8.77423
R974 VSS.n731 VSS.t11 8.77423
R975 VSS.n314 VSS.t78 8.77423
R976 VSS.n739 VSS.t115 8.77423
R977 VSS.n745 VSS.t274 8.77423
R978 VSS.n750 VSS.t5 8.77423
R979 VSS.n303 VSS.t240 8.77423
R980 VSS.n760 VSS.t86 8.77423
R981 VSS.n765 VSS.t418 8.77423
R982 VSS.n769 VSS.t153 8.77423
R983 VSS.n293 VSS.t134 8.77423
R984 VSS.n778 VSS.t255 8.77423
R985 VSS.n784 VSS.t519 8.77423
R986 VSS.n789 VSS.t159 8.77423
R987 VSS.n283 VSS.t35 8.77423
R988 VSS.n798 VSS.t150 8.77423
R989 VSS.n803 VSS.t193 8.77423
R990 VSS.n809 VSS.t60 8.77423
R991 VSS.n275 VSS.t242 8.77423
R992 VSS.n819 VSS.t120 8.77423
R993 VSS.n824 VSS.t69 8.77423
R994 VSS.n828 VSS.t270 8.77423
R995 VSS.n265 VSS.t103 8.77423
R996 VSS.n837 VSS.t147 8.77423
R997 VSS.n842 VSS.t422 8.77423
R998 VSS.n846 VSS.t14 8.77423
R999 VSS.n256 VSS.t71 8.77423
R1000 VSS.n855 VSS.t245 8.77423
R1001 VSS.n860 VSS.t508 8.77423
R1002 VSS.n864 VSS.t132 8.77423
R1003 VSS.n247 VSS.t161 8.77423
R1004 VSS.n873 VSS.t97 8.77423
R1005 VSS.n878 VSS.t498 8.77423
R1006 VSS.n884 VSS.t106 8.77423
R1007 VSS.n237 VSS.t27 8.77423
R1008 VSS.n892 VSS.t547 8.77423
R1009 VSS.n899 VSS.t235 8.77423
R1010 VSS.n483 VSS.t183 8.77323
R1011 VSS.n499 VSS.t33 8.77323
R1012 VSS.n515 VSS.t144 8.77323
R1013 VSS.n531 VSS.t211 8.77323
R1014 VSS.n533 VSS.t57 8.77323
R1015 VSS.n539 VSS.t186 8.77323
R1016 VSS.n555 VSS.t261 8.77323
R1017 VSS.n571 VSS.t167 8.77323
R1018 VSS.n396 VSS.t83 8.77323
R1019 VSS.n481 VSS.t283 8.76689
R1020 VSS.n537 VSS.t189 8.76678
R1021 VSS.n931 VSS.t528 8.75731
R1022 VSS.n929 VSS.t501 8.75731
R1023 VSS.n461 VSS.t395 8.75631
R1024 VSS.n463 VSS.t414 8.75631
R1025 VSS.n582 VSS.n93 0.0435295
R1026 VSS.n92 VSS.n0 5.65652
R1027 VSS.n91 VSS.n573 0.0633111
R1028 VSS.n90 VSS.n33 4.22409
R1029 VSS.n560 VSS.n89 0.0180497
R1030 VSS.n85 VSS.n557 0.0633111
R1031 VSS.n550 VSS.n81 0.0435295
R1032 VSS.n80 VSS.n73 5.65652
R1033 VSS.n76 VSS.n541 0.0633111
R1034 VSS.n72 VSS.n9 4.22409
R1035 VSS.n71 VSS.n9 5.65652
R1036 VSS.n70 VSS.n517 0.0633111
R1037 VSS.n510 VSS.n67 0.0435295
R1038 VSS.n66 VSS.n59 5.65652
R1039 VSS.n62 VSS.n501 0.0633111
R1040 VSS.n58 VSS.n24 4.22409
R1041 VSS.n57 VSS.n50 5.65652
R1042 VSS.n53 VSS.n485 0.0633111
R1043 VSS.n927 VSS.n911 8.5005
R1044 VSS.n927 VSS.n898 8.5005
R1045 VSS.n927 VSS.n232 8.5005
R1046 VSS.n927 VSS.n891 8.5005
R1047 VSS.n927 VSS.n890 8.5005
R1048 VSS.n927 VSS.n236 8.5005
R1049 VSS.n927 VSS.n889 8.5005
R1050 VSS.n927 VSS.n239 8.5005
R1051 VSS.n927 VSS.n883 8.5005
R1052 VSS.n927 VSS.n240 8.5005
R1053 VSS.n927 VSS.n880 8.5005
R1054 VSS.n927 VSS.n242 8.5005
R1055 VSS.n927 VSS.n872 8.5005
R1056 VSS.n927 VSS.n870 8.5005
R1057 VSS.n927 VSS.n246 8.5005
R1058 VSS.n927 VSS.n869 8.5005
R1059 VSS.n927 VSS.n249 8.5005
R1060 VSS.n927 VSS.n863 8.5005
R1061 VSS.n927 VSS.n250 8.5005
R1062 VSS.n927 VSS.n862 8.5005
R1063 VSS.n927 VSS.n252 8.5005
R1064 VSS.n927 VSS.n854 8.5005
R1065 VSS.n927 VSS.n852 8.5005
R1066 VSS.n927 VSS.n255 8.5005
R1067 VSS.n927 VSS.n851 8.5005
R1068 VSS.n927 VSS.n258 8.5005
R1069 VSS.n927 VSS.n845 8.5005
R1070 VSS.n927 VSS.n259 8.5005
R1071 VSS.n927 VSS.n844 8.5005
R1072 VSS.n927 VSS.n262 8.5005
R1073 VSS.n927 VSS.n836 8.5005
R1074 VSS.n927 VSS.n834 8.5005
R1075 VSS.n927 VSS.n264 8.5005
R1076 VSS.n927 VSS.n833 8.5005
R1077 VSS.n927 VSS.n267 8.5005
R1078 VSS.n927 VSS.n827 8.5005
R1079 VSS.n927 VSS.n268 8.5005
R1080 VSS.n927 VSS.n826 8.5005
R1081 VSS.n927 VSS.n271 8.5005
R1082 VSS.n927 VSS.n818 8.5005
R1083 VSS.n927 VSS.n815 8.5005
R1084 VSS.n927 VSS.n274 8.5005
R1085 VSS.n927 VSS.n814 8.5005
R1086 VSS.n927 VSS.n277 8.5005
R1087 VSS.n927 VSS.n808 8.5005
R1088 VSS.n927 VSS.n278 8.5005
R1089 VSS.n927 VSS.n805 8.5005
R1090 VSS.n927 VSS.n280 8.5005
R1091 VSS.n927 VSS.n797 8.5005
R1092 VSS.n927 VSS.n795 8.5005
R1093 VSS.n927 VSS.n282 8.5005
R1094 VSS.n927 VSS.n794 8.5005
R1095 VSS.n927 VSS.n285 8.5005
R1096 VSS.n927 VSS.n788 8.5005
R1097 VSS.n927 VSS.n286 8.5005
R1098 VSS.n927 VSS.n786 8.5005
R1099 VSS.n927 VSS.n289 8.5005
R1100 VSS.n927 VSS.n777 8.5005
R1101 VSS.n927 VSS.n775 8.5005
R1102 VSS.n927 VSS.n292 8.5005
R1103 VSS.n927 VSS.n774 8.5005
R1104 VSS.n927 VSS.n295 8.5005
R1105 VSS.n927 VSS.n768 8.5005
R1106 VSS.n927 VSS.n296 8.5005
R1107 VSS.n927 VSS.n767 8.5005
R1108 VSS.n927 VSS.n299 8.5005
R1109 VSS.n927 VSS.n759 8.5005
R1110 VSS.n927 VSS.n756 8.5005
R1111 VSS.n927 VSS.n302 8.5005
R1112 VSS.n927 VSS.n755 8.5005
R1113 VSS.n927 VSS.n305 8.5005
R1114 VSS.n927 VSS.n749 8.5005
R1115 VSS.n927 VSS.n306 8.5005
R1116 VSS.n927 VSS.n747 8.5005
R1117 VSS.n927 VSS.n309 8.5005
R1118 VSS.n927 VSS.n738 8.5005
R1119 VSS.n927 VSS.n737 8.5005
R1120 VSS.n927 VSS.n313 8.5005
R1121 VSS.n927 VSS.n736 8.5005
R1122 VSS.n927 VSS.n316 8.5005
R1123 VSS.n927 VSS.n730 8.5005
R1124 VSS.n927 VSS.n317 8.5005
R1125 VSS.n927 VSS.n729 8.5005
R1126 VSS.n927 VSS.n320 8.5005
R1127 VSS.n927 VSS.n720 8.5005
R1128 VSS.n927 VSS.n718 8.5005
R1129 VSS.n927 VSS.n322 8.5005
R1130 VSS.n927 VSS.n717 8.5005
R1131 VSS.n927 VSS.n325 8.5005
R1132 VSS.n927 VSS.n711 8.5005
R1133 VSS.n927 VSS.n326 8.5005
R1134 VSS.n927 VSS.n709 8.5005
R1135 VSS.n927 VSS.n328 8.5005
R1136 VSS.n927 VSS.n700 8.5005
R1137 VSS.n927 VSS.n699 8.5005
R1138 VSS.n927 VSS.n332 8.5005
R1139 VSS.n927 VSS.n698 8.5005
R1140 VSS.n927 VSS.n335 8.5005
R1141 VSS.n927 VSS.n692 8.5005
R1142 VSS.n927 VSS.n336 8.5005
R1143 VSS.n927 VSS.n690 8.5005
R1144 VSS.n927 VSS.n339 8.5005
R1145 VSS.n927 VSS.n682 8.5005
R1146 VSS.n927 VSS.n681 8.5005
R1147 VSS.n927 VSS.n343 8.5005
R1148 VSS.n927 VSS.n680 8.5005
R1149 VSS.n927 VSS.n346 8.5005
R1150 VSS.n927 VSS.n674 8.5005
R1151 VSS.n927 VSS.n347 8.5005
R1152 VSS.n927 VSS.n673 8.5005
R1153 VSS.n927 VSS.n350 8.5005
R1154 VSS.n927 VSS.n664 8.5005
R1155 VSS.n927 VSS.n662 8.5005
R1156 VSS.n927 VSS.n353 8.5005
R1157 VSS.n927 VSS.n661 8.5005
R1158 VSS.n927 VSS.n356 8.5005
R1159 VSS.n927 VSS.n655 8.5005
R1160 VSS.n927 VSS.n357 8.5005
R1161 VSS.n927 VSS.n654 8.5005
R1162 VSS.n927 VSS.n360 8.5005
R1163 VSS.n927 VSS.n646 8.5005
R1164 VSS.n927 VSS.n644 8.5005
R1165 VSS.n927 VSS.n362 8.5005
R1166 VSS.n927 VSS.n643 8.5005
R1167 VSS.n927 VSS.n365 8.5005
R1168 VSS.n927 VSS.n637 8.5005
R1169 VSS.n927 VSS.n366 8.5005
R1170 VSS.n927 VSS.n636 8.5005
R1171 VSS.n927 VSS.n369 8.5005
R1172 VSS.n927 VSS.n627 8.5005
R1173 VSS.n927 VSS.n625 8.5005
R1174 VSS.n927 VSS.n372 8.5005
R1175 VSS.n927 VSS.n624 8.5005
R1176 VSS.n927 VSS.n375 8.5005
R1177 VSS.n927 VSS.n618 8.5005
R1178 VSS.n927 VSS.n376 8.5005
R1179 VSS.n927 VSS.n616 8.5005
R1180 VSS.n927 VSS.n379 8.5005
R1181 VSS.n927 VSS.n607 8.5005
R1182 VSS.n927 VSS.n604 8.5005
R1183 VSS.n927 VSS.n381 8.5005
R1184 VSS.n927 VSS.n603 8.5005
R1185 VSS.n927 VSS.n384 8.5005
R1186 VSS.n927 VSS.n597 8.5005
R1187 VSS.n927 VSS.n385 8.5005
R1188 VSS.n927 VSS.n388 8.5005
R1189 VSS.n581 VSS.n0 8.49319
R1190 VSS.n565 VSS.n82 8.49319
R1191 VSS.n549 VSS.n73 8.49319
R1192 VSS.n525 VSS.n9 8.49319
R1193 VSS.n509 VSS.n59 8.49319
R1194 VSS.n493 VSS.n50 8.49319
R1195 VSS.n942 VSS.n927 8.47732
R1196 VSS.n927 VSS.n228 8.47732
R1197 VSS.n927 VSS.n897 8.47732
R1198 VSS.n927 VSS.n879 8.47732
R1199 VSS.n927 VSS.n861 8.47732
R1200 VSS.n927 VSS.n843 8.47732
R1201 VSS.n927 VSS.n825 8.47732
R1202 VSS.n927 VSS.n804 8.47732
R1203 VSS.n927 VSS.n785 8.47732
R1204 VSS.n927 VSS.n766 8.47732
R1205 VSS.n927 VSS.n746 8.47732
R1206 VSS.n927 VSS.n728 8.47732
R1207 VSS.n927 VSS.n708 8.47732
R1208 VSS.n927 VSS.n689 8.47732
R1209 VSS.n927 VSS.n672 8.47732
R1210 VSS.n927 VSS.n653 8.47732
R1211 VSS.n927 VSS.n635 8.47732
R1212 VSS.n927 VSS.n615 8.47732
R1213 VSS.n927 VSS.n105 8.47732
R1214 VSS.n927 VSS.n161 8.47732
R1215 VSS.n927 VSS.n160 8.47732
R1216 VSS.n0 VSS.n93 4.22409
R1217 VSS.n575 VSS.n1 8.47732
R1218 VSS.n1 VSS.n91 4.21421
R1219 VSS.n567 VSS.n90 0.176279
R1220 VSS.n559 VSS.n84 8.47732
R1221 VSS.n84 VSS.n85 4.21421
R1222 VSS.n81 VSS.n30 4.22409
R1223 VSS.n543 VSS.n75 8.47732
R1224 VSS.n75 VSS.n76 4.21421
R1225 VSS.n527 VSS.n72 0.176279
R1226 VSS.n519 VSS.n69 8.47732
R1227 VSS.n69 VSS.n70 4.21421
R1228 VSS.n67 VSS.n27 4.22409
R1229 VSS.n503 VSS.n61 8.47732
R1230 VSS.n61 VSS.n62 4.21421
R1231 VSS.n495 VSS.n58 0.176279
R1232 VSS.n487 VSS.n52 8.47732
R1233 VSS.n52 VSS.n53 4.21421
R1234 VSS.n474 VSS.n22 8.47732
R1235 VSS.n391 VSS.t387 8.46888
R1236 VSS.n587 VSS.t383 8.46888
R1237 VSS.n593 VSS.t384 8.46631
R1238 VSS.n600 VSS.t494 8.46631
R1239 VSS.n612 VSS.t446 8.46631
R1240 VSS.n621 VSS.t458 8.46631
R1241 VSS.n632 VSS.t442 8.46631
R1242 VSS.n640 VSS.t492 8.46631
R1243 VSS.n650 VSS.t444 8.46631
R1244 VSS.n658 VSS.t440 8.46631
R1245 VSS.n669 VSS.t448 8.46631
R1246 VSS.n677 VSS.t460 8.46631
R1247 VSS.n686 VSS.t476 8.46631
R1248 VSS.n695 VSS.t490 8.46631
R1249 VSS.n705 VSS.t484 8.46631
R1250 VSS.n714 VSS.t488 8.46631
R1251 VSS.n725 VSS.t482 8.46631
R1252 VSS.n733 VSS.t486 8.46631
R1253 VSS.n743 VSS.t480 8.46631
R1254 VSS.n752 VSS.t474 8.46631
R1255 VSS.n763 VSS.t478 8.46631
R1256 VSS.n771 VSS.t472 8.46631
R1257 VSS.n782 VSS.t470 8.46631
R1258 VSS.n791 VSS.t434 8.46631
R1259 VSS.n801 VSS.t468 8.46631
R1260 VSS.n811 VSS.t466 8.46631
R1261 VSS.n822 VSS.t438 8.46631
R1262 VSS.n830 VSS.t464 8.46631
R1263 VSS.n840 VSS.t432 8.46631
R1264 VSS.n848 VSS.t462 8.46631
R1265 VSS.n858 VSS.t456 8.46631
R1266 VSS.n866 VSS.t454 8.46631
R1267 VSS.n876 VSS.t436 8.46631
R1268 VSS.n886 VSS.t452 8.46631
R1269 VSS.n895 VSS.t450 8.46631
R1270 VSS.n906 VSS.t380 8.46519
R1271 VSS.n901 VSS.t376 8.46519
R1272 VSS.n914 VSS.t377 8.46519
R1273 VSS.n945 VSS.n94 6.99673
R1274 VSS.n927 VSS.n395 5.63777
R1275 VSS.n934 VSS.n927 5.62581
R1276 VSS.n938 VSS.n927 5.62581
R1277 VSS.n944 VSS.n927 5.62581
R1278 VSS.n927 VSS.n893 5.62581
R1279 VSS.n927 VSS.n241 5.62581
R1280 VSS.n927 VSS.n874 5.62581
R1281 VSS.n927 VSS.n251 5.62581
R1282 VSS.n927 VSS.n856 5.62581
R1283 VSS.n927 VSS.n260 5.62581
R1284 VSS.n927 VSS.n838 5.62581
R1285 VSS.n927 VSS.n270 5.62581
R1286 VSS.n927 VSS.n820 5.62581
R1287 VSS.n927 VSS.n279 5.62581
R1288 VSS.n927 VSS.n799 5.62581
R1289 VSS.n927 VSS.n287 5.62581
R1290 VSS.n927 VSS.n779 5.62581
R1291 VSS.n927 VSS.n297 5.62581
R1292 VSS.n927 VSS.n761 5.62581
R1293 VSS.n927 VSS.n308 5.62581
R1294 VSS.n927 VSS.n740 5.62581
R1295 VSS.n927 VSS.n319 5.62581
R1296 VSS.n927 VSS.n722 5.62581
R1297 VSS.n927 VSS.n327 5.62581
R1298 VSS.n927 VSS.n702 5.62581
R1299 VSS.n927 VSS.n337 5.62581
R1300 VSS.n927 VSS.n684 5.62581
R1301 VSS.n927 VSS.n349 5.62581
R1302 VSS.n927 VSS.n666 5.62581
R1303 VSS.n927 VSS.n358 5.62581
R1304 VSS.n927 VSS.n648 5.62581
R1305 VSS.n927 VSS.n368 5.62581
R1306 VSS.n927 VSS.n629 5.62581
R1307 VSS.n927 VSS.n377 5.62581
R1308 VSS.n927 VSS.n609 5.62581
R1309 VSS.n927 VSS.n225 5.62581
R1310 VSS.n927 VSS.n223 5.62581
R1311 VSS.n927 VSS.n221 5.62581
R1312 VSS.n927 VSS.n219 5.62581
R1313 VSS.n927 VSS.n217 5.62581
R1314 VSS.n927 VSS.n215 5.62581
R1315 VSS.n927 VSS.n213 5.62581
R1316 VSS.n927 VSS.n211 5.62581
R1317 VSS.n927 VSS.n209 5.62581
R1318 VSS.n927 VSS.n207 5.62581
R1319 VSS.n927 VSS.n205 5.62581
R1320 VSS.n927 VSS.n203 5.62581
R1321 VSS.n927 VSS.n201 5.62581
R1322 VSS.n927 VSS.n199 5.62581
R1323 VSS.n927 VSS.n197 5.62581
R1324 VSS.n927 VSS.n195 5.62581
R1325 VSS.n927 VSS.n193 5.62581
R1326 VSS.n927 VSS.n191 5.62581
R1327 VSS.n927 VSS.n189 5.62581
R1328 VSS.n927 VSS.n187 5.62581
R1329 VSS.n927 VSS.n185 5.62581
R1330 VSS.n927 VSS.n183 5.62581
R1331 VSS.n927 VSS.n181 5.62581
R1332 VSS.n927 VSS.n179 5.62581
R1333 VSS.n927 VSS.n177 5.62581
R1334 VSS.n927 VSS.n175 5.62581
R1335 VSS.n927 VSS.n173 5.62581
R1336 VSS.n927 VSS.n171 5.62581
R1337 VSS.n927 VSS.n169 5.62581
R1338 VSS.n927 VSS.n167 5.62581
R1339 VSS.n927 VSS.n165 5.62581
R1340 VSS.n927 VSS.n163 5.62581
R1341 VSS.n927 VSS.n158 5.62581
R1342 VSS.n0 VSS.n401 5.62581
R1343 VSS.n0 VSS.n405 5.62581
R1344 VSS.n568 VSS.n33 5.62581
R1345 VSS.n82 VSS.n414 5.62581
R1346 VSS.n552 VSS.n30 5.62581
R1347 VSS.n73 VSS.n423 5.62581
R1348 VSS.n536 VSS.n9 5.62581
R1349 VSS.n528 VSS.n9 5.62581
R1350 VSS.n9 VSS.n431 5.62581
R1351 VSS.n512 VSS.n27 5.62581
R1352 VSS.n59 VSS.n440 5.62581
R1353 VSS.n496 VSS.n24 5.62581
R1354 VSS.n50 VSS.n449 5.62581
R1355 VSS.n480 VSS.n22 5.62581
R1356 VSS.n478 VSS.n22 5.62581
R1357 VSS.n470 VSS.n22 5.62581
R1358 VSS.n466 VSS.n22 5.62581
R1359 VSS.n460 VSS.n94 4.28471
R1360 VSS.n0 VSS.n580 4.21914
R1361 VSS.n82 VSS.n564 4.21914
R1362 VSS.n73 VSS.n548 4.21914
R1363 VSS.n9 VSS.n524 4.21914
R1364 VSS.n59 VSS.n508 4.21914
R1365 VSS.n50 VSS.n492 4.21914
R1366 VSS.n927 VSS.n159 4.20662
R1367 VSS.n930 VSS.n927 4.19244
R1368 VSS.n927 VSS.n910 4.19244
R1369 VSS.n462 VSS.n22 4.19244
R1370 VSS VSS.n94 3.80469
R1371 VSS.n898 VSS.t449 3.34498
R1372 VSS.n890 VSS.t451 3.34498
R1373 VSS.n880 VSS.t435 3.34498
R1374 VSS.n870 VSS.t453 3.34498
R1375 VSS.n862 VSS.t455 3.34498
R1376 VSS.n852 VSS.t461 3.34498
R1377 VSS.n844 VSS.t431 3.34498
R1378 VSS.n834 VSS.t463 3.34498
R1379 VSS.n826 VSS.t437 3.34498
R1380 VSS.n815 VSS.t465 3.34498
R1381 VSS.n805 VSS.t467 3.34498
R1382 VSS.n795 VSS.t433 3.34498
R1383 VSS.n786 VSS.t469 3.34498
R1384 VSS.n775 VSS.t471 3.34498
R1385 VSS.n767 VSS.t477 3.34498
R1386 VSS.n756 VSS.t473 3.34498
R1387 VSS.n747 VSS.t479 3.34498
R1388 VSS.n737 VSS.t485 3.34498
R1389 VSS.n729 VSS.t481 3.34498
R1390 VSS.n718 VSS.t487 3.34498
R1391 VSS.n709 VSS.t483 3.34498
R1392 VSS.n699 VSS.t489 3.34498
R1393 VSS.n690 VSS.t475 3.34498
R1394 VSS.n681 VSS.t459 3.34498
R1395 VSS.n673 VSS.t447 3.34498
R1396 VSS.n662 VSS.t439 3.34498
R1397 VSS.n654 VSS.t443 3.34498
R1398 VSS.n644 VSS.t491 3.34498
R1399 VSS.n636 VSS.t441 3.34498
R1400 VSS.n625 VSS.t457 3.34498
R1401 VSS.n616 VSS.t445 3.34498
R1402 VSS.n604 VSS.t493 3.34498
R1403 VSS.n936 VSS.n927 3.3265
R1404 VSS.n940 VSS.n927 3.3265
R1405 VSS.n927 VSS.n888 3.3265
R1406 VSS.n927 VSS.n868 3.3265
R1407 VSS.n927 VSS.n850 3.3265
R1408 VSS.n927 VSS.n832 3.3265
R1409 VSS.n927 VSS.n813 3.3265
R1410 VSS.n927 VSS.n793 3.3265
R1411 VSS.n927 VSS.n773 3.3265
R1412 VSS.n927 VSS.n754 3.3265
R1413 VSS.n927 VSS.n735 3.3265
R1414 VSS.n927 VSS.n716 3.3265
R1415 VSS.n927 VSS.n697 3.3265
R1416 VSS.n927 VSS.n679 3.3265
R1417 VSS.n927 VSS.n660 3.3265
R1418 VSS.n927 VSS.n642 3.3265
R1419 VSS.n927 VSS.n623 3.3265
R1420 VSS.n927 VSS.n602 3.3265
R1421 VSS.n572 VSS.n33 3.3265
R1422 VSS.n556 VSS.n30 3.3265
R1423 VSS.n540 VSS.n9 3.3265
R1424 VSS.n516 VSS.n27 3.3265
R1425 VSS.n500 VSS.n24 3.3265
R1426 VSS.n484 VSS.n22 3.3265
R1427 VSS.n476 VSS.n22 3.3265
R1428 VSS.n472 VSS.n22 3.3265
R1429 VSS.n468 VSS.n22 3.3265
R1430 VSS.n917 VSS 3.16675
R1431 VSS.n585 VSS.n584 3.01826
R1432 VSS.n927 VSS.n95 2.83376
R1433 VSS.n932 VSS.n927 2.74446
R1434 VSS.n927 VSS.n234 2.74446
R1435 VSS.n927 VSS.n245 2.74446
R1436 VSS.n927 VSS.n254 2.74446
R1437 VSS.n927 VSS.n263 2.74446
R1438 VSS.n927 VSS.n273 2.74446
R1439 VSS.n927 VSS.n281 2.74446
R1440 VSS.n927 VSS.n290 2.74446
R1441 VSS.n927 VSS.n301 2.74446
R1442 VSS.n927 VSS.n311 2.74446
R1443 VSS.n927 VSS.n321 2.74446
R1444 VSS.n927 VSS.n330 2.74446
R1445 VSS.n927 VSS.n342 2.74446
R1446 VSS.n927 VSS.n352 2.74446
R1447 VSS.n927 VSS.n361 2.74446
R1448 VSS.n927 VSS.n370 2.74446
R1449 VSS.n927 VSS.n380 2.74446
R1450 VSS.n927 VSS.n226 2.74446
R1451 VSS.n464 VSS.n22 2.74446
R1452 VSS.n927 VSS.n108 2.32483
R1453 VSS.n927 VSS.n109 2.32483
R1454 VSS.n927 VSS.n110 2.32483
R1455 VSS.n927 VSS.n111 2.32483
R1456 VSS.n927 VSS.n115 2.32483
R1457 VSS.n927 VSS.n116 2.32483
R1458 VSS.n927 VSS.n119 2.32483
R1459 VSS.n927 VSS.n121 2.32483
R1460 VSS.n927 VSS.n123 2.32483
R1461 VSS.n927 VSS.n124 2.32483
R1462 VSS.n927 VSS.n126 2.32483
R1463 VSS.n927 VSS.n128 2.32483
R1464 VSS.n927 VSS.n129 2.32483
R1465 VSS.n927 VSS.n130 2.32483
R1466 VSS.n927 VSS.n132 2.32483
R1467 VSS.n927 VSS.n133 2.32483
R1468 VSS.n927 VSS.n134 2.32483
R1469 VSS.n927 VSS.n135 2.32483
R1470 VSS.n927 VSS.n137 2.32483
R1471 VSS.n927 VSS.n139 2.32483
R1472 VSS.n927 VSS.n141 2.32483
R1473 VSS.n927 VSS.n142 2.32483
R1474 VSS.n927 VSS.n143 2.32483
R1475 VSS.n927 VSS.n145 2.32483
R1476 VSS.n927 VSS.n147 2.32483
R1477 VSS.n927 VSS.n148 2.32483
R1478 VSS.n927 VSS.n151 2.32483
R1479 VSS.n927 VSS.n153 2.32483
R1480 VSS.n927 VSS.n155 2.32483
R1481 VSS.n927 VSS.n156 2.32483
R1482 VSS.n927 VSS.n157 2.32483
R1483 VSS.n534 VSS.n9 2.00687
R1484 VSS.n927 VSS.n96 1.64417
R1485 VSS.n927 VSS.n924 1.64417
R1486 VSS.n927 VSS.n100 1.64417
R1487 VSS.n927 VSS.n102 1.64417
R1488 VSS.n927 VSS.n920 1.64417
R1489 VSS.n0 VSS.n398 1.56144
R1490 VSS.n570 VSS.n33 1.56144
R1491 VSS.n554 VSS.n30 1.56144
R1492 VSS.n530 VSS.n9 1.56144
R1493 VSS.n514 VSS.n27 1.56144
R1494 VSS.n498 VSS.n24 1.56144
R1495 VSS.n538 VSS.n9 1.12565
R1496 VSS.n584 VSS.n0 0.92982
R1497 VSS.n482 VSS.n481 0.909006
R1498 VSS.n483 VSS.n482 0.898984
R1499 VSS.n532 VSS.n9 0.849178
R1500 VSS.n532 VSS.n531 0.728316
R1501 VSS.n533 VSS.n532 0.69965
R1502 VSS.n584 VSS.n396 0.69304
R1503 VSS.n413 VSS.n33 0.613782
R1504 VSS.n422 VSS.n30 0.613782
R1505 VSS.n10 VSS.n9 0.00100169
R1506 VSS.n439 VSS.n27 0.613782
R1507 VSS.n448 VSS.n24 0.613782
R1508 VSS.n22 VSS.n12 0.613782
R1509 VSS.n22 VSS.n14 0.613782
R1510 VSS.n22 VSS.n21 0.613782
R1511 VSS.n22 VSS.n17 0.613782
R1512 VSS.n22 VSS.n18 0.613782
R1513 VSS.n538 VSS.n537 0.603496
R1514 VSS.n927 VSS.n49 0.00104694
R1515 VSS.n927 VSS.n104 0.556705
R1516 VSS.n539 VSS.n538 0.540438
R1517 VSS VSS.n945 0.48296
R1518 VSS.n594 VSS.n593 0.419816
R1519 VSS.n601 VSS.n600 0.419816
R1520 VSS.n613 VSS.n612 0.419816
R1521 VSS.n622 VSS.n621 0.419816
R1522 VSS.n633 VSS.n632 0.419816
R1523 VSS.n641 VSS.n640 0.419816
R1524 VSS.n651 VSS.n650 0.419816
R1525 VSS.n659 VSS.n658 0.419816
R1526 VSS.n670 VSS.n669 0.419816
R1527 VSS.n678 VSS.n677 0.419816
R1528 VSS.n687 VSS.n686 0.419816
R1529 VSS.n696 VSS.n695 0.419816
R1530 VSS.n706 VSS.n705 0.419816
R1531 VSS.n715 VSS.n714 0.419816
R1532 VSS.n726 VSS.n725 0.419816
R1533 VSS.n734 VSS.n733 0.419816
R1534 VSS.n744 VSS.n743 0.419816
R1535 VSS.n753 VSS.n752 0.419816
R1536 VSS.n764 VSS.n763 0.419816
R1537 VSS.n772 VSS.n771 0.419816
R1538 VSS.n783 VSS.n782 0.419816
R1539 VSS.n792 VSS.n791 0.419816
R1540 VSS.n802 VSS.n801 0.419816
R1541 VSS.n812 VSS.n811 0.419816
R1542 VSS.n823 VSS.n822 0.419816
R1543 VSS.n831 VSS.n830 0.419816
R1544 VSS.n841 VSS.n840 0.419816
R1545 VSS.n849 VSS.n848 0.419816
R1546 VSS.n859 VSS.n858 0.419816
R1547 VSS.n867 VSS.n866 0.419816
R1548 VSS.n877 VSS.n876 0.419816
R1549 VSS.n887 VSS.n886 0.419816
R1550 VSS.n896 VSS.n895 0.419816
R1551 VSS.n499 VSS.n498 0.413418
R1552 VSS.n515 VSS.n514 0.413418
R1553 VSS.n531 VSS.n530 0.413418
R1554 VSS.n555 VSS.n554 0.413418
R1555 VSS.n571 VSS.n570 0.413418
R1556 VSS.n398 VSS.n396 0.413418
R1557 VSS.n482 VSS.n22 0.405836
R1558 VSS.n906 VSS.n905 0.385697
R1559 VSS.n901 VSS.n900 0.385697
R1560 VSS.n593 VSS.n592 0.383459
R1561 VSS.n600 VSS.n599 0.383459
R1562 VSS.n612 VSS.n611 0.383459
R1563 VSS.n621 VSS.n620 0.383459
R1564 VSS.n632 VSS.n631 0.383459
R1565 VSS.n640 VSS.n639 0.383459
R1566 VSS.n650 VSS.n649 0.383459
R1567 VSS.n658 VSS.n657 0.383459
R1568 VSS.n669 VSS.n668 0.383459
R1569 VSS.n677 VSS.n676 0.383459
R1570 VSS.n686 VSS.n685 0.383459
R1571 VSS.n695 VSS.n694 0.383459
R1572 VSS.n705 VSS.n704 0.383459
R1573 VSS.n714 VSS.n713 0.383459
R1574 VSS.n725 VSS.n724 0.383459
R1575 VSS.n733 VSS.n732 0.383459
R1576 VSS.n743 VSS.n742 0.383459
R1577 VSS.n752 VSS.n751 0.383459
R1578 VSS.n763 VSS.n762 0.383459
R1579 VSS.n771 VSS.n770 0.383459
R1580 VSS.n782 VSS.n781 0.383459
R1581 VSS.n791 VSS.n790 0.383459
R1582 VSS.n801 VSS.n800 0.383459
R1583 VSS.n811 VSS.n810 0.383459
R1584 VSS.n822 VSS.n821 0.383459
R1585 VSS.n830 VSS.n829 0.383459
R1586 VSS.n840 VSS.n839 0.383459
R1587 VSS.n848 VSS.n847 0.383459
R1588 VSS.n858 VSS.n857 0.383459
R1589 VSS.n866 VSS.n865 0.383459
R1590 VSS.n876 VSS.n875 0.383459
R1591 VSS.n886 VSS.n885 0.383459
R1592 VSS.n895 VSS.n894 0.383459
R1593 VSS.n535 VSS.n534 0.380519
R1594 VSS.n915 VSS.n914 0.379351
R1595 VSS.n588 VSS.n587 0.37817
R1596 VSS.n534 VSS.n533 0.359515
R1597 VSS.n224 VSS.n108 0.351341
R1598 VSS.n222 VSS.n109 0.351341
R1599 VSS.n220 VSS.n110 0.351341
R1600 VSS.n218 VSS.n111 0.351341
R1601 VSS.n216 VSS.n115 0.351341
R1602 VSS.n214 VSS.n116 0.351341
R1603 VSS.n212 VSS.n119 0.351341
R1604 VSS.n210 VSS.n121 0.351341
R1605 VSS.n208 VSS.n123 0.351341
R1606 VSS.n206 VSS.n124 0.351341
R1607 VSS.n204 VSS.n126 0.351341
R1608 VSS.n202 VSS.n128 0.351341
R1609 VSS.n200 VSS.n129 0.351341
R1610 VSS.n198 VSS.n130 0.351341
R1611 VSS.n196 VSS.n132 0.351341
R1612 VSS.n194 VSS.n133 0.351341
R1613 VSS.n192 VSS.n134 0.351341
R1614 VSS.n190 VSS.n135 0.351341
R1615 VSS.n188 VSS.n137 0.351341
R1616 VSS.n186 VSS.n139 0.351341
R1617 VSS.n184 VSS.n141 0.351341
R1618 VSS.n182 VSS.n142 0.351341
R1619 VSS.n180 VSS.n143 0.351341
R1620 VSS.n178 VSS.n145 0.351341
R1621 VSS.n176 VSS.n147 0.351341
R1622 VSS.n174 VSS.n148 0.351341
R1623 VSS.n172 VSS.n151 0.351341
R1624 VSS.n170 VSS.n153 0.351341
R1625 VSS.n168 VSS.n155 0.351341
R1626 VSS.n166 VSS.n156 0.351341
R1627 VSS.n164 VSS.n157 0.351341
R1628 VSS.n391 VSS.n390 0.345929
R1629 VSS.n587 VSS.n586 0.345929
R1630 VSS.n400 VSS.n398 0.340858
R1631 VSS.n570 VSS.n569 0.340858
R1632 VSS.n554 VSS.n553 0.340858
R1633 VSS.n530 VSS.n529 0.340858
R1634 VSS.n514 VSS.n513 0.340858
R1635 VSS.n498 VSS.n497 0.340858
R1636 VSS.n933 VSS.n932 0.318018
R1637 VSS.n465 VSS.n464 0.316299
R1638 VSS.n885 VSS.n108 0.311066
R1639 VSS.n875 VSS.n109 0.311066
R1640 VSS.n865 VSS.n110 0.311066
R1641 VSS.n857 VSS.n111 0.311066
R1642 VSS.n847 VSS.n115 0.311066
R1643 VSS.n839 VSS.n116 0.311066
R1644 VSS.n829 VSS.n119 0.311066
R1645 VSS.n821 VSS.n121 0.311066
R1646 VSS.n810 VSS.n123 0.311066
R1647 VSS.n800 VSS.n124 0.311066
R1648 VSS.n790 VSS.n126 0.311066
R1649 VSS.n781 VSS.n128 0.311066
R1650 VSS.n770 VSS.n129 0.311066
R1651 VSS.n762 VSS.n130 0.311066
R1652 VSS.n751 VSS.n132 0.311066
R1653 VSS.n742 VSS.n133 0.311066
R1654 VSS.n732 VSS.n134 0.311066
R1655 VSS.n724 VSS.n135 0.311066
R1656 VSS.n713 VSS.n137 0.311066
R1657 VSS.n704 VSS.n139 0.311066
R1658 VSS.n694 VSS.n141 0.311066
R1659 VSS.n685 VSS.n142 0.311066
R1660 VSS.n676 VSS.n143 0.311066
R1661 VSS.n668 VSS.n145 0.311066
R1662 VSS.n657 VSS.n147 0.311066
R1663 VSS.n649 VSS.n148 0.311066
R1664 VSS.n639 VSS.n151 0.311066
R1665 VSS.n631 VSS.n153 0.311066
R1666 VSS.n620 VSS.n155 0.311066
R1667 VSS.n611 VSS.n156 0.311066
R1668 VSS.n599 VSS.n157 0.311066
R1669 VSS.n237 VSS.n234 0.284268
R1670 VSS.n247 VSS.n245 0.284268
R1671 VSS.n256 VSS.n254 0.284268
R1672 VSS.n265 VSS.n263 0.284268
R1673 VSS.n275 VSS.n273 0.284268
R1674 VSS.n283 VSS.n281 0.284268
R1675 VSS.n293 VSS.n290 0.284268
R1676 VSS.n303 VSS.n301 0.284268
R1677 VSS.n314 VSS.n311 0.284268
R1678 VSS.n323 VSS.n321 0.284268
R1679 VSS.n333 VSS.n330 0.284268
R1680 VSS.n344 VSS.n342 0.284268
R1681 VSS.n354 VSS.n352 0.284268
R1682 VSS.n363 VSS.n361 0.284268
R1683 VSS.n373 VSS.n370 0.284268
R1684 VSS.n382 VSS.n380 0.284268
R1685 VSS.n914 VSS.n913 0.279928
R1686 VSS.n464 VSS.n463 0.274268
R1687 VSS.n472 VSS.n471 0.274227
R1688 VSS.n484 VSS.n483 0.274227
R1689 VSS.n500 VSS.n499 0.274227
R1690 VSS.n516 VSS.n515 0.274227
R1691 VSS.n540 VSS.n539 0.274227
R1692 VSS.n556 VSS.n555 0.274227
R1693 VSS.n572 VSS.n571 0.274227
R1694 VSS.n940 VSS.n939 0.272997
R1695 VSS.n932 VSS.n931 0.272549
R1696 VSS.n905 VSS.n226 0.271299
R1697 VSS.n927 VSS.n919 0.267794
R1698 VSS.n927 VSS.n231 0.267794
R1699 VSS.n927 VSS.n235 0.267794
R1700 VSS.n927 VSS.n882 0.267794
R1701 VSS.n927 VSS.n881 0.267794
R1702 VSS.n927 VSS.n243 0.267794
R1703 VSS.n927 VSS.n871 0.267794
R1704 VSS.n927 VSS.n853 0.267794
R1705 VSS.n927 VSS.n261 0.267794
R1706 VSS.n927 VSS.n269 0.267794
R1707 VSS.n927 VSS.n272 0.267794
R1708 VSS.n927 VSS.n816 0.267794
R1709 VSS.n927 VSS.n807 0.267794
R1710 VSS.n927 VSS.n806 0.267794
R1711 VSS.n927 VSS.n787 0.267794
R1712 VSS.n927 VSS.n288 0.267794
R1713 VSS.n927 VSS.n780 0.267794
R1714 VSS.n927 VSS.n291 0.267794
R1715 VSS.n927 VSS.n298 0.267794
R1716 VSS.n927 VSS.n300 0.267794
R1717 VSS.n927 VSS.n757 0.267794
R1718 VSS.n927 VSS.n307 0.267794
R1719 VSS.n927 VSS.n748 0.267794
R1720 VSS.n927 VSS.n741 0.267794
R1721 VSS.n927 VSS.n312 0.267794
R1722 VSS.n927 VSS.n318 0.267794
R1723 VSS.n927 VSS.n723 0.267794
R1724 VSS.n927 VSS.n710 0.267794
R1725 VSS.n927 VSS.n703 0.267794
R1726 VSS.n927 VSS.n331 0.267794
R1727 VSS.n927 VSS.n691 0.267794
R1728 VSS.n927 VSS.n338 0.267794
R1729 VSS.n927 VSS.n340 0.267794
R1730 VSS.n927 VSS.n348 0.267794
R1731 VSS.n927 VSS.n667 0.267794
R1732 VSS.n927 VSS.n663 0.267794
R1733 VSS.n927 VSS.n359 0.267794
R1734 VSS.n927 VSS.n367 0.267794
R1735 VSS.n927 VSS.n630 0.267794
R1736 VSS.n927 VSS.n371 0.267794
R1737 VSS.n927 VSS.n617 0.267794
R1738 VSS.n927 VSS.n378 0.267794
R1739 VSS.n927 VSS.n610 0.267794
R1740 VSS.n927 VSS.n605 0.267794
R1741 VSS.n927 VSS.n590 0.267794
R1742 VSS.n927 VSS.n107 0.267794
R1743 VSS.n927 VSS.n112 0.267794
R1744 VSS.n927 VSS.n113 0.267794
R1745 VSS.n927 VSS.n114 0.267794
R1746 VSS.n927 VSS.n117 0.267794
R1747 VSS.n927 VSS.n118 0.267794
R1748 VSS.n927 VSS.n120 0.267794
R1749 VSS.n927 VSS.n122 0.267794
R1750 VSS.n927 VSS.n125 0.267794
R1751 VSS.n927 VSS.n127 0.267794
R1752 VSS.n927 VSS.n131 0.267794
R1753 VSS.n927 VSS.n136 0.267794
R1754 VSS.n927 VSS.n138 0.267794
R1755 VSS.n927 VSS.n140 0.267794
R1756 VSS.n927 VSS.n144 0.267794
R1757 VSS.n927 VSS.n146 0.267794
R1758 VSS.n927 VSS.n149 0.267794
R1759 VSS.n927 VSS.n150 0.267794
R1760 VSS.n927 VSS.n152 0.267794
R1761 VSS.n927 VSS.n154 0.267794
R1762 VSS.n894 VSS.n226 0.265518
R1763 VSS.n394 VSS.n159 0.259448
R1764 VSS.n392 VSS.n391 0.251101
R1765 VSS.n477 VSS.n476 0.245497
R1766 VSS.n888 VSS.n887 0.244247
R1767 VSS.n868 VSS.n867 0.244247
R1768 VSS.n850 VSS.n849 0.244247
R1769 VSS.n832 VSS.n831 0.244247
R1770 VSS.n813 VSS.n812 0.244247
R1771 VSS.n793 VSS.n792 0.244247
R1772 VSS.n773 VSS.n772 0.244247
R1773 VSS.n754 VSS.n753 0.244247
R1774 VSS.n735 VSS.n734 0.244247
R1775 VSS.n716 VSS.n715 0.244247
R1776 VSS.n697 VSS.n696 0.244247
R1777 VSS.n679 VSS.n678 0.244247
R1778 VSS.n660 VSS.n659 0.244247
R1779 VSS.n642 VSS.n641 0.244247
R1780 VSS.n623 VSS.n622 0.244247
R1781 VSS.n602 VSS.n601 0.244247
R1782 VSS.n892 VSS.n234 0.240049
R1783 VSS.n873 VSS.n245 0.240049
R1784 VSS.n855 VSS.n254 0.240049
R1785 VSS.n837 VSS.n263 0.240049
R1786 VSS.n819 VSS.n273 0.240049
R1787 VSS.n798 VSS.n281 0.240049
R1788 VSS.n778 VSS.n290 0.240049
R1789 VSS.n760 VSS.n301 0.240049
R1790 VSS.n739 VSS.n311 0.240049
R1791 VSS.n721 VSS.n321 0.240049
R1792 VSS.n701 VSS.n330 0.240049
R1793 VSS.n683 VSS.n342 0.240049
R1794 VSS.n665 VSS.n352 0.240049
R1795 VSS.n647 VSS.n361 0.240049
R1796 VSS.n628 VSS.n370 0.240049
R1797 VSS.n608 VSS.n380 0.240049
R1798 VSS.n485 VSS.n484 0.237997
R1799 VSS.n501 VSS.n500 0.237997
R1800 VSS.n517 VSS.n516 0.237997
R1801 VSS.n541 VSS.n540 0.237997
R1802 VSS.n557 VSS.n556 0.237997
R1803 VSS.n573 VSS.n572 0.237997
R1804 VSS.n468 VSS.n467 0.234227
R1805 VSS.n936 VSS.n935 0.232997
R1806 VSS.n937 VSS.n936 0.231727
R1807 VSS.n469 VSS.n468 0.230497
R1808 VSS.n888 VSS.n884 0.224227
R1809 VSS.n868 VSS.n864 0.224227
R1810 VSS.n850 VSS.n846 0.224227
R1811 VSS.n832 VSS.n828 0.224227
R1812 VSS.n813 VSS.n809 0.224227
R1813 VSS.n793 VSS.n789 0.224227
R1814 VSS.n773 VSS.n769 0.224227
R1815 VSS.n754 VSS.n750 0.224227
R1816 VSS.n735 VSS.n731 0.224227
R1817 VSS.n716 VSS.n712 0.224227
R1818 VSS.n697 VSS.n693 0.224227
R1819 VSS.n679 VSS.n675 0.224227
R1820 VSS.n660 VSS.n656 0.224227
R1821 VSS.n642 VSS.n638 0.224227
R1822 VSS.n623 VSS.n619 0.224227
R1823 VSS.n602 VSS.n598 0.224227
R1824 VSS.n476 VSS.n475 0.219227
R1825 VSS.n907 VSS.n906 0.21012
R1826 VSS.n903 VSS.n901 0.21012
R1827 VSS.n395 VSS.n394 0.206787
R1828 VSS.n931 VSS.n930 0.201058
R1829 VSS.n463 VSS.n462 0.200293
R1830 VSS.n941 VSS.n940 0.191727
R1831 VSS.n473 VSS.n472 0.190497
R1832 VSS.n893 VSS.n892 0.186138
R1833 VSS.n874 VSS.n873 0.186138
R1834 VSS.n856 VSS.n855 0.186138
R1835 VSS.n838 VSS.n837 0.186138
R1836 VSS.n820 VSS.n819 0.186138
R1837 VSS.n799 VSS.n798 0.186138
R1838 VSS.n779 VSS.n778 0.186138
R1839 VSS.n761 VSS.n760 0.186138
R1840 VSS.n740 VSS.n739 0.186138
R1841 VSS.n722 VSS.n721 0.186138
R1842 VSS.n702 VSS.n701 0.186138
R1843 VSS.n684 VSS.n683 0.186138
R1844 VSS.n666 VSS.n665 0.186138
R1845 VSS.n648 VSS.n647 0.186138
R1846 VSS.n629 VSS.n628 0.186138
R1847 VSS.n609 VSS.n608 0.186138
R1848 VSS.n481 VSS.n480 0.1833
R1849 VSS.n910 VSS.n909 0.179043
R1850 VSS.n390 VSS.n159 0.177116
R1851 VSS.n945 VSS.n944 0.167388
R1852 VSS.n162 VSS.n158 0.16705
R1853 VSS.n492 VSS.n491 0.166269
R1854 VSS.n508 VSS.n507 0.166269
R1855 VSS.n524 VSS.n523 0.166269
R1856 VSS.n548 VSS.n547 0.166269
R1857 VSS.n564 VSS.n563 0.166269
R1858 VSS.n580 VSS.n579 0.166269
R1859 VSS.n480 VSS.n479 0.164888
R1860 VSS.n894 VSS.n225 0.16205
R1861 VSS.n885 VSS.n223 0.16205
R1862 VSS.n875 VSS.n221 0.16205
R1863 VSS.n865 VSS.n219 0.16205
R1864 VSS.n857 VSS.n217 0.16205
R1865 VSS.n847 VSS.n215 0.16205
R1866 VSS.n839 VSS.n213 0.16205
R1867 VSS.n829 VSS.n211 0.16205
R1868 VSS.n821 VSS.n209 0.16205
R1869 VSS.n810 VSS.n207 0.16205
R1870 VSS.n800 VSS.n205 0.16205
R1871 VSS.n790 VSS.n203 0.16205
R1872 VSS.n781 VSS.n201 0.16205
R1873 VSS.n770 VSS.n199 0.16205
R1874 VSS.n762 VSS.n197 0.16205
R1875 VSS.n751 VSS.n195 0.16205
R1876 VSS.n742 VSS.n193 0.16205
R1877 VSS.n732 VSS.n191 0.16205
R1878 VSS.n724 VSS.n189 0.16205
R1879 VSS.n713 VSS.n187 0.16205
R1880 VSS.n704 VSS.n185 0.16205
R1881 VSS.n694 VSS.n183 0.16205
R1882 VSS.n685 VSS.n181 0.16205
R1883 VSS.n676 VSS.n179 0.16205
R1884 VSS.n668 VSS.n177 0.16205
R1885 VSS.n657 VSS.n175 0.16205
R1886 VSS.n649 VSS.n173 0.16205
R1887 VSS.n639 VSS.n171 0.16205
R1888 VSS.n631 VSS.n169 0.16205
R1889 VSS.n620 VSS.n167 0.16205
R1890 VSS.n611 VSS.n165 0.16205
R1891 VSS.n599 VSS.n163 0.16205
R1892 VSS.n927 VSS.n925 0.16137
R1893 VSS.n927 VSS.n101 0.16137
R1894 VSS.n927 VSS.n103 0.16137
R1895 VSS.n910 VSS.n899 0.161058
R1896 VSS.n462 VSS.n461 0.161058
R1897 VSS.n930 VSS.n929 0.160293
R1898 VSS.n884 VSS.n241 0.15705
R1899 VSS.n864 VSS.n251 0.15705
R1900 VSS.n846 VSS.n260 0.15705
R1901 VSS.n828 VSS.n270 0.15705
R1902 VSS.n809 VSS.n279 0.15705
R1903 VSS.n789 VSS.n287 0.15705
R1904 VSS.n769 VSS.n297 0.15705
R1905 VSS.n750 VSS.n308 0.15705
R1906 VSS.n731 VSS.n319 0.15705
R1907 VSS.n712 VSS.n327 0.15705
R1908 VSS.n693 VSS.n337 0.15705
R1909 VSS.n675 VSS.n349 0.15705
R1910 VSS.n656 VSS.n358 0.15705
R1911 VSS.n638 VSS.n368 0.15705
R1912 VSS.n619 VSS.n377 0.15705
R1913 VSS.n488 VSS.n450 0.155582
R1914 VSS.n447 VSS.n446 0.155582
R1915 VSS.n497 VSS.n444 0.155582
R1916 VSS.n504 VSS.n441 0.155582
R1917 VSS.n438 VSS.n437 0.155582
R1918 VSS.n513 VSS.n435 0.155582
R1919 VSS.n520 VSS.n432 0.155582
R1920 VSS.n430 VSS.n429 0.155582
R1921 VSS.n529 VSS.n427 0.155582
R1922 VSS.n544 VSS.n424 0.155582
R1923 VSS.n421 VSS.n420 0.155582
R1924 VSS.n553 VSS.n418 0.155582
R1925 VSS.n560 VSS.n415 0.155582
R1926 VSS.n412 VSS.n411 0.155582
R1927 VSS.n569 VSS.n409 0.155582
R1928 VSS.n576 VSS.n406 0.155582
R1929 VSS.n404 VSS.n403 0.155582
R1930 VSS.n400 VSS.n399 0.155582
R1931 VSS.n896 VSS.n893 0.1508
R1932 VSS.n877 VSS.n874 0.1508
R1933 VSS.n859 VSS.n856 0.1508
R1934 VSS.n841 VSS.n838 0.1508
R1935 VSS.n823 VSS.n820 0.1508
R1936 VSS.n802 VSS.n799 0.1508
R1937 VSS.n783 VSS.n779 0.1508
R1938 VSS.n764 VSS.n761 0.1508
R1939 VSS.n744 VSS.n740 0.1508
R1940 VSS.n726 VSS.n722 0.1508
R1941 VSS.n706 VSS.n702 0.1508
R1942 VSS.n687 VSS.n684 0.1508
R1943 VSS.n670 VSS.n666 0.1508
R1944 VSS.n651 VSS.n648 0.1508
R1945 VSS.n633 VSS.n629 0.1508
R1946 VSS.n613 VSS.n609 0.1508
R1947 VSS.n470 VSS.n469 0.149888
R1948 VSS.n938 VSS.n937 0.14955
R1949 VSS.n485 VSS.n459 0.149476
R1950 VSS.n490 VSS.n489 0.149476
R1951 VSS.n494 VSS.n445 0.149476
R1952 VSS.n501 VSS.n443 0.149476
R1953 VSS.n506 VSS.n505 0.149476
R1954 VSS.n510 VSS.n436 0.149476
R1955 VSS.n517 VSS.n434 0.149476
R1956 VSS.n522 VSS.n521 0.149476
R1957 VSS.n526 VSS.n428 0.149476
R1958 VSS.n541 VSS.n426 0.149476
R1959 VSS.n546 VSS.n545 0.149476
R1960 VSS.n550 VSS.n419 0.149476
R1961 VSS.n557 VSS.n417 0.149476
R1962 VSS.n562 VSS.n561 0.149476
R1963 VSS.n566 VSS.n410 0.149476
R1964 VSS.n573 VSS.n408 0.149476
R1965 VSS.n578 VSS.n577 0.149476
R1966 VSS.n582 VSS.n402 0.149476
R1967 VSS.n913 VSS.n912 0.148577
R1968 VSS.n935 VSS.n934 0.147388
R1969 VSS.n467 VSS.n466 0.14705
R1970 VSS.n942 VSS.n941 0.142118
R1971 VSS.n474 VSS.n473 0.142118
R1972 VSS.n395 VSS.n393 0.141022
R1973 VSS.n478 VSS.n477 0.134888
R1974 VSS.n536 VSS.n535 0.134888
R1975 VSS.n488 VSS.n487 0.129618
R1976 VSS.n504 VSS.n503 0.129618
R1977 VSS.n520 VSS.n519 0.129618
R1978 VSS.n544 VSS.n543 0.129618
R1979 VSS.n560 VSS.n559 0.129618
R1980 VSS.n576 VSS.n575 0.129618
R1981 VSS.n393 VSS.n392 0.127569
R1982 VSS.n491 VSS.n449 0.126138
R1983 VSS.n507 VSS.n440 0.126138
R1984 VSS.n523 VSS.n431 0.126138
R1985 VSS.n547 VSS.n423 0.126138
R1986 VSS.n563 VSS.n414 0.126138
R1987 VSS.n579 VSS.n405 0.126138
R1988 VSS.n899 VSS.n897 0.125868
R1989 VSS.n879 VSS.n878 0.125868
R1990 VSS.n861 VSS.n860 0.125868
R1991 VSS.n843 VSS.n842 0.125868
R1992 VSS.n825 VSS.n824 0.125868
R1993 VSS.n804 VSS.n803 0.125868
R1994 VSS.n785 VSS.n784 0.125868
R1995 VSS.n766 VSS.n765 0.125868
R1996 VSS.n746 VSS.n745 0.125868
R1997 VSS.n728 VSS.n727 0.125868
R1998 VSS.n708 VSS.n707 0.125868
R1999 VSS.n689 VSS.n688 0.125868
R2000 VSS.n672 VSS.n671 0.125868
R2001 VSS.n653 VSS.n652 0.125868
R2002 VSS.n635 VSS.n634 0.125868
R2003 VSS.n615 VSS.n614 0.125868
R2004 VSS.n53 VSS.n451 0.156005
R2005 VSS.n62 VSS.n442 0.156005
R2006 VSS.n70 VSS.n433 0.156005
R2007 VSS.n76 VSS.n425 0.156005
R2008 VSS.n85 VSS.n416 0.156005
R2009 VSS.n91 VSS.n407 0.156005
R2010 VSS.n592 VSS.n161 0.124618
R2011 VSS.n944 VSS.n943 0.12455
R2012 VSS.n586 VSS.n161 0.122118
R2013 VSS.n479 VSS.n478 0.12205
R2014 VSS.n497 VSS.n496 0.12205
R2015 VSS.n513 VSS.n512 0.12205
R2016 VSS.n529 VSS.n528 0.12205
R2017 VSS.n537 VSS.n536 0.12205
R2018 VSS.n553 VSS.n552 0.12205
R2019 VSS.n569 VSS.n568 0.12205
R2020 VSS.n401 VSS.n400 0.12205
R2021 VSS.n225 VSS.n224 0.119888
R2022 VSS.n223 VSS.n222 0.119888
R2023 VSS.n221 VSS.n220 0.119888
R2024 VSS.n219 VSS.n218 0.119888
R2025 VSS.n217 VSS.n216 0.119888
R2026 VSS.n215 VSS.n214 0.119888
R2027 VSS.n213 VSS.n212 0.119888
R2028 VSS.n211 VSS.n210 0.119888
R2029 VSS.n209 VSS.n208 0.119888
R2030 VSS.n207 VSS.n206 0.119888
R2031 VSS.n205 VSS.n204 0.119888
R2032 VSS.n203 VSS.n202 0.119888
R2033 VSS.n201 VSS.n200 0.119888
R2034 VSS.n199 VSS.n198 0.119888
R2035 VSS.n197 VSS.n196 0.119888
R2036 VSS.n195 VSS.n194 0.119888
R2037 VSS.n193 VSS.n192 0.119888
R2038 VSS.n191 VSS.n190 0.119888
R2039 VSS.n189 VSS.n188 0.119888
R2040 VSS.n187 VSS.n186 0.119888
R2041 VSS.n185 VSS.n184 0.119888
R2042 VSS.n183 VSS.n182 0.119888
R2043 VSS.n181 VSS.n180 0.119888
R2044 VSS.n179 VSS.n178 0.119888
R2045 VSS.n177 VSS.n176 0.119888
R2046 VSS.n175 VSS.n174 0.119888
R2047 VSS.n173 VSS.n172 0.119888
R2048 VSS.n171 VSS.n170 0.119888
R2049 VSS.n169 VSS.n168 0.119888
R2050 VSS.n167 VSS.n166 0.119888
R2051 VSS.n165 VSS.n164 0.119888
R2052 VSS.n163 VSS.n162 0.119888
R2053 VSS.n592 VSS.n158 0.114888
R2054 VSS.n943 VSS.n942 0.114618
R2055 VSS.n475 VSS.n474 0.114618
R2056 VSS.n878 VSS.n241 0.113638
R2057 VSS.n860 VSS.n251 0.113638
R2058 VSS.n842 VSS.n260 0.113638
R2059 VSS.n824 VSS.n270 0.113638
R2060 VSS.n803 VSS.n279 0.113638
R2061 VSS.n784 VSS.n287 0.113638
R2062 VSS.n765 VSS.n297 0.113638
R2063 VSS.n745 VSS.n308 0.113638
R2064 VSS.n727 VSS.n319 0.113638
R2065 VSS.n707 VSS.n327 0.113638
R2066 VSS.n688 VSS.n337 0.113638
R2067 VSS.n671 VSS.n349 0.113638
R2068 VSS.n652 VSS.n358 0.113638
R2069 VSS.n634 VSS.n368 0.113638
R2070 VSS.n614 VSS.n377 0.113638
R2071 VSS.n466 VSS.n465 0.109888
R2072 VSS.n934 VSS.n933 0.10955
R2073 VSS.n939 VSS.n938 0.107388
R2074 VSS.n471 VSS.n470 0.10705
R2075 VSS.n496 VSS.n495 0.106138
R2076 VSS.n512 VSS.n511 0.106138
R2077 VSS.n528 VSS.n527 0.106138
R2078 VSS.n552 VSS.n551 0.106138
R2079 VSS.n568 VSS.n567 0.106138
R2080 VSS.n583 VSS.n401 0.106138
R2081 VSS.n494 VSS.n493 0.105361
R2082 VSS.n510 VSS.n509 0.105361
R2083 VSS.n526 VSS.n525 0.105361
R2084 VSS.n550 VSS.n549 0.105361
R2085 VSS.n566 VSS.n565 0.105361
R2086 VSS.n582 VSS.n581 0.105361
R2087 VSS.n449 VSS.n447 0.10205
R2088 VSS.n440 VSS.n438 0.10205
R2089 VSS.n431 VSS.n430 0.10205
R2090 VSS.n423 VSS.n421 0.10205
R2091 VSS.n414 VSS.n412 0.10205
R2092 VSS.n405 VSS.n404 0.10205
R2093 VSS.n487 VSS.n451 0.0983676
R2094 VSS.n503 VSS.n442 0.0983676
R2095 VSS.n519 VSS.n433 0.0983676
R2096 VSS.n543 VSS.n425 0.0983676
R2097 VSS.n559 VSS.n416 0.0983676
R2098 VSS.n575 VSS.n407 0.0983676
R2099 VSS.n904 VSS.n903 0.094
R2100 VSS.n907 VSS.n904 0.094
R2101 VSS.n912 VSS.n227 0.08925
R2102 VSS.n897 VSS.n896 0.0883676
R2103 VSS.n879 VSS.n877 0.0883676
R2104 VSS.n861 VSS.n859 0.0883676
R2105 VSS.n843 VSS.n841 0.0883676
R2106 VSS.n825 VSS.n823 0.0883676
R2107 VSS.n804 VSS.n802 0.0883676
R2108 VSS.n785 VSS.n783 0.0883676
R2109 VSS.n766 VSS.n764 0.0883676
R2110 VSS.n746 VSS.n744 0.0883676
R2111 VSS.n728 VSS.n726 0.0883676
R2112 VSS.n708 VSS.n706 0.0883676
R2113 VSS.n689 VSS.n687 0.0883676
R2114 VSS.n672 VSS.n670 0.0883676
R2115 VSS.n653 VSS.n651 0.0883676
R2116 VSS.n635 VSS.n633 0.0883676
R2117 VSS.n615 VSS.n613 0.0883676
R2118 VSS.n595 VSS.n594 0.088
R2119 VSS.n58 VSS.n494 0.0435295
R2120 VSS.n511 VSS.n67 0.176279
R2121 VSS.n72 VSS.n526 0.0435295
R2122 VSS.n551 VSS.n81 0.176279
R2123 VSS.n90 VSS.n566 0.0435295
R2124 VSS.n583 VSS.n93 0.176279
R2125 VSS.n903 VSS.n902 0.0851154
R2126 VSS.n909 VSS.n907 0.0851154
R2127 VSS.n589 VSS.n585 0.0805
R2128 VSS.n929 VSS.n928 0.078
R2129 VSS.n461 VSS.n460 0.078
R2130 VSS.n390 VSS.n160 0.0771176
R2131 VSS.n902 VSS.n228 0.0746176
R2132 VSS.n900 VSS.n105 0.0746176
R2133 VSS.n588 VSS.n387 0.07425
R2134 VSS.n586 VSS.n160 0.0696176
R2135 VSS.n902 VSS.n230 0.06925
R2136 VSS.n900 VSS.n106 0.06925
R2137 VSS.n490 VSS.n57 0.103847
R2138 VSS.n506 VSS.n66 0.103847
R2139 VSS.n522 VSS.n71 0.103847
R2140 VSS.n546 VSS.n80 0.103847
R2141 VSS.n562 VSS.n89 0.103847
R2142 VSS.n578 VSS.n92 0.103847
R2143 VSS.n598 VSS.n386 0.06175
R2144 VSS.n905 VSS.n106 0.05925
R2145 VSS.n918 VSS.n916 0.05675
R2146 VSS.n915 VSS.n228 0.0546176
R2147 VSS.n912 VSS.n105 0.0546176
R2148 VSS.n580 VSS.n578 0.0543074
R2149 VSS.n564 VSS.n562 0.0543074
R2150 VSS.n548 VSS.n546 0.0543074
R2151 VSS.n524 VSS.n522 0.0543074
R2152 VSS.n508 VSS.n506 0.0543074
R2153 VSS.n492 VSS.n490 0.0543074
R2154 VSS.n57 VSS.n488 0.0180497
R2155 VSS.n66 VSS.n504 0.0180497
R2156 VSS.n71 VSS.n520 0.0180497
R2157 VSS.n80 VSS.n544 0.0180497
R2158 VSS.n92 VSS.n576 0.0180497
R2159 VSS.n591 VSS.n387 0.04925
R2160 VSS.n238 VSS.n237 0.048
R2161 VSS.n248 VSS.n247 0.048
R2162 VSS.n257 VSS.n256 0.048
R2163 VSS.n266 VSS.n265 0.048
R2164 VSS.n276 VSS.n275 0.048
R2165 VSS.n284 VSS.n283 0.048
R2166 VSS.n294 VSS.n293 0.048
R2167 VSS.n304 VSS.n303 0.048
R2168 VSS.n315 VSS.n314 0.048
R2169 VSS.n324 VSS.n323 0.048
R2170 VSS.n334 VSS.n333 0.048
R2171 VSS.n345 VSS.n344 0.048
R2172 VSS.n355 VSS.n354 0.048
R2173 VSS.n364 VSS.n363 0.048
R2174 VSS.n374 VSS.n373 0.048
R2175 VSS.n383 VSS.n382 0.048
R2176 VSS.n595 VSS.n591 0.04675
R2177 VSS.n887 VSS.n238 0.0405
R2178 VSS.n867 VSS.n248 0.0405
R2179 VSS.n849 VSS.n257 0.0405
R2180 VSS.n831 VSS.n266 0.0405
R2181 VSS.n812 VSS.n276 0.0405
R2182 VSS.n792 VSS.n284 0.0405
R2183 VSS.n772 VSS.n294 0.0405
R2184 VSS.n753 VSS.n304 0.0405
R2185 VSS.n734 VSS.n315 0.0405
R2186 VSS.n715 VSS.n324 0.0405
R2187 VSS.n696 VSS.n334 0.0405
R2188 VSS.n678 VSS.n345 0.0405
R2189 VSS.n659 VSS.n355 0.0405
R2190 VSS.n641 VSS.n364 0.0405
R2191 VSS.n622 VSS.n374 0.0405
R2192 VSS.n601 VSS.n383 0.0405
R2193 VSS.n928 VSS 0.038
R2194 VSS.n916 VSS.n915 0.033
R2195 VSS.n909 VSS.n908 0.033
R2196 VSS.n393 VSS.n389 0.02925
R2197 VSS.n908 VSS.n230 0.02675
R2198 VSS.n0 VSS.n3 0.00760728
R2199 VSS.n41 VSS.n30 0.00760728
R2200 VSS.t143 VSS.n29 116.468
R2201 VSS.n44 VSS.n27 0.00760728
R2202 VSS.t32 VSS.n26 116.468
R2203 VSS.n37 VSS.t182 116.468
R2204 VSS.n22 VSS.n13 0.023135
R2205 VSS.n22 VSS.n20 0.023135
R2206 VSS.n589 VSS.n588 0.02175
R2207 VSS.n927 VSS.n926 0.0166972
R2208 VSS.n927 VSS.n98 0.0166972
R2209 VSS.n581 VSS.n404 0.0166107
R2210 VSS.n565 VSS.n412 0.0166107
R2211 VSS.n549 VSS.n421 0.0166107
R2212 VSS.n525 VSS.n430 0.0166107
R2213 VSS.n509 VSS.n438 0.0166107
R2214 VSS.n493 VSS.n447 0.0166107
R2215 VSS.n585 VSS.n389 0.0155
R2216 VSS.n917 VSS.n95 0.0112403
R2217 VSS.n945 VSS.n95 0.0095322
R2218 VSS.n927 VSS.n253 0.00938635
R2219 VSS.n927 VSS.n229 0.00937856
R2220 VSS.n927 VSS.n244 0.00937856
R2221 VSS.n927 VSS.n817 0.00937856
R2222 VSS.n927 VSS.n796 0.00937856
R2223 VSS.n927 VSS.n776 0.00937856
R2224 VSS.n927 VSS.n758 0.00937856
R2225 VSS.n927 VSS.n719 0.00937856
R2226 VSS.n927 VSS.n351 0.00937856
R2227 VSS.n927 VSS.n645 0.00937856
R2228 VSS.n927 VSS.n626 0.00937856
R2229 VSS.n927 VSS.n606 0.00937856
R2230 VSS.n927 VSS.n596 0.00937856
R2231 VSS.n927 VSS.n233 0.00937856
R2232 VSS.n927 VSS.n835 0.00937856
R2233 VSS.n927 VSS.n310 0.00937856
R2234 VSS.n927 VSS.n329 0.00937856
R2235 VSS.n927 VSS.n341 0.00937856
R2236 VSS.n594 VSS.n386 0.008
R2237 VSS.n918 VSS.n917 0.00675
R2238 VSS.n917 VSS.n227 0.00675
R2239 VSS.n0 VSS.n6 0.00100169
R2240 VSS.n0 VSS.n5 0.00179957
R2241 VSS.n0 VSS.n4 0.00179957
R2242 VSS.n82 VSS.n88 0.00179957
R2243 VSS.n82 VSS.n87 0.00179957
R2244 VSS.n82 VSS.n86 0.00179957
R2245 VSS.n84 VSS.n83 0.00179957
R2246 VSS.n73 VSS.n79 0.00179957
R2247 VSS.n73 VSS.n78 0.00179957
R2248 VSS.n73 VSS.n77 0.00179957
R2249 VSS.n75 VSS.n74 0.00179957
R2250 VSS.n10 VSS.t322 229.441
R2251 VSS.n9 VSS.n8 0.00179957
R2252 VSS.n9 VSS.n7 0.00179957
R2253 VSS.n69 VSS.n68 0.00179957
R2254 VSS.n59 VSS.n65 0.00179957
R2255 VSS.n59 VSS.n64 0.00179957
R2256 VSS.n59 VSS.n63 0.00179957
R2257 VSS.n61 VSS.n60 0.00179957
R2258 VSS.n50 VSS.n56 0.00179957
R2259 VSS.n50 VSS.n55 0.00179957
R2260 VSS.n50 VSS.n54 0.00179957
R2261 VSS.n52 VSS.n51 0.00179957
R2262 VSS.n22 VSS.n16 0.00179957
R2263 VSS.n22 VSS.n19 0.00179957
R2264 VSS.n82 VSS.n33 0.0015
R2265 VSS.n84 VSS.n82 0.0015
R2266 VSS.n73 VSS.n30 0.0015
R2267 VSS.n75 VSS.n73 0.0015
R2268 VSS.n59 VSS.n27 0.0015
R2269 VSS.n61 VSS.n59 0.0015
R2270 VSS.n50 VSS.n24 0.0015
R2271 VSS.n52 VSS.n50 0.0015
R2272 VSS.n52 VSS.n11 0.00103609
R2273 VSS.n49 VSS.n394 8.48044
R2274 VSS.n22 VSS.n15 0.00354492
R2275 VSS.n1 VSS.n0 0.00351876
R2276 VSS.n69 VSS.n9 0.00350131
R2277 VSS.n36 VSS.n9 0.00344529
R2278 VSS.n32 VSS.n30 0.00296271
R2279 VSS.n28 VSS.n27 0.00296271
R2280 VSS.n25 VSS.n24 0.00296271
R2281 VSS.n2 VSS.t362 148.827
R2282 a_3747_311.n0 a_3747_311.t2 52.0388
R2283 a_3747_311.t1 a_3747_311.n0 35.4491
R2284 a_3747_311.n0 a_3747_311.t3 33.5891
R2285 a_3747_311.t0 a_3747_311.t1 5.61942
R2286 a_3171_311.n0 a_3171_311.t2 51.8377
R2287 a_3171_311.n0 a_3171_311.t3 33.3881
R2288 a_3171_311.t1 a_3171_311.n0 31.8923
R2289 a_3171_311.t0 a_3171_311.t1 5.61777
R2290 a_2595_311.n0 a_2595_311.t2 51.6367
R2291 a_2595_311.n0 a_2595_311.t3 33.187
R2292 a_2595_311.t1 a_2595_311.n0 27.993
R2293 a_2595_311.t0 a_2595_311.t1 5.73018
R2294 a_3747_1047.n0 a_3747_1047.t2 38.0081
R2295 a_3747_1047.n0 a_3747_1047.t3 33.3957
R2296 a_3747_1047.n1 a_3747_1047.t4 33.3957
R2297 a_3747_1047.n2 a_3747_1047.t5 33.3957
R2298 a_3747_1047.n3 a_3747_1047.t6 33.3957
R2299 a_3747_1047.n4 a_3747_1047.t7 33.3957
R2300 a_3747_1047.n5 a_3747_1047.t8 33.3957
R2301 a_3747_1047.n6 a_3747_1047.t9 33.3957
R2302 a_3747_1047.t1 a_3747_1047.n6 23.2419
R2303 a_3747_1047.t0 a_3747_1047.t1 5.61942
R2304 a_3747_1047.n6 a_3747_1047.n5 4.61291
R2305 a_3747_1047.n5 a_3747_1047.n4 4.61291
R2306 a_3747_1047.n4 a_3747_1047.n3 4.61291
R2307 a_3747_1047.n3 a_3747_1047.n2 4.61291
R2308 a_3747_1047.n2 a_3747_1047.n1 4.61291
R2309 a_3747_1047.n1 a_3747_1047.n0 4.61291
R2310 a_3171_1047.n0 a_3171_1047.t2 37.8054
R2311 a_3171_1047.n0 a_3171_1047.t3 33.193
R2312 a_3171_1047.n1 a_3171_1047.t4 33.193
R2313 a_3171_1047.n2 a_3171_1047.t5 33.193
R2314 a_3171_1047.n3 a_3171_1047.t6 33.193
R2315 a_3171_1047.n4 a_3171_1047.t7 33.193
R2316 a_3171_1047.n5 a_3171_1047.t8 33.193
R2317 a_3171_1047.n6 a_3171_1047.t9 33.193
R2318 a_3171_1047.t1 a_3171_1047.n6 23.0313
R2319 a_3171_1047.t0 a_3171_1047.t1 5.61777
R2320 a_3171_1047.n6 a_3171_1047.n5 4.61291
R2321 a_3171_1047.n5 a_3171_1047.n4 4.61291
R2322 a_3171_1047.n4 a_3171_1047.n3 4.61291
R2323 a_3171_1047.n3 a_3171_1047.n2 4.61291
R2324 a_3171_1047.n2 a_3171_1047.n1 4.61291
R2325 a_3171_1047.n1 a_3171_1047.n0 4.61291
R2326 a_2595_1047.n0 a_2595_1047.t2 37.7691
R2327 a_2595_1047.n0 a_2595_1047.t3 33.1567
R2328 a_2595_1047.n1 a_2595_1047.t4 33.1567
R2329 a_2595_1047.n2 a_2595_1047.t5 33.1567
R2330 a_2595_1047.n3 a_2595_1047.t6 33.1567
R2331 a_2595_1047.n4 a_2595_1047.t7 33.1567
R2332 a_2595_1047.n5 a_2595_1047.t8 33.1567
R2333 a_2595_1047.n6 a_2595_1047.t9 33.1567
R2334 a_2595_1047.t1 a_2595_1047.n6 22.7941
R2335 a_2595_1047.t0 a_2595_1047.t1 5.65522
R2336 a_2595_1047.n6 a_2595_1047.n5 4.61291
R2337 a_2595_1047.n5 a_2595_1047.n4 4.61291
R2338 a_2595_1047.n4 a_2595_1047.n3 4.61291
R2339 a_2595_1047.n3 a_2595_1047.n2 4.61291
R2340 a_2595_1047.n2 a_2595_1047.n1 4.61291
R2341 a_2595_1047.n1 a_2595_1047.n0 4.61291
R2342 a_2019_1047.n0 a_2019_1047.t2 37.9701
R2343 a_2019_1047.n0 a_2019_1047.t3 33.3577
R2344 a_2019_1047.n1 a_2019_1047.t4 33.3577
R2345 a_2019_1047.n2 a_2019_1047.t5 33.3577
R2346 a_2019_1047.n3 a_2019_1047.t6 33.3577
R2347 a_2019_1047.n4 a_2019_1047.t7 33.3577
R2348 a_2019_1047.n5 a_2019_1047.t8 33.3577
R2349 a_2019_1047.t1 a_2019_1047.t9 22.5945
R2350 a_2019_1047.t0 a_2019_1047.t1 5.62052
R2351 a_2019_1047.t9 a_2019_1047.n5 4.61291
R2352 a_2019_1047.n5 a_2019_1047.n4 4.61291
R2353 a_2019_1047.n4 a_2019_1047.n3 4.61291
R2354 a_2019_1047.n3 a_2019_1047.n2 4.61291
R2355 a_2019_1047.n2 a_2019_1047.n1 4.61291
R2356 a_2019_1047.n1 a_2019_1047.n0 4.61291
C1105 MUX_OUT VSS 3.24058f
C1106 MUX_SEL4 VSS 1.60778f
C1107 MUX_SEL3 VSS 0.90686f
C1108 MUX_SEL2 VSS 1.81137f
C1109 MUX_SEL1 VSS 0.95076f
C1110 MUX_SEL0 VSS 1.55166f
C1111 DELAY_VBIASN VSS 12.41106f
C1112 DELAY_OUT_LAST VSS 0.39284f
C1113 DELAY_VBIASP VSS 4.13999f
C1114 DELAY_IN VSS 1.91954f
C1115 VDD VSS 46.2831f
C1116 a_26985_519# VSS 0.17928f ; **FLOATING
C1117 a_23945_519# VSS 0.17928f ; **FLOATING
C1118 a_20905_519# VSS 0.17928f ; **FLOATING
C1119 a_17865_519# VSS 0.17593f ; **FLOATING
C1120 a_16851_309# VSS 0.38699f ; **FLOATING
C1121 a_16108_289# VSS 3.85084f ; **FLOATING
C1122 a_15964_289# VSS 0.17613f ; **FLOATING
C1123 a_15765_463# VSS 0.36132f ; **FLOATING
C1124 a_14825_519# VSS 0.17928f ; **FLOATING
C1125 a_11785_519# VSS 0.17928f ; **FLOATING
C1126 a_8745_519# VSS 0.17928f ; **FLOATING
C1127 a_5731_289# VSS 3.39133f ; **FLOATING
C1128 a_2019_311# VSS 1.61601f ; **FLOATING
C1129 a_5705_519# VSS 0.17638f ; **FLOATING
C1130 a_3449_331# VSS 0.18478f ; **FLOATING
C1131 a_2873_331# VSS 0.18321f ; **FLOATING
C1132 a_2297_331# VSS 0.18321f ; **FLOATING
C1133 a_1721_331# VSS 0.17001f ; **FLOATING
C1134 a_1544_289# VSS 0.30014f ; **FLOATING
C1135 a_1256_289# VSS 0.84266f ; **FLOATING
C1136 a_27991_1008# VSS 0.18706f ; **FLOATING
C1137 a_27915_1044# VSS 0.10926f ; **FLOATING
C1138 a_27124_1008# VSS 0.17878f ; **FLOATING
C1139 a_27048_1044# VSS 0.12122f ; **FLOATING
C1140 a_26471_1008# VSS 0.18175f ; **FLOATING
C1141 a_26395_1044# VSS 0.11073f ; **FLOATING
C1142 a_25604_1008# VSS 0.18087f ; **FLOATING
C1143 a_25630_1044# VSS 0.34158f ; **FLOATING
C1144 a_25528_1044# VSS 0.12433f ; **FLOATING
C1145 a_24951_1008# VSS 0.18335f ; **FLOATING
C1146 a_24875_1044# VSS 0.11016f ; **FLOATING
C1147 a_24084_1008# VSS 0.17878f ; **FLOATING
C1148 a_24008_1044# VSS 0.12122f ; **FLOATING
C1149 a_23431_1008# VSS 0.18175f ; **FLOATING
C1150 a_23355_1044# VSS 0.11073f ; **FLOATING
C1151 a_22564_1008# VSS 0.18087f ; **FLOATING
C1152 a_22590_1044# VSS 0.33314f ; **FLOATING
C1153 a_22488_1044# VSS 0.12433f ; **FLOATING
C1154 a_21911_1008# VSS 0.18335f ; **FLOATING
C1155 a_21835_1044# VSS 0.11016f ; **FLOATING
C1156 a_21044_1008# VSS 0.17878f ; **FLOATING
C1157 a_20968_1044# VSS 0.12122f ; **FLOATING
C1158 a_20391_1008# VSS 0.18175f ; **FLOATING
C1159 a_20315_1044# VSS 0.11073f ; **FLOATING
C1160 a_19524_1008# VSS 0.18087f ; **FLOATING
C1161 a_19550_1044# VSS 0.33563f ; **FLOATING
C1162 a_19448_1044# VSS 0.12433f ; **FLOATING
C1163 a_18871_1008# VSS 0.18335f ; **FLOATING
C1164 a_18795_1044# VSS 0.11016f ; **FLOATING
C1165 a_18004_1008# VSS 0.17878f ; **FLOATING
C1166 a_17928_1044# VSS 0.12122f ; **FLOATING
C1167 a_17351_1008# VSS 0.18022f ; **FLOATING
C1168 a_17275_1044# VSS 0.10926f ; **FLOATING
C1169 a_16484_1008# VSS 0.18023f ; **FLOATING
C1170 a_16510_1044# VSS 0.28935f ; **FLOATING
C1171 a_16408_1044# VSS 0.1229f ; **FLOATING
C1172 a_15831_1008# VSS 0.17846f ; **FLOATING
C1173 a_15755_1044# VSS 0.10926f ; **FLOATING
C1174 a_14964_1008# VSS 0.17878f ; **FLOATING
C1175 a_14888_1044# VSS 0.12122f ; **FLOATING
C1176 a_14311_1008# VSS 0.18175f ; **FLOATING
C1177 a_14235_1044# VSS 0.11073f ; **FLOATING
C1178 a_13444_1008# VSS 0.18087f ; **FLOATING
C1179 a_13470_1044# VSS 0.30333f ; **FLOATING
C1180 a_13368_1044# VSS 0.12433f ; **FLOATING
C1181 a_12791_1008# VSS 0.18335f ; **FLOATING
C1182 a_12715_1044# VSS 0.11016f ; **FLOATING
C1183 a_11924_1008# VSS 0.17878f ; **FLOATING
C1184 a_11848_1044# VSS 0.12122f ; **FLOATING
C1185 a_11271_1008# VSS 0.18175f ; **FLOATING
C1186 a_11195_1044# VSS 0.11073f ; **FLOATING
C1187 a_10404_1008# VSS 0.18087f ; **FLOATING
C1188 a_10430_1044# VSS 0.31665f ; **FLOATING
C1189 a_10328_1044# VSS 0.12433f ; **FLOATING
C1190 a_9751_1008# VSS 0.18335f ; **FLOATING
C1191 a_9675_1044# VSS 0.11016f ; **FLOATING
C1192 a_8884_1008# VSS 0.17878f ; **FLOATING
C1193 a_8808_1044# VSS 0.12122f ; **FLOATING
C1194 a_8231_1008# VSS 0.18175f ; **FLOATING
C1195 a_8155_1044# VSS 0.11073f ; **FLOATING
C1196 a_7364_1008# VSS 0.18087f ; **FLOATING
C1197 a_7390_1044# VSS 0.31357f ; **FLOATING
C1198 a_7288_1044# VSS 0.12433f ; **FLOATING
C1199 a_6711_1008# VSS 0.18335f ; **FLOATING
C1200 a_6635_1044# VSS 0.11016f ; **FLOATING
C1201 a_5844_1008# VSS 0.17878f ; **FLOATING
C1202 a_5768_1044# VSS 0.12122f ; **FLOATING
C1203 a_5191_1008# VSS 0.18022f ; **FLOATING
C1204 a_5115_1044# VSS 0.10926f ; **FLOATING
C1205 a_4324_1008# VSS 0.18023f ; **FLOATING
C1206 a_4350_1044# VSS 0.26655f ; **FLOATING
C1207 a_4248_1044# VSS 0.12443f ; **FLOATING
C1208 a_27705_1044# VSS 0.25296f ; **FLOATING
C1209 a_26185_1044# VSS 0.23475f ; **FLOATING
C1210 a_24665_1044# VSS 0.25432f ; **FLOATING
C1211 a_23145_1044# VSS 0.23475f ; **FLOATING
C1212 a_21625_1044# VSS 0.25432f ; **FLOATING
C1213 a_20105_1044# VSS 0.23475f ; **FLOATING
C1214 a_18585_1044# VSS 0.25432f ; **FLOATING
C1215 a_17065_1044# VSS 0.23385f ; **FLOATING
C1216 a_15545_1044# VSS 0.25296f ; **FLOATING
C1217 a_14025_1044# VSS 0.23475f ; **FLOATING
C1218 a_12505_1044# VSS 0.25432f ; **FLOATING
C1219 a_10985_1044# VSS 0.23475f ; **FLOATING
C1220 a_9465_1044# VSS 0.25432f ; **FLOATING
C1221 a_7945_1044# VSS 0.23475f ; **FLOATING
C1222 a_6425_1044# VSS 0.25432f ; **FLOATING
C1223 a_4905_1044# VSS 0.23549f ; **FLOATING
C1224 a_4157_1313# VSS 0.32875f ; **FLOATING
C1225 a_3449_1395# VSS 0.18629f ; **FLOATING
C1226 a_2873_1395# VSS 0.18349f ; **FLOATING
C1227 a_2297_1395# VSS 0.18349f ; **FLOATING
C1228 a_1721_1395# VSS 0.17029f ; **FLOATING
C1229 a_1544_1044# VSS 0.29829f ; **FLOATING
C1230 a_1256_1044# VSS 0.82978f ; **FLOATING
C1231 a_27671_1842# VSS 0.01336f ; **FLOATING
C1232 a_26911_1842# VSS 0.01336f ; **FLOATING
C1233 a_26151_1842# VSS 0.01336f ; **FLOATING
C1234 a_25391_1842# VSS 0.01336f ; **FLOATING
C1235 a_24631_1842# VSS 0.01336f ; **FLOATING
C1236 a_23871_1842# VSS 0.01336f ; **FLOATING
C1237 a_23111_1842# VSS 0.01336f ; **FLOATING
C1238 a_22351_1842# VSS 0.01336f ; **FLOATING
C1239 a_21591_1842# VSS 0.01336f ; **FLOATING
C1240 a_20831_1842# VSS 0.01336f ; **FLOATING
C1241 a_20071_1842# VSS 0.01336f ; **FLOATING
C1242 a_19311_1842# VSS 0.01336f ; **FLOATING
C1243 a_18551_1842# VSS 0.01336f ; **FLOATING
C1244 a_17791_1842# VSS 0.01336f ; **FLOATING
C1245 a_17031_1842# VSS 0.01336f ; **FLOATING
C1246 a_16271_1842# VSS 0.01336f ; **FLOATING
C1247 a_15511_1842# VSS 0.01336f ; **FLOATING
C1248 a_14751_1842# VSS 0.01336f ; **FLOATING
C1249 a_13991_1842# VSS 0.01336f ; **FLOATING
C1250 a_13231_1842# VSS 0.01336f ; **FLOATING
C1251 a_12471_1842# VSS 0.01336f ; **FLOATING
C1252 a_11711_1842# VSS 0.01336f ; **FLOATING
C1253 a_10951_1842# VSS 0.01336f ; **FLOATING
C1254 a_10191_1842# VSS 0.01336f ; **FLOATING
C1255 a_9431_1842# VSS 0.01336f ; **FLOATING
C1256 a_8671_1842# VSS 0.01336f ; **FLOATING
C1257 a_7911_1842# VSS 0.01336f ; **FLOATING
C1258 a_7151_1842# VSS 0.01336f ; **FLOATING
C1259 a_6391_1842# VSS 0.01336f ; **FLOATING
C1260 a_5631_1842# VSS 0.01336f ; **FLOATING
C1261 a_4871_1842# VSS 0.01336f ; **FLOATING
C1262 a_4111_1842# VSS 0.0139f ; **FLOATING
C1263 a_27563_1842# VSS 0.51284f ; **FLOATING
C1264 a_27997_1842# VSS 0.6533f ; **FLOATING
C1265 a_27433_1842# VSS 0.45843f ; **FLOATING
C1266 a_26803_1842# VSS 0.50902f ; **FLOATING
C1267 a_27237_1842# VSS 0.93747f ; **FLOATING
C1268 a_26673_1842# VSS 0.45994f ; **FLOATING
C1269 a_26043_1842# VSS 0.51137f ; **FLOATING
C1270 a_26477_1842# VSS 0.96549f ; **FLOATING
C1271 a_25913_1842# VSS 0.46292f ; **FLOATING
C1272 a_25283_1842# VSS 0.50906f ; **FLOATING
C1273 a_25717_1842# VSS 0.87619f ; **FLOATING
C1274 a_25153_1842# VSS 0.45997f ; **FLOATING
C1275 a_24523_1842# VSS 0.51043f ; **FLOATING
C1276 a_24957_1842# VSS 0.97121f ; **FLOATING
C1277 a_24393_1842# VSS 0.45843f ; **FLOATING
C1278 a_23763_1842# VSS 0.50902f ; **FLOATING
C1279 a_24197_1842# VSS 0.93322f ; **FLOATING
C1280 a_23633_1842# VSS 0.45994f ; **FLOATING
C1281 a_23003_1842# VSS 0.51137f ; **FLOATING
C1282 a_23437_1842# VSS 0.96549f ; **FLOATING
C1283 a_22873_1842# VSS 0.46292f ; **FLOATING
C1284 a_22243_1842# VSS 0.50906f ; **FLOATING
C1285 a_22677_1842# VSS 0.87619f ; **FLOATING
C1286 a_22113_1842# VSS 0.45997f ; **FLOATING
C1287 a_21483_1842# VSS 0.51043f ; **FLOATING
C1288 a_21917_1842# VSS 0.97121f ; **FLOATING
C1289 a_21353_1842# VSS 0.45843f ; **FLOATING
C1290 a_20723_1842# VSS 0.50902f ; **FLOATING
C1291 a_21157_1842# VSS 0.93322f ; **FLOATING
C1292 a_20593_1842# VSS 0.45994f ; **FLOATING
C1293 a_19963_1842# VSS 0.51137f ; **FLOATING
C1294 a_20397_1842# VSS 0.96549f ; **FLOATING
C1295 a_19833_1842# VSS 0.46292f ; **FLOATING
C1296 a_19203_1842# VSS 0.50906f ; **FLOATING
C1297 a_19637_1842# VSS 0.87619f ; **FLOATING
C1298 a_19073_1842# VSS 0.45997f ; **FLOATING
C1299 a_18443_1842# VSS 0.51043f ; **FLOATING
C1300 a_18877_1842# VSS 0.97121f ; **FLOATING
C1301 a_18313_1842# VSS 0.45843f ; **FLOATING
C1302 a_17683_1842# VSS 0.50902f ; **FLOATING
C1303 a_18117_1842# VSS 0.93322f ; **FLOATING
C1304 a_17553_1842# VSS 0.45994f ; **FLOATING
C1305 a_16923_1842# VSS 0.51133f ; **FLOATING
C1306 a_17357_1842# VSS 0.96549f ; **FLOATING
C1307 a_16793_1842# VSS 0.46262f ; **FLOATING
C1308 a_16163_1842# VSS 0.50902f ; **FLOATING
C1309 a_16597_1842# VSS 0.87137f ; **FLOATING
C1310 a_16033_1842# VSS 0.45859f ; **FLOATING
C1311 a_15403_1842# VSS 0.51041f ; **FLOATING
C1312 a_15837_1842# VSS 0.9618f ; **FLOATING
C1313 a_15273_1842# VSS 0.45843f ; **FLOATING
C1314 a_14643_1842# VSS 0.50902f ; **FLOATING
C1315 a_15077_1842# VSS 0.93209f ; **FLOATING
C1316 a_14513_1842# VSS 0.45994f ; **FLOATING
C1317 a_13883_1842# VSS 0.51137f ; **FLOATING
C1318 a_14317_1842# VSS 0.96549f ; **FLOATING
C1319 a_13753_1842# VSS 0.46292f ; **FLOATING
C1320 a_13123_1842# VSS 0.50904f ; **FLOATING
C1321 a_13557_1842# VSS 0.87619f ; **FLOATING
C1322 a_12993_1842# VSS 0.45997f ; **FLOATING
C1323 a_12363_1842# VSS 0.51043f ; **FLOATING
C1324 a_12797_1842# VSS 0.96954f ; **FLOATING
C1325 a_12233_1842# VSS 0.45843f ; **FLOATING
C1326 a_11603_1842# VSS 0.50902f ; **FLOATING
C1327 a_12037_1842# VSS 0.93322f ; **FLOATING
C1328 a_11473_1842# VSS 0.45994f ; **FLOATING
C1329 a_10843_1842# VSS 0.51137f ; **FLOATING
C1330 a_11277_1842# VSS 0.96549f ; **FLOATING
C1331 a_10713_1842# VSS 0.46292f ; **FLOATING
C1332 a_10083_1842# VSS 0.50904f ; **FLOATING
C1333 a_10517_1842# VSS 0.87619f ; **FLOATING
C1334 a_9953_1842# VSS 0.45997f ; **FLOATING
C1335 a_9323_1842# VSS 0.51043f ; **FLOATING
C1336 a_9757_1842# VSS 0.96954f ; **FLOATING
C1337 a_9193_1842# VSS 0.45843f ; **FLOATING
C1338 a_8563_1842# VSS 0.50902f ; **FLOATING
C1339 a_8997_1842# VSS 0.93322f ; **FLOATING
C1340 a_8433_1842# VSS 0.45994f ; **FLOATING
C1341 a_7803_1842# VSS 0.51137f ; **FLOATING
C1342 a_8237_1842# VSS 0.96549f ; **FLOATING
C1343 a_7673_1842# VSS 0.46292f ; **FLOATING
C1344 a_7043_1842# VSS 0.50904f ; **FLOATING
C1345 a_7477_1842# VSS 0.87619f ; **FLOATING
C1346 a_6913_1842# VSS 0.45997f ; **FLOATING
C1347 a_6283_1842# VSS 0.51043f ; **FLOATING
C1348 a_6717_1842# VSS 0.96895f ; **FLOATING
C1349 a_6153_1842# VSS 0.45843f ; **FLOATING
C1350 a_5523_1842# VSS 0.50902f ; **FLOATING
C1351 a_5957_1842# VSS 0.93322f ; **FLOATING
C1352 a_5393_1842# VSS 0.45994f ; **FLOATING
C1353 a_4763_1842# VSS 0.51133f ; **FLOATING
C1354 a_5197_1842# VSS 0.96549f ; **FLOATING
C1355 a_4633_1842# VSS 0.4629f ; **FLOATING
C1356 a_4003_1842# VSS 0.58899f ; **FLOATING
C1357 a_4437_1842# VSS 0.87666f ; **FLOATING
C1358 a_2019_1047.t2 VSS 0.93017f ; **FLOATING
C1359 a_2019_1047.t3 VSS 0.70616f ; **FLOATING
C1360 a_2019_1047.n0 VSS 5.0083f ; **FLOATING
C1361 a_2019_1047.t4 VSS 0.70616f ; **FLOATING
C1362 a_2019_1047.n1 VSS 3.38825f ; **FLOATING
C1363 a_2019_1047.t5 VSS 0.70616f ; **FLOATING
C1364 a_2019_1047.n2 VSS 3.38825f ; **FLOATING
C1365 a_2019_1047.t6 VSS 0.70616f ; **FLOATING
C1366 a_2019_1047.n3 VSS 3.38825f ; **FLOATING
C1367 a_2019_1047.t7 VSS 0.70616f ; **FLOATING
C1368 a_2019_1047.n4 VSS 3.38825f ; **FLOATING
C1369 a_2019_1047.t8 VSS 0.70616f ; **FLOATING
C1370 a_2019_1047.n5 VSS 3.38825f ; **FLOATING
C1371 a_2019_1047.t9 VSS 5.45427f ; **FLOATING
C1372 a_2019_1047.t1 VSS 1.07246f ; **FLOATING
C1373 a_2019_1047.t0 VSS 0.30482f ; **FLOATING
C1374 a_2595_1047.t2 VSS 1.36702f ; **FLOATING
C1375 a_2595_1047.t3 VSS 1.02093f ; **FLOATING
C1376 a_2595_1047.n0 VSS 7.7612f ; **FLOATING
C1377 a_2595_1047.t4 VSS 1.02093f ; **FLOATING
C1378 a_2595_1047.n1 VSS 5.27337f ; **FLOATING
C1379 a_2595_1047.t5 VSS 1.02093f ; **FLOATING
C1380 a_2595_1047.n2 VSS 5.27337f ; **FLOATING
C1381 a_2595_1047.t6 VSS 1.02093f ; **FLOATING
C1382 a_2595_1047.n3 VSS 5.27337f ; **FLOATING
C1383 a_2595_1047.t7 VSS 1.02093f ; **FLOATING
C1384 a_2595_1047.n4 VSS 5.27337f ; **FLOATING
C1385 a_2595_1047.t8 VSS 1.02093f ; **FLOATING
C1386 a_2595_1047.n5 VSS 5.27337f ; **FLOATING
C1387 a_2595_1047.t9 VSS 1.02093f ; **FLOATING
C1388 a_2595_1047.n6 VSS 7.58543f ; **FLOATING
C1389 a_2595_1047.t1 VSS 1.75118f ; **FLOATING
C1390 a_2595_1047.t0 VSS 0.48227f ; **FLOATING
C1391 a_3171_1047.t2 VSS 1.38442f ; **FLOATING
C1392 a_3171_1047.t3 VSS 1.03733f ; **FLOATING
C1393 a_3171_1047.n0 VSS 7.77854f ; **FLOATING
C1394 a_3171_1047.t4 VSS 1.03733f ; **FLOATING
C1395 a_3171_1047.n1 VSS 5.28081f ; **FLOATING
C1396 a_3171_1047.t5 VSS 1.03733f ; **FLOATING
C1397 a_3171_1047.n2 VSS 5.28081f ; **FLOATING
C1398 a_3171_1047.t6 VSS 1.03733f ; **FLOATING
C1399 a_3171_1047.n3 VSS 5.28081f ; **FLOATING
C1400 a_3171_1047.t7 VSS 1.03733f ; **FLOATING
C1401 a_3171_1047.n4 VSS 5.28081f ; **FLOATING
C1402 a_3171_1047.t8 VSS 1.03733f ; **FLOATING
C1403 a_3171_1047.n5 VSS 5.28081f ; **FLOATING
C1404 a_3171_1047.t9 VSS 1.03733f ; **FLOATING
C1405 a_3171_1047.n6 VSS 7.68345f ; **FLOATING
C1406 a_3171_1047.t1 VSS 1.77026f ; **FLOATING
C1407 a_3171_1047.t0 VSS 0.48084f ; **FLOATING
C1408 a_3747_1047.t2 VSS 0.96886f ; **FLOATING
C1409 a_3747_1047.t3 VSS 0.73761f ; **FLOATING
C1410 a_3747_1047.n0 VSS 5.16753f ; **FLOATING
C1411 a_3747_1047.t4 VSS 0.73761f ; **FLOATING
C1412 a_3747_1047.n1 VSS 3.49318f ; **FLOATING
C1413 a_3747_1047.t5 VSS 0.73761f ; **FLOATING
C1414 a_3747_1047.n2 VSS 3.49318f ; **FLOATING
C1415 a_3747_1047.t6 VSS 0.73761f ; **FLOATING
C1416 a_3747_1047.n3 VSS 3.49318f ; **FLOATING
C1417 a_3747_1047.t7 VSS 0.73761f ; **FLOATING
C1418 a_3747_1047.n4 VSS 3.49318f ; **FLOATING
C1419 a_3747_1047.t8 VSS 0.73761f ; **FLOATING
C1420 a_3747_1047.n5 VSS 3.49318f ; **FLOATING
C1421 a_3747_1047.t9 VSS 0.73761f ; **FLOATING
C1422 a_3747_1047.n6 VSS 5.18696f ; **FLOATING
C1423 a_3747_1047.t1 VSS 1.18537f ; **FLOATING
C1424 a_3747_1047.t0 VSS 0.31338f ; **FLOATING
C1425 a_2595_311.t1 VSS 3.27037f ; **FLOATING
C1426 a_2595_311.t2 VSS 5.04145f ; **FLOATING
C1427 a_2595_311.t3 VSS 1.20632f ; **FLOATING
C1428 a_2595_311.n0 VSS 26.8668f ; **FLOATING
C1429 a_2595_311.t0 VSS 0.49572f ; **FLOATING
C1430 a_3171_311.t2 VSS 5.05009f ; **FLOATING
C1431 a_3171_311.t3 VSS 1.21149f ; **FLOATING
C1432 a_3171_311.n0 VSS 29.8499f ; **FLOATING
C1433 a_3171_311.t1 VSS 4.61154f ; **FLOATING
C1434 a_3171_311.t0 VSS 0.4973f ; **FLOATING
C1435 a_3747_311.t2 VSS 3.09203f ; **FLOATING
C1436 a_3747_311.t3 VSS 0.74422f ; **FLOATING
C1437 a_3747_311.n0 VSS 19.8885f ; **FLOATING
C1438 a_3747_311.t1 VSS 3.68893f ; **FLOATING
C1439 a_3747_311.t0 VSS 0.30537f ; **FLOATING
C1440 DELAY_VBIASP.n0 VSS 0.14465f ; **FLOATING
C1441 DELAY_VBIASP.t31 VSS 0.37042f ; **FLOATING
C1442 DELAY_VBIASP.t30 VSS 0.36213f ; **FLOATING
C1443 DELAY_VBIASP.n1 VSS 0.64895f ; **FLOATING
C1444 DELAY_VBIASP.t29 VSS 0.36213f ; **FLOATING
C1445 DELAY_VBIASP.n2 VSS 0.44908f ; **FLOATING
C1446 DELAY_VBIASP.t28 VSS 0.36213f ; **FLOATING
C1447 DELAY_VBIASP.n3 VSS 0.44908f ; **FLOATING
C1448 DELAY_VBIASP.t27 VSS 0.36213f ; **FLOATING
C1449 DELAY_VBIASP.n4 VSS 0.44908f ; **FLOATING
C1450 DELAY_VBIASP.t26 VSS 0.36213f ; **FLOATING
C1451 DELAY_VBIASP.n5 VSS 0.44908f ; **FLOATING
C1452 DELAY_VBIASP.t25 VSS 0.36213f ; **FLOATING
C1453 DELAY_VBIASP.n6 VSS 0.44908f ; **FLOATING
C1454 DELAY_VBIASP.t24 VSS 0.36213f ; **FLOATING
C1455 DELAY_VBIASP.n7 VSS 0.44908f ; **FLOATING
C1456 DELAY_VBIASP.t23 VSS 0.36213f ; **FLOATING
C1457 DELAY_VBIASP.n8 VSS 0.44908f ; **FLOATING
C1458 DELAY_VBIASP.t22 VSS 0.36213f ; **FLOATING
C1459 DELAY_VBIASP.n9 VSS 0.44908f ; **FLOATING
C1460 DELAY_VBIASP.t21 VSS 0.36213f ; **FLOATING
C1461 DELAY_VBIASP.n10 VSS 0.44908f ; **FLOATING
C1462 DELAY_VBIASP.t20 VSS 0.36213f ; **FLOATING
C1463 DELAY_VBIASP.n11 VSS 0.44908f ; **FLOATING
C1464 DELAY_VBIASP.t19 VSS 0.36213f ; **FLOATING
C1465 DELAY_VBIASP.n12 VSS 0.44908f ; **FLOATING
C1466 DELAY_VBIASP.t18 VSS 0.36213f ; **FLOATING
C1467 DELAY_VBIASP.n13 VSS 0.44908f ; **FLOATING
C1468 DELAY_VBIASP.t17 VSS 0.36213f ; **FLOATING
C1469 DELAY_VBIASP.n14 VSS 0.44908f ; **FLOATING
C1470 DELAY_VBIASP.t16 VSS 0.36213f ; **FLOATING
C1471 DELAY_VBIASP.n15 VSS 0.44908f ; **FLOATING
C1472 DELAY_VBIASP.t15 VSS 0.36213f ; **FLOATING
C1473 DELAY_VBIASP.n16 VSS 0.44908f ; **FLOATING
C1474 DELAY_VBIASP.t14 VSS 0.36213f ; **FLOATING
C1475 DELAY_VBIASP.n17 VSS 0.44908f ; **FLOATING
C1476 DELAY_VBIASP.t13 VSS 0.36213f ; **FLOATING
C1477 DELAY_VBIASP.n18 VSS 0.44908f ; **FLOATING
C1478 DELAY_VBIASP.t12 VSS 0.36213f ; **FLOATING
C1479 DELAY_VBIASP.n19 VSS 0.44908f ; **FLOATING
C1480 DELAY_VBIASP.t11 VSS 0.36213f ; **FLOATING
C1481 DELAY_VBIASP.n20 VSS 0.44908f ; **FLOATING
C1482 DELAY_VBIASP.t10 VSS 0.36213f ; **FLOATING
C1483 DELAY_VBIASP.n21 VSS 0.44908f ; **FLOATING
C1484 DELAY_VBIASP.t9 VSS 0.36213f ; **FLOATING
C1485 DELAY_VBIASP.n22 VSS 0.44908f ; **FLOATING
C1486 DELAY_VBIASP.t8 VSS 0.36213f ; **FLOATING
C1487 DELAY_VBIASP.n23 VSS 0.44908f ; **FLOATING
C1488 DELAY_VBIASP.t7 VSS 0.36213f ; **FLOATING
C1489 DELAY_VBIASP.n24 VSS 0.44908f ; **FLOATING
C1490 DELAY_VBIASP.t6 VSS 0.36213f ; **FLOATING
C1491 DELAY_VBIASP.n25 VSS 0.44908f ; **FLOATING
C1492 DELAY_VBIASP.t5 VSS 0.36213f ; **FLOATING
C1493 DELAY_VBIASP.n26 VSS 0.44908f ; **FLOATING
C1494 DELAY_VBIASP.t4 VSS 0.36213f ; **FLOATING
C1495 DELAY_VBIASP.n27 VSS 0.44908f ; **FLOATING
C1496 DELAY_VBIASP.t3 VSS 0.36213f ; **FLOATING
C1497 DELAY_VBIASP.n28 VSS 0.44908f ; **FLOATING
C1498 DELAY_VBIASP.t2 VSS 0.36213f ; **FLOATING
C1499 DELAY_VBIASP.n29 VSS 0.44908f ; **FLOATING
C1500 DELAY_VBIASP.t1 VSS 0.36213f ; **FLOATING
C1501 DELAY_VBIASP.n30 VSS 0.44908f ; **FLOATING
C1502 DELAY_VBIASP.t0 VSS 0.36213f ; **FLOATING
C1503 DELAY_VBIASN.n0 VSS 0.37703f ; **FLOATING
C1504 DELAY_VBIASN.t31 VSS 0.22492f ; **FLOATING
C1505 DELAY_VBIASN.t30 VSS 0.21832f ; **FLOATING
C1506 DELAY_VBIASN.n1 VSS 0.51667f ; **FLOATING
C1507 DELAY_VBIASN.t29 VSS 0.21832f ; **FLOATING
C1508 DELAY_VBIASN.n2 VSS 0.35838f ; **FLOATING
C1509 DELAY_VBIASN.t28 VSS 0.21832f ; **FLOATING
C1510 DELAY_VBIASN.n3 VSS 0.35838f ; **FLOATING
C1511 DELAY_VBIASN.t27 VSS 0.21832f ; **FLOATING
C1512 DELAY_VBIASN.n4 VSS 0.35838f ; **FLOATING
C1513 DELAY_VBIASN.t26 VSS 0.21832f ; **FLOATING
C1514 DELAY_VBIASN.n5 VSS 0.35838f ; **FLOATING
C1515 DELAY_VBIASN.t25 VSS 0.21832f ; **FLOATING
C1516 DELAY_VBIASN.n6 VSS 0.35838f ; **FLOATING
C1517 DELAY_VBIASN.t24 VSS 0.21832f ; **FLOATING
C1518 DELAY_VBIASN.n7 VSS 0.35838f ; **FLOATING
C1519 DELAY_VBIASN.t23 VSS 0.21832f ; **FLOATING
C1520 DELAY_VBIASN.n8 VSS 0.35838f ; **FLOATING
C1521 DELAY_VBIASN.t22 VSS 0.21832f ; **FLOATING
C1522 DELAY_VBIASN.n9 VSS 0.35838f ; **FLOATING
C1523 DELAY_VBIASN.t21 VSS 0.21832f ; **FLOATING
C1524 DELAY_VBIASN.n10 VSS 0.35838f ; **FLOATING
C1525 DELAY_VBIASN.t20 VSS 0.21832f ; **FLOATING
C1526 DELAY_VBIASN.n11 VSS 0.35838f ; **FLOATING
C1527 DELAY_VBIASN.t19 VSS 0.21832f ; **FLOATING
C1528 DELAY_VBIASN.n12 VSS 0.35838f ; **FLOATING
C1529 DELAY_VBIASN.t18 VSS 0.21832f ; **FLOATING
C1530 DELAY_VBIASN.n13 VSS 0.35838f ; **FLOATING
C1531 DELAY_VBIASN.t17 VSS 0.21832f ; **FLOATING
C1532 DELAY_VBIASN.n14 VSS 0.35838f ; **FLOATING
C1533 DELAY_VBIASN.t16 VSS 0.21832f ; **FLOATING
C1534 DELAY_VBIASN.n15 VSS 0.35838f ; **FLOATING
C1535 DELAY_VBIASN.t15 VSS 0.21832f ; **FLOATING
C1536 DELAY_VBIASN.n16 VSS 0.35838f ; **FLOATING
C1537 DELAY_VBIASN.t14 VSS 0.21832f ; **FLOATING
C1538 DELAY_VBIASN.n17 VSS 0.35838f ; **FLOATING
C1539 DELAY_VBIASN.t13 VSS 0.21832f ; **FLOATING
C1540 DELAY_VBIASN.n18 VSS 0.35838f ; **FLOATING
C1541 DELAY_VBIASN.t12 VSS 0.21832f ; **FLOATING
C1542 DELAY_VBIASN.n19 VSS 0.35838f ; **FLOATING
C1543 DELAY_VBIASN.t11 VSS 0.21832f ; **FLOATING
C1544 DELAY_VBIASN.n20 VSS 0.35838f ; **FLOATING
C1545 DELAY_VBIASN.t10 VSS 0.21832f ; **FLOATING
C1546 DELAY_VBIASN.n21 VSS 0.35838f ; **FLOATING
C1547 DELAY_VBIASN.t9 VSS 0.21832f ; **FLOATING
C1548 DELAY_VBIASN.n22 VSS 0.35838f ; **FLOATING
C1549 DELAY_VBIASN.t8 VSS 0.21832f ; **FLOATING
C1550 DELAY_VBIASN.n23 VSS 0.35838f ; **FLOATING
C1551 DELAY_VBIASN.t7 VSS 0.21832f ; **FLOATING
C1552 DELAY_VBIASN.n24 VSS 0.35838f ; **FLOATING
C1553 DELAY_VBIASN.t6 VSS 0.21832f ; **FLOATING
C1554 DELAY_VBIASN.n25 VSS 0.35838f ; **FLOATING
C1555 DELAY_VBIASN.t5 VSS 0.21832f ; **FLOATING
C1556 DELAY_VBIASN.n26 VSS 0.35838f ; **FLOATING
C1557 DELAY_VBIASN.t4 VSS 0.21832f ; **FLOATING
C1558 DELAY_VBIASN.n27 VSS 0.35838f ; **FLOATING
C1559 DELAY_VBIASN.t3 VSS 0.21832f ; **FLOATING
C1560 DELAY_VBIASN.n28 VSS 0.35838f ; **FLOATING
C1561 DELAY_VBIASN.t2 VSS 0.21832f ; **FLOATING
C1562 DELAY_VBIASN.n29 VSS 0.35838f ; **FLOATING
C1563 DELAY_VBIASN.t1 VSS 0.21832f ; **FLOATING
C1564 DELAY_VBIASN.n30 VSS 0.35838f ; **FLOATING
C1565 DELAY_VBIASN.t0 VSS 0.21832f ; **FLOATING
.ends
