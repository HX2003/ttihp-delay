* NGSPICE file created from hx_delay_line_with_mux.ext - technology: ihp-sg13g2

.subckt hx_delay_line_with_mux VSS VDD DELAY_OUT_LAST DELAY_IN MUX_SEL0 MUX_SEL1 MUX_OUT
+ MUX_SEL4 MUX_SEL2 MUX_SEL3 DELAY_VBIASN DELAY_VBIASP
X0 VDD a_4003_1842# a_4437_1842# VDD sg13_lv_pmos ad=0.2128p pd=1.5u as=0.3808p ps=2.92u w=1.12u l=0.13u
X1 VSS.t112 a_15077_1842# a_15545_1044# VSS.t151 sg13_lv_nmos ad=0.1665p pd=1.19u as=0.2516p ps=2.16u w=0.74u l=0.13u
X2 a_27915_1044# a_27705_1044# VDD VDD sg13_lv_pmos ad=0.2128p pd=1.5u as=0.252p ps=1.57u w=1.12u l=0.13u
X3 VSS.t280 VDD VSS.t278 VSS.t279 sg13_lv_nmos ad=79.8f pd=0.8u as=0 ps=0 w=0.42u l=1u
X4 a_10951_2470# a_10713_1842# a_10843_1842# VDD sg13_lv_pmos ad=0.2128p pd=1.5u as=0.3808p ps=2.92u w=1.12u l=0.2u
X5 VSS.t262 a_3171_1047.t7 a_11924_1008# VSS.t261 sg13_lv_nmos ad=0.2516p pd=2.16u as=0.2516p ps=2.16u w=0.74u l=0.13u
X6 VDD VSS.t572 VDD VDD sg13_lv_pmos ad=0.34p pd=2.68u as=0.30484n ps=1.54979m w=1u l=1u
X7 VSS.t108 a_1256_1044# a_2967_1395# VSS.t235 sg13_lv_nmos ad=0.1331p pd=1.12u as=0.1216p ps=1.02u w=0.64u l=0.13u
X8 VSS.t283 VDD VSS.t282 VSS.t281 sg13_lv_nmos ad=0.1428p pd=1.52u as=0 ps=0 w=0.42u l=1u
X9 a_25153_1842# a_24957_1842# VSS.t147 VSS.t511 sg13_lv_nmos ad=0.2516p pd=2.16u as=0.1406p ps=1.12u w=0.74u l=0.13u
X10 VDD VSS.t586 VDD VDD sg13_lv_pmos ad=0.34p pd=2.68u as=0 ps=0 w=1u l=1u
X11 a_25630_1044# a_2019_1047.t2 a_25528_1044# VSS.t239 sg13_lv_nmos ad=0.2516p pd=2.16u as=0.1406p ps=1.12u w=0.74u l=0.13u
X12 VDD DELAY_VBIASP.t11 a_19311_2470# VDD sg13_lv_pmos ad=0.3808p pd=2.92u as=0.2128p ps=1.5u w=1.12u l=0.6u
X13 a_16108_289# a_2019_311# a_16510_1044# VSS.t135 sg13_lv_nmos ad=0.2516p pd=2.16u as=0.2516p ps=2.16u w=0.74u l=0.13u
X14 VDD DELAY_VBIASP.t24 a_9431_2470# VDD sg13_lv_pmos ad=0.3808p pd=2.92u as=0.2128p ps=1.5u w=1.12u l=0.6u
X15 VSS.t348 VDD VSS.t347 VSS.t346 sg13_lv_nmos ad=0.1428p pd=1.52u as=0 ps=0 w=0.42u l=1u
X16 VDD DELAY_VBIASP.t6 a_23111_2470# VDD sg13_lv_pmos ad=0.3808p pd=2.92u as=0.2128p ps=1.5u w=1.12u l=0.6u
X17 a_7390_1044# a_8231_1008# a_8155_1044# VDD sg13_lv_pmos ad=0.3808p pd=2.92u as=0.2128p ps=1.5u w=1.12u l=0.13u
X18 VSS.t518 a_2595_311.t3 a_8745_519# VSS.t517 sg13_lv_nmos ad=0.2516p pd=2.16u as=0.2516p ps=2.16u w=0.74u l=0.13u
X19 a_17791_1842# a_17553_1842# a_17683_1842# VSS.t507 sg13_lv_nmos ad=0.1406p pd=1.12u as=0.2516p ps=2.16u w=0.74u l=0.2u
X20 VDD a_12037_1842# a_12505_1044# VDD sg13_lv_pmos ad=0.252p pd=1.57u as=0.3808p ps=2.92u w=1.12u l=0.13u
X21 a_16510_1044# a_2019_1047.t5 a_16408_1044# VSS.t85 sg13_lv_nmos ad=0.2516p pd=2.16u as=0.1406p ps=1.12u w=0.74u l=0.13u
X22 a_21591_1842# a_21353_1842# a_21483_1842# VSS.t361 sg13_lv_nmos ad=0.1406p pd=1.12u as=0.2516p ps=2.16u w=0.74u l=0.2u
X23 a_6153_1842# a_5957_1842# VSS.t190 VSS.t208 sg13_lv_nmos ad=0.2516p pd=2.16u as=0.1406p ps=1.12u w=0.74u l=0.13u
X24 VSS.t484 a_16163_1842# a_16597_1842# VSS.t483 sg13_lv_nmos ad=0.1406p pd=1.12u as=0.2516p ps=2.16u w=0.74u l=0.13u
X25 VSS.t18 a_3171_1047.t2 a_27124_1008# VSS.t17 sg13_lv_nmos ad=0.2516p pd=2.16u as=0.2516p ps=2.16u w=0.74u l=0.13u
X26 VDD a_11603_1842# a_12037_1842# VDD sg13_lv_pmos ad=0.2128p pd=1.5u as=0.3808p ps=2.92u w=1.12u l=0.13u
X27 VDD a_3171_311.t3 a_11785_519# VDD sg13_lv_pmos ad=0.3808p pd=2.92u as=0.3808p ps=2.92u w=1.12u l=0.13u
X28 a_24393_1842# a_24197_1842# VDD VDD sg13_lv_pmos ad=0.3808p pd=2.92u as=0.2128p ps=1.5u w=1.12u l=0.13u
X29 a_5731_289# a_2595_311.t3 a_7390_1044# VSS.t516 sg13_lv_nmos ad=0.2516p pd=2.16u as=0.2516p ps=2.16u w=0.74u l=0.13u
X30 a_10430_1044# a_2595_1047.t7 a_11195_1044# VSS.t263 sg13_lv_nmos ad=0.2516p pd=2.16u as=0.1406p ps=1.12u w=0.74u l=0.13u
X31 a_23355_1044# a_23145_1044# VSS.t143 VSS.t174 sg13_lv_nmos ad=0.1406p pd=1.12u as=0.1665p ps=1.19u w=0.74u l=0.13u
X32 VDD DELAY_VBIASP.t17 a_14751_2470# VDD sg13_lv_pmos ad=0.3808p pd=2.92u as=0.2128p ps=1.5u w=1.12u l=0.6u
X33 VSS.t433 DELAY_VBIASN.t23 a_10191_1842# VSS.t432 sg13_lv_nmos ad=0.2516p pd=2.16u as=0.1406p ps=1.12u w=0.74u l=0.6u
X34 VSS.t104 a_3747_1047.t4 a_21911_1008# VSS.t103 sg13_lv_nmos ad=0.2516p pd=2.16u as=0.2516p ps=2.16u w=0.74u l=0.13u
X35 VSS.t77 a_19963_1842# a_20397_1842# VSS.t76 sg13_lv_nmos ad=0.1406p pd=1.12u as=0.2516p ps=2.16u w=0.74u l=0.13u
X36 VDD DELAY_VBIASP.t31 a_4111_2470# VDD sg13_lv_pmos ad=0.3808p pd=2.92u as=0.2128p ps=1.5u w=1.12u l=0.6u
X37 a_10328_1044# a_9757_1842# VDD VDD sg13_lv_pmos ad=0.2128p pd=1.5u as=0.3808p ps=2.92u w=1.12u l=0.13u
X38 a_20968_1044# a_20397_1842# VSS.t184 VSS.t183 sg13_lv_nmos ad=0.1406p pd=1.12u as=0.2516p ps=2.16u w=0.74u l=0.13u
X39 a_22590_1044# a_22564_1008# a_22488_1044# VDD sg13_lv_pmos ad=0.3808p pd=2.92u as=0.2128p ps=1.5u w=1.12u l=0.13u
X40 VDD VSS.t589 VDD VDD sg13_lv_pmos ad=0.19p pd=1.38u as=0 ps=0 w=1u l=1u
X41 a_8808_1044# a_8237_1842# VDD VDD sg13_lv_pmos ad=0.2128p pd=1.5u as=0.3808p ps=2.92u w=1.12u l=0.13u
X42 a_4157_1313# DELAY_IN VDD VDD sg13_lv_pmos ad=0.3808p pd=2.92u as=0.3808p ps=2.92u w=1.12u l=0.13u
X43 a_17031_2470# a_16793_1842# a_16923_1842# VDD sg13_lv_pmos ad=0.2128p pd=1.5u as=0.3808p ps=2.92u w=1.12u l=0.2u
X44 a_11473_1842# a_11277_1842# VSS.t5 VSS.t193 sg13_lv_nmos ad=0.2516p pd=2.16u as=0.1406p ps=1.12u w=0.74u l=0.13u
X45 VSS.t340 VDD VSS.t338 VSS.t339 sg13_lv_nmos ad=79.8f pd=0.8u as=0 ps=0 w=0.42u l=1u
X46 a_19448_1044# a_18877_1842# VSS.t522 VSS.t521 sg13_lv_nmos ad=0.1406p pd=1.12u as=0.2516p ps=2.16u w=0.74u l=0.13u
X47 a_10430_1044# a_3171_1047.t7 a_11848_1044# VSS.t260 sg13_lv_nmos ad=0.2516p pd=2.16u as=0.1406p ps=1.12u w=0.74u l=0.13u
X48 a_20831_2470# a_20593_1842# a_20723_1842# VDD sg13_lv_pmos ad=0.2128p pd=1.5u as=0.3808p ps=2.92u w=1.12u l=0.2u
X49 VSS.t305 VDD VSS.t303 VSS.t304 sg13_lv_nmos ad=79.8f pd=0.8u as=0 ps=0 w=0.42u l=1u
X50 VDD a_27237_1842# a_27705_1044# VDD sg13_lv_pmos ad=0.252p pd=1.57u as=0.3808p ps=2.92u w=1.12u l=0.13u
X51 a_5393_1842# a_5197_1842# VDD VDD sg13_lv_pmos ad=0.3808p pd=2.92u as=0.2128p ps=1.5u w=1.12u l=0.13u
X52 VDD DELAY_VBIASP.t14 a_17031_2470# VDD sg13_lv_pmos ad=0.3808p pd=2.92u as=0.2128p ps=1.5u w=1.12u l=0.6u
X53 VDD a_26803_1842# a_27237_1842# VDD sg13_lv_pmos ad=0.2128p pd=1.5u as=0.3808p ps=2.92u w=1.12u l=0.13u
X54 VDD MUX_SEL1 a_3449_1395# VDD sg13_lv_pmos ad=0.1918p pd=1.5u as=0.1596p ps=1.22u w=0.84u l=0.13u
X55 a_25630_1044# a_2595_1047.t2 a_26395_1044# VSS.t228 sg13_lv_nmos ad=0.2516p pd=2.16u as=0.1406p ps=1.12u w=0.74u l=0.13u
X56 VSS.t465 DELAY_VBIASN.t3 a_25391_1842# VSS.t464 sg13_lv_nmos ad=0.2516p pd=2.16u as=0.1406p ps=1.12u w=0.74u l=0.6u
X57 a_6635_1044# a_6425_1044# VDD VDD sg13_lv_pmos ad=0.2128p pd=1.5u as=0.252p ps=1.57u w=1.12u l=0.13u
X58 a_20315_1044# a_20105_1044# VDD VDD sg13_lv_pmos ad=0.2128p pd=1.5u as=0.252p ps=1.57u w=1.12u l=0.13u
X59 VDD a_2595_1047.t9 a_5191_1008# VDD sg13_lv_pmos ad=0.3808p pd=2.92u as=0.3808p ps=2.92u w=1.12u l=0.13u
X60 a_19311_2470# a_19073_1842# a_19203_1842# VDD sg13_lv_pmos ad=0.2128p pd=1.5u as=0.3808p ps=2.92u w=1.12u l=0.2u
X61 VSS.t56 a_1721_1395# a_2019_1047.t1 VSS.t55 sg13_lv_nmos ad=0.2812p pd=2.24u as=0.1406p ps=1.12u w=0.74u l=0.13u
X62 a_25528_1044# a_24957_1842# VDD VDD sg13_lv_pmos ad=0.2128p pd=1.5u as=0.3808p ps=2.92u w=1.12u l=0.13u
X63 VSS.t210 a_5957_1842# a_6425_1044# VSS.t209 sg13_lv_nmos ad=0.1665p pd=1.19u as=0.2516p ps=2.16u w=0.74u l=0.13u
X64 VSS.t90 a_2019_1047.t6 a_13444_1008# VSS.t89 sg13_lv_nmos ad=0.2516p pd=2.16u as=0.2516p ps=2.16u w=0.74u l=0.13u
X65 a_23111_2470# a_22873_1842# a_23003_1842# VDD sg13_lv_pmos ad=0.2128p pd=1.5u as=0.3808p ps=2.92u w=1.12u l=0.2u
X66 VSS.t278 VDD VSS.t277 VSS.t276 sg13_lv_nmos ad=0.1428p pd=1.52u as=0 ps=0 w=0.42u l=1u
X67 VSS.t139 a_15964_289# a_16851_309# VSS.t542 sg13_lv_nmos ad=0.1371p pd=1.12u as=0.2176p ps=1.96u w=0.64u l=0.13u
X68 a_10713_1842# a_10517_1842# VDD VDD sg13_lv_pmos ad=0.3808p pd=2.92u as=0.2128p ps=1.5u w=1.12u l=0.13u
X69 VDD a_17683_1842# a_18117_1842# VDD sg13_lv_pmos ad=0.2128p pd=1.5u as=0.3808p ps=2.92u w=1.12u l=0.13u
X70 a_16108_289# a_17865_519# a_16510_1044# VDD sg13_lv_pmos ad=0.3808p pd=2.92u as=0.3808p ps=2.92u w=1.12u l=0.13u
X71 a_26673_1842# a_26477_1842# VSS.t167 VSS.t166 sg13_lv_nmos ad=0.2516p pd=2.16u as=0.1406p ps=1.12u w=0.74u l=0.13u
X72 VDD a_7803_1842# a_8237_1842# VDD sg13_lv_pmos ad=0.2128p pd=1.5u as=0.3808p ps=2.92u w=1.12u l=0.13u
X73 a_4248_1044# a_4157_1313# VSS.t106 VSS.t105 sg13_lv_nmos ad=0.1406p pd=1.12u as=0.2516p ps=2.16u w=0.74u l=0.13u
X74 a_16108_289# a_3171_311.t2 a_22590_1044# VSS.t254 sg13_lv_nmos ad=0.2516p pd=2.16u as=0.2516p ps=2.16u w=0.74u l=0.13u
X75 VSS.t411 DELAY_VBIASN.t28 a_6391_1842# VSS.t410 sg13_lv_nmos ad=0.2516p pd=2.16u as=0.1406p ps=1.12u w=0.74u l=0.6u
X76 a_16408_1044# a_15837_1842# VDD VDD sg13_lv_pmos ad=0.2128p pd=1.5u as=0.3808p ps=2.92u w=1.12u l=0.13u
X77 a_19550_1044# a_3747_1047.t4 a_21835_1044# VSS.t102 sg13_lv_nmos ad=0.2516p pd=2.16u as=0.1406p ps=1.12u w=0.74u l=0.13u
X78 VSS.t459 DELAY_VBIASN.t9 a_20831_1842# VSS.t458 sg13_lv_nmos ad=0.2516p pd=2.16u as=0.1406p ps=1.12u w=0.74u l=0.6u
X79 a_3171_311.t0 a_2873_331# VDD VDD sg13_lv_pmos ad=0.2128p pd=1.5u as=0.1918p ps=1.5u w=1.12u l=0.13u
X80 a_3747_311.t0 a_3449_331# VDD VDD sg13_lv_pmos ad=0.2128p pd=1.5u as=0.1918p ps=1.5u w=1.12u l=0.13u
X81 a_7390_1044# a_9751_1008# a_9675_1044# VDD sg13_lv_pmos ad=0.3808p pd=2.92u as=0.2128p ps=1.5u w=1.12u l=0.13u
X82 a_10191_1842# a_9953_1842# a_10083_1842# VSS.t398 sg13_lv_nmos ad=0.1406p pd=1.12u as=0.2516p ps=2.16u w=0.74u l=0.2u
X83 VSS.t143 a_22677_1842# a_23145_1044# VSS.t142 sg13_lv_nmos ad=0.1665p pd=1.19u as=0.2516p ps=2.16u w=0.74u l=0.13u
X84 a_14751_2470# a_14513_1842# a_14643_1842# VDD sg13_lv_pmos ad=0.2128p pd=1.5u as=0.3808p ps=2.92u w=1.12u l=0.2u
X85 a_5731_289# a_8745_519# a_7390_1044# VDD sg13_lv_pmos ad=0.3808p pd=2.92u as=0.3808p ps=2.92u w=1.12u l=0.13u
X86 VDD VDD VDD VDD sg13_lv_pmos ad=0.2128p pd=1.5u as=0 ps=0 w=1.12u l=0.13u
X87 a_4111_2470# DELAY_IN a_4003_1842# VDD sg13_lv_pmos ad=0.2128p pd=1.5u as=0.3808p ps=2.92u w=1.12u l=0.2u
X88 a_7673_1842# a_7477_1842# VSS.t186 VSS.t504 sg13_lv_nmos ad=0.2516p pd=2.16u as=0.1406p ps=1.12u w=0.74u l=0.13u
X89 VDD a_3171_1047.t5 a_18004_1008# VDD sg13_lv_pmos ad=0.3808p pd=2.92u as=0.3808p ps=2.92u w=1.12u l=0.13u
X90 VDD a_13123_1842# a_13557_1842# VDD sg13_lv_pmos ad=0.2128p pd=1.5u as=0.3808p ps=2.92u w=1.12u l=0.13u
X91 VDD a_3747_311.t2 a_26985_519# VDD sg13_lv_pmos ad=0.3808p pd=2.92u as=0.3808p ps=2.92u w=1.12u l=0.13u
X92 a_25913_1842# a_25717_1842# VDD VDD sg13_lv_pmos ad=0.3808p pd=2.92u as=0.2128p ps=1.5u w=1.12u l=0.13u
X93 a_10430_1044# a_3747_1047.t7 a_12715_1044# VSS.t10 sg13_lv_nmos ad=0.2516p pd=2.16u as=0.1406p ps=1.12u w=0.74u l=0.13u
X94 a_14235_1044# a_14025_1044# VDD VDD sg13_lv_pmos ad=0.2128p pd=1.5u as=0.252p ps=1.57u w=1.12u l=0.13u
X95 a_24875_1044# a_24665_1044# VSS.t36 VSS.t519 sg13_lv_nmos ad=0.1406p pd=1.12u as=0.1665p ps=1.19u w=0.74u l=0.13u
X96 VSS.t439 DELAY_VBIASN.t21 a_11711_1842# VSS.t438 sg13_lv_nmos ad=0.2516p pd=2.16u as=0.1406p ps=1.12u w=0.74u l=0.6u
X97 VDD a_3747_1047.t7 a_12791_1008# VDD sg13_lv_pmos ad=0.3808p pd=2.92u as=0.3808p ps=2.92u w=1.12u l=0.13u
X98 VSS.t62 a_2595_1047.t3 a_23431_1008# VSS.t61 sg13_lv_nmos ad=0.2516p pd=2.16u as=0.2516p ps=2.16u w=0.74u l=0.13u
X99 VSS.t200 a_21483_1842# a_21917_1842# VSS.t380 sg13_lv_nmos ad=0.1406p pd=1.12u as=0.2516p ps=2.16u w=0.74u l=0.13u
X100 VSS.t217 a_13557_1842# a_14025_1044# VSS.t216 sg13_lv_nmos ad=0.1665p pd=1.19u as=0.2516p ps=2.16u w=0.74u l=0.13u
X101 a_11848_1044# a_11277_1842# VDD VDD sg13_lv_pmos ad=0.2128p pd=1.5u as=0.3808p ps=2.92u w=1.12u l=0.13u
X102 VDD VSS.t565 VDD VDD sg13_lv_pmos ad=0.19p pd=1.38u as=0 ps=0 w=1u l=1u
X103 a_25391_1842# a_25153_1842# a_25283_1842# VSS.t543 sg13_lv_nmos ad=0.1406p pd=1.12u as=0.2516p ps=2.16u w=0.74u l=0.2u
X104 a_12993_1842# a_12797_1842# VSS.t160 VSS.t159 sg13_lv_nmos ad=0.2516p pd=2.16u as=0.1406p ps=1.12u w=0.74u l=0.13u
X105 DELAY_OUT_LAST a_27997_1842# VDD VDD sg13_lv_pmos ad=0.3808p pd=2.92u as=0.2128p ps=1.5u w=1.12u l=0.13u
X106 VDD VSS.t564 VDD VDD sg13_lv_pmos ad=0.34p pd=2.68u as=0 ps=0 w=1u l=1u
X107 VDD a_19637_1842# a_20105_1044# VDD sg13_lv_pmos ad=0.252p pd=1.57u as=0.3808p ps=2.92u w=1.12u l=0.13u
X108 VSS.t443 DELAY_VBIASN.t18 a_13991_1842# VSS.t442 sg13_lv_nmos ad=0.2516p pd=2.16u as=0.1406p ps=1.12u w=0.74u l=0.6u
X109 VSS.t338 VDD VSS.t337 VSS.t336 sg13_lv_nmos ad=0.1428p pd=1.52u as=0 ps=0 w=0.42u l=1u
X110 a_22590_1044# a_3171_1047.t3 a_24008_1044# VSS.t251 sg13_lv_nmos ad=0.2516p pd=2.16u as=0.1406p ps=1.12u w=0.74u l=0.13u
X111 a_6913_1842# a_6717_1842# VDD VDD sg13_lv_pmos ad=0.3808p pd=2.92u as=0.2128p ps=1.5u w=1.12u l=0.13u
X112 VDD DELAY_VBIASP.t12 a_18551_2470# VDD sg13_lv_pmos ad=0.3808p pd=2.92u as=0.2128p ps=1.5u w=1.12u l=0.6u
X113 VSS.t34 a_23763_1842# a_24197_1842# VSS.t163 sg13_lv_nmos ad=0.1406p pd=1.12u as=0.2516p ps=2.16u w=0.74u l=0.13u
X114 VSS.t303 VDD VSS.t302 VSS.t301 sg13_lv_nmos ad=0.1428p pd=1.52u as=0 ps=0 w=0.42u l=1u
X115 VDD a_1256_1044# a_2873_1395# VDD sg13_lv_pmos ad=0.1918p pd=1.5u as=0.1596p ps=1.22u w=0.84u l=0.13u
X116 a_3171_311.t1 a_2873_331# VSS.t129 VSS.t128 sg13_lv_nmos ad=0.1406p pd=1.12u as=0.1331p ps=1.12u w=0.74u l=0.13u
X117 VDD a_2873_331# a_3171_311.t0 VDD sg13_lv_pmos ad=0.4256p pd=3u as=0.2128p ps=1.5u w=1.12u l=0.13u
X118 a_16510_1044# a_17351_1008# a_17275_1044# VDD sg13_lv_pmos ad=0.3808p pd=2.92u as=0.2128p ps=1.5u w=1.12u l=0.13u
X119 a_25630_1044# a_3747_1047.t2 a_27915_1044# VSS.t7 sg13_lv_nmos ad=0.2516p pd=2.16u as=0.1406p ps=1.12u w=0.74u l=0.13u
X120 VSS.t417 DELAY_VBIASN.t1 a_26911_1842# VSS.t416 sg13_lv_nmos ad=0.2516p pd=2.16u as=0.1406p ps=1.12u w=0.74u l=0.6u
X121 a_3747_311.t1 a_3449_331# VSS.t29 VSS.t28 sg13_lv_nmos ad=0.1406p pd=1.12u as=0.1331p ps=1.12u w=0.74u l=0.13u
X122 VDD a_3449_331# a_3747_311.t0 VDD sg13_lv_pmos ad=0.4256p pd=3u as=0.2128p ps=1.5u w=1.12u l=0.13u
X123 VDD DELAY_VBIASP.t7 a_22351_2470# VDD sg13_lv_pmos ad=0.3808p pd=2.92u as=0.2128p ps=1.5u w=1.12u l=0.6u
X124 VDD a_3747_1047.t2 a_27991_1008# VDD sg13_lv_pmos ad=0.3808p pd=2.92u as=0.3808p ps=2.92u w=1.12u l=0.13u
X125 VDD VSS.t597 VDD VDD sg13_lv_pmos ad=0.19p pd=1.38u as=0 ps=0 w=1u l=1u
X126 VDD a_3747_1047.t9 a_6711_1008# VDD sg13_lv_pmos ad=0.3808p pd=2.92u as=0.3808p ps=2.92u w=1.12u l=0.13u
X127 a_6391_1842# a_6153_1842# a_6283_1842# VSS.t32 sg13_lv_nmos ad=0.1406p pd=1.12u as=0.2516p ps=2.16u w=0.74u l=0.2u
X128 a_15273_1842# a_15077_1842# VSS.t153 VSS.t152 sg13_lv_nmos ad=0.2516p pd=2.16u as=0.1406p ps=1.12u w=0.74u l=0.13u
X129 a_19833_1842# a_19637_1842# VDD VDD sg13_lv_pmos ad=0.3808p pd=2.92u as=0.2128p ps=1.5u w=1.12u l=0.13u
X130 a_16108_289# a_23945_519# a_22590_1044# VDD sg13_lv_pmos ad=0.3808p pd=2.92u as=0.3808p ps=2.92u w=1.12u l=0.13u
X131 a_9193_1842# a_8997_1842# VDD VDD sg13_lv_pmos ad=0.3808p pd=2.92u as=0.2128p ps=1.5u w=1.12u l=0.13u
X132 a_24631_2470# a_24393_1842# a_24523_1842# VDD sg13_lv_pmos ad=0.2128p pd=1.5u as=0.3808p ps=2.92u w=1.12u l=0.2u
X133 VSS.t101 a_15403_1842# a_15837_1842# VSS.t100 sg13_lv_nmos ad=0.1406p pd=1.12u as=0.2516p ps=2.16u w=0.74u l=0.13u
X134 a_8155_1044# a_7945_1044# VSS.t64 VSS.t63 sg13_lv_nmos ad=0.1406p pd=1.12u as=0.1665p ps=1.19u w=0.74u l=0.13u
X135 a_23633_1842# a_23437_1842# VDD VDD sg13_lv_pmos ad=0.3808p pd=2.92u as=0.2128p ps=1.5u w=1.12u l=0.13u
X136 VSS.t488 a_4763_1842# a_5197_1842# VSS.t523 sg13_lv_nmos ad=0.1406p pd=1.12u as=0.2516p ps=2.16u w=0.74u l=0.13u
X137 a_27048_1044# a_26477_1842# VSS.t165 VSS.t164 sg13_lv_nmos ad=0.1406p pd=1.12u as=0.2516p ps=2.16u w=0.74u l=0.13u
X138 VDD a_9323_1842# a_9757_1842# VDD sg13_lv_pmos ad=0.2128p pd=1.5u as=0.3808p ps=2.92u w=1.12u l=0.13u
X139 a_5768_1044# a_5197_1842# VSS.t486 VSS.t485 sg13_lv_nmos ad=0.1406p pd=1.12u as=0.2516p ps=2.16u w=0.74u l=0.13u
X140 a_7390_1044# a_7364_1008# a_7288_1044# VDD sg13_lv_pmos ad=0.3808p pd=2.92u as=0.2128p ps=1.5u w=1.12u l=0.13u
X141 VSS.t427 DELAY_VBIASN.t26 a_7911_1842# VSS.t426 sg13_lv_nmos ad=0.2516p pd=2.16u as=0.1406p ps=1.12u w=0.74u l=0.6u
X142 VDD VSS.t581 VDD VDD sg13_lv_pmos ad=0.19p pd=1.38u as=0 ps=0 w=1u l=1u
X143 a_11711_1842# a_11473_1842# a_11603_1842# VSS.t181 sg13_lv_nmos ad=0.1406p pd=1.12u as=0.2516p ps=2.16u w=0.74u l=0.2u
X144 VSS.t36 a_24197_1842# a_24665_1044# VSS.t35 sg13_lv_nmos ad=0.1665p pd=1.19u as=0.2516p ps=2.16u w=0.74u l=0.13u
X145 a_16510_1044# a_3171_1047.t5 a_17928_1044# VSS.t79 sg13_lv_nmos ad=0.2516p pd=2.16u as=0.1406p ps=1.12u w=0.74u l=0.13u
X146 VSS.t295 VDD VSS.t293 VSS.t294 sg13_lv_nmos ad=79.8f pd=0.8u as=0 ps=0 w=0.42u l=1u
X147 a_5631_2470# a_5393_1842# a_5523_1842# VDD sg13_lv_pmos ad=0.2128p pd=1.5u as=0.3808p ps=2.92u w=1.12u l=0.2u
X148 a_14513_1842# a_14317_1842# VDD VDD sg13_lv_pmos ad=0.3808p pd=2.92u as=0.2128p ps=1.5u w=1.12u l=0.13u
X149 a_4633_1842# a_4437_1842# VDD VDD sg13_lv_pmos ad=0.3808p pd=2.92u as=0.2128p ps=1.5u w=1.12u l=0.13u
X150 VSS.t41 a_10083_1842# a_10517_1842# VSS.t40 sg13_lv_nmos ad=0.1406p pd=1.12u as=0.2516p ps=2.16u w=0.74u l=0.13u
X151 VDD a_2019_1047.t4 a_19524_1008# VDD sg13_lv_pmos ad=0.3808p pd=2.92u as=0.3808p ps=2.92u w=1.12u l=0.13u
X152 VSS.t117 a_3171_1047.t4 a_21044_1008# VSS.t116 sg13_lv_nmos ad=0.2516p pd=2.16u as=0.2516p ps=2.16u w=0.74u l=0.13u
X153 VSS.t131 a_2873_331# a_3171_311.t1 VSS.t130 sg13_lv_nmos ad=0.2812p pd=2.24u as=0.1406p ps=1.12u w=0.74u l=0.13u
X154 VSS.t31 a_3449_331# a_3747_311.t1 VSS.t30 sg13_lv_nmos ad=0.2812p pd=2.24u as=0.1406p ps=1.12u w=0.74u l=0.13u
X155 a_15755_1044# a_15545_1044# VDD VDD sg13_lv_pmos ad=0.2128p pd=1.5u as=0.252p ps=1.57u w=1.12u l=0.13u
X156 VDD a_2595_1047.t6 a_14311_1008# VDD sg13_lv_pmos ad=0.3808p pd=2.92u as=0.3808p ps=2.92u w=1.12u l=0.13u
X157 VSS.t423 DELAY_VBIASN.t4 a_24631_1842# VSS.t422 sg13_lv_nmos ad=0.2516p pd=2.16u as=0.1406p ps=1.12u w=0.74u l=0.6u
X158 a_5115_1044# a_4905_1044# VDD VDD sg13_lv_pmos ad=0.2128p pd=1.5u as=0.252p ps=1.57u w=1.12u l=0.13u
X159 a_18551_2470# a_18313_1842# a_18443_1842# VDD sg13_lv_pmos ad=0.2128p pd=1.5u as=0.3808p ps=2.92u w=1.12u l=0.2u
X160 VDD VSS.t573 VDD VDD sg13_lv_pmos ad=0.19p pd=1.38u as=0 ps=0 w=1u l=1u
X161 a_3171_1047.t1 a_2873_1395# VSS.t108 VSS.t107 sg13_lv_nmos ad=0.1406p pd=1.12u as=0.1331p ps=1.12u w=0.74u l=0.13u
X162 VSS.t223 a_2297_1395# a_2595_1047.t1 VSS.t222 sg13_lv_nmos ad=0.2812p pd=2.24u as=0.1406p ps=1.12u w=0.74u l=0.13u
X163 a_22351_2470# a_22113_1842# a_22243_1842# VDD sg13_lv_pmos ad=0.2128p pd=1.5u as=0.3808p ps=2.92u w=1.12u l=0.2u
X164 VSS.t366 VSS.t363 VSS.t365 VSS.t364 sg13_lv_nmos ad=0.2516p pd=2.16u as=0 ps=0 w=0.74u l=0.13u
X165 a_26911_1842# a_26673_1842# a_26803_1842# VSS.t393 sg13_lv_nmos ad=0.1406p pd=1.12u as=0.2516p ps=2.16u w=0.74u l=0.2u
X166 VSS.t220 a_3171_311.t3 a_11785_519# VSS.t219 sg13_lv_nmos ad=0.2516p pd=2.16u as=0.2516p ps=2.16u w=0.74u l=0.13u
X167 VDD a_1721_1395# a_2019_1047.t0 VDD sg13_lv_pmos ad=0.4256p pd=3u as=0.2128p ps=1.5u w=1.12u l=0.13u
X168 VDD a_16923_1842# a_17357_1842# VDD sg13_lv_pmos ad=0.2128p pd=1.5u as=0.3808p ps=2.92u w=1.12u l=0.13u
X169 a_2391_1395# MUX_SEL0 a_2297_1395# VSS.t476 sg13_lv_nmos ad=0.1216p pd=1.02u as=0.2176p ps=1.96u w=0.64u l=0.13u
X170 VSS.t23 a_1544_1044# a_1815_1395# VSS.t22 sg13_lv_nmos ad=0.1331p pd=1.12u as=0.1216p ps=1.02u w=0.64u l=0.13u
X171 a_13368_1044# a_12797_1842# VSS.t158 VSS.t157 sg13_lv_nmos ad=0.1406p pd=1.12u as=0.2516p ps=2.16u w=0.74u l=0.13u
X172 a_5731_289# a_3171_311.t3 a_10430_1044# VSS.t218 sg13_lv_nmos ad=0.2516p pd=2.16u as=0.2516p ps=2.16u w=0.74u l=0.13u
X173 VDD a_21157_1842# a_21625_1044# VDD sg13_lv_pmos ad=0.252p pd=1.57u as=0.3808p ps=2.92u w=1.12u l=0.13u
X174 VDD DELAY_VBIASP.t22 a_10951_2470# VDD sg13_lv_pmos ad=0.3808p pd=2.92u as=0.2128p ps=1.5u w=1.12u l=0.6u
X175 VSS.t445 DELAY_VBIASN.t16 a_15511_1842# VSS.t444 sg13_lv_nmos ad=0.2516p pd=2.16u as=0.1406p ps=1.12u w=0.74u l=0.6u
X176 VDD a_20723_1842# a_21157_1842# VDD sg13_lv_pmos ad=0.2128p pd=1.5u as=0.3808p ps=2.92u w=1.12u l=0.13u
X177 VSS.t51 a_25283_1842# a_25717_1842# VSS.t50 sg13_lv_nmos ad=0.1406p pd=1.12u as=0.2516p ps=2.16u w=0.74u l=0.13u
X178 a_4350_1044# a_3747_1047.t9 a_6635_1044# VSS.t73 sg13_lv_nmos ad=0.2516p pd=2.16u as=0.1406p ps=1.12u w=0.74u l=0.13u
X179 VSS.t415 DELAY_VBIASN.t29 a_5631_1842# VSS.t414 sg13_lv_nmos ad=0.2516p pd=2.16u as=0.1406p ps=1.12u w=0.74u l=0.6u
X180 VDD a_2019_1047.t9 a_4324_1008# VDD sg13_lv_pmos ad=0.3808p pd=2.92u as=0.3808p ps=2.92u w=1.12u l=0.13u
X181 a_16510_1044# a_18871_1008# a_18795_1044# VDD sg13_lv_pmos ad=0.3808p pd=2.92u as=0.2128p ps=1.5u w=1.12u l=0.13u
X182 a_19550_1044# a_2595_1047.t4 a_20315_1044# VSS.t19 sg13_lv_nmos ad=0.2516p pd=2.16u as=0.1406p ps=1.12u w=0.74u l=0.13u
X183 VDD DELAY_VBIASP.t5 a_23871_2470# VDD sg13_lv_pmos ad=0.3808p pd=2.92u as=0.2128p ps=1.5u w=1.12u l=0.6u
X184 VSS.t64 a_7477_1842# a_7945_1044# VSS.t503 sg13_lv_nmos ad=0.1665p pd=1.19u as=0.2516p ps=2.16u w=0.74u l=0.13u
X185 a_13231_2470# a_12993_1842# a_13123_1842# VDD sg13_lv_pmos ad=0.2128p pd=1.5u as=0.3808p ps=2.92u w=1.12u l=0.2u
X186 VDD VSS.t598 VDD VDD sg13_lv_pmos ad=0.34p pd=2.68u as=0 ps=0 w=1u l=1u
X187 a_12233_1842# a_12037_1842# VDD VDD sg13_lv_pmos ad=0.3808p pd=2.92u as=0.2128p ps=1.5u w=1.12u l=0.13u
X188 a_7911_1842# a_7673_1842# a_7803_1842# VSS.t65 sg13_lv_nmos ad=0.1406p pd=1.12u as=0.2516p ps=2.16u w=0.74u l=0.2u
X189 a_16793_1842# a_16597_1842# VSS.t484 VSS.t545 sg13_lv_nmos ad=0.2516p pd=2.16u as=0.1406p ps=1.12u w=0.74u l=0.13u
X190 VDD a_3747_311.t3 a_14825_519# VDD sg13_lv_pmos ad=0.3808p pd=2.92u as=0.3808p ps=2.92u w=1.12u l=0.13u
X191 VSS.t403 a_27563_1842# a_27997_1842# VSS.t402 sg13_lv_nmos ad=0.1406p pd=1.12u as=0.2516p ps=2.16u w=0.74u l=0.13u
X192 a_9675_1044# a_9465_1044# VSS.t53 VSS.t52 sg13_lv_nmos ad=0.1406p pd=1.12u as=0.1665p ps=1.19u w=0.74u l=0.13u
X193 a_20593_1842# a_20397_1842# VSS.t77 VSS.t182 sg13_lv_nmos ad=0.2516p pd=2.16u as=0.1406p ps=1.12u w=0.74u l=0.13u
X194 VSS.t540 a_2595_1047.t8 a_8231_1008# VSS.t539 sg13_lv_nmos ad=0.2516p pd=2.16u as=0.2516p ps=2.16u w=0.74u l=0.13u
X195 VSS.t67 a_6283_1842# a_6717_1842# VSS.t66 sg13_lv_nmos ad=0.1406p pd=1.12u as=0.2516p ps=2.16u w=0.74u l=0.13u
X196 a_10430_1044# a_10404_1008# a_10328_1044# VDD sg13_lv_pmos ad=0.3808p pd=2.92u as=0.2128p ps=1.5u w=1.12u l=0.13u
X197 VDD DELAY_VBIASP.t2 a_26151_2470# VDD sg13_lv_pmos ad=0.3808p pd=2.92u as=0.2128p ps=1.5u w=1.12u l=0.6u
X198 a_7390_1044# a_8884_1008# a_8808_1044# VDD sg13_lv_pmos ad=0.3808p pd=2.92u as=0.2128p ps=1.5u w=1.12u l=0.13u
X199 VDD DELAY_VBIASP.t30 a_4871_2470# VDD sg13_lv_pmos ad=0.3808p pd=2.92u as=0.2128p ps=1.5u w=1.12u l=0.6u
X200 a_3449_331# MUX_SEL2 VDD VDD sg13_lv_pmos ad=0.1596p pd=1.22u as=0.2856p ps=2.36u w=0.84u l=0.13u
X201 VDD VSS.t575 VDD VDD sg13_lv_pmos ad=0.19p pd=1.38u as=0 ps=0 w=1u l=1u
X202 a_19073_1842# a_18877_1842# VSS.t162 VSS.t520 sg13_lv_nmos ad=0.2516p pd=2.16u as=0.1406p ps=1.12u w=0.74u l=0.13u
X203 VDD a_15077_1842# a_15545_1044# VDD sg13_lv_pmos ad=0.252p pd=1.57u as=0.3808p ps=2.92u w=1.12u l=0.13u
X204 a_19550_1044# a_2019_1047.t4 a_19448_1044# VSS.t242 sg13_lv_nmos ad=0.2516p pd=2.16u as=0.1406p ps=1.12u w=0.74u l=0.13u
X205 VDD VDD VDD VDD sg13_lv_pmos ad=0.3808p pd=2.92u as=0 ps=0 w=1.12u l=0.6u
X206 VSS.t355 VDD VSS.t353 VSS.t354 sg13_lv_nmos ad=79.8f pd=0.8u as=0 ps=0 w=0.42u l=1u
X207 VSS.t170 a_19203_1842# a_19637_1842# VSS.t169 sg13_lv_nmos ad=0.1406p pd=1.12u as=0.2516p ps=2.16u w=0.74u l=0.13u
X208 VDD VSS.t577 VDD VDD sg13_lv_pmos ad=0.19p pd=1.38u as=0 ps=0 w=1u l=1u
X209 VDD VSS.t588 VDD VDD sg13_lv_pmos ad=0.34p pd=2.68u as=0 ps=0 w=1u l=1u
X210 a_27433_1842# a_27237_1842# VDD VDD sg13_lv_pmos ad=0.3808p pd=2.92u as=0.2128p ps=1.5u w=1.12u l=0.13u
X211 VDD a_1256_289# a_2873_331# VDD sg13_lv_pmos ad=0.1918p pd=1.5u as=0.1596p ps=1.22u w=0.84u l=0.13u
X212 a_13470_1044# a_2595_1047.t6 a_14235_1044# VSS.t57 sg13_lv_nmos ad=0.2516p pd=2.16u as=0.1406p ps=1.12u w=0.74u l=0.13u
X213 VSS.t397 a_8563_1842# a_8997_1842# VSS.t396 sg13_lv_nmos ad=0.1406p pd=1.12u as=0.2516p ps=2.16u w=0.74u l=0.13u
X214 VSS.t441 DELAY_VBIASN.t19 a_13231_1842# VSS.t440 sg13_lv_nmos ad=0.2516p pd=2.16u as=0.1406p ps=1.12u w=0.74u l=0.6u
X215 VDD a_3171_1047.t7 a_11924_1008# VDD sg13_lv_pmos ad=0.3808p pd=2.92u as=0.3808p ps=2.92u w=1.12u l=0.13u
X216 VSS.t93 a_2019_1047.t3 a_22564_1008# VSS.t92 sg13_lv_nmos ad=0.2516p pd=2.16u as=0.2516p ps=2.16u w=0.74u l=0.13u
X217 VSS.t551 a_23003_1842# a_23437_1842# VSS.t550 sg13_lv_nmos ad=0.1406p pd=1.12u as=0.2516p ps=2.16u w=0.74u l=0.13u
X218 VSS.t358 VDD VSS.t357 VSS.t356 sg13_lv_nmos ad=0.1428p pd=1.52u as=0 ps=0 w=0.42u l=1u
X219 VDD DELAY_VBIASP.t27 a_7151_2470# VDD sg13_lv_pmos ad=0.3808p pd=2.92u as=0.2128p ps=1.5u w=1.12u l=0.6u
X220 a_25630_1044# a_25604_1008# a_25528_1044# VDD sg13_lv_pmos ad=0.3808p pd=2.92u as=0.2128p ps=1.5u w=1.12u l=0.13u
X221 a_15511_1842# a_15273_1842# a_15403_1842# VSS.t524 sg13_lv_nmos ad=0.1406p pd=1.12u as=0.2516p ps=2.16u w=0.74u l=0.2u
X222 a_18313_1842# a_18117_1842# VDD VDD sg13_lv_pmos ad=0.3808p pd=2.92u as=0.2128p ps=1.5u w=1.12u l=0.13u
X223 a_5731_289# a_11785_519# a_10430_1044# VDD sg13_lv_pmos ad=0.3808p pd=2.92u as=0.3808p ps=2.92u w=1.12u l=0.13u
X224 VSS.t275 VDD VSS.t273 VSS.t274 sg13_lv_nmos ad=79.8f pd=0.8u as=0 ps=0 w=0.42u l=1u
X225 a_9431_2470# a_9193_1842# a_9323_1842# VDD sg13_lv_pmos ad=0.2128p pd=1.5u as=0.3808p ps=2.92u w=1.12u l=0.2u
X226 a_17275_1044# a_17065_1044# VSS.t125 VSS.t124 sg13_lv_nmos ad=0.1406p pd=1.12u as=0.1665p ps=1.19u w=0.74u l=0.13u
X227 VDD VSS.t574 VDD VDD sg13_lv_pmos ad=0.34p pd=2.68u as=0 ps=0 w=1u l=1u
X228 VSS.t39 a_3747_1047.t6 a_15831_1008# VSS.t38 sg13_lv_nmos ad=0.2516p pd=2.16u as=0.2516p ps=2.16u w=0.74u l=0.13u
X229 a_23871_2470# a_23633_1842# a_23763_1842# VDD sg13_lv_pmos ad=0.2128p pd=1.5u as=0.3808p ps=2.92u w=1.12u l=0.2u
X230 VSS.t382 a_13883_1842# a_14317_1842# VSS.t381 sg13_lv_nmos ad=0.1406p pd=1.12u as=0.2516p ps=2.16u w=0.74u l=0.13u
X231 VSS.t527 a_3747_311.t2 a_26985_519# VSS.t526 sg13_lv_nmos ad=0.2516p pd=2.16u as=0.2516p ps=2.16u w=0.74u l=0.13u
X232 a_8433_1842# a_8237_1842# VDD VDD sg13_lv_pmos ad=0.3808p pd=2.92u as=0.2128p ps=1.5u w=1.12u l=0.13u
X233 VDD a_18443_1842# a_18877_1842# VDD sg13_lv_pmos ad=0.2128p pd=1.5u as=0.3808p ps=2.92u w=1.12u l=0.13u
X234 a_22113_1842# a_21917_1842# VDD VDD sg13_lv_pmos ad=0.3808p pd=2.92u as=0.2128p ps=1.5u w=1.12u l=0.13u
X235 a_4350_1044# a_2019_1047.t9 a_4248_1044# VSS.t528 sg13_lv_nmos ad=0.2516p pd=2.16u as=0.1406p ps=1.12u w=0.74u l=0.13u
X236 a_14888_1044# a_14317_1842# VSS.t480 VSS.t479 sg13_lv_nmos ad=0.1406p pd=1.12u as=0.2516p ps=2.16u w=0.74u l=0.13u
X237 a_16108_289# a_3747_311.t2 a_25630_1044# VSS.t525 sg13_lv_nmos ad=0.2516p pd=2.16u as=0.2516p ps=2.16u w=0.74u l=0.13u
X238 VDD DELAY_VBIASP.t20 a_12471_2470# VDD sg13_lv_pmos ad=0.3808p pd=2.92u as=0.2128p ps=1.5u w=1.12u l=0.6u
X239 VSS.t401 a_4003_1842# a_4437_1842# VSS.t552 sg13_lv_nmos ad=0.1406p pd=1.12u as=0.2516p ps=2.16u w=0.74u l=0.13u
X240 a_16510_1044# a_16484_1008# a_16408_1044# VDD sg13_lv_pmos ad=0.3808p pd=2.92u as=0.2128p ps=1.5u w=1.12u l=0.13u
X241 VDD a_22243_1842# a_22677_1842# VDD sg13_lv_pmos ad=0.2128p pd=1.5u as=0.3808p ps=2.92u w=1.12u l=0.13u
X242 VDD a_3171_1047.t2 a_27124_1008# VDD sg13_lv_pmos ad=0.3808p pd=2.92u as=0.3808p ps=2.92u w=1.12u l=0.13u
X243 VDD MUX_SEL3 a_3449_331# VDD sg13_lv_pmos ad=0.1918p pd=1.5u as=0.1596p ps=1.22u w=0.84u l=0.13u
X244 a_2595_311.t0 a_2297_331# VDD VDD sg13_lv_pmos ad=0.2128p pd=1.5u as=0.1918p ps=1.5u w=1.12u l=0.13u
X245 a_10430_1044# a_11271_1008# a_11195_1044# VDD sg13_lv_pmos ad=0.3808p pd=2.92u as=0.2128p ps=1.5u w=1.12u l=0.13u
X246 a_23355_1044# a_23145_1044# VDD VDD sg13_lv_pmos ad=0.2128p pd=1.5u as=0.252p ps=1.57u w=1.12u l=0.13u
X247 VDD a_3747_1047.t4 a_21911_1008# VDD sg13_lv_pmos ad=0.3808p pd=2.92u as=0.3808p ps=2.92u w=1.12u l=0.13u
X248 VSS.t53 a_8997_1842# a_9465_1044# VSS.t472 sg13_lv_nmos ad=0.1665p pd=1.19u as=0.2516p ps=2.16u w=0.74u l=0.13u
X249 a_20968_1044# a_20397_1842# VDD VDD sg13_lv_pmos ad=0.2128p pd=1.5u as=0.3808p ps=2.92u w=1.12u l=0.13u
X250 a_10951_1842# a_10713_1842# a_10843_1842# VSS.t505 sg13_lv_nmos ad=0.1406p pd=1.12u as=0.2516p ps=2.16u w=0.74u l=0.2u
X251 VSS.t87 a_2019_1047.t5 a_16484_1008# VSS.t86 sg13_lv_nmos ad=0.2516p pd=2.16u as=0.2516p ps=2.16u w=0.74u l=0.13u
X252 a_26151_2470# a_25913_1842# a_26043_1842# VDD sg13_lv_pmos ad=0.2128p pd=1.5u as=0.3808p ps=2.92u w=1.12u l=0.2u
X253 a_13753_1842# a_13557_1842# VDD VDD sg13_lv_pmos ad=0.3808p pd=2.92u as=0.2128p ps=1.5u w=1.12u l=0.13u
X254 VDD a_1721_331# a_2019_311# VDD sg13_lv_pmos ad=0.4256p pd=3u as=0.2128p ps=1.5u w=1.12u l=0.13u
X255 a_4871_2470# a_4633_1842# a_4763_1842# VDD sg13_lv_pmos ad=0.2128p pd=1.5u as=0.3808p ps=2.92u w=1.12u l=0.2u
X256 VSS.t123 a_3171_1047.t9 a_5844_1008# VSS.t122 sg13_lv_nmos ad=0.2516p pd=2.16u as=0.2516p ps=2.16u w=0.74u l=0.13u
X257 VSS.t315 VDD VSS.t313 VSS.t314 sg13_lv_nmos ad=79.8f pd=0.8u as=0 ps=0 w=0.42u l=1u
X258 VDD a_2595_311.t2 a_20905_519# VDD sg13_lv_pmos ad=0.3808p pd=2.92u as=0.3808p ps=2.92u w=1.12u l=0.13u
X259 VDD a_2297_331# a_2595_311.t0 VDD sg13_lv_pmos ad=0.4256p pd=3u as=0.2128p ps=1.5u w=1.12u l=0.13u
X260 VSS.t265 a_2595_1047.t7 a_11271_1008# VSS.t264 sg13_lv_nmos ad=0.2516p pd=2.16u as=0.2516p ps=2.16u w=0.74u l=0.13u
X261 VSS.t461 DELAY_VBIASN.t11 a_19311_1842# VSS.t460 sg13_lv_nmos ad=0.2516p pd=2.16u as=0.1406p ps=1.12u w=0.74u l=0.6u
X262 VDD a_24523_1842# a_24957_1842# VDD sg13_lv_pmos ad=0.2128p pd=1.5u as=0.3808p ps=2.92u w=1.12u l=0.13u
X263 VSS.t120 a_3747_1047.t8 a_9751_1008# VSS.t119 sg13_lv_nmos ad=0.2516p pd=2.16u as=0.2516p ps=2.16u w=0.74u l=0.13u
X264 VSS.t437 DELAY_VBIASN.t24 a_9431_1842# VSS.t436 sg13_lv_nmos ad=0.2516p pd=2.16u as=0.1406p ps=1.12u w=0.74u l=0.6u
X265 a_19448_1044# a_18877_1842# VDD VDD sg13_lv_pmos ad=0.2128p pd=1.5u as=0.3808p ps=2.92u w=1.12u l=0.13u
X266 VSS.t463 DELAY_VBIASN.t6 a_23111_1842# VSS.t462 sg13_lv_nmos ad=0.2516p pd=2.16u as=0.1406p ps=1.12u w=0.74u l=0.6u
X267 a_10430_1044# a_11924_1008# a_11848_1044# VDD sg13_lv_pmos ad=0.3808p pd=2.92u as=0.2128p ps=1.5u w=1.12u l=0.13u
X268 VDD DELAY_VBIASP.t0 a_27671_2470# VDD sg13_lv_pmos ad=0.3808p pd=2.92u as=0.2128p ps=1.5u w=1.12u l=0.6u
X269 a_25630_1044# a_26471_1008# a_26395_1044# VDD sg13_lv_pmos ad=0.3808p pd=2.92u as=0.2128p ps=1.5u w=1.12u l=0.13u
X270 a_7151_2470# a_6913_1842# a_7043_1842# VDD sg13_lv_pmos ad=0.2128p pd=1.5u as=0.3808p ps=2.92u w=1.12u l=0.2u
X271 a_16033_1842# a_15837_1842# VDD VDD sg13_lv_pmos ad=0.3808p pd=2.92u as=0.2128p ps=1.5u w=1.12u l=0.13u
X272 VDD a_15964_289# a_16851_309# VDD sg13_lv_pmos ad=0.2086p pd=1.5u as=0.34p ps=2.68u w=1u l=0.13u
X273 VDD VSS.t576 VDD VDD sg13_lv_pmos ad=0.34p pd=2.68u as=0 ps=0 w=1u l=1u
X274 VSS.t69 a_11603_1842# a_12037_1842# VSS.t68 sg13_lv_nmos ad=0.1406p pd=1.12u as=0.2516p ps=2.16u w=0.74u l=0.13u
X275 VSS.t335 VDD VSS.t333 VSS.t334 sg13_lv_nmos ad=79.8f pd=0.8u as=0 ps=0 w=0.42u l=1u
X276 VDD VSS.t590 VDD VDD sg13_lv_pmos ad=0.34p pd=2.68u as=0 ps=0 w=1u l=1u
X277 VDD a_5957_1842# a_6425_1044# VDD sg13_lv_pmos ad=0.252p pd=1.57u as=0.3808p ps=2.92u w=1.12u l=0.13u
X278 a_24393_1842# a_24197_1842# VSS.t34 VSS.t33 sg13_lv_nmos ad=0.2516p pd=2.16u as=0.1406p ps=1.12u w=0.74u l=0.13u
X279 a_3747_1047.t1 a_3449_1395# VSS.t501 VSS.t531 sg13_lv_nmos ad=0.1406p pd=1.12u as=0.1331p ps=1.12u w=0.74u l=0.13u
X280 a_1544_1044# MUX_SEL1 VSS.t498 VSS.t497 sg13_lv_nmos ad=0.2516p pd=2.16u as=0.2516p ps=2.16u w=0.74u l=0.13u
X281 VDD VSS.t578 VDD VDD sg13_lv_pmos ad=0.34p pd=2.68u as=0 ps=0 w=1u l=1u
X282 a_3171_1047.t0 a_2873_1395# VDD VDD sg13_lv_pmos ad=0.2128p pd=1.5u as=0.1918p ps=1.5u w=1.12u l=0.13u
X283 a_13470_1044# a_3747_1047.t6 a_15755_1044# VSS.t37 sg13_lv_nmos ad=0.2516p pd=2.16u as=0.1406p ps=1.12u w=0.74u l=0.13u
X284 VDD a_5523_1842# a_5957_1842# VDD sg13_lv_pmos ad=0.2128p pd=1.5u as=0.3808p ps=2.92u w=1.12u l=0.13u
X285 VDD a_2297_1395# a_2595_1047.t0 VDD sg13_lv_pmos ad=0.4256p pd=3u as=0.2128p ps=1.5u w=1.12u l=0.13u
X286 VSS.t449 DELAY_VBIASN.t17 a_14751_1842# VSS.t448 sg13_lv_nmos ad=0.2516p pd=2.16u as=0.1406p ps=1.12u w=0.74u l=0.6u
X287 a_2967_1395# MUX_SEL1 a_2873_1395# VSS.t499 sg13_lv_nmos ad=0.1216p pd=1.02u as=0.2176p ps=1.96u w=0.64u l=0.13u
X288 a_4350_1044# a_2595_1047.t9 a_5115_1044# VSS.t257 sg13_lv_nmos ad=0.2516p pd=2.16u as=0.1406p ps=1.12u w=0.74u l=0.13u
X289 VDD a_2019_1047.t6 a_13444_1008# VDD sg13_lv_pmos ad=0.3808p pd=2.92u as=0.3808p ps=2.92u w=1.12u l=0.13u
X290 VSS.t230 a_2595_1047.t2 a_26471_1008# VSS.t229 sg13_lv_nmos ad=0.2516p pd=2.16u as=0.2516p ps=2.16u w=0.74u l=0.13u
X291 a_2595_311.t1 a_2297_331# VSS.t3 VSS.t94 sg13_lv_nmos ad=0.1406p pd=1.12u as=0.1331p ps=1.12u w=0.74u l=0.13u
X292 VSS.t419 DELAY_VBIASN.t31 a_4111_1842# VSS.t418 sg13_lv_nmos ad=0.2516p pd=2.16u as=0.1406p ps=1.12u w=0.74u l=0.6u
X293 a_2297_1395# MUX_SEL0 VDD VDD sg13_lv_pmos ad=0.1596p pd=1.22u as=0.2856p ps=2.36u w=0.84u l=0.13u
X294 VSS.t125 a_16597_1842# a_17065_1044# VSS.t544 sg13_lv_nmos ad=0.1665p pd=1.19u as=0.2516p ps=2.16u w=0.74u l=0.13u
X295 VDD DELAY_VBIASP.t25 a_8671_2470# VDD sg13_lv_pmos ad=0.3808p pd=2.92u as=0.2128p ps=1.5u w=1.12u l=0.6u
X296 VDD VSS.t591 VDD VDD sg13_lv_pmos ad=0.19p pd=1.38u as=0 ps=0 w=1u l=1u
X297 VDD a_1544_1044# a_1721_1395# VDD sg13_lv_pmos ad=0.1918p pd=1.5u as=0.1596p ps=1.22u w=0.84u l=0.13u
X298 a_4248_1044# a_4157_1313# VDD VDD sg13_lv_pmos ad=0.2128p pd=1.5u as=0.3808p ps=2.92u w=1.12u l=0.13u
X299 a_12471_2470# a_12233_1842# a_12363_1842# VDD sg13_lv_pmos ad=0.2128p pd=1.5u as=0.3808p ps=2.92u w=1.12u l=0.2u
X300 a_17031_1842# a_16793_1842# a_16923_1842# VSS.t559 sg13_lv_nmos ad=0.1406p pd=1.12u as=0.2516p ps=2.16u w=0.74u l=0.2u
X301 VSS.t562 a_1721_331# a_2019_311# VSS.t561 sg13_lv_nmos ad=0.2812p pd=2.24u as=0.1406p ps=1.12u w=0.74u l=0.13u
X302 a_19550_1044# a_21911_1008# a_21835_1044# VDD sg13_lv_pmos ad=0.3808p pd=2.92u as=0.2128p ps=1.5u w=1.12u l=0.13u
X303 a_16108_289# a_26985_519# a_25630_1044# VDD sg13_lv_pmos ad=0.3808p pd=2.92u as=0.3808p ps=2.92u w=1.12u l=0.13u
X304 VSS.t96 a_2297_331# a_2595_311.t1 VSS.t95 sg13_lv_nmos ad=0.2812p pd=2.24u as=0.1406p ps=1.12u w=0.74u l=0.13u
X305 a_18795_1044# a_18585_1044# VSS.t238 VSS.t237 sg13_lv_nmos ad=0.1406p pd=1.12u as=0.1665p ps=1.19u w=0.74u l=0.13u
X306 a_20831_1842# a_20593_1842# a_20723_1842# VSS.t404 sg13_lv_nmos ad=0.1406p pd=1.12u as=0.2516p ps=2.16u w=0.74u l=0.2u
X307 VSS.t273 VDD VSS.t272 VSS.t271 sg13_lv_nmos ad=0.1428p pd=1.52u as=0 ps=0 w=0.42u l=1u
X308 VDD a_22677_1842# a_23145_1044# VDD sg13_lv_pmos ad=0.252p pd=1.57u as=0.3808p ps=2.92u w=1.12u l=0.13u
X309 VSS.t537 a_2595_1047.t5 a_17351_1008# VSS.t536 sg13_lv_nmos ad=0.2516p pd=2.16u as=0.2516p ps=2.16u w=0.74u l=0.13u
X310 a_5393_1842# a_5197_1842# VSS.t488 VSS.t487 sg13_lv_nmos ad=0.2516p pd=2.16u as=0.1406p ps=1.12u w=0.74u l=0.13u
X311 VSS.t447 DELAY_VBIASN.t14 a_17031_1842# VSS.t446 sg13_lv_nmos ad=0.2516p pd=2.16u as=0.1406p ps=1.12u w=0.74u l=0.6u
X312 a_25630_1044# a_3171_1047.t2 a_27048_1044# VSS.t16 sg13_lv_nmos ad=0.2516p pd=2.16u as=0.1406p ps=1.12u w=0.74u l=0.13u
X313 a_9953_1842# a_9757_1842# VDD VDD sg13_lv_pmos ad=0.3808p pd=2.92u as=0.2128p ps=1.5u w=1.12u l=0.13u
X314 VDD a_10843_1842# a_11277_1842# VDD sg13_lv_pmos ad=0.2128p pd=1.5u as=0.3808p ps=2.92u w=1.12u l=0.13u
X315 VSS.t206 a_26803_1842# a_27237_1842# VSS.t391 sg13_lv_nmos ad=0.1406p pd=1.12u as=0.2516p ps=2.16u w=0.74u l=0.13u
X316 a_4350_1044# a_3171_1047.t9 a_5768_1044# VSS.t121 sg13_lv_nmos ad=0.2516p pd=2.16u as=0.1406p ps=1.12u w=0.74u l=0.13u
X317 a_10430_1044# a_12791_1008# a_12715_1044# VDD sg13_lv_pmos ad=0.3808p pd=2.92u as=0.2128p ps=1.5u w=1.12u l=0.13u
X318 a_19311_1842# a_19073_1842# a_19203_1842# VSS.t168 sg13_lv_nmos ad=0.1406p pd=1.12u as=0.2516p ps=2.16u w=0.74u l=0.2u
X319 a_24875_1044# a_24665_1044# VDD VDD sg13_lv_pmos ad=0.2128p pd=1.5u as=0.252p ps=1.57u w=1.12u l=0.13u
X320 VDD a_2595_1047.t3 a_23431_1008# VDD sg13_lv_pmos ad=0.3808p pd=2.92u as=0.3808p ps=2.92u w=1.12u l=0.13u
X321 VDD a_13557_1842# a_14025_1044# VDD sg13_lv_pmos ad=0.252p pd=1.57u as=0.3808p ps=2.92u w=1.12u l=0.13u
X322 a_23111_1842# a_22873_1842# a_23003_1842# VSS.t267 sg13_lv_nmos ad=0.1406p pd=1.12u as=0.2516p ps=2.16u w=0.74u l=0.2u
X323 a_27671_2470# a_27433_1842# a_27563_1842# VDD sg13_lv_pmos ad=0.2128p pd=1.5u as=0.3808p ps=2.92u w=1.12u l=0.2u
X324 VSS.t379 a_17683_1842# a_18117_1842# VSS.t496 sg13_lv_nmos ad=0.1406p pd=1.12u as=0.2516p ps=2.16u w=0.74u l=0.13u
X325 VSS.t330 VDD VSS.t328 VSS.t329 sg13_lv_nmos ad=79.8f pd=0.8u as=0 ps=0 w=0.42u l=1u
X326 a_10713_1842# a_10517_1842# VSS.t41 VSS.t493 sg13_lv_nmos ad=0.2516p pd=2.16u as=0.1406p ps=1.12u w=0.74u l=0.13u
X327 VSS.t177 a_2019_1047.t8 a_7364_1008# VSS.t176 sg13_lv_nmos ad=0.2516p pd=2.16u as=0.2516p ps=2.16u w=0.74u l=0.13u
X328 VSS.t188 a_7803_1842# a_8237_1842# VSS.t187 sg13_lv_nmos ad=0.1406p pd=1.12u as=0.2516p ps=2.16u w=0.74u l=0.13u
X329 VDD DELAY_VBIASP.t15 a_16271_2470# VDD sg13_lv_pmos ad=0.3808p pd=2.92u as=0.2128p ps=1.5u w=1.12u l=0.6u
X330 VSS.t325 VDD VSS.t323 VSS.t324 sg13_lv_nmos ad=79.8f pd=0.8u as=0 ps=0 w=0.42u l=1u
X331 VSS.t298 VDD VSS.t297 VSS.t296 sg13_lv_nmos ad=0.1428p pd=1.52u as=0 ps=0 w=0.42u l=1u
X332 VDD a_26043_1842# a_26477_1842# VDD sg13_lv_pmos ad=0.2128p pd=1.5u as=0.3808p ps=2.92u w=1.12u l=0.13u
X333 a_3543_331# MUX_SEL2 a_3449_331# VSS.t197 sg13_lv_nmos ad=0.1216p pd=1.02u as=0.2176p ps=1.96u w=0.64u l=0.13u
X334 a_22488_1044# a_21917_1842# VSS.t202 VSS.t201 sg13_lv_nmos ad=0.1406p pd=1.12u as=0.2516p ps=2.16u w=0.74u l=0.13u
X335 VDD VSS.t593 VDD VDD sg13_lv_pmos ad=0.19p pd=1.38u as=0 ps=0 w=1u l=1u
X336 a_22590_1044# a_24084_1008# a_24008_1044# VDD sg13_lv_pmos ad=0.3808p pd=2.92u as=0.2128p ps=1.5u w=1.12u l=0.13u
X337 VDD DELAY_VBIASP.t10 a_20071_2470# VDD sg13_lv_pmos ad=0.3808p pd=2.92u as=0.2128p ps=1.5u w=1.12u l=0.6u
X338 a_14751_1842# a_14513_1842# a_14643_1842# VSS.t553 sg13_lv_nmos ad=0.1406p pd=1.12u as=0.2516p ps=2.16u w=0.74u l=0.2u
X339 VSS.t110 a_2873_1395# a_3171_1047.t1 VSS.t109 sg13_lv_nmos ad=0.2812p pd=2.24u as=0.1406p ps=1.12u w=0.74u l=0.13u
X340 VDD VSS.t567 VDD VDD sg13_lv_pmos ad=0.19p pd=1.38u as=0 ps=0 w=1u l=1u
X341 a_25630_1044# a_27991_1008# a_27915_1044# VDD sg13_lv_pmos ad=0.3808p pd=2.92u as=0.2128p ps=1.5u w=1.12u l=0.13u
X342 VSS.t369 VSS.t367 VSS.t365 VSS.t368 sg13_lv_nmos ad=0.1406p pd=1.12u as=0 ps=0 w=0.74u l=0.13u
X343 a_4111_1842# DELAY_IN a_4003_1842# VSS.t268 sg13_lv_nmos ad=0.1406p pd=1.12u as=0.2516p ps=2.16u w=0.74u l=0.2u
X344 a_8671_2470# a_8433_1842# a_8563_1842# VDD sg13_lv_pmos ad=0.2128p pd=1.5u as=0.3808p ps=2.92u w=1.12u l=0.2u
X345 a_17553_1842# a_17357_1842# VDD VDD sg13_lv_pmos ad=0.3808p pd=2.92u as=0.2128p ps=1.5u w=1.12u l=0.13u
X346 VSS.t25 a_1544_1044# a_2391_1395# VSS.t24 sg13_lv_nmos ad=0.1331p pd=1.12u as=0.1216p ps=1.02u w=0.64u l=0.13u
X347 VSS.t233 a_3747_311.t3 a_14825_519# VSS.t232 sg13_lv_nmos ad=0.2516p pd=2.16u as=0.2516p ps=2.16u w=0.74u l=0.13u
X348 VSS.t129 a_1256_289# a_2967_331# VSS.t156 sg13_lv_nmos ad=0.1331p pd=1.12u as=0.1216p ps=1.02u w=0.64u l=0.13u
X349 a_2019_1047.t1 a_1721_1395# VSS.t23 VSS.t54 sg13_lv_nmos ad=0.1406p pd=1.12u as=0.1331p ps=1.12u w=0.74u l=0.13u
X350 a_15964_289# a_15765_463# a_5731_289# VSS.t78 sg13_lv_nmos ad=0.2183p pd=1.33u as=0.2516p ps=2.16u w=0.74u l=0.13u
X351 a_13470_1044# a_2019_1047.t6 a_13368_1044# VSS.t88 sg13_lv_nmos ad=0.2516p pd=2.16u as=0.1406p ps=1.12u w=0.74u l=0.13u
X352 VSS.t204 a_13123_1842# a_13557_1842# VSS.t203 sg13_lv_nmos ad=0.1406p pd=1.12u as=0.2516p ps=2.16u w=0.74u l=0.13u
X353 VDD VSS.t566 VDD VDD sg13_lv_pmos ad=0.34p pd=2.68u as=0 ps=0 w=1u l=1u
X354 VSS.t253 a_3171_1047.t3 a_24084_1008# VSS.t252 sg13_lv_nmos ad=0.2516p pd=2.16u as=0.2516p ps=2.16u w=0.74u l=0.13u
X355 a_25913_1842# a_25717_1842# VSS.t51 VSS.t148 sg13_lv_nmos ad=0.2516p pd=2.16u as=0.1406p ps=1.12u w=0.74u l=0.13u
X356 a_21353_1842# a_21157_1842# VDD VDD sg13_lv_pmos ad=0.3808p pd=2.92u as=0.2128p ps=1.5u w=1.12u l=0.13u
X357 VSS.t333 VDD VSS.t332 VSS.t331 sg13_lv_nmos ad=0.1428p pd=1.52u as=0 ps=0 w=0.42u l=1u
X358 a_2297_331# MUX_SEL2 VDD VDD sg13_lv_pmos ad=0.1596p pd=1.22u as=0.2856p ps=2.36u w=0.84u l=0.13u
X359 VDD a_7043_1842# a_7477_1842# VDD sg13_lv_pmos ad=0.2128p pd=1.5u as=0.3808p ps=2.92u w=1.12u l=0.13u
X360 a_2873_331# MUX_SEL3 VDD VDD sg13_lv_pmos ad=0.1596p pd=1.22u as=0.2856p ps=2.36u w=0.84u l=0.13u
X361 a_8155_1044# a_7945_1044# VDD VDD sg13_lv_pmos ad=0.2128p pd=1.5u as=0.252p ps=1.57u w=1.12u l=0.13u
X362 VSS.t238 a_18117_1842# a_18585_1044# VSS.t377 sg13_lv_nmos ad=0.1665p pd=1.19u as=0.2516p ps=2.16u w=0.74u l=0.13u
X363 a_27048_1044# a_26477_1842# VDD VDD sg13_lv_pmos ad=0.2128p pd=1.5u as=0.3808p ps=2.92u w=1.12u l=0.13u
X364 a_5768_1044# a_5197_1842# VDD VDD sg13_lv_pmos ad=0.2128p pd=1.5u as=0.3808p ps=2.92u w=1.12u l=0.13u
X365 a_13991_2470# a_13753_1842# a_13883_1842# VDD sg13_lv_pmos ad=0.2128p pd=1.5u as=0.3808p ps=2.92u w=1.12u l=0.2u
X366 VSS.t250 a_3171_1047.t6 a_14964_1008# VSS.t249 sg13_lv_nmos ad=0.2516p pd=2.16u as=0.2516p ps=2.16u w=0.74u l=0.13u
X367 VDD a_2019_311# a_17865_519# VDD sg13_lv_pmos ad=0.3808p pd=2.92u as=0.3808p ps=2.92u w=1.12u l=0.13u
X368 DELAY_OUT_LAST a_27997_1842# VSS.t403 VSS.t482 sg13_lv_nmos ad=0.2516p pd=2.16u as=0.1406p ps=1.12u w=0.74u l=0.13u
X369 a_11195_1044# a_10985_1044# VSS.t114 VSS.t113 sg13_lv_nmos ad=0.1406p pd=1.12u as=0.1665p ps=1.19u w=0.74u l=0.13u
X370 VDD a_24197_1842# a_24665_1044# VDD sg13_lv_pmos ad=0.252p pd=1.57u as=0.3808p ps=2.92u w=1.12u l=0.13u
X371 a_6913_1842# a_6717_1842# VSS.t67 VSS.t549 sg13_lv_nmos ad=0.2516p pd=2.16u as=0.1406p ps=1.12u w=0.74u l=0.13u
X372 VSS.t457 DELAY_VBIASN.t12 a_18551_1842# VSS.t456 sg13_lv_nmos ad=0.2516p pd=2.16u as=0.1406p ps=1.12u w=0.74u l=0.6u
X373 a_16510_1044# a_18004_1008# a_17928_1044# VDD sg13_lv_pmos ad=0.3808p pd=2.92u as=0.2128p ps=1.5u w=1.12u l=0.13u
X374 VDD a_12363_1842# a_12797_1842# VDD sg13_lv_pmos ad=0.2128p pd=1.5u as=0.3808p ps=2.92u w=1.12u l=0.13u
X375 VSS.t29 MUX_SEL3 a_3543_331# VSS.t390 sg13_lv_nmos ad=0.1331p pd=1.12u as=0.1216p ps=1.02u w=0.64u l=0.13u
X376 a_22590_1044# a_2595_1047.t3 a_23355_1044# VSS.t60 sg13_lv_nmos ad=0.2516p pd=2.16u as=0.1406p ps=1.12u w=0.74u l=0.13u
X377 VSS.t467 DELAY_VBIASN.t7 a_22351_1842# VSS.t466 sg13_lv_nmos ad=0.2516p pd=2.16u as=0.1406p ps=1.12u w=0.74u l=0.6u
X378 VDD a_3171_1047.t4 a_21044_1008# VDD sg13_lv_pmos ad=0.3808p pd=2.92u as=0.3808p ps=2.92u w=1.12u l=0.13u
X379 VDD VSS.t569 VDD VDD sg13_lv_pmos ad=0.19p pd=1.38u as=0 ps=0 w=1u l=1u
X380 a_16271_2470# a_16033_1842# a_16163_1842# VDD sg13_lv_pmos ad=0.2128p pd=1.5u as=0.3808p ps=2.92u w=1.12u l=0.2u
X381 VDD VSS.t583 VDD VDD sg13_lv_pmos ad=0.19p pd=1.38u as=0 ps=0 w=1u l=1u
X382 a_19833_1842# a_19637_1842# VSS.t170 VSS.t180 sg13_lv_nmos ad=0.2516p pd=2.16u as=0.1406p ps=1.12u w=0.74u l=0.13u
X383 VDD a_2019_311# a_5705_519# VDD sg13_lv_pmos ad=0.3808p pd=2.92u as=0.3808p ps=2.92u w=1.12u l=0.13u
X384 a_20071_2470# a_19833_1842# a_19963_1842# VDD sg13_lv_pmos ad=0.2128p pd=1.5u as=0.3808p ps=2.92u w=1.12u l=0.2u
X385 a_9193_1842# a_8997_1842# VSS.t397 VSS.t473 sg13_lv_nmos ad=0.2516p pd=2.16u as=0.1406p ps=1.12u w=0.74u l=0.13u
X386 a_24631_1842# a_24393_1842# a_24523_1842# VSS.t502 sg13_lv_nmos ad=0.1406p pd=1.12u as=0.2516p ps=2.16u w=0.74u l=0.2u
X387 VDD VSS.t582 VDD VDD sg13_lv_pmos ad=0.34p pd=2.68u as=0 ps=0 w=1u l=1u
X388 VSS.t247 a_2019_1047.t7 a_10404_1008# VSS.t246 sg13_lv_nmos ad=0.2516p pd=2.16u as=0.2516p ps=2.16u w=0.74u l=0.13u
X389 VDD a_14643_1842# a_15077_1842# VDD sg13_lv_pmos ad=0.2128p pd=1.5u as=0.3808p ps=2.92u w=1.12u l=0.13u
X390 VDD a_1544_289# a_2297_331# VDD sg13_lv_pmos ad=0.1918p pd=1.5u as=0.1596p ps=1.22u w=0.84u l=0.13u
X391 a_23633_1842# a_23437_1842# VSS.t551 VSS.t557 sg13_lv_nmos ad=0.2516p pd=2.16u as=0.1406p ps=1.12u w=0.74u l=0.13u
X392 VSS.t328 VDD VSS.t327 VSS.t326 sg13_lv_nmos ad=0.1428p pd=1.52u as=0 ps=0 w=0.42u l=1u
X393 a_2019_311# a_1721_331# VDD VDD sg13_lv_pmos ad=0.2128p pd=1.5u as=0.1918p ps=1.5u w=1.12u l=0.13u
X394 VSS.t491 a_9323_1842# a_9757_1842# VSS.t490 sg13_lv_nmos ad=0.1406p pd=1.12u as=0.2516p ps=2.16u w=0.74u l=0.13u
X395 a_26395_1044# a_26185_1044# VSS.t150 VSS.t227 sg13_lv_nmos ad=0.1406p pd=1.12u as=0.1665p ps=1.19u w=0.74u l=0.13u
X396 VDD DELAY_VBIASP.t13 a_17791_2470# VDD sg13_lv_pmos ad=0.3808p pd=2.92u as=0.2128p ps=1.5u w=1.12u l=0.6u
X397 VSS.t72 a_3747_1047.t3 a_24951_1008# VSS.t71 sg13_lv_nmos ad=0.2516p pd=2.16u as=0.2516p ps=2.16u w=0.74u l=0.13u
X398 VSS.t293 VDD VSS.t292 VSS.t291 sg13_lv_nmos ad=0.1428p pd=1.52u as=0 ps=0 w=0.42u l=1u
X399 VSS.t323 VDD VSS.t322 VSS.t321 sg13_lv_nmos ad=0.1428p pd=1.52u as=0 ps=0 w=0.42u l=1u
X400 a_3747_1047.t0 a_3449_1395# VDD VDD sg13_lv_pmos ad=0.2128p pd=1.5u as=0.1918p ps=1.5u w=1.12u l=0.13u
X401 a_13368_1044# a_12797_1842# VDD VDD sg13_lv_pmos ad=0.2128p pd=1.5u as=0.3808p ps=2.92u w=1.12u l=0.13u
X402 a_24008_1044# a_23437_1842# VSS.t556 VSS.t555 sg13_lv_nmos ad=0.1406p pd=1.12u as=0.2516p ps=2.16u w=0.74u l=0.13u
X403 VDD DELAY_VBIASP.t8 a_21591_2470# VDD sg13_lv_pmos ad=0.3808p pd=2.92u as=0.2128p ps=1.5u w=1.12u l=0.6u
X404 a_15964_289# MUX_SEL4 a_5731_289# VDD sg13_lv_pmos ad=0.3304p pd=1.71u as=0.3808p ps=2.92u w=1.12u l=0.13u
X405 a_4350_1044# a_6711_1008# a_6635_1044# VDD sg13_lv_pmos ad=0.3808p pd=2.92u as=0.2128p ps=1.5u w=1.12u l=0.13u
X406 a_2873_1395# MUX_SEL1 VDD VDD sg13_lv_pmos ad=0.1596p pd=1.22u as=0.2856p ps=2.36u w=0.84u l=0.13u
X407 a_1256_1044# MUX_SEL0 VSS.t475 VSS.t474 sg13_lv_nmos ad=0.2516p pd=2.16u as=0.2516p ps=2.16u w=0.74u l=0.13u
X408 VSS.t290 VDD VSS.t288 VSS.t289 sg13_lv_nmos ad=79.8f pd=0.8u as=0 ps=0 w=0.42u l=1u
X409 a_19550_1044# a_20391_1008# a_20315_1044# VDD sg13_lv_pmos ad=0.3808p pd=2.92u as=0.2128p ps=1.5u w=1.12u l=0.13u
X410 VDD VDD VDD VDD sg13_lv_pmos ad=0.2128p pd=1.5u as=0 ps=0 w=1.12u l=0.2u
X411 a_5631_1842# a_5393_1842# a_5523_1842# VSS.t384 sg13_lv_nmos ad=0.1406p pd=1.12u as=0.2516p ps=2.16u w=0.74u l=0.2u
X412 a_14513_1842# a_14317_1842# VSS.t382 VSS.t481 sg13_lv_nmos ad=0.2516p pd=2.16u as=0.1406p ps=1.12u w=0.74u l=0.13u
X413 VSS.t15 a_2595_311.t2 a_20905_519# VSS.t14 sg13_lv_nmos ad=0.2516p pd=2.16u as=0.2516p ps=2.16u w=0.74u l=0.13u
X414 VDD a_7477_1842# a_7945_1044# VDD sg13_lv_pmos ad=0.252p pd=1.57u as=0.3808p ps=2.92u w=1.12u l=0.13u
X415 a_13470_1044# a_3171_1047.t6 a_14888_1044# VSS.t248 sg13_lv_nmos ad=0.2516p pd=2.16u as=0.1406p ps=1.12u w=0.74u l=0.13u
X416 a_4633_1842# a_4437_1842# VSS.t401 VSS.t400 sg13_lv_nmos ad=0.2516p pd=2.16u as=0.1406p ps=1.12u w=0.74u l=0.13u
X417 a_1256_289# MUX_SEL2 VSS.t195 VSS.t194 sg13_lv_nmos ad=0.2516p pd=2.16u as=0.2516p ps=2.16u w=0.74u l=0.13u
X418 VSS.t241 a_2019_1047.t2 a_25604_1008# VSS.t240 sg13_lv_nmos ad=0.2516p pd=2.16u as=0.2516p ps=2.16u w=0.74u l=0.13u
X419 a_16108_289# MUX_SEL4 a_15964_289# VSS.t42 sg13_lv_nmos ad=0.2516p pd=2.16u as=0.2183p ps=1.33u w=0.74u l=0.13u
X420 a_22873_1842# a_22677_1842# VDD VDD sg13_lv_pmos ad=0.3808p pd=2.92u as=0.2128p ps=1.5u w=1.12u l=0.13u
X421 a_21835_1044# a_21625_1044# VSS.t127 VSS.t126 sg13_lv_nmos ad=0.1406p pd=1.12u as=0.1665p ps=1.19u w=0.74u l=0.13u
X422 VSS.t21 a_2595_1047.t4 a_20391_1008# VSS.t20 sg13_lv_nmos ad=0.2516p pd=2.16u as=0.2516p ps=2.16u w=0.74u l=0.13u
X423 a_9675_1044# a_9465_1044# VDD VDD sg13_lv_pmos ad=0.2128p pd=1.5u as=0.252p ps=1.57u w=1.12u l=0.13u
X424 VSS.t114 a_10517_1842# a_10985_1044# VSS.t492 sg13_lv_nmos ad=0.1665p pd=1.19u as=0.2516p ps=2.16u w=0.74u l=0.13u
X425 VDD a_2595_1047.t8 a_8231_1008# VDD sg13_lv_pmos ad=0.3808p pd=2.92u as=0.3808p ps=2.92u w=1.12u l=0.13u
X426 a_18551_1842# a_18313_1842# a_18443_1842# VSS.t266 sg13_lv_nmos ad=0.1406p pd=1.12u as=0.2516p ps=2.16u w=0.74u l=0.2u
X427 a_22351_1842# a_22113_1842# a_22243_1842# VSS.t506 sg13_lv_nmos ad=0.1406p pd=1.12u as=0.2516p ps=2.16u w=0.74u l=0.2u
X428 VSS.t173 a_3747_1047.t5 a_18871_1008# VSS.t172 sg13_lv_nmos ad=0.2516p pd=2.16u as=0.2516p ps=2.16u w=0.74u l=0.13u
X429 VSS.t48 a_16923_1842# a_17357_1842# VSS.t392 sg13_lv_nmos ad=0.1406p pd=1.12u as=0.2516p ps=2.16u w=0.74u l=0.13u
X430 VDD a_3171_311.t2 a_23945_519# VDD sg13_lv_pmos ad=0.3808p pd=2.92u as=0.3808p ps=2.92u w=1.12u l=0.13u
X431 a_2019_311# a_1721_331# VSS.t1 VSS.t560 sg13_lv_nmos ad=0.1406p pd=1.12u as=0.1331p ps=1.12u w=0.74u l=0.13u
X432 a_25153_1842# a_24957_1842# VDD VDD sg13_lv_pmos ad=0.3808p pd=2.92u as=0.2128p ps=1.5u w=1.12u l=0.13u
X433 a_17928_1044# a_17357_1842# VSS.t46 VSS.t45 sg13_lv_nmos ad=0.1406p pd=1.12u as=0.2516p ps=2.16u w=0.74u l=0.13u
X434 a_12715_1044# a_12505_1044# VSS.t99 VSS.t226 sg13_lv_nmos ad=0.1406p pd=1.12u as=0.1665p ps=1.19u w=0.74u l=0.13u
X435 VDD MUX_SEL4 a_15765_463# VDD sg13_lv_pmos ad=0.3808p pd=2.92u as=0.3808p ps=2.92u w=1.12u l=0.13u
X436 a_19550_1044# a_3171_1047.t4 a_20968_1044# VSS.t115 sg13_lv_nmos ad=0.2516p pd=2.16u as=0.1406p ps=1.12u w=0.74u l=0.13u
X437 VSS.t413 DELAY_VBIASN.t22 a_10951_1842# VSS.t412 sg13_lv_nmos ad=0.2516p pd=2.16u as=0.1406p ps=1.12u w=0.74u l=0.6u
X438 a_19550_1044# a_19524_1008# a_19448_1044# VDD sg13_lv_pmos ad=0.3808p pd=2.92u as=0.2128p ps=1.5u w=1.12u l=0.13u
X439 a_7288_1044# a_6717_1842# VSS.t548 VSS.t547 sg13_lv_nmos ad=0.1406p pd=1.12u as=0.2516p ps=2.16u w=0.74u l=0.13u
X440 VSS.t395 a_20723_1842# a_21157_1842# VSS.t394 sg13_lv_nmos ad=0.1406p pd=1.12u as=0.2516p ps=2.16u w=0.74u l=0.13u
X441 a_1544_289# MUX_SEL3 VSS.t388 VSS.t387 sg13_lv_nmos ad=0.2516p pd=2.16u as=0.2516p ps=2.16u w=0.74u l=0.13u
X442 a_13470_1044# a_14311_1008# a_14235_1044# VDD sg13_lv_pmos ad=0.3808p pd=2.92u as=0.2128p ps=1.5u w=1.12u l=0.13u
X443 a_22590_1044# a_3747_1047.t3 a_24875_1044# VSS.t70 sg13_lv_nmos ad=0.2516p pd=2.16u as=0.1406p ps=1.12u w=0.74u l=0.13u
X444 VSS.t469 DELAY_VBIASN.t5 a_23871_1842# VSS.t468 sg13_lv_nmos ad=0.2516p pd=2.16u as=0.1406p ps=1.12u w=0.74u l=0.6u
X445 VDD a_2019_1047.t3 a_22564_1008# VDD sg13_lv_pmos ad=0.3808p pd=2.92u as=0.3808p ps=2.92u w=1.12u l=0.13u
X446 VSS.t150 a_25717_1842# a_26185_1044# VSS.t149 sg13_lv_nmos ad=0.1665p pd=1.19u as=0.2516p ps=2.16u w=0.74u l=0.13u
X447 a_13231_1842# a_12993_1842# a_13123_1842# VSS.t385 sg13_lv_nmos ad=0.1406p pd=1.12u as=0.2516p ps=2.16u w=0.74u l=0.2u
X448 VSS.t285 VDD VSS.t283 VSS.t284 sg13_lv_nmos ad=79.8f pd=0.8u as=0 ps=0 w=0.42u l=1u
X449 a_17791_2470# a_17553_1842# a_17683_1842# VDD sg13_lv_pmos ad=0.2128p pd=1.5u as=0.3808p ps=2.92u w=1.12u l=0.2u
X450 VSS.t225 a_4437_1842# a_4905_1044# VSS.t399 sg13_lv_nmos ad=0.1665p pd=1.19u as=0.2516p ps=2.16u w=0.74u l=0.13u
X451 VDD VSS.t570 VDD VDD sg13_lv_pmos ad=0.34p pd=2.68u as=0 ps=0 w=1u l=1u
X452 a_12233_1842# a_12037_1842# VSS.t69 VSS.t97 sg13_lv_nmos ad=0.2516p pd=2.16u as=0.1406p ps=1.12u w=0.74u l=0.13u
X453 VSS.t533 a_3449_1395# a_3747_1047.t1 VSS.t532 sg13_lv_nmos ad=0.2812p pd=2.24u as=0.1406p ps=1.12u w=0.74u l=0.13u
X454 VDD VSS.t584 VDD VDD sg13_lv_pmos ad=0.34p pd=2.68u as=0 ps=0 w=1u l=1u
X455 VDD VSS.t579 VDD VDD sg13_lv_pmos ad=0.19p pd=1.38u as=0 ps=0 w=1u l=1u
X456 VSS.t350 VDD VSS.t348 VSS.t349 sg13_lv_nmos ad=79.8f pd=0.8u as=0 ps=0 w=0.42u l=1u
X457 VSS.t84 a_3171_1047.t8 a_8884_1008# VSS.t83 sg13_lv_nmos ad=0.2516p pd=2.16u as=0.2516p ps=2.16u w=0.74u l=0.13u
X458 a_21591_2470# a_21353_1842# a_21483_1842# VDD sg13_lv_pmos ad=0.2128p pd=1.5u as=0.3808p ps=2.92u w=1.12u l=0.2u
X459 VDD a_2873_1395# a_3171_1047.t0 VDD sg13_lv_pmos ad=0.4256p pd=3u as=0.2128p ps=1.5u w=1.12u l=0.13u
X460 a_6153_1842# a_5957_1842# VDD VDD sg13_lv_pmos ad=0.3808p pd=2.92u as=0.2128p ps=1.5u w=1.12u l=0.13u
X461 VDD a_16163_1842# a_16597_1842# VDD sg13_lv_pmos ad=0.2128p pd=1.5u as=0.3808p ps=2.92u w=1.12u l=0.13u
X462 a_3543_1395# MUX_SEL0 a_3449_1395# VSS.t477 sg13_lv_nmos ad=0.1216p pd=1.02u as=0.2176p ps=1.96u w=0.64u l=0.13u
X463 VDD a_1544_1044# a_2297_1395# VDD sg13_lv_pmos ad=0.1918p pd=1.5u as=0.1596p ps=1.22u w=0.84u l=0.13u
X464 VDD DELAY_VBIASP.t23 a_10191_2470# VDD sg13_lv_pmos ad=0.3808p pd=2.92u as=0.2128p ps=1.5u w=1.12u l=0.6u
X465 a_17275_1044# a_17065_1044# VDD VDD sg13_lv_pmos ad=0.2128p pd=1.5u as=0.252p ps=1.57u w=1.12u l=0.13u
X466 a_2019_1047.t0 a_1721_1395# VDD VDD sg13_lv_pmos ad=0.2128p pd=1.5u as=0.1918p ps=1.5u w=1.12u l=0.13u
X467 a_27915_1044# a_27705_1044# VSS.t27 VSS.t26 sg13_lv_nmos ad=0.1406p pd=1.12u as=0.1665p ps=1.19u w=0.74u l=0.13u
X468 VSS.t421 DELAY_VBIASN.t2 a_26151_1842# VSS.t420 sg13_lv_nmos ad=0.2516p pd=2.16u as=0.1406p ps=1.12u w=0.74u l=0.6u
X469 VDD a_3747_1047.t6 a_15831_1008# VDD sg13_lv_pmos ad=0.3808p pd=2.92u as=0.3808p ps=2.92u w=1.12u l=0.13u
X470 VDD a_19963_1842# a_20397_1842# VDD sg13_lv_pmos ad=0.2128p pd=1.5u as=0.3808p ps=2.92u w=1.12u l=0.13u
X471 VSS.t353 VDD VSS.t352 VSS.t351 sg13_lv_nmos ad=0.1428p pd=1.52u as=0 ps=0 w=0.42u l=1u
X472 VSS.t429 DELAY_VBIASN.t30 a_4871_1842# VSS.t428 sg13_lv_nmos ad=0.2516p pd=2.16u as=0.1406p ps=1.12u w=0.74u l=0.6u
X473 a_14888_1044# a_14317_1842# VDD VDD sg13_lv_pmos ad=0.2128p pd=1.5u as=0.3808p ps=2.92u w=1.12u l=0.13u
X474 a_4350_1044# a_4324_1008# a_4248_1044# VDD sg13_lv_pmos ad=0.3808p pd=2.92u as=0.2128p ps=1.5u w=1.12u l=0.13u
X475 a_1256_289# MUX_SEL2 VDD VDD sg13_lv_pmos ad=0.3808p pd=2.92u as=0.3808p ps=2.92u w=1.12u l=0.13u
X476 VSS.t373 VSS.t370 VSS.t372 VSS.t371 sg13_lv_nmos ad=0.2516p pd=2.16u as=0 ps=0 w=0.74u l=0.6u
X477 a_16108_289# a_15765_463# a_15964_289# VDD sg13_lv_pmos ad=0.3808p pd=2.92u as=0.3304p ps=1.71u w=1.12u l=0.13u
X478 a_11473_1842# a_11277_1842# VDD VDD sg13_lv_pmos ad=0.3808p pd=2.92u as=0.2128p ps=1.5u w=1.12u l=0.13u
X479 VDD a_8997_1842# a_9465_1044# VDD sg13_lv_pmos ad=0.252p pd=1.57u as=0.3808p ps=2.92u w=1.12u l=0.13u
X480 a_27433_1842# a_27237_1842# VSS.t206 VSS.t205 sg13_lv_nmos ad=0.2516p pd=2.16u as=0.1406p ps=1.12u w=0.74u l=0.13u
X481 a_2391_331# MUX_SEL2 a_2297_331# VSS.t196 sg13_lv_nmos ad=0.1216p pd=1.02u as=0.2176p ps=1.96u w=0.64u l=0.13u
X482 a_2967_331# MUX_SEL3 a_2873_331# VSS.t389 sg13_lv_nmos ad=0.1216p pd=1.02u as=0.2176p ps=1.96u w=0.64u l=0.13u
X483 VDD a_2019_1047.t5 a_16484_1008# VDD sg13_lv_pmos ad=0.3808p pd=2.92u as=0.3808p ps=2.92u w=1.12u l=0.13u
X484 a_7390_1044# a_2595_1047.t8 a_8155_1044# VSS.t538 sg13_lv_nmos ad=0.2516p pd=2.16u as=0.1406p ps=1.12u w=0.74u l=0.13u
X485 VSS.t431 DELAY_VBIASN.t27 a_7151_1842# VSS.t430 sg13_lv_nmos ad=0.2516p pd=2.16u as=0.1406p ps=1.12u w=0.74u l=0.6u
X486 VDD a_3171_1047.t9 a_5844_1008# VDD sg13_lv_pmos ad=0.3808p pd=2.92u as=0.3808p ps=2.92u w=1.12u l=0.13u
X487 VDD DELAY_VBIASP.t3 a_25391_2470# VDD sg13_lv_pmos ad=0.3808p pd=2.92u as=0.2128p ps=1.5u w=1.12u l=0.6u
X488 VDD a_2595_1047.t7 a_11271_1008# VDD sg13_lv_pmos ad=0.3808p pd=2.92u as=0.3808p ps=2.92u w=1.12u l=0.13u
X489 VDD VSS.t587 VDD VDD sg13_lv_pmos ad=0.19p pd=1.38u as=0 ps=0 w=1u l=1u
X490 VSS.t99 a_12037_1842# a_12505_1044# VSS.t98 sg13_lv_nmos ad=0.1665p pd=1.19u as=0.2516p ps=2.16u w=0.74u l=0.13u
X491 VDD a_3747_1047.t8 a_9751_1008# VDD sg13_lv_pmos ad=0.3808p pd=2.92u as=0.3808p ps=2.92u w=1.12u l=0.13u
X492 a_9431_1842# a_9193_1842# a_9323_1842# VSS.t386 sg13_lv_nmos ad=0.1406p pd=1.12u as=0.2516p ps=2.16u w=0.74u l=0.2u
X493 a_18313_1842# a_18117_1842# VSS.t379 VSS.t378 sg13_lv_nmos ad=0.2516p pd=2.16u as=0.1406p ps=1.12u w=0.74u l=0.13u
X494 MUX_OUT a_16851_309# VSS.t139 VSS.t138 sg13_lv_nmos ad=0.1406p pd=1.12u as=0.1371p ps=1.12u w=0.74u l=0.13u
X495 VSS.t345 VDD VSS.t343 VSS.t344 sg13_lv_nmos ad=79.8f pd=0.8u as=0 ps=0 w=0.42u l=1u
X496 a_23871_1842# a_23633_1842# a_23763_1842# VSS.t508 sg13_lv_nmos ad=0.1406p pd=1.12u as=0.2516p ps=2.16u w=0.74u l=0.2u
X497 a_8433_1842# a_8237_1842# VSS.t188 VSS.t407 sg13_lv_nmos ad=0.2516p pd=2.16u as=0.1406p ps=1.12u w=0.74u l=0.13u
X498 VSS.t162 a_18443_1842# a_18877_1842# VSS.t161 sg13_lv_nmos ad=0.1406p pd=1.12u as=0.2516p ps=2.16u w=0.74u l=0.13u
X499 VSS.t310 VDD VSS.t308 VSS.t309 sg13_lv_nmos ad=79.8f pd=0.8u as=0 ps=0 w=0.42u l=1u
X500 a_22113_1842# a_21917_1842# VSS.t200 VSS.t199 sg13_lv_nmos ad=0.2516p pd=2.16u as=0.1406p ps=1.12u w=0.74u l=0.13u
X501 a_1544_289# MUX_SEL3 VDD VDD sg13_lv_pmos ad=0.3808p pd=2.92u as=0.3808p ps=2.92u w=1.12u l=0.13u
X502 a_26673_1842# a_26477_1842# VDD VDD sg13_lv_pmos ad=0.3808p pd=2.92u as=0.2128p ps=1.5u w=1.12u l=0.13u
X503 a_10328_1044# a_9757_1842# VSS.t514 VSS.t513 sg13_lv_nmos ad=0.1406p pd=1.12u as=0.2516p ps=2.16u w=0.74u l=0.13u
X504 VSS.t313 VDD VSS.t312 VSS.t311 sg13_lv_nmos ad=0.1428p pd=1.52u as=0 ps=0 w=0.42u l=1u
X505 a_22590_1044# a_2019_1047.t3 a_22488_1044# VSS.t91 sg13_lv_nmos ad=0.2516p pd=2.16u as=0.1406p ps=1.12u w=0.74u l=0.13u
X506 VSS.t409 DELAY_VBIASN.t20 a_12471_1842# VSS.t408 sg13_lv_nmos ad=0.2516p pd=2.16u as=0.1406p ps=1.12u w=0.74u l=0.6u
X507 a_8808_1044# a_8237_1842# VSS.t406 VSS.t405 sg13_lv_nmos ad=0.1406p pd=1.12u as=0.2516p ps=2.16u w=0.74u l=0.13u
X508 VSS.t145 a_22243_1842# a_22677_1842# VSS.t154 sg13_lv_nmos ad=0.1406p pd=1.12u as=0.2516p ps=2.16u w=0.74u l=0.13u
X509 VDD DELAY_VBIASP.t28 a_6391_2470# VDD sg13_lv_pmos ad=0.3808p pd=2.92u as=0.2128p ps=1.5u w=1.12u l=0.6u
X510 a_13470_1044# a_15831_1008# a_15755_1044# VDD sg13_lv_pmos ad=0.3808p pd=2.92u as=0.2128p ps=1.5u w=1.12u l=0.13u
X511 a_1544_1044# MUX_SEL1 VDD VDD sg13_lv_pmos ad=0.3808p pd=2.92u as=0.3808p ps=2.92u w=1.12u l=0.13u
X512 VDD DELAY_VBIASP.t9 a_20831_2470# VDD sg13_lv_pmos ad=0.3808p pd=2.92u as=0.2128p ps=1.5u w=1.12u l=0.6u
X513 VDD a_2595_1047.t2 a_26471_1008# VDD sg13_lv_pmos ad=0.3808p pd=2.92u as=0.3808p ps=2.92u w=1.12u l=0.13u
X514 a_4350_1044# a_5191_1008# a_5115_1044# VDD sg13_lv_pmos ad=0.3808p pd=2.92u as=0.2128p ps=1.5u w=1.12u l=0.13u
X515 VDD a_16597_1842# a_17065_1044# VDD sg13_lv_pmos ad=0.252p pd=1.57u as=0.3808p ps=2.92u w=1.12u l=0.13u
X516 VSS.t27 a_27237_1842# a_27705_1044# VSS.t207 sg13_lv_nmos ad=0.1665p pd=1.19u as=0.2516p ps=2.16u w=0.74u l=0.13u
X517 a_10191_2470# a_9953_1842# a_10083_1842# VDD sg13_lv_pmos ad=0.2128p pd=1.5u as=0.3808p ps=2.92u w=1.12u l=0.2u
X518 a_2595_1047.t1 a_2297_1395# VSS.t25 VSS.t221 sg13_lv_nmos ad=0.1406p pd=1.12u as=0.1331p ps=1.12u w=0.74u l=0.13u
X519 a_26151_1842# a_25913_1842# a_26043_1842# VSS.t49 sg13_lv_nmos ad=0.1406p pd=1.12u as=0.2516p ps=2.16u w=0.74u l=0.2u
X520 VSS.t137 a_2019_311# a_17865_519# VSS.t136 sg13_lv_nmos ad=0.2516p pd=2.16u as=0.2516p ps=2.16u w=0.74u l=0.13u
X521 VSS.t3 a_1544_289# a_2391_331# VSS.t2 sg13_lv_nmos ad=0.1331p pd=1.12u as=0.1216p ps=1.02u w=0.64u l=0.13u
X522 a_4871_1842# a_4633_1842# a_4763_1842# VSS.t512 sg13_lv_nmos ad=0.1406p pd=1.12u as=0.2516p ps=2.16u w=0.74u l=0.2u
X523 a_13753_1842# a_13557_1842# VSS.t204 VSS.t215 sg13_lv_nmos ad=0.2516p pd=2.16u as=0.1406p ps=1.12u w=0.74u l=0.13u
X524 a_1815_1395# a_1256_1044# a_1721_1395# VSS.t234 sg13_lv_nmos ad=0.1216p pd=1.02u as=0.2176p ps=1.96u w=0.64u l=0.13u
X525 a_7673_1842# a_7477_1842# VDD VDD sg13_lv_pmos ad=0.3808p pd=2.92u as=0.2128p ps=1.5u w=1.12u l=0.13u
X526 VDD VSS.t580 VDD VDD sg13_lv_pmos ad=0.34p pd=2.68u as=0 ps=0 w=1u l=1u
X527 a_1721_331# a_1256_289# VDD VDD sg13_lv_pmos ad=0.1596p pd=1.22u as=0.2856p ps=2.36u w=0.84u l=0.13u
X528 VSS.t147 a_24523_1842# a_24957_1842# VSS.t146 sg13_lv_nmos ad=0.1406p pd=1.12u as=0.2516p ps=2.16u w=0.74u l=0.13u
X529 a_6635_1044# a_6425_1044# VSS.t210 VSS.t236 sg13_lv_nmos ad=0.1406p pd=1.12u as=0.1665p ps=1.19u w=0.74u l=0.13u
X530 VSS.t259 a_2595_1047.t9 a_5191_1008# VSS.t258 sg13_lv_nmos ad=0.2516p pd=2.16u as=0.2516p ps=2.16u w=0.74u l=0.13u
X531 a_20315_1044# a_20105_1044# VSS.t179 VSS.t541 sg13_lv_nmos ad=0.1406p pd=1.12u as=0.1665p ps=1.19u w=0.74u l=0.13u
X532 VDD DELAY_VBIASP.t21 a_11711_2470# VDD sg13_lv_pmos ad=0.3808p pd=2.92u as=0.2128p ps=1.5u w=1.12u l=0.6u
X533 a_18795_1044# a_18585_1044# VDD VDD sg13_lv_pmos ad=0.2128p pd=1.5u as=0.252p ps=1.57u w=1.12u l=0.13u
X534 a_25528_1044# a_24957_1842# VSS.t510 VSS.t509 sg13_lv_nmos ad=0.1406p pd=1.12u as=0.2516p ps=2.16u w=0.74u l=0.13u
X535 VSS.t471 DELAY_VBIASN.t0 a_27671_1842# VSS.t470 sg13_lv_nmos ad=0.2516p pd=2.16u as=0.1406p ps=1.12u w=0.74u l=0.6u
X536 a_5731_289# a_3747_311.t3 a_13470_1044# VSS.t231 sg13_lv_nmos ad=0.2516p pd=2.16u as=0.2516p ps=2.16u w=0.74u l=0.13u
X537 a_25630_1044# a_27124_1008# a_27048_1044# VDD sg13_lv_pmos ad=0.3808p pd=2.92u as=0.2128p ps=1.5u w=1.12u l=0.13u
X538 VDD a_2595_1047.t5 a_17351_1008# VDD sg13_lv_pmos ad=0.3808p pd=2.92u as=0.3808p ps=2.92u w=1.12u l=0.13u
X539 VDD a_21483_1842# a_21917_1842# VDD sg13_lv_pmos ad=0.2128p pd=1.5u as=0.3808p ps=2.92u w=1.12u l=0.13u
X540 a_4350_1044# a_5844_1008# a_5768_1044# VDD sg13_lv_pmos ad=0.3808p pd=2.92u as=0.2128p ps=1.5u w=1.12u l=0.13u
X541 VSS.t141 a_16851_309# MUX_OUT VSS.t140 sg13_lv_nmos ad=0.2516p pd=2.16u as=0.1406p ps=1.12u w=0.74u l=0.13u
X542 VSS.t134 a_2019_311# a_5705_519# VSS.t133 sg13_lv_nmos ad=0.2516p pd=2.16u as=0.2516p ps=2.16u w=0.74u l=0.13u
X543 VDD a_1544_289# a_1721_331# VDD sg13_lv_pmos ad=0.1918p pd=1.5u as=0.1596p ps=1.22u w=0.84u l=0.13u
X544 a_7151_1842# a_6913_1842# a_7043_1842# VSS.t362 sg13_lv_nmos ad=0.1406p pd=1.12u as=0.2516p ps=2.16u w=0.74u l=0.2u
X545 a_16033_1842# a_15837_1842# VSS.t101 VSS.t213 sg13_lv_nmos ad=0.2516p pd=2.16u as=0.1406p ps=1.12u w=0.74u l=0.13u
X546 MUX_OUT a_16851_309# VDD VDD sg13_lv_pmos ad=0.2128p pd=1.5u as=0.2086p ps=1.5u w=1.12u l=0.13u
X547 a_25391_2470# a_25153_1842# a_25283_1842# VDD sg13_lv_pmos ad=0.2128p pd=1.5u as=0.3808p ps=2.92u w=1.12u l=0.2u
X548 VDD VSS.t592 VDD VDD sg13_lv_pmos ad=0.34p pd=2.68u as=0 ps=0 w=1u l=1u
X549 a_12993_1842# a_12797_1842# VDD VDD sg13_lv_pmos ad=0.3808p pd=2.92u as=0.2128p ps=1.5u w=1.12u l=0.13u
X550 a_16408_1044# a_15837_1842# VSS.t212 VSS.t211 sg13_lv_nmos ad=0.1406p pd=1.12u as=0.2516p ps=2.16u w=0.74u l=0.13u
X551 VSS.t190 a_5523_1842# a_5957_1842# VSS.t189 sg13_lv_nmos ad=0.1406p pd=1.12u as=0.2516p ps=2.16u w=0.74u l=0.13u
X552 VDD DELAY_VBIASP.t18 a_13991_2470# VDD sg13_lv_pmos ad=0.3808p pd=2.92u as=0.2128p ps=1.5u w=1.12u l=0.6u
X553 a_5731_289# a_2019_311# a_4350_1044# VSS.t132 sg13_lv_nmos ad=0.2516p pd=2.16u as=0.2516p ps=2.16u w=0.74u l=0.13u
X554 a_7390_1044# a_3747_1047.t8 a_9675_1044# VSS.t118 sg13_lv_nmos ad=0.2516p pd=2.16u as=0.1406p ps=1.12u w=0.74u l=0.13u
X555 VDD a_23763_1842# a_24197_1842# VDD sg13_lv_pmos ad=0.2128p pd=1.5u as=0.3808p ps=2.92u w=1.12u l=0.13u
X556 VSS.t435 DELAY_VBIASN.t25 a_8671_1842# VSS.t434 sg13_lv_nmos ad=0.2516p pd=2.16u as=0.1406p ps=1.12u w=0.74u l=0.6u
X557 VDD a_2019_1047.t8 a_7364_1008# VDD sg13_lv_pmos ad=0.3808p pd=2.92u as=0.3808p ps=2.92u w=1.12u l=0.13u
X558 VDD DELAY_VBIASP.t1 a_26911_2470# VDD sg13_lv_pmos ad=0.3808p pd=2.92u as=0.2128p ps=1.5u w=1.12u l=0.6u
X559 VDD VSS.t563 VDD VDD sg13_lv_pmos ad=0.19p pd=1.38u as=0 ps=0 w=1u l=1u
X560 a_12471_1842# a_12233_1842# a_12363_1842# VSS.t214 sg13_lv_nmos ad=0.1406p pd=1.12u as=0.2516p ps=2.16u w=0.74u l=0.2u
X561 a_22488_1044# a_21917_1842# VDD VDD sg13_lv_pmos ad=0.2128p pd=1.5u as=0.3808p ps=2.92u w=1.12u l=0.13u
X562 VDD a_2595_311.t3 a_8745_519# VDD sg13_lv_pmos ad=0.3808p pd=2.92u as=0.3808p ps=2.92u w=1.12u l=0.13u
X563 VSS.t81 a_3171_1047.t5 a_18004_1008# VSS.t80 sg13_lv_nmos ad=0.2516p pd=2.16u as=0.2516p ps=2.16u w=0.74u l=0.13u
X564 a_6391_2470# a_6153_1842# a_6283_1842# VDD sg13_lv_pmos ad=0.2128p pd=1.5u as=0.3808p ps=2.92u w=1.12u l=0.2u
X565 a_15273_1842# a_15077_1842# VDD VDD sg13_lv_pmos ad=0.3808p pd=2.92u as=0.2128p ps=1.5u w=1.12u l=0.13u
X566 a_14235_1044# a_14025_1044# VSS.t217 VSS.t534 sg13_lv_nmos ad=0.1406p pd=1.12u as=0.1665p ps=1.19u w=0.74u l=0.13u
X567 VSS.t12 a_3747_1047.t7 a_12791_1008# VSS.t11 sg13_lv_nmos ad=0.2516p pd=2.16u as=0.2516p ps=2.16u w=0.74u l=0.13u
X568 a_9953_1842# a_9757_1842# VSS.t491 VSS.t515 sg13_lv_nmos ad=0.2516p pd=2.16u as=0.1406p ps=1.12u w=0.74u l=0.13u
X569 VSS.t5 a_10843_1842# a_11277_1842# VSS.t4 sg13_lv_nmos ad=0.1406p pd=1.12u as=0.2516p ps=2.16u w=0.74u l=0.13u
X570 VSS.t343 VDD VSS.t342 VSS.t341 sg13_lv_nmos ad=0.1428p pd=1.52u as=0 ps=0 w=0.42u l=1u
X571 VDD a_15403_1842# a_15837_1842# VDD sg13_lv_pmos ad=0.2128p pd=1.5u as=0.3808p ps=2.92u w=1.12u l=0.13u
X572 VSS.t308 VDD VSS.t307 VSS.t306 sg13_lv_nmos ad=0.1428p pd=1.52u as=0 ps=0 w=0.42u l=1u
X573 a_11848_1044# a_11277_1842# VSS.t192 VSS.t191 sg13_lv_nmos ad=0.1406p pd=1.12u as=0.2516p ps=2.16u w=0.74u l=0.13u
X574 VDD a_4763_1842# a_5197_1842# VDD sg13_lv_pmos ad=0.2128p pd=1.5u as=0.3808p ps=2.92u w=1.12u l=0.13u
X575 VSS.t320 VDD VSS.t318 VSS.t319 sg13_lv_nmos ad=79.8f pd=0.8u as=0 ps=0 w=0.42u l=1u
X576 a_13470_1044# a_13444_1008# a_13368_1044# VDD sg13_lv_pmos ad=0.3808p pd=2.92u as=0.2128p ps=1.5u w=1.12u l=0.13u
X577 VDD a_3449_1395# a_3747_1047.t0 VDD sg13_lv_pmos ad=0.4256p pd=3u as=0.2128p ps=1.5u w=1.12u l=0.13u
X578 VDD a_3171_1047.t3 a_24084_1008# VDD sg13_lv_pmos ad=0.3808p pd=2.92u as=0.3808p ps=2.92u w=1.12u l=0.13u
X579 a_3449_1395# MUX_SEL0 VDD VDD sg13_lv_pmos ad=0.1596p pd=1.22u as=0.2856p ps=2.36u w=0.84u l=0.13u
X580 VDD DELAY_VBIASP.t26 a_7911_2470# VDD sg13_lv_pmos ad=0.3808p pd=2.92u as=0.2128p ps=1.5u w=1.12u l=0.6u
X581 VDD VSS.t595 VDD VDD sg13_lv_pmos ad=0.19p pd=1.38u as=0 ps=0 w=1u l=1u
X582 VDD VSS.t594 VDD VDD sg13_lv_pmos ad=0.34p pd=2.68u as=0 ps=0 w=1u l=1u
X583 VDD a_16851_309# MUX_OUT VDD sg13_lv_pmos ad=0.7336p pd=3.55u as=0.2128p ps=1.5u w=1.12u l=0.13u
X584 VSS.t256 a_3171_311.t2 a_23945_519# VSS.t255 sg13_lv_nmos ad=0.2516p pd=2.16u as=0.2516p ps=2.16u w=0.74u l=0.13u
X585 VDD a_18117_1842# a_18585_1044# VDD sg13_lv_pmos ad=0.252p pd=1.57u as=0.3808p ps=2.92u w=1.12u l=0.13u
X586 VSS.t179 a_19637_1842# a_20105_1044# VSS.t178 sg13_lv_nmos ad=0.1665p pd=1.19u as=0.2516p ps=2.16u w=0.74u l=0.13u
X587 a_11711_2470# a_11473_1842# a_11603_1842# VDD sg13_lv_pmos ad=0.2128p pd=1.5u as=0.3808p ps=2.92u w=1.12u l=0.2u
X588 a_27671_1842# a_27433_1842# a_27563_1842# VSS.t6 sg13_lv_nmos ad=0.1406p pd=1.12u as=0.2516p ps=2.16u w=0.74u l=0.2u
X589 VSS.t44 MUX_SEL4 a_15765_463# VSS.t43 sg13_lv_nmos ad=0.2516p pd=2.16u as=0.2516p ps=2.16u w=0.74u l=0.13u
X590 a_5731_289# a_14825_519# a_13470_1044# VDD sg13_lv_pmos ad=0.3808p pd=2.92u as=0.3808p ps=2.92u w=1.12u l=0.13u
X591 a_16510_1044# a_2595_1047.t5 a_17275_1044# VSS.t535 sg13_lv_nmos ad=0.2516p pd=2.16u as=0.1406p ps=1.12u w=0.74u l=0.13u
X592 VSS.t451 DELAY_VBIASN.t15 a_16271_1842# VSS.t450 sg13_lv_nmos ad=0.2516p pd=2.16u as=0.1406p ps=1.12u w=0.74u l=0.6u
X593 VDD VSS.t568 VDD VDD sg13_lv_pmos ad=0.34p pd=2.68u as=0 ps=0 w=1u l=1u
X594 VDD a_3171_1047.t6 a_14964_1008# VDD sg13_lv_pmos ad=0.3808p pd=2.92u as=0.3808p ps=2.92u w=1.12u l=0.13u
X595 VDD a_10083_1842# a_10517_1842# VDD sg13_lv_pmos ad=0.2128p pd=1.5u as=0.3808p ps=2.92u w=1.12u l=0.13u
X596 VSS.t9 a_3747_1047.t2 a_27991_1008# VSS.t8 sg13_lv_nmos ad=0.2516p pd=2.16u as=0.2516p ps=2.16u w=0.74u l=0.13u
X597 VSS.t167 a_26043_1842# a_26477_1842# VSS.t478 sg13_lv_nmos ad=0.1406p pd=1.12u as=0.2516p ps=2.16u w=0.74u l=0.13u
X598 a_11195_1044# a_10985_1044# VDD VDD sg13_lv_pmos ad=0.2128p pd=1.5u as=0.252p ps=1.57u w=1.12u l=0.13u
X599 VSS.t75 a_3747_1047.t9 a_6711_1008# VSS.t74 sg13_lv_nmos ad=0.2516p pd=2.16u as=0.2516p ps=2.16u w=0.74u l=0.13u
X600 a_16108_289# a_2595_311.t2 a_19550_1044# VSS.t13 sg13_lv_nmos ad=0.2516p pd=2.16u as=0.2516p ps=2.16u w=0.74u l=0.13u
X601 VSS.t453 DELAY_VBIASN.t10 a_20071_1842# VSS.t452 sg13_lv_nmos ad=0.2516p pd=2.16u as=0.1406p ps=1.12u w=0.74u l=0.6u
X602 VDD DELAY_VBIASP.t4 a_24631_2470# VDD sg13_lv_pmos ad=0.3808p pd=2.92u as=0.2128p ps=1.5u w=1.12u l=0.6u
X603 a_22590_1044# a_23431_1008# a_23355_1044# VDD sg13_lv_pmos ad=0.3808p pd=2.92u as=0.2128p ps=1.5u w=1.12u l=0.13u
X604 VSS.t300 VDD VSS.t298 VSS.t299 sg13_lv_nmos ad=79.8f pd=0.8u as=0 ps=0 w=0.42u l=1u
X605 a_8671_1842# a_8433_1842# a_8563_1842# VSS.t198 sg13_lv_nmos ad=0.1406p pd=1.12u as=0.2516p ps=2.16u w=0.74u l=0.2u
X606 a_17553_1842# a_17357_1842# VSS.t48 VSS.t47 sg13_lv_nmos ad=0.2516p pd=2.16u as=0.1406p ps=1.12u w=0.74u l=0.13u
X607 a_5731_289# a_5705_519# a_4350_1044# VDD sg13_lv_pmos ad=0.3808p pd=2.92u as=0.3808p ps=2.92u w=1.12u l=0.13u
X608 VDD VDD VDD VDD sg13_lv_pmos ad=0.3808p pd=2.92u as=0 ps=0 w=1.12u l=0.13u
X609 a_26911_2470# a_26673_1842# a_26803_1842# VDD sg13_lv_pmos ad=0.2128p pd=1.5u as=0.3808p ps=2.92u w=1.12u l=0.2u
X610 a_7390_1044# a_2019_1047.t8 a_7288_1044# VSS.t175 sg13_lv_nmos ad=0.2516p pd=2.16u as=0.1406p ps=1.12u w=0.74u l=0.13u
X611 a_21353_1842# a_21157_1842# VSS.t395 VSS.t495 sg13_lv_nmos ad=0.2516p pd=2.16u as=0.1406p ps=1.12u w=0.74u l=0.13u
X612 VSS.t186 a_7043_1842# a_7477_1842# VSS.t185 sg13_lv_nmos ad=0.1406p pd=1.12u as=0.2516p ps=2.16u w=0.74u l=0.13u
X613 VDD DELAY_VBIASP.t16 a_15511_2470# VDD sg13_lv_pmos ad=0.3808p pd=2.92u as=0.2128p ps=1.5u w=1.12u l=0.6u
X614 VDD a_2019_1047.t7 a_10404_1008# VDD sg13_lv_pmos ad=0.3808p pd=2.92u as=0.3808p ps=2.92u w=1.12u l=0.13u
X615 VDD a_25283_1842# a_25717_1842# VDD sg13_lv_pmos ad=0.2128p pd=1.5u as=0.3808p ps=2.92u w=1.12u l=0.13u
X616 VDD DELAY_VBIASP.t29 a_5631_2470# VDD sg13_lv_pmos ad=0.3808p pd=2.92u as=0.2128p ps=1.5u w=1.12u l=0.6u
X617 a_26395_1044# a_26185_1044# VDD VDD sg13_lv_pmos ad=0.2128p pd=1.5u as=0.252p ps=1.57u w=1.12u l=0.13u
X618 VDD a_3747_1047.t3 a_24951_1008# VDD sg13_lv_pmos ad=0.3808p pd=2.92u as=0.3808p ps=2.92u w=1.12u l=0.13u
X619 VDD VSS.t571 VDD VDD sg13_lv_pmos ad=0.19p pd=1.38u as=0 ps=0 w=1u l=1u
X620 a_13991_1842# a_13753_1842# a_13883_1842# VSS.t383 sg13_lv_nmos ad=0.1406p pd=1.12u as=0.2516p ps=2.16u w=0.74u l=0.2u
X621 a_24008_1044# a_23437_1842# VDD VDD sg13_lv_pmos ad=0.2128p pd=1.5u as=0.3808p ps=2.92u w=1.12u l=0.13u
X622 VDD VSS.t585 VDD VDD sg13_lv_pmos ad=0.19p pd=1.38u as=0 ps=0 w=1u l=1u
X623 VSS.t244 a_2019_1047.t4 a_19524_1008# VSS.t243 sg13_lv_nmos ad=0.2516p pd=2.16u as=0.2516p ps=2.16u w=0.74u l=0.13u
X624 a_7911_2470# a_7673_1842# a_7803_1842# VDD sg13_lv_pmos ad=0.2128p pd=1.5u as=0.3808p ps=2.92u w=1.12u l=0.2u
X625 a_16793_1842# a_16597_1842# VDD VDD sg13_lv_pmos ad=0.3808p pd=2.92u as=0.2128p ps=1.5u w=1.12u l=0.13u
X626 VSS.t501 MUX_SEL1 a_3543_1395# VSS.t500 sg13_lv_nmos ad=0.1331p pd=1.12u as=0.1216p ps=1.02u w=0.64u l=0.13u
X627 a_15755_1044# a_15545_1044# VSS.t112 VSS.t111 sg13_lv_nmos ad=0.1406p pd=1.12u as=0.1665p ps=1.19u w=0.74u l=0.13u
X628 a_2595_1047.t0 a_2297_1395# VDD VDD sg13_lv_pmos ad=0.2128p pd=1.5u as=0.1918p ps=1.5u w=1.12u l=0.13u
X629 VSS.t59 a_2595_1047.t6 a_14311_1008# VSS.t58 sg13_lv_nmos ad=0.2516p pd=2.16u as=0.2516p ps=2.16u w=0.74u l=0.13u
X630 VSS.t160 a_12363_1842# a_12797_1842# VSS.t489 sg13_lv_nmos ad=0.1406p pd=1.12u as=0.2516p ps=2.16u w=0.74u l=0.13u
X631 a_5115_1044# a_4905_1044# VSS.t225 VSS.t224 sg13_lv_nmos ad=0.1406p pd=1.12u as=0.1665p ps=1.19u w=0.74u l=0.13u
X632 a_1256_1044# MUX_SEL0 VDD VDD sg13_lv_pmos ad=0.3808p pd=2.92u as=0.3808p ps=2.92u w=1.12u l=0.13u
X633 VDD a_27563_1842# a_27997_1842# VDD sg13_lv_pmos ad=0.2128p pd=1.5u as=0.3808p ps=2.92u w=1.12u l=0.13u
X634 a_20593_1842# a_20397_1842# VDD VDD sg13_lv_pmos ad=0.3808p pd=2.92u as=0.2128p ps=1.5u w=1.12u l=0.13u
X635 a_1721_1395# a_1256_1044# VDD VDD sg13_lv_pmos ad=0.1596p pd=1.22u as=0.2856p ps=2.36u w=0.84u l=0.13u
X636 VDD a_6283_1842# a_6717_1842# VDD sg13_lv_pmos ad=0.2128p pd=1.5u as=0.3808p ps=2.92u w=1.12u l=0.13u
X637 a_13470_1044# a_14964_1008# a_14888_1044# VDD sg13_lv_pmos ad=0.3808p pd=2.92u as=0.2128p ps=1.5u w=1.12u l=0.13u
X638 VSS.t318 VDD VSS.t317 VSS.t316 sg13_lv_nmos ad=0.1428p pd=1.52u as=0 ps=0 w=0.42u l=1u
X639 VDD a_2019_1047.t2 a_25604_1008# VDD sg13_lv_pmos ad=0.3808p pd=2.92u as=0.3808p ps=2.92u w=1.12u l=0.13u
X640 a_16271_1842# a_16033_1842# a_16163_1842# VSS.t558 sg13_lv_nmos ad=0.1406p pd=1.12u as=0.2516p ps=2.16u w=0.74u l=0.2u
X641 a_21835_1044# a_21625_1044# VDD VDD sg13_lv_pmos ad=0.2128p pd=1.5u as=0.252p ps=1.57u w=1.12u l=0.13u
X642 VDD VSS.t596 VDD VDD sg13_lv_pmos ad=0.34p pd=2.68u as=0 ps=0 w=1u l=1u
X643 VDD a_2595_1047.t4 a_20391_1008# VDD sg13_lv_pmos ad=0.3808p pd=2.92u as=0.3808p ps=2.92u w=1.12u l=0.13u
X644 a_19073_1842# a_18877_1842# VDD VDD sg13_lv_pmos ad=0.3808p pd=2.92u as=0.2128p ps=1.5u w=1.12u l=0.13u
X645 VDD a_10517_1842# a_10985_1044# VDD sg13_lv_pmos ad=0.252p pd=1.57u as=0.3808p ps=2.92u w=1.12u l=0.13u
X646 VSS.t127 a_21157_1842# a_21625_1044# VSS.t494 sg13_lv_nmos ad=0.1665p pd=1.19u as=0.2516p ps=2.16u w=0.74u l=0.13u
X647 a_20071_1842# a_19833_1842# a_19963_1842# VSS.t546 sg13_lv_nmos ad=0.1406p pd=1.12u as=0.2516p ps=2.16u w=0.74u l=0.2u
X648 VSS.t153 a_14643_1842# a_15077_1842# VSS.t554 sg13_lv_nmos ad=0.1406p pd=1.12u as=0.2516p ps=2.16u w=0.74u l=0.13u
X649 a_1815_331# a_1256_289# a_1721_331# VSS.t155 sg13_lv_nmos ad=0.1216p pd=1.02u as=0.2176p ps=1.96u w=0.64u l=0.13u
X650 VDD a_19203_1842# a_19637_1842# VDD sg13_lv_pmos ad=0.2128p pd=1.5u as=0.3808p ps=2.92u w=1.12u l=0.13u
X651 VSS.t530 a_2019_1047.t9 a_4324_1008# VSS.t529 sg13_lv_nmos ad=0.2516p pd=2.16u as=0.2516p ps=2.16u w=0.74u l=0.13u
X652 a_16108_289# a_20905_519# a_19550_1044# VDD sg13_lv_pmos ad=0.3808p pd=2.92u as=0.3808p ps=2.92u w=1.12u l=0.13u
X653 a_16510_1044# a_3747_1047.t5 a_18795_1044# VSS.t171 sg13_lv_nmos ad=0.2516p pd=2.16u as=0.1406p ps=1.12u w=0.74u l=0.13u
X654 VDD a_8563_1842# a_8997_1842# VDD sg13_lv_pmos ad=0.2128p pd=1.5u as=0.3808p ps=2.92u w=1.12u l=0.13u
X655 VDD DELAY_VBIASP.t19 a_13231_2470# VDD sg13_lv_pmos ad=0.3808p pd=2.92u as=0.2128p ps=1.5u w=1.12u l=0.6u
X656 VSS.t455 DELAY_VBIASN.t13 a_17791_1842# VSS.t454 sg13_lv_nmos ad=0.2516p pd=2.16u as=0.1406p ps=1.12u w=0.74u l=0.6u
X657 VSS.t288 VDD VSS.t287 VSS.t286 sg13_lv_nmos ad=0.1428p pd=1.52u as=0 ps=0 w=0.42u l=1u
X658 VDD a_3747_1047.t5 a_18871_1008# VDD sg13_lv_pmos ad=0.3808p pd=2.92u as=0.3808p ps=2.92u w=1.12u l=0.13u
X659 VDD a_23003_1842# a_23437_1842# VDD sg13_lv_pmos ad=0.2128p pd=1.5u as=0.3808p ps=2.92u w=1.12u l=0.13u
X660 a_12715_1044# a_12505_1044# VDD VDD sg13_lv_pmos ad=0.2128p pd=1.5u as=0.252p ps=1.57u w=1.12u l=0.13u
X661 a_19550_1044# a_21044_1008# a_20968_1044# VDD sg13_lv_pmos ad=0.3808p pd=2.92u as=0.2128p ps=1.5u w=1.12u l=0.13u
X662 a_17928_1044# a_17357_1842# VDD VDD sg13_lv_pmos ad=0.2128p pd=1.5u as=0.3808p ps=2.92u w=1.12u l=0.13u
X663 VSS.t425 DELAY_VBIASN.t8 a_21591_1842# VSS.t424 sg13_lv_nmos ad=0.2516p pd=2.16u as=0.1406p ps=1.12u w=0.74u l=0.6u
X664 VSS.t1 a_1544_289# a_1815_331# VSS.t0 sg13_lv_nmos ad=0.1331p pd=1.12u as=0.1216p ps=1.02u w=0.64u l=0.13u
X665 a_7288_1044# a_6717_1842# VDD VDD sg13_lv_pmos ad=0.2128p pd=1.5u as=0.3808p ps=2.92u w=1.12u l=0.13u
X666 a_15511_2470# a_15273_1842# a_15403_1842# VDD sg13_lv_pmos ad=0.2128p pd=1.5u as=0.3808p ps=2.92u w=1.12u l=0.2u
X667 VSS.t372 VSS.t374 VSS.t376 VSS.t375 sg13_lv_nmos ad=0.1406p pd=1.12u as=0 ps=0 w=0.74u l=0.2u
X668 a_22590_1044# a_24951_1008# a_24875_1044# VDD sg13_lv_pmos ad=0.3808p pd=2.92u as=0.2128p ps=1.5u w=1.12u l=0.13u
X669 VSS.t360 VDD VSS.t358 VSS.t359 sg13_lv_nmos ad=79.8f pd=0.8u as=0 ps=0 w=0.42u l=1u
X670 a_10430_1044# a_2019_1047.t7 a_10328_1044# VSS.t245 sg13_lv_nmos ad=0.2516p pd=2.16u as=0.1406p ps=1.12u w=0.74u l=0.13u
X671 VDD a_25717_1842# a_26185_1044# VDD sg13_lv_pmos ad=0.252p pd=1.57u as=0.3808p ps=2.92u w=1.12u l=0.13u
X672 VDD a_13883_1842# a_14317_1842# VDD sg13_lv_pmos ad=0.2128p pd=1.5u as=0.3808p ps=2.92u w=1.12u l=0.13u
X673 VDD a_4437_1842# a_4905_1044# VDD sg13_lv_pmos ad=0.252p pd=1.57u as=0.3808p ps=2.92u w=1.12u l=0.13u
X674 a_4157_1313# DELAY_IN VSS.t270 VSS.t269 sg13_lv_nmos ad=0.2516p pd=2.16u as=0.2553p ps=2.17u w=0.74u l=0.13u
X675 a_7390_1044# a_3171_1047.t8 a_8808_1044# VSS.t82 sg13_lv_nmos ad=0.2516p pd=2.16u as=0.1406p ps=1.12u w=0.74u l=0.13u
X676 a_22873_1842# a_22677_1842# VSS.t145 VSS.t144 sg13_lv_nmos ad=0.2516p pd=2.16u as=0.1406p ps=1.12u w=0.74u l=0.13u
X677 VDD a_3171_1047.t8 a_8884_1008# VDD sg13_lv_pmos ad=0.3808p pd=2.92u as=0.3808p ps=2.92u w=1.12u l=0.13u
C0 a_1256_1044# a_1544_1044# 1.26509f
C1 VDD a_9465_1044# 0.29722f
C2 a_10517_1842# a_10430_1044# 0.1088f
C3 MUX_SEL3 MUX_OUT 0.79533f
C4 DELAY_VBIASP a_16163_1842# 0.06627f
C5 VDD a_19203_1842# 0.49737f
C6 a_12233_1842# a_12797_1842# 0.0114f
C7 a_13368_1044# a_13470_1044# 0.37183f
C8 a_15837_1842# a_16484_1008# 0.02011f
C9 VDD a_12715_1044# 0.15406f
C10 a_18585_1044# a_16510_1044# 0.03208f
C11 a_4157_1313# a_4248_1044# 0.11672f
C12 DELAY_VBIASN a_8433_1842# 0.0961f
C13 a_1544_289# VDD 0.39113f
C14 DELAY_VBIASP a_8563_1842# 0.06627f
C15 a_17865_519# a_2019_311# 0.13959f
C16 VDD a_15765_463# 0.35368f
C17 a_27237_1842# a_25630_1044# 0.05253f
C18 VDD DELAY_OUT_LAST 0.46312f
C19 DELAY_VBIASN a_18313_1842# 0.0961f
C20 a_5731_289# a_7390_1044# 0.41331f
C21 a_16597_1842# a_16163_1842# 0.69698f
C22 a_13883_1842# a_13470_1044# 0.01012f
C23 a_17683_1842# a_17791_2470# 0.01697f
C24 VDD a_21835_1044# 0.15406f
C25 a_4633_1842# VDD 0.49285f
C26 DELAY_VBIASN a_26477_1842# 0.10224f
C27 a_1256_289# a_2873_331# 0.27926f
C28 a_1544_289# a_2297_331# 0.27303f
C29 DELAY_VBIASP a_6913_1842# 0.11222f
C30 DELAY_VBIASN a_23633_1842# 0.0961f
C31 VDD a_19524_1008# 0.28633f
C32 DELAY_VBIASP a_23763_1842# 0.06627f
C33 VDD a_5844_1008# 0.28225f
C34 DELAY_VBIASN a_13557_1842# 0.08375f
C35 DELAY_VBIASP a_13753_1842# 0.11222f
C36 DELAY_IN a_3449_331# 0.01017f
C37 a_22590_1044# a_23437_1842# 0.08038f
C38 a_21157_1842# a_21917_1842# 0.02912f
C39 a_12471_1842# a_12363_1842# 0.01163f
C40 VDD a_15837_1842# 0.87963f
C41 VDD a_17065_1044# 0.30218f
C42 MUX_SEL4 a_9757_1842# 0.01829f
C43 a_11277_1842# a_10843_1842# 0.6972f
C44 VDD a_25630_1044# 0.89531f
C45 a_4763_1842# a_4871_1842# 0.01163f
C46 DELAY_VBIASP a_24957_1842# 0.0414f
C47 a_19637_1842# a_20397_1842# 0.01669f
C48 a_17928_1044# a_17357_1842# 0.10863f
C49 a_27433_1842# a_27563_1842# 0.70845f
C50 a_12791_1008# a_10430_1044# 0.26208f
C51 a_16408_1044# a_16484_1008# 0.01176f
C52 MUX_SEL1 a_1544_1044# 0.1672f
C53 DELAY_VBIASN a_22113_1842# 0.0961f
C54 VDD a_4350_1044# 0.87635f
C55 a_14751_2470# a_14643_1842# 0.01697f
C56 DELAY_VBIASN a_11603_1842# 0.07254f
C57 a_6717_1842# a_7043_1842# 0.01427f
C58 a_14643_1842# a_14317_1842# 0.01427f
C59 a_24631_1842# a_24523_1842# 0.01163f
C60 DELAY_VBIASN a_13883_1842# 0.07254f
C61 a_11277_1842# a_11271_1008# 0.02349f
C62 a_21157_1842# a_21625_1044# 0.2079f
C63 a_5731_289# a_14825_519# 0.28056f
C64 a_12037_1842# a_10430_1044# 0.05231f
C65 VDD a_4763_1842# 0.4973f
C66 a_22590_1044# a_23945_519# 0.02165f
C67 DELAY_VBIASP a_20397_1842# 0.0414f
C68 a_18877_1842# a_18443_1842# 0.6972f
C69 DELAY_VBIASN a_19203_1842# 0.07254f
C70 a_16793_1842# a_16923_1842# 0.70845f
C71 a_10083_1842# a_10191_2470# 0.01697f
C72 a_15837_1842# a_13470_1044# 0.02479f
C73 MUX_SEL4 a_5705_519# 0.03556f
C74 a_21044_1008# a_20397_1842# 0.02312f
C75 a_14235_1044# a_14025_1044# 0.09424f
C76 MUX_SEL3 a_2019_311# 0.06209f
C77 a_25528_1044# a_24957_1842# 0.10864f
C78 DELAY_VBIASP a_20593_1842# 0.11222f
C79 DELAY_VBIASP a_10083_1842# 0.06627f
C80 VDD a_23111_2470# 0.01806f
C81 a_10430_1044# a_11924_1008# 0.28279f
C82 a_15765_463# a_15964_289# 0.061f
C83 a_11195_1044# a_11271_1008# 0.01194f
C84 a_23437_1842# a_24008_1044# 0.10863f
C85 a_20397_1842# a_19550_1044# 0.08038f
C86 a_7945_1044# a_8231_1008# 0.01885f
C87 a_26185_1044# a_25717_1842# 0.19203f
C88 DELAY_OUT_LAST DELAY_VBIASN 0.04786f
C89 VDD a_18117_1842# 0.85848f
C90 a_4324_1008# a_4350_1044# 0.277f
C91 a_9193_1842# a_9323_1842# 0.70845f
C92 VDD a_16408_1044# 0.17274f
C93 a_20105_1044# a_19637_1842# 0.19203f
C94 a_4633_1842# DELAY_VBIASN 0.0961f
C95 a_21835_1044# a_21911_1008# 0.01194f
C96 a_20723_1842# a_20831_2470# 0.01697f
C97 a_16108_289# a_19550_1044# 0.58202f
C98 a_22351_1842# a_22243_1842# 0.01163f
C99 VDD a_10517_1842# 0.86707f
C100 a_4633_1842# a_5197_1842# 0.0114f
C101 a_18877_1842# a_18871_1008# 0.02354f
C102 a_26673_1842# a_26477_1842# 0.76914f
C103 a_15837_1842# a_15964_289# 0.02f
C104 a_5197_1842# a_5844_1008# 0.02312f
C105 DELAY_VBIASN a_15837_1842# 0.09992f
C106 a_8237_1842# a_8563_1842# 0.01427f
C107 DELAY_VBIASP a_16033_1842# 0.11222f
C108 DELAY_VBIASN a_25630_1044# 0.02756f
C109 a_24393_1842# a_24957_1842# 0.0114f
C110 a_22590_1044# a_24951_1008# 0.26208f
C111 a_19550_1044# a_20391_1008# 0.28268f
C112 MUX_OUT a_16851_309# 0.45865f
C113 a_10985_1044# a_11271_1008# 0.01885f
C114 VDD a_7803_1842# 0.4973f
C115 a_1544_1044# a_1721_1395# 0.38063f
C116 a_26395_1044# a_25630_1044# 0.39037f
C117 DELAY_VBIASN a_4350_1044# 0.02115f
C118 a_20105_1044# a_19550_1044# 0.03209f
C119 VDD a_26911_2470# 0.01806f
C120 a_22113_1842# a_22677_1842# 0.0114f
C121 a_10951_2470# a_10843_1842# 0.01697f
C122 a_5197_1842# a_4350_1044# 0.08038f
C123 a_19311_1842# a_19203_1842# 0.01163f
C124 a_16033_1842# a_16597_1842# 0.0114f
C125 a_7477_1842# a_7673_1842# 0.73897f
C126 DELAY_VBIASP a_5957_1842# 0.04141f
C127 DELAY_VBIASN a_4763_1842# 0.07254f
C128 a_15837_1842# a_15403_1842# 0.6972f
C129 a_1256_1044# MUX_OUT 0.02466f
C130 VDD a_25913_1842# 0.49294f
C131 a_18795_1044# a_18871_1008# 0.01194f
C132 a_25630_1044# a_25604_1008# 0.277f
C133 a_6635_1044# a_4350_1044# 0.39036f
C134 a_8997_1842# a_7390_1044# 0.05231f
C135 a_11711_2470# VDD 0.01806f
C136 a_8237_1842# a_8231_1008# 0.02349f
C137 a_5197_1842# a_4763_1842# 0.6972f
C138 VDD a_23003_1842# 0.4973f
C139 a_3449_331# a_2019_311# 0.01176f
C140 VDD a_12993_1842# 0.49426f
C141 VDD a_7390_1044# 0.8686f
C142 a_14888_1044# a_14317_1842# 0.10863f
C143 DELAY_IN a_4157_1313# 0.50642f
C144 a_14513_1842# a_15077_1842# 0.0114f
C145 a_9953_1842# a_10083_1842# 0.70845f
C146 VDD a_12791_1008# 0.2822f
C147 DELAY_VBIASN a_18117_1842# 0.09156f
C148 MUX_SEL0 a_1544_1044# 0.07603f
C149 a_4437_1842# a_4157_1313# 0.01771f
C150 a_23437_1842# a_23763_1842# 0.01427f
C151 a_12993_1842# a_13123_1842# 0.70845f
C152 a_6153_1842# a_6717_1842# 0.0114f
C153 DELAY_IN MUX_SEL1 0.01858f
C154 a_19963_1842# a_20397_1842# 0.6972f
C155 VDD a_21483_1842# 0.4973f
C156 a_24957_1842# a_25283_1842# 0.01427f
C157 VDD a_12037_1842# 0.85848f
C158 DELAY_VBIASN a_10517_1842# 0.08375f
C159 a_4905_1044# a_5115_1044# 0.09424f
C160 DELAY_VBIASP a_27237_1842# 0.06189f
C161 a_7390_1044# a_8155_1044# 0.39037f
C162 a_16923_1842# a_17031_1842# 0.01163f
C163 a_24665_1044# a_24951_1008# 0.01885f
C164 MUX_SEL3 MUX_SEL4 0.75489f
C165 MUX_SEL2 MUX_OUT 0.08497f
C166 VDD a_19637_1842# 0.86707f
C167 a_23111_1842# a_23003_1842# 0.01163f
C168 a_16484_1008# a_16597_1842# 0.05157f
C169 a_18585_1044# a_18117_1842# 0.2079f
C170 VDD a_11924_1008# 0.28225f
C171 a_17065_1044# a_16510_1044# 0.03209f
C172 DELAY_VBIASP a_8997_1842# 0.04141f
C173 VDD a_10191_2470# 0.01806f
C174 a_1256_289# VDD 0.40292f
C175 DELAY_VBIASN a_7803_1842# 0.07254f
C176 a_16851_309# a_2019_311# 0.01299f
C177 VDD a_14825_519# 0.29292f
C178 MUX_SEL1 MUX_OUT 0.09357f
C179 VDD DELAY_VBIASP 13.3418f
C180 VDD a_21044_1008# 0.28225f
C181 a_4003_1842# a_4111_1842# 0.01163f
C182 a_4003_1842# VDD 0.61559f
C183 DELAY_VBIASN a_25913_1842# 0.0961f
C184 a_1256_289# a_2297_331# 0.04261f
C185 a_1544_289# a_1721_331# 0.36963f
C186 VDD a_5768_1044# 0.17499f
C187 DELAY_VBIASN a_23003_1842# 0.07254f
C188 VDD a_19550_1044# 0.89766f
C189 DELAY_VBIASP a_24197_1842# 0.04141f
C190 DELAY_VBIASP a_13123_1842# 0.06627f
C191 DELAY_VBIASN a_12993_1842# 0.0961f
C192 VDD a_22351_2470# 0.01806f
C193 DELAY_VBIASN a_7390_1044# 0.02115f
C194 VDD a_16597_1842# 0.86876f
C195 a_12363_1842# a_10430_1044# 0.01012f
C196 a_21157_1842# a_21353_1842# 0.77122f
C197 VDD a_15273_1842# 0.49285f
C198 a_13470_1044# a_14825_519# 0.02058f
C199 VDD a_15545_1044# 0.29918f
C200 a_1256_1044# a_2297_1395# 0.04619f
C201 a_10713_1842# a_10843_1842# 0.70845f
C202 VDD a_25528_1044# 0.17274f
C203 a_18117_1842# a_17683_1842# 0.6972f
C204 a_19637_1842# a_19833_1842# 0.73897f
C205 a_27433_1842# a_27997_1842# 0.0114f
C206 a_16510_1044# a_18117_1842# 0.05231f
C207 a_21917_1842# a_16108_289# 0.0157f
C208 a_17351_1008# a_17357_1842# 0.02349f
C209 a_25630_1044# a_26477_1842# 0.08038f
C210 DELAY_VBIASN a_21483_1842# 0.07254f
C211 a_16408_1044# a_16510_1044# 0.37183f
C212 VDD a_4248_1044# 0.17587f
C213 DELAY_VBIASN a_12037_1842# 0.09156f
C214 a_21917_1842# a_22488_1044# 0.10864f
C215 a_6717_1842# a_7477_1842# 0.06198f
C216 a_16108_289# a_23945_519# 0.2906f
C217 a_15077_1842# a_14317_1842# 0.03319f
C218 VDD a_7945_1044# 0.30409f
C219 a_16793_1842# a_17357_1842# 0.0114f
C220 DELAY_VBIASP a_19833_1842# 0.11222f
C221 a_19963_1842# a_20071_1842# 0.01163f
C222 DELAY_VBIASN a_19637_1842# 0.08375f
C223 a_13470_1044# a_15545_1044# 0.03208f
C224 a_20968_1044# a_20397_1842# 0.10863f
C225 MUX_SEL4 a_3449_331# 0.05166f
C226 a_24951_1008# a_24957_1842# 0.02354f
C227 a_22590_1044# a_23355_1044# 0.39037f
C228 a_10430_1044# a_11848_1044# 0.38994f
C229 VDD a_4111_2470# 0.01866f
C230 a_4157_1313# a_2019_311# 0.01018f
C231 a_23437_1842# a_23431_1008# 0.02349f
C232 a_7945_1044# a_8155_1044# 0.09424f
C233 VDD a_17553_1842# 0.49417f
C234 DELAY_VBIASP DELAY_VBIASN 3.50557f
C235 VDD a_24393_1842# 0.49285f
C236 DELAY_IN MUX_SEL0 0.14089f
C237 a_18117_1842# a_18313_1842# 0.77122f
C238 a_9193_1842# a_9757_1842# 0.0114f
C239 VDD a_1544_1044# 0.45079f
C240 a_4324_1008# a_4248_1044# 0.01176f
C241 VDD a_15831_1008# 0.2816f
C242 a_5197_1842# DELAY_VBIASP 0.0414f
C243 a_5523_1842# a_5631_1842# 0.01163f
C244 a_4003_1842# DELAY_VBIASN 0.06486f
C245 a_15511_1842# a_15403_1842# 0.01163f
C246 VDD a_9953_1842# 0.49426f
C247 a_8745_519# MUX_SEL4 0.04472f
C248 a_5731_289# MUX_OUT 1.04829f
C249 a_16271_2470# a_16163_1842# 0.01697f
C250 a_24197_1842# a_24393_1842# 0.77122f
C251 DELAY_VBIASN a_19550_1044# 0.02115f
C252 MUX_SEL1 a_2297_1395# 0.01995f
C253 a_21911_1008# a_19550_1044# 0.26208f
C254 a_5197_1842# a_5768_1044# 0.10863f
C255 DELAY_VBIASN a_16597_1842# 0.08375f
C256 DELAY_VBIASP a_15403_1842# 0.06627f
C257 a_8237_1842# a_8997_1842# 0.03319f
C258 DELAY_VBIASN a_15273_1842# 0.0961f
C259 VDD a_19963_1842# 0.4973f
C260 a_19550_1044# a_20315_1044# 0.39037f
C261 a_22590_1044# a_24875_1044# 0.39036f
C262 MUX_OUT a_16108_289# 0.24265f
C263 a_13470_1044# a_15831_1008# 0.26208f
C264 a_10985_1044# a_11195_1044# 0.09424f
C265 VDD a_8237_1842# 0.86909f
C266 a_6283_1842# a_6391_2470# 0.01697f
C267 a_9323_1842# a_9431_1842# 0.01163f
C268 a_6717_1842# a_7288_1044# 0.10864f
C269 VDD a_9751_1008# 0.2822f
C270 VDD a_26151_2470# 0.01806f
C271 a_7477_1842# a_7043_1842# 0.69698f
C272 a_15273_1842# a_15403_1842# 0.70845f
C273 DELAY_VBIASP a_5393_1842# 0.11222f
C274 VDD a_25283_1842# 0.49737f
C275 VDD a_14964_1008# 0.28225f
C276 a_1256_1044# MUX_SEL4 0.04908f
C277 a_25528_1044# a_25604_1008# 0.01176f
C278 a_5844_1008# a_4350_1044# 0.28279f
C279 a_4633_1842# a_4763_1842# 0.70845f
C280 VDD a_12363_1842# 0.4973f
C281 a_25913_1842# a_26477_1842# 0.0114f
C282 VDD a_23437_1842# 0.86909f
C283 a_7803_1842# a_7911_1842# 0.01163f
C284 a_8808_1044# a_8884_1008# 0.01176f
C285 a_14311_1008# a_14317_1842# 0.02349f
C286 DELAY_IN a_3449_1395# 0.01058f
C287 DELAY_VBIASN a_24393_1842# 0.0961f
C288 a_24631_2470# a_24523_1842# 0.01697f
C289 DELAY_VBIASN a_17553_1842# 0.0961f
C290 DELAY_VBIASP a_17683_1842# 0.06627f
C291 a_23437_1842# a_24197_1842# 0.03319f
C292 a_12993_1842# a_13557_1842# 0.0114f
C293 a_27671_1842# a_27563_1842# 0.01163f
C294 a_13470_1044# a_14964_1008# 0.28279f
C295 a_14235_1044# a_14311_1008# 0.01194f
C296 DELAY_VBIASP a_22677_1842# 0.0414f
C297 a_19963_1842# a_19833_1842# 0.70845f
C298 VDD a_21917_1842# 0.87825f
C299 a_24957_1842# a_25717_1842# 0.06198f
C300 VDD a_11473_1842# 0.49417f
C301 DELAY_VBIASN a_9953_1842# 0.0961f
C302 DELAY_VBIASP a_26673_1842# 0.11222f
C303 a_7390_1044# a_7364_1008# 0.277f
C304 a_13444_1008# a_12797_1842# 0.02011f
C305 a_4763_1842# a_4350_1044# 0.01012f
C306 a_24665_1044# a_24875_1044# 0.09424f
C307 VDD a_23945_519# 0.29292f
C308 a_5731_289# a_2019_311# 1.15781f
C309 a_9757_1842# a_10404_1008# 0.02011f
C310 a_17928_1044# a_18004_1008# 0.01176f
C311 MUX_SEL2 MUX_SEL4 0.01978f
C312 VDD a_19073_1842# 0.49426f
C313 a_11711_2470# a_11603_1842# 0.01697f
C314 a_8563_1842# a_8671_2470# 0.01697f
C315 a_16510_1044# a_16597_1842# 0.1088f
C316 VDD a_11848_1044# 0.17499f
C317 DELAY_VBIASN a_19963_1842# 0.07254f
C318 a_15837_1842# a_16408_1044# 0.10864f
C319 VDD a_21625_1044# 0.29722f
C320 MUX_SEL4 a_4157_1313# 0.08229f
C321 VDD a_9431_2470# 0.01806f
C322 DELAY_VBIASN a_8237_1842# 0.09974f
C323 DELAY_VBIASP a_8433_1842# 0.11222f
C324 a_27991_1008# VDD 0.28201f
C325 a_16108_289# a_2019_311# 0.33889f
C326 a_17357_1842# a_18004_1008# 0.02312f
C327 a_9465_1044# a_7390_1044# 0.03208f
C328 MUX_SEL1 MUX_SEL4 0.03574f
C329 DELAY_VBIASP a_18313_1842# 0.11222f
C330 VDD DELAY_IN 1.33375f
C331 a_7043_1842# a_7151_2470# 0.01697f
C332 VDD a_20968_1044# 0.17499f
C333 a_12037_1842# a_11603_1842# 0.6972f
C334 a_4437_1842# VDD 0.86998f
C335 DELAY_VBIASP a_26477_1842# 0.04144f
C336 DELAY_VBIASN a_25283_1842# 0.07254f
C337 a_1256_289# a_1721_331# 0.13421f
C338 MUX_SEL0 a_2297_1395# 0.10655f
C339 a_12791_1008# a_12715_1044# 0.01194f
C340 VDD a_19448_1044# 0.17274f
C341 DELAY_VBIASN a_23437_1842# 0.09974f
C342 VDD a_5191_1008# 0.28565f
C343 DELAY_VBIASP a_23633_1842# 0.11222f
C344 DELAY_VBIASN a_12363_1842# 0.07254f
C345 DELAY_VBIASP a_13557_1842# 0.0414f
C346 VDD a_21591_2470# 0.01806f
C347 a_21157_1842# a_20723_1842# 0.6972f
C348 a_12797_1842# a_10430_1044# 0.02479f
C349 a_17683_1842# a_17791_1842# 0.01163f
C350 VDD a_14643_1842# 0.49671f
C351 VDD a_14025_1044# 0.30409f
C352 VDD a_24951_1008# 0.2822f
C353 VDD a_6283_1842# 0.4973f
C354 a_10713_1842# a_11277_1842# 0.0114f
C355 a_19637_1842# a_19203_1842# 0.69698f
C356 a_23871_1842# a_23763_1842# 0.01163f
C357 a_17553_1842# a_17683_1842# 0.70845f
C358 VDD MUX_OUT 0.35871f
C359 DELAY_VBIASP a_22113_1842# 0.11222f
C360 DELAY_VBIASN a_21917_1842# 0.09992f
C361 DELAY_VBIASN a_11473_1842# 0.0961f
C362 DELAY_VBIASP a_11603_1842# 0.06627f
C363 a_21917_1842# a_21911_1008# 0.02354f
C364 a_14513_1842# a_14317_1842# 0.76914f
C365 a_6717_1842# a_6913_1842# 0.76914f
C366 a_16108_289# a_20905_519# 0.2906f
C367 a_4437_1842# a_4324_1008# 0.05157f
C368 a_10843_1842# a_10430_1044# 0.01012f
C369 DELAY_VBIASP a_13883_1842# 0.06627f
C370 DELAY_VBIASN a_19073_1842# 0.0961f
C371 DELAY_VBIASP a_19203_1842# 0.06627f
C372 MUX_SEL3 a_3449_331# 0.28429f
C373 MUX_SEL4 a_2873_331# 0.04916f
C374 a_1256_289# a_1544_289# 1.25711f
C375 MUX_OUT a_2297_331# 0.01179f
C376 a_13470_1044# a_14025_1044# 0.03209f
C377 a_22590_1044# a_22564_1008# 0.277f
C378 a_10430_1044# a_11271_1008# 0.28268f
C379 VDD a_27563_1842# 0.49811f
C380 a_21911_1008# a_21625_1044# 0.01885f
C381 a_19637_1842# a_19524_1008# 0.05157f
C382 DELAY_VBIASP DELAY_OUT_LAST 0.21225f
C383 VDD a_16923_1842# 0.4973f
C384 DELAY_IN DELAY_VBIASN 0.07156f
C385 a_27048_1044# a_27124_1008# 0.01176f
C386 VDD a_15755_1044# 0.15389f
C387 a_4437_1842# DELAY_VBIASN 0.08375f
C388 a_4633_1842# DELAY_VBIASP 0.11222f
C389 a_23003_1842# a_23111_2470# 0.01697f
C390 VDD a_9323_1842# 0.4973f
C391 a_4437_1842# a_5197_1842# 0.01669f
C392 a_5731_289# MUX_SEL4 4.60702f
C393 a_21835_1044# a_19550_1044# 0.39036f
C394 a_18443_1842# a_18551_2470# 0.01697f
C395 a_5197_1842# a_5191_1008# 0.02349f
C396 a_22677_1842# a_23437_1842# 0.01669f
C397 DELAY_VBIASP a_15837_1842# 0.0414f
C398 DELAY_VBIASN a_14643_1842# 0.07254f
C399 a_8237_1842# a_8433_1842# 0.76914f
C400 DELAY_VBIASP a_25630_1044# 0.01522f
C401 DELAY_VBIASN a_6283_1842# 0.07254f
C402 MUX_OUT a_15964_289# 0.01307f
C403 a_22590_1044# a_24084_1008# 0.28279f
C404 MUX_SEL4 a_16108_289# 0.1283f
C405 a_5768_1044# a_5844_1008# 0.01176f
C406 a_19550_1044# a_19524_1008# 0.277f
C407 a_23355_1044# a_23431_1008# 0.01194f
C408 a_13470_1044# a_15755_1044# 0.39036f
C409 a_20723_1842# a_20831_1842# 0.01163f
C410 a_12505_1044# a_10430_1044# 0.03208f
C411 a_16271_2470# VDD 0.01806f
C412 VDD a_7673_1842# 0.49294f
C413 VDD a_2019_311# 1.43004f
C414 MUX_SEL4 a_10430_1044# 0.24983f
C415 a_6717_1842# a_6711_1008# 0.02354f
C416 VDD a_9675_1044# 0.15406f
C417 a_23355_1044# a_23145_1044# 0.09424f
C418 VDD a_25391_2470# 0.01806f
C419 a_21917_1842# a_22677_1842# 0.06198f
C420 a_15837_1842# a_16597_1842# 0.06198f
C421 a_6913_1842# a_7043_1842# 0.70845f
C422 a_17065_1044# a_16597_1842# 0.19203f
C423 DELAY_VBIASP a_4763_1842# 0.06627f
C424 a_15273_1842# a_15837_1842# 0.0114f
C425 VDD a_14888_1044# 0.17499f
C426 VDD a_25717_1842# 0.86707f
C427 a_25528_1044# a_25630_1044# 0.37183f
C428 VDD a_4871_2470# 0.01806f
C429 a_5768_1044# a_4350_1044# 0.38994f
C430 VDD a_2297_1395# 0.46536f
C431 a_7803_1842# a_7390_1044# 0.01012f
C432 VDD a_22873_1842# 0.49294f
C433 a_2297_331# a_2019_311# 0.04011f
C434 VDD a_12797_1842# 0.87771f
C435 a_6425_1044# a_6711_1008# 0.01885f
C436 DELAY_VBIASN a_27563_1842# 0.07259f
C437 DELAY_VBIASN a_16923_1842# 0.07254f
C438 a_9757_1842# a_10083_1842# 0.01427f
C439 DELAY_VBIASP a_18117_1842# 0.04141f
C440 a_12471_2470# a_12363_1842# 0.01697f
C441 a_24008_1044# a_24084_1008# 0.01176f
C442 a_23437_1842# a_23633_1842# 0.76914f
C443 a_12797_1842# a_13123_1842# 0.01427f
C444 a_5957_1842# a_6717_1842# 0.02912f
C445 a_13470_1044# a_14888_1044# 0.38994f
C446 a_4248_1044# a_4350_1044# 0.37183f
C447 VDD a_21353_1842# 0.49285f
C448 a_24957_1842# a_25153_1842# 0.76914f
C449 VDD a_10843_1842# 0.4973f
C450 DELAY_VBIASP a_10517_1842# 0.0414f
C451 DELAY_VBIASN a_9323_1842# 0.07254f
C452 VDD a_17031_2470# 0.01806f
C453 a_9465_1044# a_9751_1008# 0.01885f
C454 VDD a_20905_519# 0.29292f
C455 a_5731_289# a_5705_519# 0.28954f
C456 MUX_SEL2 MUX_SEL3 3.21891f
C457 VDD a_18443_1842# 0.4973f
C458 a_5957_1842# a_6425_1044# 0.2079f
C459 VDD a_23355_1044# 0.15389f
C460 VDD a_11271_1008# 0.28336f
C461 a_15837_1842# a_15831_1008# 0.02354f
C462 VDD a_8671_2470# 0.01806f
C463 a_27915_1044# VDD 0.15389f
C464 DELAY_VBIASP a_7803_1842# 0.06627f
C465 DELAY_VBIASN a_7673_1842# 0.0961f
C466 a_15964_289# a_2019_311# 0.02413f
C467 a_21917_1842# a_22113_1842# 0.76914f
C468 a_11473_1842# a_11603_1842# 0.70845f
C469 DELAY_VBIASP a_25913_1842# 0.11222f
C470 DELAY_VBIASN a_25717_1842# 0.08411f
C471 a_27705_1044# a_27237_1842# 0.2079f
C472 VDD a_26043_1842# 0.4973f
C473 a_22590_1044# a_24523_1842# 0.01012f
C474 VDD a_18871_1008# 0.2822f
C475 DELAY_VBIASN a_22873_1842# 0.0961f
C476 VDD a_5115_1044# 0.15389f
C477 DELAY_VBIASP a_12993_1842# 0.11222f
C478 DELAY_VBIASN a_12797_1842# 0.09992f
C479 a_20723_1842# a_20397_1842# 0.01427f
C480 a_17275_1044# a_17351_1008# 0.01194f
C481 DELAY_VBIASP a_23003_1842# 0.06627f
C482 VDD a_20831_2470# 0.01806f
C483 a_20593_1842# a_20723_1842# 0.70845f
C484 a_12037_1842# a_11924_1008# 0.02055f
C485 VDD a_15077_1842# 0.85963f
C486 VDD a_24875_1044# 0.15406f
C487 VDD a_12505_1044# 0.29722f
C488 VDD a_6717_1842# 0.87726f
C489 a_19073_1842# a_19203_1842# 0.70845f
C490 a_17553_1842# a_18117_1842# 0.0114f
C491 a_16510_1044# a_16923_1842# 0.01012f
C492 a_25604_1008# a_25717_1842# 0.05157f
C493 VDD MUX_SEL4 2.63176f
C494 DELAY_VBIASP a_21483_1842# 0.06627f
C495 DELAY_VBIASN a_21353_1842# 0.0961f
C496 DELAY_VBIASP a_12037_1842# 0.04141f
C497 DELAY_VBIASN a_10843_1842# 0.07254f
C498 VDD a_27705_1044# 0.29918f
C499 a_16108_289# a_17865_519# 0.29564f
C500 a_14025_1044# a_13557_1842# 0.19203f
C501 a_11277_1842# a_10430_1044# 0.08038f
C502 a_16108_289# a_18877_1842# 0.0157f
C503 VDD a_6425_1044# 0.29722f
C504 DELAY_VBIASN a_18443_1842# 0.07254f
C505 DELAY_VBIASP a_19637_1842# 0.0414f
C506 a_21483_1842# a_19550_1044# 0.01012f
C507 a_9953_1842# a_10517_1842# 0.0114f
C508 MUX_SEL4 a_2297_331# 0.04338f
C509 MUX_SEL3 a_2873_331# 0.12606f
C510 MUX_SEL2 a_3449_331# 0.10741f
C511 a_15077_1842# a_13470_1044# 0.05231f
C512 VDD a_17928_1044# 0.17499f
C513 a_22488_1044# a_22564_1008# 0.01176f
C514 VDD a_27997_1842# 0.76025f
C515 MUX_SEL4 a_13470_1044# 0.256f
C516 a_10430_1044# a_11195_1044# 0.39037f
C517 a_27563_1842# a_27671_2470# 0.01697f
C518 a_21835_1044# a_21625_1044# 0.09424f
C519 a_19637_1842# a_19550_1044# 0.1088f
C520 a_7945_1044# a_7390_1044# 0.03209f
C521 VDD a_17357_1842# 0.86909f
C522 a_8997_1842# a_9757_1842# 0.02912f
C523 a_16510_1044# a_2019_311# 0.03139f
C524 a_4003_1842# DELAY_VBIASP 0.05992f
C525 VDD a_9757_1842# 0.87771f
C526 DELAY_VBIASN a_26043_1842# 0.07254f
C527 a_4437_1842# a_4633_1842# 0.73897f
C528 a_26985_519# a_16108_289# 0.2906f
C529 a_27991_1008# a_25630_1044# 0.26208f
C530 a_21044_1008# a_19550_1044# 0.28279f
C531 DELAY_VBIASP a_16597_1842# 0.0414f
C532 a_22677_1842# a_22873_1842# 0.73897f
C533 DELAY_VBIASN a_15077_1842# 0.09156f
C534 DELAY_VBIASP a_15273_1842# 0.11222f
C535 a_1544_289# MUX_OUT 0.69943f
C536 a_8237_1842# a_7803_1842# 0.6972f
C537 DELAY_VBIASN a_6717_1842# 0.09992f
C538 a_19448_1044# a_19524_1008# 0.01176f
C539 a_22590_1044# a_24008_1044# 0.38994f
C540 MUX_SEL4 a_15964_289# 0.5544f
C541 a_10985_1044# a_10430_1044# 0.03209f
C542 a_8997_1842# a_8884_1008# 0.02055f
C543 a_15511_2470# VDD 0.01806f
C544 VDD a_7043_1842# 0.49723f
C545 a_18585_1044# a_18871_1008# 0.01885f
C546 VDD a_5705_519# 0.29556f
C547 a_22590_1044# a_24665_1044# 0.03208f
C548 VDD a_24631_2470# 0.01806f
C549 VDD a_8884_1008# 0.28225f
C550 a_4437_1842# a_4350_1044# 0.1088f
C551 a_6913_1842# a_7477_1842# 0.0114f
C552 VDD a_14311_1008# 0.28336f
C553 VDD a_25153_1842# 0.49426f
C554 a_26471_1008# a_26185_1044# 0.01885f
C555 a_13753_1842# a_14317_1842# 0.0114f
C556 a_16510_1044# a_18443_1842# 0.01012f
C557 a_5191_1008# a_4350_1044# 0.28268f
C558 a_8237_1842# a_7390_1044# 0.08038f
C559 VDD a_12233_1842# 0.49285f
C560 a_25717_1842# a_26477_1842# 0.01669f
C561 VDD a_22243_1842# 0.49737f
C562 a_1721_331# a_2019_311# 0.18452f
C563 a_23763_1842# a_23871_2470# 0.01697f
C564 a_6425_1044# a_6635_1044# 0.09424f
C565 DELAY_VBIASN a_27997_1842# 0.04176f
C566 a_7390_1044# a_9751_1008# 0.26208f
C567 a_6283_1842# a_4350_1044# 0.01012f
C568 a_4003_1842# a_4111_2470# 0.01697f
C569 a_1256_1044# MUX_SEL1 1.44243f
C570 DELAY_VBIASP a_17553_1842# 0.11222f
C571 DELAY_VBIASN a_17357_1842# 0.09974f
C572 DELAY_VBIASP a_24393_1842# 0.11222f
C573 a_27124_1008# a_27237_1842# 0.02055f
C574 a_12797_1842# a_13557_1842# 0.06198f
C575 a_23437_1842# a_23003_1842# 0.6972f
C576 a_5957_1842# a_6153_1842# 0.77122f
C577 a_13470_1044# a_14311_1008# 0.28268f
C578 VDD a_20723_1842# 0.49671f
C579 a_24957_1842# a_24523_1842# 0.6972f
C580 VDD a_11277_1842# 0.86909f
C581 DELAY_VBIASP a_9953_1842# 0.11222f
C582 DELAY_VBIASN a_9757_1842# 0.09992f
C583 a_13368_1044# a_12797_1842# 0.10864f
C584 a_9465_1044# a_9675_1044# 0.09424f
C585 VDD a_17865_519# 0.29444f
C586 a_9757_1842# a_10328_1044# 0.10864f
C587 a_27563_1842# a_25630_1044# 0.01024f
C588 a_16510_1044# a_18871_1008# 0.26208f
C589 a_18313_1842# a_18443_1842# 0.70845f
C590 VDD a_18877_1842# 0.87825f
C591 VDD a_22564_1008# 0.28633f
C592 VDD a_11195_1044# 0.15389f
C593 DELAY_VBIASP a_19963_1842# 0.06627f
C594 a_1544_289# a_2019_311# 0.01747f
C595 a_15545_1044# a_15831_1008# 0.01885f
C596 a_27124_1008# VDD 0.28225f
C597 VDD a_7911_2470# 0.01806f
C598 DELAY_VBIASP a_8237_1842# 0.0414f
C599 DELAY_VBIASN a_7043_1842# 0.07254f
C600 a_15765_463# a_2019_311# 0.05969f
C601 a_10083_1842# a_10191_1842# 0.01163f
C602 a_13231_1842# a_13123_1842# 0.01163f
C603 a_19963_1842# a_19550_1044# 0.01012f
C604 a_21917_1842# a_21483_1842# 0.6972f
C605 a_11473_1842# a_12037_1842# 0.0114f
C606 a_5731_289# a_8745_519# 0.28635f
C607 DELAY_VBIASN a_25153_1842# 0.0961f
C608 DELAY_VBIASP a_25283_1842# 0.06627f
C609 a_22590_1044# a_24957_1842# 0.02479f
C610 a_16510_1044# a_17928_1044# 0.38994f
C611 VDD a_18795_1044# 0.15406f
C612 DELAY_VBIASN a_12233_1842# 0.0961f
C613 DELAY_VBIASP a_23437_1842# 0.0414f
C614 a_15511_2470# a_15403_1842# 0.01697f
C615 DELAY_VBIASP a_12363_1842# 0.06627f
C616 DELAY_VBIASN a_22243_1842# 0.07254f
C617 a_21157_1842# a_20397_1842# 0.03319f
C618 a_26043_1842# a_26477_1842# 0.6972f
C619 a_26985_519# VDD 0.29292f
C620 VDD a_20071_2470# 0.01806f
C621 a_25391_1842# a_25283_1842# 0.01163f
C622 a_20593_1842# a_21157_1842# 0.0114f
C623 VDD a_14513_1842# 0.49417f
C624 VDD a_10985_1044# 0.30409f
C625 VDD a_24084_1008# 0.28225f
C626 a_1256_1044# a_1721_1395# 0.13421f
C627 VDD a_6153_1842# 0.49285f
C628 a_17357_1842# a_17683_1842# 0.01427f
C629 a_13991_1842# a_13883_1842# 0.01163f
C630 a_19073_1842# a_19637_1842# 0.0114f
C631 a_27237_1842# a_27433_1842# 0.77122f
C632 a_16510_1044# a_17357_1842# 0.08038f
C633 VDD MUX_SEL3 0.4053f
C634 a_25630_1044# a_25717_1842# 0.1088f
C635 DELAY_VBIASN a_20723_1842# 0.07254f
C636 DELAY_VBIASP a_21917_1842# 0.0414f
C637 a_4350_1044# a_2019_311# 0.02042f
C638 DELAY_VBIASN a_11277_1842# 0.09974f
C639 VDD a_26185_1044# 0.30409f
C640 DELAY_VBIASP a_11473_1842# 0.11222f
C641 a_16108_289# a_16851_309# 0.06181f
C642 a_24197_1842# a_24084_1008# 0.02055f
C643 a_11848_1044# a_11924_1008# 0.01176f
C644 VDD a_4905_1044# 0.30126f
C645 a_22590_1044# a_16108_289# 0.58202f
C646 a_6717_1842# a_7364_1008# 0.02011f
C647 DELAY_VBIASP a_19073_1842# 0.11222f
C648 DELAY_VBIASN a_18877_1842# 0.09992f
C649 a_21917_1842# a_19550_1044# 0.02479f
C650 MUX_SEL3 a_2297_331# 0.01595f
C651 MUX_SEL4 a_1721_331# 0.05813f
C652 MUX_SEL2 a_2873_331# 0.01422f
C653 VDD a_17351_1008# 0.28565f
C654 a_10951_2470# VDD 0.01806f
C655 a_21483_1842# a_21591_2470# 0.01697f
C656 a_22488_1044# a_22590_1044# 0.37183f
C657 a_4763_1842# a_4871_2470# 0.01697f
C658 VDD a_27433_1842# 0.49285f
C659 a_11785_519# MUX_SEL4 0.03255f
C660 a_10430_1044# a_10404_1008# 0.277f
C661 a_1256_1044# MUX_SEL0 0.3314f
C662 DELAY_IN DELAY_VBIASP 0.07719f
C663 VDD a_16793_1842# 0.49277f
C664 a_8997_1842# a_9193_1842# 0.77122f
C665 a_21625_1044# a_19550_1044# 0.03208f
C666 a_20968_1044# a_21044_1008# 0.01176f
C667 a_4437_1842# DELAY_VBIASP 0.0414f
C668 a_4003_1842# DELAY_IN 0.54998f
C669 a_12505_1044# a_12715_1044# 0.09424f
C670 VDD a_9193_1842# 0.49285f
C671 a_4437_1842# a_4003_1842# 0.69698f
C672 a_27915_1044# a_25630_1044# 0.39036f
C673 a_20968_1044# a_19550_1044# 0.38994f
C674 a_22677_1842# a_22243_1842# 0.69698f
C675 DELAY_VBIASN a_14513_1842# 0.0961f
C676 DELAY_VBIASP a_14643_1842# 0.06627f
C677 a_26151_1842# a_26043_1842# 0.01163f
C678 a_1544_289# MUX_SEL4 0.47529f
C679 a_1256_289# MUX_OUT 0.1134f
C680 a_7673_1842# a_7803_1842# 0.70845f
C681 DELAY_VBIASN a_6153_1842# 0.0961f
C682 DELAY_VBIASP a_6283_1842# 0.06627f
C683 MUX_SEL4 a_15765_463# 0.65508f
C684 a_19448_1044# a_19550_1044# 0.37183f
C685 a_22590_1044# a_23431_1008# 0.28268f
C686 a_9323_1842# a_7390_1044# 0.01012f
C687 a_14751_2470# VDD 0.01806f
C688 MUX_SEL0 MUX_SEL2 0.01204f
C689 VDD a_7477_1842# 0.86707f
C690 VDD a_14317_1842# 0.86909f
C691 a_26043_1842# a_25630_1044# 0.01012f
C692 a_18585_1044# a_18795_1044# 0.09424f
C693 VDD a_3449_331# 0.46596f
C694 a_22590_1044# a_23145_1044# 0.03209f
C695 VDD a_23871_2470# 0.01806f
C696 VDD a_8808_1044# 0.17499f
C697 a_18551_1842# a_18443_1842# 0.01163f
C698 a_15077_1842# a_15837_1842# 0.02912f
C699 VDD a_14235_1044# 0.15389f
C700 a_16510_1044# a_17865_519# 0.02165f
C701 a_26395_1044# a_26185_1044# 0.09424f
C702 VDD a_24523_1842# 0.4973f
C703 a_16510_1044# a_18877_1842# 0.02479f
C704 a_5115_1044# a_4350_1044# 0.39037f
C705 MUX_SEL0 MUX_SEL1 3.14917f
C706 a_25717_1842# a_25913_1842# 0.73897f
C707 a_22564_1008# a_22677_1842# 0.05157f
C708 DELAY_OUT_LAST a_27997_1842# 0.70955f
C709 DELAY_VBIASP a_27563_1842# 0.06629f
C710 DELAY_VBIASN a_27433_1842# 0.0961f
C711 a_7390_1044# a_9675_1044# 0.39036f
C712 a_27705_1044# a_25630_1044# 0.03208f
C713 a_6717_1842# a_4350_1044# 0.02479f
C714 a_13470_1044# a_14317_1842# 0.08038f
C715 VDD a_8745_519# 0.29292f
C716 DELAY_VBIASP a_16923_1842# 0.06627f
C717 DELAY_VBIASN a_16793_1842# 0.0961f
C718 MUX_SEL4 a_4350_1044# 0.31434f
C719 a_12797_1842# a_12993_1842# 0.76914f
C720 a_22873_1842# a_23003_1842# 0.70845f
C721 a_5957_1842# a_5523_1842# 0.6972f
C722 a_13470_1044# a_14235_1044# 0.39037f
C723 VDD a_21157_1842# 0.85848f
C724 VDD a_10713_1842# 0.49294f
C725 DELAY_VBIASN a_9193_1842# 0.0961f
C726 DELAY_VBIASP a_9323_1842# 0.06627f
C727 a_6425_1044# a_4350_1044# 0.03208f
C728 a_12791_1008# a_12797_1842# 0.02354f
C729 VDD a_16851_309# 0.51536f
C730 a_16510_1044# a_18795_1044# 0.39036f
C731 a_18313_1842# a_18877_1842# 0.0114f
C732 a_22113_1842# a_22243_1842# 0.70845f
C733 VDD a_22590_1044# 0.89557f
C734 a_16033_1842# a_16163_1842# 0.70845f
C735 a_12797_1842# a_12037_1842# 0.02912f
C736 VDD a_10404_1008# 0.28633f
C737 a_15545_1044# a_15755_1044# 0.09424f
C738 a_1256_289# a_2019_311# 0.02904f
C739 a_27048_1044# VDD 0.17499f
C740 VDD a_7151_2470# 0.01806f
C741 DELAY_VBIASP a_7673_1842# 0.11222f
C742 DELAY_VBIASN a_7477_1842# 0.08375f
C743 a_1256_1044# VDD 0.475f
C744 VDD a_7288_1044# 0.17274f
C745 DELAY_VBIASN a_14317_1842# 0.09974f
C746 MUX_OUT a_1544_1044# 0.04258f
C747 a_22590_1044# a_24197_1842# 0.05231f
C748 a_27124_1008# a_26477_1842# 0.02312f
C749 a_21353_1842# a_21483_1842# 0.70845f
C750 a_16108_289# a_24957_1842# 0.0157f
C751 a_11277_1842# a_11603_1842# 0.01427f
C752 DELAY_VBIASP a_25717_1842# 0.0414f
C753 DELAY_VBIASN a_24523_1842# 0.07254f
C754 MUX_SEL1 a_3449_1395# 0.29404f
C755 MUX_SEL0 a_1721_1395# 0.01315f
C756 a_16510_1044# a_17351_1008# 0.28268f
C757 VDD a_18004_1008# 0.28225f
C758 a_20593_1842# a_20397_1842# 0.76914f
C759 DELAY_VBIASP a_22873_1842# 0.11222f
C760 DELAY_VBIASP a_12797_1842# 0.0414f
C761 a_26043_1842# a_25913_1842# 0.70845f
C762 VDD a_19311_2470# 0.01806f
C763 a_5731_289# a_16108_289# 0.01334f
C764 VDD a_24008_1044# 0.17499f
C765 VDD a_5523_1842# 0.49671f
C766 a_17357_1842# a_18117_1842# 0.03319f
C767 a_18877_1842# a_19203_1842# 0.01427f
C768 a_27237_1842# a_26803_1842# 0.6972f
C769 VDD MUX_SEL2 0.50938f
C770 a_5731_289# a_10430_1044# 0.41176f
C771 DELAY_VBIASP a_21353_1842# 0.11222f
C772 a_4350_1044# a_5705_519# 0.02005f
C773 a_15755_1044# a_15831_1008# 0.01194f
C774 DELAY_VBIASN a_21157_1842# 0.09156f
C775 DELAY_VBIASN a_10713_1842# 0.0961f
C776 DELAY_VBIASP a_10843_1842# 0.06627f
C777 VDD a_24665_1044# 0.29722f
C778 a_15964_289# a_16851_309# 0.16757f
C779 a_20397_1842# a_20391_1008# 0.02349f
C780 VDD a_4157_1313# 0.48935f
C781 DELAY_VBIASP a_18443_1842# 0.06627f
C782 a_9757_1842# a_10517_1842# 0.06198f
C783 DELAY_VBIASN a_22590_1044# 0.02115f
C784 a_12791_1008# a_12505_1044# 0.01885f
C785 VDD a_17275_1044# 0.15389f
C786 MUX_SEL2 a_2297_331# 0.10655f
C787 a_24665_1044# a_24197_1842# 0.2079f
C788 MUX_SEL4 a_7390_1044# 0.34655f
C789 VDD MUX_SEL1 0.50267f
C790 a_6283_1842# a_6391_1842# 0.01163f
C791 a_20905_519# a_19550_1044# 0.02165f
C792 VDD a_26803_1842# 0.49671f
C793 a_10328_1044# a_10404_1008# 0.01176f
C794 a_12505_1044# a_12037_1842# 0.2079f
C795 a_18877_1842# a_19524_1008# 0.02011f
C796 VDD a_16163_1842# 0.4973f
C797 a_8997_1842# a_8563_1842# 0.6972f
C798 a_4437_1842# DELAY_IN 0.05007f
C799 a_14751_1842# a_14643_1842# 0.01163f
C800 a_4157_1313# a_4324_1008# 0.02463f
C801 VDD a_8563_1842# 0.49671f
C802 DELAY_VBIASP a_26043_1842# 0.06627f
C803 a_1544_1044# a_2297_1395# 0.28651f
C804 a_27124_1008# a_25630_1044# 0.28279f
C805 a_20105_1044# a_20391_1008# 0.01885f
C806 DELAY_VBIASP a_15077_1842# 0.04141f
C807 a_7673_1842# a_8237_1842# 0.0114f
C808 a_1256_289# MUX_SEL4 0.65005f
C809 a_1544_289# MUX_SEL3 0.15976f
C810 DELAY_VBIASP a_6717_1842# 0.0414f
C811 DELAY_VBIASN a_5523_1842# 0.07254f
C812 MUX_SEL4 a_14825_519# 0.03307f
C813 a_9757_1842# a_7390_1044# 0.02479f
C814 VDD a_6913_1842# 0.49426f
C815 a_5197_1842# a_5523_1842# 0.01427f
C816 a_13991_2470# VDD 0.01806f
C817 VDD a_23763_1842# 0.49671f
C818 VDD a_13753_1842# 0.49294f
C819 a_5523_1842# a_5631_2470# 0.01697f
C820 VDD a_2873_331# 0.46491f
C821 a_8563_1842# a_8671_1842# 0.01163f
C822 a_9675_1044# a_9751_1008# 0.01194f
C823 VDD a_8231_1008# 0.28336f
C824 MUX_SEL0 a_3449_1395# 0.10753f
C825 DELAY_VBIASN a_4157_1313# 0.01202f
C826 a_26985_519# a_25630_1044# 0.02165f
C827 VDD a_13444_1008# 0.28633f
C828 a_15077_1842# a_15273_1842# 0.77122f
C829 a_16510_1044# a_16851_309# 0.02131f
C830 a_25391_2470# a_25283_1842# 0.01697f
C831 VDD a_24957_1842# 0.87825f
C832 a_18117_1842# a_18877_1842# 0.02912f
C833 a_15077_1842# a_15545_1044# 0.2079f
C834 a_10517_1842# a_11277_1842# 0.01669f
C835 a_24197_1842# a_23763_1842# 0.6972f
C836 VDD a_1721_1395# 0.4533f
C837 a_13557_1842# a_14317_1842# 0.01669f
C838 a_7477_1842# a_7364_1008# 0.05157f
C839 a_14888_1044# a_14964_1008# 0.01176f
C840 a_25717_1842# a_25283_1842# 0.69698f
C841 a_22590_1044# a_22677_1842# 0.1088f
C842 DELAY_VBIASP a_27997_1842# 0.04001f
C843 DELAY_VBIASN a_26803_1842# 0.07254f
C844 a_8155_1044# a_8231_1008# 0.01194f
C845 a_7390_1044# a_8884_1008# 0.28279f
C846 a_26185_1044# a_25630_1044# 0.03209f
C847 a_7043_1842# a_7151_1842# 0.01163f
C848 a_24197_1842# a_24957_1842# 0.02912f
C849 VDD a_5731_289# 0.6143f
C850 DELAY_VBIASP a_17357_1842# 0.0414f
C851 VDD a_20397_1842# 0.86909f
C852 DELAY_VBIASN a_16163_1842# 0.07254f
C853 a_22873_1842# a_23437_1842# 0.0114f
C854 a_9323_1842# a_9431_2470# 0.01697f
C855 a_5393_1842# a_5523_1842# 0.70845f
C856 a_12797_1842# a_12363_1842# 0.6972f
C857 a_13470_1044# a_13444_1008# 0.277f
C858 a_26911_1842# a_26803_1842# 0.01163f
C859 VDD a_20593_1842# 0.49417f
C860 a_17065_1044# a_17351_1008# 0.01885f
C861 VDD a_10083_1842# 0.49727f
C862 a_13883_1842# a_14317_1842# 0.6972f
C863 DELAY_VBIASN a_8563_1842# 0.07254f
C864 DELAY_VBIASP a_9757_1842# 0.0414f
C865 a_4905_1044# a_4350_1044# 0.03209f
C866 a_23145_1044# a_23431_1008# 0.01885f
C867 a_10951_1842# a_10843_1842# 0.01163f
C868 VDD a_16108_289# 1.25759f
C869 a_16510_1044# a_18004_1008# 0.28279f
C870 a_16597_1842# a_17357_1842# 0.01669f
C871 VDD MUX_SEL0 0.56365f
C872 VDD a_22488_1044# 0.17274f
C873 a_7803_1842# a_7911_2470# 0.01697f
C874 a_12233_1842# a_12037_1842# 0.77122f
C875 VDD a_10430_1044# 0.88416f
C876 a_5731_289# a_13470_1044# 0.41365f
C877 a_26471_1008# VDD 0.28336f
C878 VDD a_6391_2470# 0.01806f
C879 DELAY_VBIASP a_7043_1842# 0.06627f
C880 DELAY_VBIASN a_6913_1842# 0.0961f
C881 VDD a_6711_1008# 0.2822f
C882 VDD a_20391_1008# 0.28336f
C883 DELAY_VBIASN a_13753_1842# 0.0961f
C884 DELAY_VBIASN a_23763_1842# 0.07254f
C885 MUX_SEL4 a_1544_1044# 0.03407f
C886 a_10985_1044# a_10517_1842# 0.19203f
C887 a_27048_1044# a_26477_1842# 0.10863f
C888 a_21353_1842# a_21917_1842# 0.0114f
C889 VDD a_16033_1842# 0.49413f
C890 a_1256_1044# a_2873_1395# 0.28892f
C891 VDD a_20105_1044# 0.30409f
C892 a_11277_1842# a_12037_1842# 0.03319f
C893 a_19833_1842# a_20397_1842# 0.0114f
C894 DELAY_VBIASP a_25153_1842# 0.11222f
C895 DELAY_VBIASN a_24957_1842# 0.09992f
C896 a_26043_1842# a_26151_2470# 0.01697f
C897 a_7288_1044# a_7364_1008# 0.01176f
C898 a_16510_1044# a_17275_1044# 0.39037f
C899 DELAY_VBIASP a_22243_1842# 0.06627f
C900 DELAY_VBIASP a_12233_1842# 0.11222f
C901 VDD a_18551_2470# 0.01806f
C902 a_11277_1842# a_11924_1008# 0.02312f
C903 a_5731_289# a_15964_289# 0.2778f
C904 VDD a_5957_1842# 0.85848f
C905 VDD a_23431_1008# 0.28336f
C906 DELAY_VBIASN a_20397_1842# 0.09974f
C907 a_17357_1842# a_17553_1842# 0.76914f
C908 a_18877_1842# a_19637_1842# 0.06198f
C909 a_15077_1842# a_14964_1008# 0.02055f
C910 a_26673_1842# a_26803_1842# 0.70845f
C911 MUX_OUT a_2019_311# 8.45486f
C912 a_25604_1008# a_24957_1842# 0.02011f
C913 DELAY_VBIASN a_20593_1842# 0.0961f
C914 a_22243_1842# a_22351_2470# 0.01697f
C915 DELAY_VBIASP a_20723_1842# 0.06627f
C916 DELAY_VBIASN a_10083_1842# 0.07254f
C917 DELAY_VBIASP a_11277_1842# 0.0414f
C918 VDD a_23145_1044# 0.30409f
C919 a_15964_289# a_16108_289# 0.42202f
C920 VDD a_3449_1395# 0.46731f
C921 DELAY_VBIASP a_18877_1842# 0.0414f
C922 a_9757_1842# a_9953_1842# 0.76914f
C923 MUX_SEL2 a_1721_331# 0.01315f
C924 a_27915_1044# a_27991_1008# 0.01194f
C925 VDD a_16484_1008# 0.28597f
C926 DELAY_VBIASN a_10430_1044# 0.02115f
C927 a_10328_1044# a_10430_1044# 0.37183f
C928 VDD a_27237_1842# 0.85969f
C929 MUX_SEL1 a_2873_1395# 0.13092f
C930 a_26803_1842# a_26477_1842# 0.01427f
C931 a_19203_1842# a_19311_2470# 0.01697f
C932 DELAY_VBIASN a_16033_1842# 0.0961f
C933 a_26395_1044# a_26471_1008# 0.01194f
C934 a_8433_1842# a_8563_1842# 0.70845f
C935 a_20315_1044# a_20391_1008# 0.01194f
C936 a_6635_1044# a_6711_1008# 0.01194f
C937 a_21483_1842# a_21591_1842# 0.01163f
C938 VDD a_8997_1842# 0.85848f
C939 a_9757_1842# a_9751_1008# 0.02354f
C940 a_27048_1044# a_25630_1044# 0.38994f
C941 a_20105_1044# a_20315_1044# 0.09424f
C942 DELAY_VBIASP a_14513_1842# 0.11222f
C943 a_1256_289# MUX_SEL3 1.41161f
C944 a_1544_289# MUX_SEL2 0.07405f
C945 DELAY_VBIASP a_6153_1842# 0.11222f
C946 DELAY_VBIASN a_5957_1842# 0.09156f
C947 a_27991_1008# a_27705_1044# 0.01885f
C948 a_5115_1044# a_5191_1008# 0.01194f
C949 a_5197_1842# a_5957_1842# 0.03319f
C950 a_13231_2470# VDD 0.01806f
C951 a_8237_1842# a_8884_1008# 0.02312f
C952 DELAY_IN MUX_SEL4 0.0663f
C953 VDD a_24197_1842# 0.85848f
C954 VDD a_13123_1842# 0.49727f
C955 VDD a_2297_331# 0.46496f
C956 a_16923_1842# a_17031_2470# 0.01697f
C957 VDD a_8155_1044# 0.15389f
C958 a_15077_1842# a_14643_1842# 0.6972f
C959 a_16510_1044# a_16108_289# 0.56108f
C960 VDD a_13470_1044# 0.87936f
C961 a_10517_1842# a_10713_1842# 0.73897f
C962 a_13231_2470# a_13123_1842# 0.01697f
C963 a_23633_1842# a_23763_1842# 0.70845f
C964 a_24875_1044# a_24951_1008# 0.01194f
C965 a_6717_1842# a_6283_1842# 0.6972f
C966 a_13557_1842# a_13753_1842# 0.73897f
C967 a_7477_1842# a_7390_1044# 0.1088f
C968 a_16271_1842# a_16163_1842# 0.01163f
C969 VDD a_4324_1008# 0.28597f
C970 a_25153_1842# a_25283_1842# 0.70845f
C971 DELAY_VBIASP a_27433_1842# 0.11222f
C972 DELAY_VBIASN a_27237_1842# 0.09456f
C973 a_7390_1044# a_8808_1044# 0.38994f
C974 a_13444_1008# a_13557_1842# 0.05157f
C975 a_10517_1842# a_10404_1008# 0.05157f
C976 MUX_SEL4 MUX_OUT 0.91933f
C977 DELAY_VBIASP a_16793_1842# 0.11222f
C978 VDD a_19833_1842# 0.49294f
C979 a_5393_1842# a_5957_1842# 0.0114f
C980 a_12233_1842# a_12363_1842# 0.70845f
C981 a_13368_1044# a_13444_1008# 0.01176f
C982 a_13991_2470# a_13883_1842# 0.01697f
C983 a_17065_1044# a_17275_1044# 0.09424f
C984 a_13883_1842# a_13753_1842# 0.70845f
C985 DELAY_VBIASP a_9193_1842# 0.11222f
C986 DELAY_VBIASN a_8997_1842# 0.09156f
C987 a_4157_1313# a_4350_1044# 0.04624f
C988 a_18117_1842# a_18004_1008# 0.02055f
C989 VDD a_15964_289# 0.31312f
C990 a_16597_1842# a_16793_1842# 0.73897f
C991 a_8745_519# a_7390_1044# 0.01756f
C992 VDD DELAY_VBIASN 0.9333f
C993 a_21917_1842# a_22243_1842# 0.01427f
C994 a_15837_1842# a_16163_1842# 0.01427f
C995 VDD a_21911_1008# 0.2822f
C996 VDD a_10328_1044# 0.17274f
C997 a_5197_1842# VDD 0.86909f
C998 a_5731_289# a_11785_519# 0.28056f
C999 MUX_SEL0 a_2873_1395# 0.01504f
C1000 DELAY_VBIASP a_7477_1842# 0.0414f
C1001 VDD a_5631_2470# 0.01806f
C1002 a_26395_1044# VDD 0.15389f
C1003 VDD a_20315_1044# 0.15389f
C1004 VDD a_6635_1044# 0.15406f
C1005 DELAY_VBIASN a_13123_1842# 0.07254f
C1006 DELAY_VBIASN a_24197_1842# 0.09156f
C1007 DELAY_VBIASP a_14317_1842# 0.0414f
C1008 a_26471_1008# a_26477_1842# 0.02349f
C1009 a_22590_1044# a_23003_1842# 0.01012f
C1010 VDD a_15403_1842# 0.4973f
C1011 a_23145_1044# a_22677_1842# 0.19203f
C1012 VDD a_18585_1044# 0.29722f
C1013 VDD a_25604_1008# 0.28633f
C1014 a_11277_1842# a_11473_1842# 0.76914f
C1015 DELAY_VBIASN a_13470_1044# 0.02115f
C1016 a_19963_1842# a_20071_2470# 0.01697f
C1017 DELAY_VBIASP a_24523_1842# 0.06627f
C1018 a_27997_1842# a_27563_1842# 0.69646f
C1019 a_11785_519# a_10430_1044# 0.02058f
C1020 a_16510_1044# a_16484_1008# 0.277f
C1021 a_7288_1044# a_7390_1044# 0.37183f
C1022 a_21917_1842# a_22564_1008# 0.02011f
C1023 VDD a_17791_2470# 0.01806f
C1024 a_5731_289# a_15765_463# 0.23301f
C1025 a_11277_1842# a_11848_1044# 0.10863f
C1026 a_11711_1842# a_11603_1842# 0.01163f
C1027 VDD a_5393_1842# 0.49417f
C1028 a_18877_1842# a_19073_1842# 0.76914f
C1029 a_17357_1842# a_16923_1842# 0.6972f
C1030 DELAY_VBIASN a_19833_1842# 0.0961f
C1031 a_15403_1842# a_13470_1044# 0.01012f
C1032 a_26673_1842# a_27237_1842# 0.0114f
C1033 MUX_SEL4 a_2019_311# 0.90276f
C1034 a_14311_1008# a_14025_1044# 0.01885f
C1035 a_7945_1044# a_7477_1842# 0.19203f
C1036 DELAY_VBIASP a_21157_1842# 0.04141f
C1037 DELAY_VBIASP a_10713_1842# 0.11222f
C1038 a_21157_1842# a_21044_1008# 0.02055f
C1039 a_10430_1044# a_12715_1044# 0.39036f
C1040 a_15765_463# a_16108_289# 0.42004f
C1041 a_23437_1842# a_24084_1008# 0.02312f
C1042 VDD a_17683_1842# 0.49671f
C1043 MUX_SEL4 a_12797_1842# 0.01829f
C1044 a_21157_1842# a_19550_1044# 0.05231f
C1045 a_9757_1842# a_9323_1842# 0.6972f
C1046 VDD a_16510_1044# 0.8795f
C1047 a_5197_1842# DELAY_VBIASN 0.09974f
C1048 VDD a_22677_1842# 0.86707f
C1049 VDD a_26673_1842# 0.49417f
C1050 a_26803_1842# a_26911_2470# 0.01697f
C1051 a_18877_1842# a_19448_1044# 0.10864f
C1052 a_5731_289# a_4350_1044# 0.41099f
C1053 a_27237_1842# a_26477_1842# 0.03319f
C1054 a_16108_289# a_25630_1044# 0.55833f
C1055 a_8433_1842# a_8997_1842# 0.0114f
C1056 DELAY_VBIASN a_15403_1842# 0.07254f
C1057 a_24393_1842# a_24523_1842# 0.70845f
C1058 VDD a_8433_1842# 0.49417f
C1059 a_26471_1008# a_25630_1044# 0.28268f
C1060 VDD a_18313_1842# 0.49285f
C1061 VDD a_27671_2470# 0.01806f
C1062 a_7477_1842# a_8237_1842# 0.01669f
C1063 a_1256_289# MUX_SEL2 0.33134f
C1064 DELAY_VBIASP a_5523_1842# 0.06627f
C1065 DELAY_VBIASN a_5393_1842# 0.0961f
C1066 a_15837_1842# a_16033_1842# 0.76914f
C1067 a_27915_1044# a_27705_1044# 0.09424f
C1068 VDD a_26477_1842# 0.86909f
C1069 VDD a_2873_1395# 0.46517f
C1070 a_6711_1008# a_4350_1044# 0.26208f
C1071 a_5197_1842# a_5393_1842# 0.76914f
C1072 a_8237_1842# a_8808_1044# 0.10863f
C1073 a_12471_2470# VDD 0.01806f
C1074 a_5705_519# a_2019_311# 0.13872f
C1075 VDD a_23633_1842# 0.49417f
C1076 VDD a_13557_1842# 0.86707f
C1077 VDD a_1721_331# 0.45259f
C1078 a_5957_1842# a_5844_1008# 0.02055f
C1079 VDD a_7364_1008# 0.28633f
C1080 a_14964_1008# a_14317_1842# 0.02312f
C1081 a_14513_1842# a_14643_1842# 0.70845f
C1082 VDD a_13368_1044# 0.17274f
C1083 VDD a_11785_519# 0.29292f
C1084 a_16510_1044# a_15964_289# 0.05416f
C1085 a_10517_1842# a_10083_1842# 0.69698f
C1086 DELAY_VBIASN a_17683_1842# 0.07254f
C1087 a_4437_1842# a_4905_1044# 0.19203f
C1088 a_23633_1842# a_24197_1842# 0.0114f
C1089 DELAY_VBIASN a_16510_1044# 0.02115f
C1090 a_13557_1842# a_13123_1842# 0.69698f
C1091 a_6153_1842# a_6283_1842# 0.70845f
C1092 VDD a_22113_1842# 0.49426f
C1093 a_9465_1044# a_8997_1842# 0.2079f
C1094 DELAY_VBIASN a_22677_1842# 0.08375f
C1095 a_25153_1842# a_25717_1842# 0.0114f
C1096 VDD a_11603_1842# 0.49671f
C1097 a_4905_1044# a_5191_1008# 0.01885f
C1098 DELAY_VBIASN a_26673_1842# 0.0961f
C1099 DELAY_VBIASP a_26803_1842# 0.06627f
C1100 MUX_SEL4 a_6717_1842# 0.0195f
C1101 a_5957_1842# a_4350_1044# 0.05231f
C1102 a_13470_1044# a_13557_1842# 0.1088f
C1103 a_7390_1044# a_8231_1008# 0.28268f
C1104 VDD a_13883_1842# 0.4973f
R0 DELAY_VBIASN.n1 DELAY_VBIASN.t31 34.3755
R1 DELAY_VBIASN.n1 DELAY_VBIASN.t30 33.0005
R2 DELAY_VBIASN.n2 DELAY_VBIASN.t29 33.0005
R3 DELAY_VBIASN.n3 DELAY_VBIASN.t28 33.0005
R4 DELAY_VBIASN.n4 DELAY_VBIASN.t27 33.0005
R5 DELAY_VBIASN.n5 DELAY_VBIASN.t26 33.0005
R6 DELAY_VBIASN.n6 DELAY_VBIASN.t25 33.0005
R7 DELAY_VBIASN.n7 DELAY_VBIASN.t24 33.0005
R8 DELAY_VBIASN.n8 DELAY_VBIASN.t23 33.0005
R9 DELAY_VBIASN.n9 DELAY_VBIASN.t22 33.0005
R10 DELAY_VBIASN.n10 DELAY_VBIASN.t21 33.0005
R11 DELAY_VBIASN.n11 DELAY_VBIASN.t20 33.0005
R12 DELAY_VBIASN.n12 DELAY_VBIASN.t19 33.0005
R13 DELAY_VBIASN.n13 DELAY_VBIASN.t18 33.0005
R14 DELAY_VBIASN.n14 DELAY_VBIASN.t17 33.0005
R15 DELAY_VBIASN.n15 DELAY_VBIASN.t16 33.0005
R16 DELAY_VBIASN.n16 DELAY_VBIASN.t15 33.0005
R17 DELAY_VBIASN.n17 DELAY_VBIASN.t14 33.0005
R18 DELAY_VBIASN.n18 DELAY_VBIASN.t13 33.0005
R19 DELAY_VBIASN.n19 DELAY_VBIASN.t12 33.0005
R20 DELAY_VBIASN.n20 DELAY_VBIASN.t11 33.0005
R21 DELAY_VBIASN.n21 DELAY_VBIASN.t10 33.0005
R22 DELAY_VBIASN.n22 DELAY_VBIASN.t9 33.0005
R23 DELAY_VBIASN.n23 DELAY_VBIASN.t8 33.0005
R24 DELAY_VBIASN.n24 DELAY_VBIASN.t7 33.0005
R25 DELAY_VBIASN.n25 DELAY_VBIASN.t6 33.0005
R26 DELAY_VBIASN.n26 DELAY_VBIASN.t5 33.0005
R27 DELAY_VBIASN.n27 DELAY_VBIASN.t4 33.0005
R28 DELAY_VBIASN.n28 DELAY_VBIASN.t3 33.0005
R29 DELAY_VBIASN.n29 DELAY_VBIASN.t2 33.0005
R30 DELAY_VBIASN.n30 DELAY_VBIASN.t1 33.0005
R31 DELAY_VBIASN.n0 DELAY_VBIASN.t0 33.0005
R32 DELAY_VBIASN DELAY_VBIASN.n0 1.55517
R33 DELAY_VBIASN.n0 DELAY_VBIASN.n30 1.3755
R34 DELAY_VBIASN.n30 DELAY_VBIASN.n29 1.3755
R35 DELAY_VBIASN.n29 DELAY_VBIASN.n28 1.3755
R36 DELAY_VBIASN.n28 DELAY_VBIASN.n27 1.3755
R37 DELAY_VBIASN.n27 DELAY_VBIASN.n26 1.3755
R38 DELAY_VBIASN.n26 DELAY_VBIASN.n25 1.3755
R39 DELAY_VBIASN.n25 DELAY_VBIASN.n24 1.3755
R40 DELAY_VBIASN.n24 DELAY_VBIASN.n23 1.3755
R41 DELAY_VBIASN.n23 DELAY_VBIASN.n22 1.3755
R42 DELAY_VBIASN.n22 DELAY_VBIASN.n21 1.3755
R43 DELAY_VBIASN.n21 DELAY_VBIASN.n20 1.3755
R44 DELAY_VBIASN.n20 DELAY_VBIASN.n19 1.3755
R45 DELAY_VBIASN.n19 DELAY_VBIASN.n18 1.3755
R46 DELAY_VBIASN.n18 DELAY_VBIASN.n17 1.3755
R47 DELAY_VBIASN.n17 DELAY_VBIASN.n16 1.3755
R48 DELAY_VBIASN.n16 DELAY_VBIASN.n15 1.3755
R49 DELAY_VBIASN.n15 DELAY_VBIASN.n14 1.3755
R50 DELAY_VBIASN.n14 DELAY_VBIASN.n13 1.3755
R51 DELAY_VBIASN.n13 DELAY_VBIASN.n12 1.3755
R52 DELAY_VBIASN.n12 DELAY_VBIASN.n11 1.3755
R53 DELAY_VBIASN.n11 DELAY_VBIASN.n10 1.3755
R54 DELAY_VBIASN.n10 DELAY_VBIASN.n9 1.3755
R55 DELAY_VBIASN.n9 DELAY_VBIASN.n8 1.3755
R56 DELAY_VBIASN.n8 DELAY_VBIASN.n7 1.3755
R57 DELAY_VBIASN.n7 DELAY_VBIASN.n6 1.3755
R58 DELAY_VBIASN.n6 DELAY_VBIASN.n5 1.3755
R59 DELAY_VBIASN.n5 DELAY_VBIASN.n4 1.3755
R60 DELAY_VBIASN.n4 DELAY_VBIASN.n3 1.3755
R61 DELAY_VBIASN.n3 DELAY_VBIASN.n2 1.3755
R62 DELAY_VBIASN.n2 DELAY_VBIASN.n1 1.3755
R63 DELAY_VBIASP.n1 DELAY_VBIASP.t31 34.3685
R64 DELAY_VBIASP.n1 DELAY_VBIASP.t30 33.0005
R65 DELAY_VBIASP.n2 DELAY_VBIASP.t29 33.0005
R66 DELAY_VBIASP.n3 DELAY_VBIASP.t28 33.0005
R67 DELAY_VBIASP.n4 DELAY_VBIASP.t27 33.0005
R68 DELAY_VBIASP.n5 DELAY_VBIASP.t26 33.0005
R69 DELAY_VBIASP.n6 DELAY_VBIASP.t25 33.0005
R70 DELAY_VBIASP.n7 DELAY_VBIASP.t24 33.0005
R71 DELAY_VBIASP.n8 DELAY_VBIASP.t23 33.0005
R72 DELAY_VBIASP.n9 DELAY_VBIASP.t22 33.0005
R73 DELAY_VBIASP.n10 DELAY_VBIASP.t21 33.0005
R74 DELAY_VBIASP.n11 DELAY_VBIASP.t20 33.0005
R75 DELAY_VBIASP.n12 DELAY_VBIASP.t19 33.0005
R76 DELAY_VBIASP.n13 DELAY_VBIASP.t18 33.0005
R77 DELAY_VBIASP.n14 DELAY_VBIASP.t17 33.0005
R78 DELAY_VBIASP.n15 DELAY_VBIASP.t16 33.0005
R79 DELAY_VBIASP.n16 DELAY_VBIASP.t15 33.0005
R80 DELAY_VBIASP.n17 DELAY_VBIASP.t14 33.0005
R81 DELAY_VBIASP.n18 DELAY_VBIASP.t13 33.0005
R82 DELAY_VBIASP.n19 DELAY_VBIASP.t12 33.0005
R83 DELAY_VBIASP.n20 DELAY_VBIASP.t11 33.0005
R84 DELAY_VBIASP.n21 DELAY_VBIASP.t10 33.0005
R85 DELAY_VBIASP.n22 DELAY_VBIASP.t9 33.0005
R86 DELAY_VBIASP.n23 DELAY_VBIASP.t8 33.0005
R87 DELAY_VBIASP.n24 DELAY_VBIASP.t7 33.0005
R88 DELAY_VBIASP.n25 DELAY_VBIASP.t6 33.0005
R89 DELAY_VBIASP.n26 DELAY_VBIASP.t5 33.0005
R90 DELAY_VBIASP.n27 DELAY_VBIASP.t4 33.0005
R91 DELAY_VBIASP.n28 DELAY_VBIASP.t3 33.0005
R92 DELAY_VBIASP.n29 DELAY_VBIASP.t2 33.0005
R93 DELAY_VBIASP.n30 DELAY_VBIASP.t1 33.0005
R94 DELAY_VBIASP.n0 DELAY_VBIASP.t0 33.0005
R95 DELAY_VBIASP DELAY_VBIASP.n0 1.70586
R96 DELAY_VBIASP.n0 DELAY_VBIASP.n30 1.36852
R97 DELAY_VBIASP.n30 DELAY_VBIASP.n29 1.36852
R98 DELAY_VBIASP.n29 DELAY_VBIASP.n28 1.36852
R99 DELAY_VBIASP.n28 DELAY_VBIASP.n27 1.36852
R100 DELAY_VBIASP.n27 DELAY_VBIASP.n26 1.36852
R101 DELAY_VBIASP.n26 DELAY_VBIASP.n25 1.36852
R102 DELAY_VBIASP.n25 DELAY_VBIASP.n24 1.36852
R103 DELAY_VBIASP.n24 DELAY_VBIASP.n23 1.36852
R104 DELAY_VBIASP.n23 DELAY_VBIASP.n22 1.36852
R105 DELAY_VBIASP.n22 DELAY_VBIASP.n21 1.36852
R106 DELAY_VBIASP.n21 DELAY_VBIASP.n20 1.36852
R107 DELAY_VBIASP.n20 DELAY_VBIASP.n19 1.36852
R108 DELAY_VBIASP.n19 DELAY_VBIASP.n18 1.36852
R109 DELAY_VBIASP.n18 DELAY_VBIASP.n17 1.36852
R110 DELAY_VBIASP.n17 DELAY_VBIASP.n16 1.36852
R111 DELAY_VBIASP.n16 DELAY_VBIASP.n15 1.36852
R112 DELAY_VBIASP.n15 DELAY_VBIASP.n14 1.36852
R113 DELAY_VBIASP.n14 DELAY_VBIASP.n13 1.36852
R114 DELAY_VBIASP.n13 DELAY_VBIASP.n12 1.36852
R115 DELAY_VBIASP.n12 DELAY_VBIASP.n11 1.36852
R116 DELAY_VBIASP.n11 DELAY_VBIASP.n10 1.36852
R117 DELAY_VBIASP.n10 DELAY_VBIASP.n9 1.36852
R118 DELAY_VBIASP.n9 DELAY_VBIASP.n8 1.36852
R119 DELAY_VBIASP.n8 DELAY_VBIASP.n7 1.36852
R120 DELAY_VBIASP.n7 DELAY_VBIASP.n6 1.36852
R121 DELAY_VBIASP.n6 DELAY_VBIASP.n5 1.36852
R122 DELAY_VBIASP.n5 DELAY_VBIASP.n4 1.36852
R123 DELAY_VBIASP.n4 DELAY_VBIASP.n3 1.36852
R124 DELAY_VBIASP.n3 DELAY_VBIASP.n2 1.36852
R125 DELAY_VBIASP.n2 DELAY_VBIASP.n1 1.36852
R126 VSS.n3 VSS.n374 7907.02
R127 VSS.t274 VSS.n3 101.74
R128 VSS.t289 VSS.n3 101.742
R129 VSS.n3 VSS.t306 58.3213
R130 VSS.n3 VSS.t336 58.3218
R131 VSS.t349 VSS.n3 101.74
R132 VSS.t517 VSS.n3 116.469
R133 VSS.n3 VSS.t43 21.1052
R134 VSS.n7 VSS.n3 0.577899
R135 VSS.n3 VSS.n15 0.547872
R136 VSS.t326 VSS.n3 49.8619
R137 VSS.n3 VSS.t284 97.2306
R138 VSS.n8 VSS.t390 409.723
R139 VSS.n3 VSS.t42 49.7663
R140 VSS.n9 VSS.t561 59.6836
R141 VSS.t0 VSS.n425 357.007
R142 VSS.t2 VSS.n10 343.118
R143 VSS.t155 VSS.n1 69.4495
R144 VSS.n3 VSS.t299 97.2306
R145 VSS.n3 VSS.t314 97.2306
R146 VSS.n3 VSS.t344 97.2306
R147 VSS.n3 VSS.t359 97.2306
R148 VSS.t138 VSS.n13 332.017
R149 VSS.n426 VSS.t128 299.425
R150 VSS.t286 VSS.n3 105.686
R151 VSS.t301 VSS.n3 105.688
R152 VSS.t316 VSS.n3 105.688
R153 VSS.t331 VSS.n3 105.688
R154 VSS.t254 VSS.n3 110.547
R155 VSS.t13 VSS.n3 110.547
R156 VSS.n3 VSS.t136 116.469
R157 VSS.n3 VSS.t232 116.469
R158 VSS.n3 VSS.t219 116.468
R159 VSS.t516 VSS.n3 110.547
R160 VSS.t132 VSS.n3 110.547
R161 VSS.n426 VSS.t156 287.909
R162 VSS.t197 VSS.n8 105.523
R163 VSS.n14 VSS.t28 332.017
R164 VSS.n13 VSS.t140 106.362
R165 VSS.t14 VSS.n3 116.469
R166 VSS.n3 VSS.t133 116.468
R167 VSS.t255 VSS.n3 116.468
R168 VSS.t95 VSS.n12 107.335
R169 VSS.t512 VSS.n79 252.375
R170 VSS.t65 VSS.n77 252.375
R171 VSS.t386 VSS.n75 252.375
R172 VSS.t559 VSS.n65 252.375
R173 VSS.n61 VSS.t546 252.375
R174 VSS.t49 VSS.n51 252.375
R175 VSS.n18 VSS.t268 252.375
R176 VSS.n78 VSS.t32 252.375
R177 VSS.n23 VSS.t505 252.375
R178 VSS.n24 VSS.t214 252.375
R179 VSS.n66 VSS.t383 252.375
R180 VSS.n29 VSS.t524 252.375
R181 VSS.n35 VSS.t266 252.375
R182 VSS.n37 VSS.t361 252.375
R183 VSS.t267 VSS.n56 252.375
R184 VSS.n43 VSS.t502 252.375
R185 VSS.t6 VSS.n48 252.375
R186 VSS.t181 VSS.n72 252.117
R187 VSS.t385 VSS.n69 252.117
R188 VSS.t168 VSS.n63 252.117
R189 VSS.t506 VSS.n58 252.117
R190 VSS.t508 VSS.n55 252.117
R191 VSS.n21 VSS.t384 252.115
R192 VSS.t362 VSS.n97 252.115
R193 VSS.t198 VSS.n94 252.115
R194 VSS.t398 VSS.n91 252.115
R195 VSS.n26 VSS.t553 252.115
R196 VSS.t558 VSS.n88 252.115
R197 VSS.n33 VSS.t507 252.115
R198 VSS.t404 VSS.n84 252.115
R199 VSS.t543 VSS.n83 252.115
R200 VSS.n44 VSS.t393 252.115
R201 VSS.t418 VSS.n236 250.837
R202 VSS.t428 VSS.n238 250.837
R203 VSS.t414 VSS.n244 250.837
R204 VSS.t410 VSS.n246 250.837
R205 VSS.t430 VSS.n252 250.837
R206 VSS.t426 VSS.n254 250.837
R207 VSS.t434 VSS.n260 250.837
R208 VSS.t436 VSS.n262 250.837
R209 VSS.t432 VSS.n268 250.837
R210 VSS.t412 VSS.n270 250.837
R211 VSS.t438 VSS.n276 250.837
R212 VSS.t408 VSS.n278 250.837
R213 VSS.t440 VSS.n284 250.837
R214 VSS.t442 VSS.n286 250.837
R215 VSS.t448 VSS.n292 250.837
R216 VSS.t444 VSS.n294 250.837
R217 VSS.t450 VSS.n300 250.837
R218 VSS.t446 VSS.n302 250.837
R219 VSS.t454 VSS.n308 250.837
R220 VSS.t456 VSS.n310 250.837
R221 VSS.t460 VSS.n316 250.837
R222 VSS.t452 VSS.n318 250.837
R223 VSS.t458 VSS.n324 250.837
R224 VSS.t424 VSS.n326 250.837
R225 VSS.t466 VSS.n332 250.837
R226 VSS.t462 VSS.n334 250.837
R227 VSS.t468 VSS.n340 250.837
R228 VSS.t422 VSS.n342 250.837
R229 VSS.t464 VSS.n348 250.837
R230 VSS.t420 VSS.n350 250.837
R231 VSS.t416 VSS.n356 250.837
R232 VSS.t470 VSS.n358 250.837
R233 VSS.n3 VSS.t309 117.529
R234 VSS.n807 VSS.t487 234.114
R235 VSS.n790 VSS.t549 234.114
R236 VSS.n773 VSS.t407 234.114
R237 VSS.n756 VSS.t515 234.114
R238 VSS.n739 VSS.t193 234.114
R239 VSS.n722 VSS.t159 234.114
R240 VSS.n705 VSS.t481 234.114
R241 VSS.n688 VSS.t213 234.114
R242 VSS.n671 VSS.t47 234.114
R243 VSS.n654 VSS.t520 234.114
R244 VSS.n637 VSS.t182 234.114
R245 VSS.n620 VSS.t199 234.114
R246 VSS.n603 VSS.t557 234.114
R247 VSS.n586 VSS.t511 234.114
R248 VSS.n569 VSS.t166 234.114
R249 VSS.n552 VSS.t482 234.114
R250 VSS.t560 VSS.n425 230.327
R251 VSS.t294 VSS.n3 117.529
R252 VSS.t194 VSS.n3 117.216
R253 VSS.t191 VSS.n71 225.361
R254 VSS.t157 VSS.n68 225.361
R255 VSS.t521 VSS.n62 225.361
R256 VSS.t183 VSS.n60 225.361
R257 VSS.t201 VSS.n57 225.361
R258 VSS.t509 VSS.n53 225.361
R259 VSS.t164 VSS.n49 225.361
R260 VSS.n19 VSS.t105 225.359
R261 VSS.t485 VSS.n100 225.359
R262 VSS.t547 VSS.n96 225.359
R263 VSS.t405 VSS.n93 225.359
R264 VSS.n22 VSS.t513 225.359
R265 VSS.n27 VSS.t479 225.359
R266 VSS.t211 VSS.n87 225.359
R267 VSS.n34 VSS.t45 225.359
R268 VSS.n41 VSS.t555 225.359
R269 VSS.n3 VSS.t526 116.469
R270 VSS.t528 VSS.n101 211.982
R271 VSS.t121 VSS.n99 211.982
R272 VSS.t175 VSS.n95 211.982
R273 VSS.t82 VSS.n92 211.982
R274 VSS.t245 VSS.n90 211.982
R275 VSS.t79 VSS.n86 211.982
R276 VSS.t16 VSS.n82 211.982
R277 VSS.n28 VSS.t248 211.982
R278 VSS.n31 VSS.t85 211.982
R279 VSS.n36 VSS.t242 211.982
R280 VSS.n39 VSS.t91 211.982
R281 VSS.n42 VSS.t251 211.982
R282 VSS.n70 VSS.t260 211.982
R283 VSS.n67 VSS.t88 211.982
R284 VSS.n59 VSS.t115 211.982
R285 VSS.n52 VSS.t239 211.982
R286 VSS.n9 VSS.t560 221.012
R287 VSS.n10 VSS.t196 107.931
R288 VSS.t94 VSS.n12 398.622
R289 VSS.t503 VSS.n76 195.26
R290 VSS.t472 VSS.n74 195.26
R291 VSS.t492 VSS.n73 195.26
R292 VSS.t377 VSS.n64 195.26
R293 VSS.t35 VSS.n54 195.26
R294 VSS.t149 VSS.n50 195.26
R295 VSS.t207 VSS.n47 195.26
R296 VSS.n20 VSS.t399 195.26
R297 VSS.t209 VSS.n98 195.26
R298 VSS.n25 VSS.t98 195.26
R299 VSS.t216 VSS.n89 195.26
R300 VSS.n30 VSS.t151 195.26
R301 VSS.n32 VSS.t544 195.26
R302 VSS.t178 VSS.n85 195.26
R303 VSS.n38 VSS.t494 195.26
R304 VSS.n40 VSS.t142 195.26
R305 VSS.t269 VSS.n3 114.148
R306 VSS.n13 VSS.n3 6.82739
R307 VSS.n14 VSS.t30 106.362
R308 VSS.n813 VSS.t224 187.292
R309 VSS.n796 VSS.t236 187.292
R310 VSS.n779 VSS.t63 187.292
R311 VSS.n762 VSS.t52 187.292
R312 VSS.n745 VSS.t113 187.292
R313 VSS.n728 VSS.t226 187.292
R314 VSS.n711 VSS.t534 187.292
R315 VSS.n694 VSS.t111 187.292
R316 VSS.n677 VSS.t124 187.292
R317 VSS.n660 VSS.t237 187.292
R318 VSS.n643 VSS.t541 187.292
R319 VSS.n626 VSS.t126 187.292
R320 VSS.n609 VSS.t174 187.292
R321 VSS.n592 VSS.t519 187.292
R322 VSS.n575 VSS.t227 187.292
R323 VSS.n558 VSS.t26 187.292
R324 VSS.n3 VSS.t135 110.547
R325 VSS.n3 VSS.t218 110.547
R326 VSS.n3 VSS.t231 110.546
R327 VSS.t525 VSS.n3 110.546
R328 VSS.t258 VSS.n242 173.913
R329 VSS.n250 VSS.t74 173.913
R330 VSS.n258 VSS.t539 173.913
R331 VSS.n266 VSS.t119 173.913
R332 VSS.t264 VSS.n274 173.913
R333 VSS.t11 VSS.n282 173.913
R334 VSS.t58 VSS.n290 173.913
R335 VSS.n298 VSS.t38 173.913
R336 VSS.t536 VSS.n306 173.913
R337 VSS.t172 VSS.n314 173.913
R338 VSS.n322 VSS.t20 173.913
R339 VSS.t103 VSS.n330 173.913
R340 VSS.t61 VSS.n338 173.913
R341 VSS.n346 VSS.t71 173.913
R342 VSS.t229 VSS.n354 173.913
R343 VSS.t8 VSS.n362 173.913
R344 VSS.n374 VSS.n365 173.913
R345 VSS.t529 VSS.t400 163.881
R346 VSS.t122 VSS.t208 163.881
R347 VSS.t176 VSS.t504 163.881
R348 VSS.t83 VSS.t473 163.881
R349 VSS.t246 VSS.t493 163.881
R350 VSS.t261 VSS.t97 163.881
R351 VSS.t89 VSS.t215 163.881
R352 VSS.t249 VSS.t152 163.881
R353 VSS.t86 VSS.t545 163.881
R354 VSS.t80 VSS.t378 163.881
R355 VSS.t243 VSS.t180 163.881
R356 VSS.t116 VSS.t495 163.881
R357 VSS.t92 VSS.t144 163.881
R358 VSS.t252 VSS.t33 163.881
R359 VSS.t240 VSS.t148 163.881
R360 VSS.t17 VSS.t205 163.881
R361 VSS.n3 VSS.t271 105.688
R362 VSS.t304 VSS.n3 101.74
R363 VSS.t334 VSS.n3 101.74
R364 VSS.n3 VSS.t346 105.688
R365 VSS.t499 VSS.n105 157.062
R366 VSS.t477 VSS.n104 156.429
R367 VSS.t68 VSS.n70 155.126
R368 VSS.t203 VSS.n67 155.126
R369 VSS.t394 VSS.n59 155.126
R370 VSS.t50 VSS.n52 155.126
R371 VSS.t552 VSS.n101 155.125
R372 VSS.t189 VSS.n99 155.125
R373 VSS.t185 VSS.n95 155.125
R374 VSS.t396 VSS.n92 155.125
R375 VSS.t40 VSS.n90 155.125
R376 VSS.n28 VSS.t554 155.125
R377 VSS.n31 VSS.t483 155.125
R378 VSS.t496 VSS.n86 155.125
R379 VSS.n36 VSS.t169 155.125
R380 VSS.n39 VSS.t154 155.125
R381 VSS.n42 VSS.t163 155.125
R382 VSS.t391 VSS.n82 155.125
R383 VSS.n835 VSS.t532 153.846
R384 VSS.n813 VSS.t257 153.846
R385 VSS.n796 VSS.t73 153.846
R386 VSS.n779 VSS.t538 153.846
R387 VSS.n762 VSS.t118 153.846
R388 VSS.n745 VSS.t263 153.846
R389 VSS.n728 VSS.t10 153.846
R390 VSS.n711 VSS.t57 153.846
R391 VSS.n694 VSS.t37 153.846
R392 VSS.n677 VSS.t535 153.846
R393 VSS.n660 VSS.t171 153.846
R394 VSS.n643 VSS.t19 153.846
R395 VSS.n626 VSS.t102 153.846
R396 VSS.n609 VSS.t60 153.846
R397 VSS.n592 VSS.t70 153.846
R398 VSS.n575 VSS.t228 153.846
R399 VSS.n558 VSS.t7 153.846
R400 VSS.t109 VSS.n104 153.327
R401 VSS.t500 VSS.n103 153.236
R402 VSS.t156 VSS.n11 165.508
R403 VSS.t319 VSS.n3 101.74
R404 VSS.t523 VSS.n241 147.157
R405 VSS.t66 VSS.n249 147.157
R406 VSS.t187 VSS.n257 147.157
R407 VSS.t490 VSS.n265 147.157
R408 VSS.t4 VSS.n273 147.157
R409 VSS.t489 VSS.n281 147.157
R410 VSS.t381 VSS.n289 147.157
R411 VSS.t100 VSS.n297 147.157
R412 VSS.t392 VSS.n305 147.157
R413 VSS.t161 VSS.n313 147.157
R414 VSS.t76 VSS.n321 147.157
R415 VSS.t380 VSS.n329 147.157
R416 VSS.t550 VSS.n337 147.157
R417 VSS.t146 VSS.n345 147.157
R418 VSS.t478 VSS.n353 147.157
R419 VSS.t402 VSS.n361 147.157
R420 VSS.n46 VSS.t375 145.093
R421 VSS.t371 VSS.n46 138.404
R422 VSS.t329 VSS.n3 97.2306
R423 VSS.t387 VSS.n3 97.2225
R424 VSS.n17 VSS.t234 134.661
R425 VSS.n45 VSS.t371 131.974
R426 VSS.n0 VSS.t28 130.939
R427 VSS.n15 VSS.t138 131.005
R428 VSS.n845 VSS.t221 126.945
R429 VSS.n846 VSS.t55 123.212
R430 VSS.n103 VSS.t477 120.691
R431 VSS.n2 VSS.t2 119.422
R432 VSS.t497 VSS.n17 117.858
R433 VSS.t375 VSS.n365 117.058
R434 VSS.t22 VSS.n127 115.745
R435 VSS.t24 VSS.n128 108.276
R436 VSS.n815 VSS.t552 107.023
R437 VSS.n807 VSS.t523 107.023
R438 VSS.n798 VSS.t189 107.023
R439 VSS.n790 VSS.t66 107.023
R440 VSS.n781 VSS.t185 107.023
R441 VSS.n773 VSS.t187 107.023
R442 VSS.n764 VSS.t396 107.023
R443 VSS.n756 VSS.t490 107.023
R444 VSS.n747 VSS.t40 107.023
R445 VSS.n739 VSS.t4 107.023
R446 VSS.n730 VSS.t68 107.023
R447 VSS.n722 VSS.t489 107.023
R448 VSS.n713 VSS.t203 107.023
R449 VSS.n705 VSS.t381 107.023
R450 VSS.t554 VSS.n696 107.023
R451 VSS.n688 VSS.t100 107.023
R452 VSS.t483 VSS.n679 107.023
R453 VSS.n671 VSS.t392 107.023
R454 VSS.n662 VSS.t496 107.023
R455 VSS.n654 VSS.t161 107.023
R456 VSS.t169 VSS.n645 107.023
R457 VSS.n637 VSS.t76 107.023
R458 VSS.n628 VSS.t394 107.023
R459 VSS.n620 VSS.t380 107.023
R460 VSS.t154 VSS.n611 107.023
R461 VSS.n603 VSS.t550 107.023
R462 VSS.t163 VSS.n594 107.023
R463 VSS.n586 VSS.t146 107.023
R464 VSS.n577 VSS.t50 107.023
R465 VSS.n569 VSS.t478 107.023
R466 VSS.n560 VSS.t391 107.023
R467 VSS.n552 VSS.t402 107.023
R468 VSS.n835 VSS.t364 100.335
R469 VSS.t257 VSS.n241 100.335
R470 VSS.t73 VSS.n249 100.335
R471 VSS.t538 VSS.n257 100.335
R472 VSS.t118 VSS.n265 100.335
R473 VSS.t263 VSS.n273 100.335
R474 VSS.t10 VSS.n281 100.335
R475 VSS.t57 VSS.n289 100.335
R476 VSS.t37 VSS.n297 100.335
R477 VSS.t535 VSS.n305 100.335
R478 VSS.t171 VSS.n313 100.335
R479 VSS.t19 VSS.n321 100.335
R480 VSS.t102 VSS.n329 100.335
R481 VSS.t60 VSS.n337 100.335
R482 VSS.t70 VSS.n345 100.335
R483 VSS.t228 VSS.n353 100.335
R484 VSS.t7 VSS.n361 100.335
R485 VSS.n844 VSS.t107 97.0758
R486 VSS.n1 VSS.t0 96.5008
R487 VSS.t222 VSS.n105 93.5889
R488 VSS.n844 VSS.t235 93.3421
R489 VSS.n45 VSS.t8 88.4945
R490 VSS.t74 VSS.n97 88.2366
R491 VSS.t539 VSS.n94 88.2366
R492 VSS.t119 VSS.n91 88.2366
R493 VSS.t38 VSS.n88 88.2366
R494 VSS.t20 VSS.n84 88.2366
R495 VSS.t71 VSS.n83 88.2366
R496 VSS.n21 VSS.t258 88.2366
R497 VSS.n26 VSS.t58 88.2366
R498 VSS.n33 VSS.t536 88.2366
R499 VSS.n44 VSS.t229 88.2366
R500 VSS.n72 VSS.t264 88.2359
R501 VSS.n69 VSS.t11 88.2359
R502 VSS.n63 VSS.t172 88.2359
R503 VSS.n58 VSS.t103 88.2359
R504 VSS.n55 VSS.t61 88.2359
R505 VSS.n16 VSS.t474 88.133
R506 VSS.n374 VSS.n81 88.4718
R507 VSS.t364 VSS.t531 86.957
R508 VSS.t532 VSS.t368 86.957
R509 VSS.t474 VSS.n6 82.7875
R510 VSS.n128 VSS.t476 82.1411
R511 VSS.t476 VSS.n106 75.0671
R512 VSS.t531 VSS.n102 74.8579
R513 VSS.t54 VSS.n127 74.6738
R514 VSS.n9 VSS.n3 2.67074
R515 VSS.n815 VSS.t529 70.2346
R516 VSS.n798 VSS.t122 70.2346
R517 VSS.n781 VSS.t176 70.2346
R518 VSS.n764 VSS.t83 70.2346
R519 VSS.n747 VSS.t246 70.2346
R520 VSS.n730 VSS.t261 70.2346
R521 VSS.n713 VSS.t89 70.2346
R522 VSS.n696 VSS.t249 70.2346
R523 VSS.n679 VSS.t86 70.2346
R524 VSS.n662 VSS.t80 70.2346
R525 VSS.n645 VSS.t243 70.2346
R526 VSS.n628 VSS.t116 70.2346
R527 VSS.n611 VSS.t92 70.2346
R528 VSS.n594 VSS.t252 70.2346
R529 VSS.n577 VSS.t240 70.2346
R530 VSS.n560 VSS.t17 70.2346
R531 VSS.n3 VSS.t279 117.528
R532 VSS.t291 VSS.n3 58.3218
R533 VSS.t321 VSS.n3 58.3224
R534 VSS.n3 VSS.t339 117.529
R535 VSS.t351 VSS.n3 58.3221
R536 VSS.n846 VSS.t54 67.2065
R537 VSS.t399 VSS.n814 66.8901
R538 VSS.t224 VSS.n238 66.8901
R539 VSS.n797 VSS.t209 66.8901
R540 VSS.t236 VSS.n246 66.8901
R541 VSS.n780 VSS.t503 66.8901
R542 VSS.t63 VSS.n254 66.8901
R543 VSS.n763 VSS.t472 66.8901
R544 VSS.t52 VSS.n262 66.8901
R545 VSS.n746 VSS.t492 66.8901
R546 VSS.t113 VSS.n270 66.8901
R547 VSS.t98 VSS.n729 66.8901
R548 VSS.t226 VSS.n278 66.8901
R549 VSS.n712 VSS.t216 66.8901
R550 VSS.t534 VSS.n286 66.8901
R551 VSS.t151 VSS.n695 66.8901
R552 VSS.t111 VSS.n294 66.8901
R553 VSS.t544 VSS.n678 66.8901
R554 VSS.t124 VSS.n302 66.8901
R555 VSS.n661 VSS.t377 66.8901
R556 VSS.t237 VSS.n310 66.8901
R557 VSS.n644 VSS.t178 66.8901
R558 VSS.t541 VSS.n318 66.8901
R559 VSS.t494 VSS.n627 66.8901
R560 VSS.t126 VSS.n326 66.8901
R561 VSS.t142 VSS.n610 66.8901
R562 VSS.t174 VSS.n334 66.8901
R563 VSS.n593 VSS.t35 66.8901
R564 VSS.t519 VSS.n342 66.8901
R565 VSS.n576 VSS.t149 66.8901
R566 VSS.t227 VSS.n350 66.8901
R567 VSS.n559 VSS.t207 66.8901
R568 VSS.t26 VSS.n358 66.8901
R569 VSS.n845 VSS.t222 63.4728
R570 VSS.t235 VSS.n130 62.2523
R571 VSS.t94 VSS.n2 61.8407
R572 VSS.t107 VSS.n843 58.5186
R573 VSS.n3 VSS.t281 49.8619
R574 VSS.n3 VSS.t296 49.8619
R575 VSS.n3 VSS.t311 49.8619
R576 VSS.n3 VSS.t341 49.8619
R577 VSS.t356 VSS.n3 49.8619
R578 VSS.n16 VSS.t497 54.532
R579 VSS.t390 VSS.n0 50.3244
R580 VSS.t542 VSS.n15 44.8755
R581 VSS.n236 VSS.t528 50.1677
R582 VSS.n244 VSS.t121 50.1677
R583 VSS.n252 VSS.t175 50.1677
R584 VSS.n260 VSS.t82 50.1677
R585 VSS.n268 VSS.t245 50.1677
R586 VSS.t260 VSS.n276 50.1677
R587 VSS.t88 VSS.n284 50.1677
R588 VSS.t248 VSS.n292 50.1677
R589 VSS.t85 VSS.n300 50.1677
R590 VSS.n308 VSS.t79 50.1677
R591 VSS.t242 VSS.n316 50.1677
R592 VSS.t115 VSS.n324 50.1677
R593 VSS.t91 VSS.n332 50.1677
R594 VSS.t251 VSS.n340 50.1677
R595 VSS.t239 VSS.n348 50.1677
R596 VSS.n356 VSS.t16 50.1677
R597 VSS.n129 VSS.t24 47.3176
R598 VSS.n847 VSS.t22 39.8503
R599 VSS.t105 VSS.n822 36.7898
R600 VSS.n806 VSS.t485 36.7898
R601 VSS.n789 VSS.t547 36.7898
R602 VSS.n772 VSS.t405 36.7898
R603 VSS.t513 VSS.n755 36.7898
R604 VSS.n738 VSS.t191 36.7898
R605 VSS.n721 VSS.t157 36.7898
R606 VSS.t479 VSS.n704 36.7898
R607 VSS.n687 VSS.t211 36.7898
R608 VSS.t45 VSS.n670 36.7898
R609 VSS.n653 VSS.t521 36.7898
R610 VSS.n636 VSS.t183 36.7898
R611 VSS.n619 VSS.t201 36.7898
R612 VSS.t555 VSS.n602 36.7898
R613 VSS.n585 VSS.t509 36.7898
R614 VSS.n568 VSS.t164 36.7898
R615 VSS.t234 VSS.n847 36.1166
R616 VSS.t55 VSS.n106 33.9948
R617 VSS.t221 VSS.n129 28.6493
R618 VSS.t208 VSS.n78 28.2938
R619 VSS.t493 VSS.n23 28.2938
R620 VSS.t97 VSS.n24 28.2938
R621 VSS.t215 VSS.n66 28.2938
R622 VSS.t152 VSS.n29 28.2938
R623 VSS.t378 VSS.n35 28.2938
R624 VSS.t495 VSS.n37 28.2938
R625 VSS.t144 VSS.n56 28.2938
R626 VSS.t33 VSS.n43 28.2938
R627 VSS.t205 VSS.n48 28.2938
R628 VSS.t400 VSS.n79 28.2928
R629 VSS.t504 VSS.n77 28.2928
R630 VSS.t473 VSS.n75 28.2928
R631 VSS.t545 VSS.n65 28.2928
R632 VSS.t180 VSS.n61 28.2928
R633 VSS.t148 VSS.n51 28.2928
R634 VSS.n102 VSS.t500 28.0359
R635 VSS.n7 VSS.t130 25.6732
R636 VSS.n3 VSS.t78 21.009
R637 VSS.t368 VSS.n18 21.6048
R638 VSS.t487 VSS.n242 20.0674
R639 VSS.t549 VSS.n250 20.0674
R640 VSS.t407 VSS.n258 20.0674
R641 VSS.t515 VSS.n266 20.0674
R642 VSS.t193 VSS.n274 20.0674
R643 VSS.t159 VSS.n282 20.0674
R644 VSS.t481 VSS.n290 20.0674
R645 VSS.t213 VSS.n298 20.0674
R646 VSS.t47 VSS.n306 20.0674
R647 VSS.t520 VSS.n314 20.0674
R648 VSS.t182 VSS.n322 20.0674
R649 VSS.t199 VSS.n330 20.0674
R650 VSS.t557 VSS.n338 20.0674
R651 VSS.t511 VSS.n346 20.0674
R652 VSS.t166 VSS.n354 20.0674
R653 VSS.t482 VSS.n362 20.0674
R654 VSS.t384 VSS.n100 18.0025
R655 VSS.t32 VSS.n98 18.0025
R656 VSS.n96 VSS.t362 18.0025
R657 VSS.n93 VSS.t198 18.0025
R658 VSS.t383 VSS.n89 18.0025
R659 VSS.n87 VSS.t558 18.0025
R660 VSS.t546 VSS.n85 18.0025
R661 VSS.t268 VSS.n19 18.0025
R662 VSS.n20 VSS.t512 18.0025
R663 VSS.n22 VSS.t398 18.0025
R664 VSS.t214 VSS.n25 18.0025
R665 VSS.t553 VSS.n27 18.0025
R666 VSS.t524 VSS.n30 18.0025
R667 VSS.n32 VSS.t559 18.0025
R668 VSS.t507 VSS.n34 18.0025
R669 VSS.t361 VSS.n38 18.0025
R670 VSS.n40 VSS.t267 18.0025
R671 VSS.n41 VSS.t508 18.0025
R672 VSS.n76 VSS.t65 18.0017
R673 VSS.n74 VSS.t386 18.0017
R674 VSS.t505 VSS.n73 18.0017
R675 VSS.n71 VSS.t181 18.0017
R676 VSS.n68 VSS.t385 18.0017
R677 VSS.t266 VSS.n64 18.0017
R678 VSS.n62 VSS.t168 18.0017
R679 VSS.n60 VSS.t404 18.0017
R680 VSS.n57 VSS.t506 18.0017
R681 VSS.t502 VSS.n54 18.0017
R682 VSS.n53 VSS.t543 18.0017
R683 VSS.n50 VSS.t49 18.0017
R684 VSS.t393 VSS.n49 18.0017
R685 VSS.n47 VSS.t6 18.0017
R686 VSS.n843 VSS.t109 17.4483
R687 VSS.n861 VSS.t108 17.3368
R688 VSS.n857 VSS.t25 17.3368
R689 VSS.n853 VSS.t23 17.3368
R690 VSS.n433 VSS.t1 17.3368
R691 VSS.n437 VSS.t3 17.3368
R692 VSS.n441 VSS.t129 17.3368
R693 VSS.n445 VSS.t29 17.3368
R694 VSS.n840 VSS.t501 17.3368
R695 VSS.n495 VSS.t139 17.2607
R696 VSS.n424 VSS.t273 17.2313
R697 VSS.n453 VSS.t278 17.2313
R698 VSS.n457 VSS.t283 17.2313
R699 VSS.n416 VSS.t288 17.2313
R700 VSS.n468 VSS.t293 17.2313
R701 VSS.n472 VSS.t298 17.2313
R702 VSS.n408 VSS.t303 17.2313
R703 VSS.n483 VSS.t308 17.2313
R704 VSS.n487 VSS.t313 17.2313
R705 VSS.n400 VSS.t318 17.2313
R706 VSS.n506 VSS.t323 17.2313
R707 VSS.n510 VSS.t328 17.2313
R708 VSS.n392 VSS.t333 17.2313
R709 VSS.n521 VSS.t338 17.2313
R710 VSS.n525 VSS.t343 17.2313
R711 VSS.n384 VSS.t348 17.2313
R712 VSS.n536 VSS.t353 17.2313
R713 VSS.n540 VSS.t358 17.2313
R714 VSS.n848 VSS.n107 17.0005
R715 VSS.n107 VSS.n127 17.0005
R716 VSS.n107 VSS.n846 17.0005
R717 VSS.n107 VSS.n128 17.0005
R718 VSS.n107 VSS.n845 17.0005
R719 VSS.n107 VSS.n844 17.0005
R720 VSS.n107 VSS.n842 17.0005
R721 VSS.n107 VSS.n235 17.0005
R722 VSS.n107 VSS.n240 17.0005
R723 VSS.n107 VSS.n248 17.0005
R724 VSS.n107 VSS.n256 17.0005
R725 VSS.n107 VSS.n264 17.0005
R726 VSS.n107 VSS.n272 17.0005
R727 VSS.n107 VSS.n280 17.0005
R728 VSS.n107 VSS.n288 17.0005
R729 VSS.n107 VSS.n296 17.0005
R730 VSS.n107 VSS.n304 17.0005
R731 VSS.n107 VSS.n312 17.0005
R732 VSS.n107 VSS.n320 17.0005
R733 VSS.n107 VSS.n328 17.0005
R734 VSS.n107 VSS.n336 17.0005
R735 VSS.n107 VSS.n344 17.0005
R736 VSS.n107 VSS.n352 17.0005
R737 VSS.n107 VSS.n360 17.0005
R738 VSS.n107 VSS.n363 17.0005
R739 VSS.n107 VSS.n551 17.0005
R740 VSS.n107 VSS.n364 17.0005
R741 VSS.n107 VSS.n546 17.0005
R742 VSS.n107 VSS.n366 17.0005
R743 VSS.n107 VSS.n233 17.0005
R744 VSS.n107 VSS.n132 17.0005
R745 VSS.n3 VSS.n124 5.65652
R746 VSS.n3 VSS.n121 5.65652
R747 VSS.n3 VSS.n112 5.65652
R748 VSS.n3 VSS.n109 5.65652
R749 VSS.n3 VSS.n14 6.82737
R750 VSS.n3 VSS.n8 9.73657
R751 VSS.n3 VSS.n426 17.0005
R752 VSS.n3 VSS.n11 0.592458
R753 VSS.n3 VSS.n12 9.32125
R754 VSS.n3 VSS.n10 7.24297
R755 VSS.n3 VSS.n425 17.0005
R756 VSS.n428 VSS.n3 17.0005
R757 VSS.n427 VSS.t272 17.0005
R758 VSS.n423 VSS.t275 17.0005
R759 VSS.n451 VSS.t277 17.0005
R760 VSS.n420 VSS.t280 17.0005
R761 VSS.n419 VSS.t282 17.0005
R762 VSS.n418 VSS.t285 17.0005
R763 VSS.n417 VSS.t287 17.0005
R764 VSS.n415 VSS.t290 17.0005
R765 VSS.n466 VSS.t292 17.0005
R766 VSS.n412 VSS.t295 17.0005
R767 VSS.n411 VSS.t297 17.0005
R768 VSS.n410 VSS.t300 17.0005
R769 VSS.n409 VSS.t302 17.0005
R770 VSS.n407 VSS.t305 17.0005
R771 VSS.n481 VSS.t307 17.0005
R772 VSS.n404 VSS.t310 17.0005
R773 VSS.n403 VSS.t312 17.0005
R774 VSS.n402 VSS.t315 17.0005
R775 VSS.n401 VSS.t317 17.0005
R776 VSS.n399 VSS.t320 17.0005
R777 VSS.n504 VSS.t322 17.0005
R778 VSS.n396 VSS.t325 17.0005
R779 VSS.n395 VSS.t327 17.0005
R780 VSS.n394 VSS.t330 17.0005
R781 VSS.n393 VSS.t332 17.0005
R782 VSS.n391 VSS.t335 17.0005
R783 VSS.n519 VSS.t337 17.0005
R784 VSS.n388 VSS.t340 17.0005
R785 VSS.n387 VSS.t342 17.0005
R786 VSS.n386 VSS.t345 17.0005
R787 VSS.n385 VSS.t347 17.0005
R788 VSS.n383 VSS.t350 17.0005
R789 VSS.n534 VSS.t352 17.0005
R790 VSS.n380 VSS.t355 17.0005
R791 VSS.n379 VSS.t357 17.0005
R792 VSS.n376 VSS.t360 17.0005
R793 VSS.n11 VSS.t389 15.2265
R794 VSS.n423 VSS.t597 15.3099
R795 VSS.n420 VSS.t595 15.3099
R796 VSS.n418 VSS.t593 15.3099
R797 VSS.n415 VSS.t591 15.3099
R798 VSS.n412 VSS.t589 15.3099
R799 VSS.n410 VSS.t587 15.3099
R800 VSS.n407 VSS.t585 15.3099
R801 VSS.n404 VSS.t583 15.3099
R802 VSS.n402 VSS.t581 15.3099
R803 VSS.n399 VSS.t579 15.3099
R804 VSS.n396 VSS.t577 15.3099
R805 VSS.n394 VSS.t575 15.3099
R806 VSS.n391 VSS.t573 15.3099
R807 VSS.n388 VSS.t571 15.3099
R808 VSS.n386 VSS.t569 15.3099
R809 VSS.n383 VSS.t567 15.3099
R810 VSS.n380 VSS.t565 15.3099
R811 VSS.n376 VSS.t563 15.3099
R812 VSS.n427 VSS.t598 15.2696
R813 VSS.n451 VSS.t596 15.2696
R814 VSS.n419 VSS.t594 15.2696
R815 VSS.n417 VSS.t592 15.2696
R816 VSS.n466 VSS.t590 15.2696
R817 VSS.n411 VSS.t588 15.2696
R818 VSS.n409 VSS.t586 15.2696
R819 VSS.n481 VSS.t584 15.2696
R820 VSS.n403 VSS.t582 15.2696
R821 VSS.n401 VSS.t580 15.2696
R822 VSS.n504 VSS.t578 15.2696
R823 VSS.n395 VSS.t576 15.2696
R824 VSS.n393 VSS.t574 15.2696
R825 VSS.n519 VSS.t572 15.2696
R826 VSS.n387 VSS.t570 15.2696
R827 VSS.n385 VSS.t568 15.2696
R828 VSS.n534 VSS.t566 15.2696
R829 VSS.n379 VSS.t564 15.2696
R830 VSS.n547 VSS.t370 15.1276
R831 VSS.n369 VSS.t374 15.0005
R832 VSS.n828 VSS.t367 15.0005
R833 VSS.n837 VSS.t363 15.0005
R834 VSS.n130 VSS.t499 13.7147
R835 VSS.n168 VSS.t403 8.85039
R836 VSS.n170 VSS.t206 8.85039
R837 VSS.n172 VSS.t167 8.85039
R838 VSS.n174 VSS.t51 8.85039
R839 VSS.n176 VSS.t147 8.85039
R840 VSS.n178 VSS.t34 8.85039
R841 VSS.n180 VSS.t551 8.85039
R842 VSS.n182 VSS.t145 8.85039
R843 VSS.n184 VSS.t200 8.85039
R844 VSS.n186 VSS.t395 8.85039
R845 VSS.n188 VSS.t77 8.85039
R846 VSS.n190 VSS.t170 8.85039
R847 VSS.n192 VSS.t162 8.85039
R848 VSS.n194 VSS.t379 8.85039
R849 VSS.n196 VSS.t48 8.85039
R850 VSS.n198 VSS.t484 8.85039
R851 VSS.n200 VSS.t101 8.85039
R852 VSS.n202 VSS.t153 8.85039
R853 VSS.n204 VSS.t382 8.85039
R854 VSS.n206 VSS.t204 8.85039
R855 VSS.n208 VSS.t160 8.85039
R856 VSS.n210 VSS.t69 8.85039
R857 VSS.n212 VSS.t5 8.85039
R858 VSS.n214 VSS.t41 8.85039
R859 VSS.n216 VSS.t491 8.85039
R860 VSS.n218 VSS.t397 8.85039
R861 VSS.n220 VSS.t188 8.85039
R862 VSS.n222 VSS.t186 8.85039
R863 VSS.n224 VSS.t67 8.85039
R864 VSS.n226 VSS.t190 8.85039
R865 VSS.n228 VSS.t488 8.85039
R866 VSS.n230 VSS.t401 8.85039
R867 VSS.n863 VSS.t110 8.80385
R868 VSS.n859 VSS.t223 8.80385
R869 VSS.n855 VSS.t56 8.80385
R870 VSS.n832 VSS.t533 8.80385
R871 VSS.n435 VSS.t562 8.80285
R872 VSS.n439 VSS.t96 8.80285
R873 VSS.n443 VSS.t131 8.80285
R874 VSS.n447 VSS.t31 8.80285
R875 VSS.n553 VSS.t9 8.77423
R876 VSS.n359 VSS.t27 8.77423
R877 VSS.n561 VSS.t18 8.77423
R878 VSS.n566 VSS.t165 8.77423
R879 VSS.n570 VSS.t230 8.77423
R880 VSS.n351 VSS.t150 8.77423
R881 VSS.n578 VSS.t241 8.77423
R882 VSS.n583 VSS.t510 8.77423
R883 VSS.n587 VSS.t72 8.77423
R884 VSS.n343 VSS.t36 8.77423
R885 VSS.n595 VSS.t253 8.77423
R886 VSS.n600 VSS.t556 8.77423
R887 VSS.n604 VSS.t62 8.77423
R888 VSS.n335 VSS.t143 8.77423
R889 VSS.n612 VSS.t93 8.77423
R890 VSS.n617 VSS.t202 8.77423
R891 VSS.n621 VSS.t104 8.77423
R892 VSS.n327 VSS.t127 8.77423
R893 VSS.n629 VSS.t117 8.77423
R894 VSS.n634 VSS.t184 8.77423
R895 VSS.n638 VSS.t21 8.77423
R896 VSS.n319 VSS.t179 8.77423
R897 VSS.n646 VSS.t244 8.77423
R898 VSS.n651 VSS.t522 8.77423
R899 VSS.n655 VSS.t173 8.77423
R900 VSS.n311 VSS.t238 8.77423
R901 VSS.n663 VSS.t81 8.77423
R902 VSS.n668 VSS.t46 8.77423
R903 VSS.n672 VSS.t537 8.77423
R904 VSS.n303 VSS.t125 8.77423
R905 VSS.n680 VSS.t87 8.77423
R906 VSS.n685 VSS.t212 8.77423
R907 VSS.n689 VSS.t39 8.77423
R908 VSS.n295 VSS.t112 8.77423
R909 VSS.n697 VSS.t250 8.77423
R910 VSS.n702 VSS.t480 8.77423
R911 VSS.n706 VSS.t59 8.77423
R912 VSS.n287 VSS.t217 8.77423
R913 VSS.n714 VSS.t90 8.77423
R914 VSS.n719 VSS.t158 8.77423
R915 VSS.n723 VSS.t12 8.77423
R916 VSS.n279 VSS.t99 8.77423
R917 VSS.n731 VSS.t262 8.77423
R918 VSS.n736 VSS.t192 8.77423
R919 VSS.n740 VSS.t265 8.77423
R920 VSS.n271 VSS.t114 8.77423
R921 VSS.n748 VSS.t247 8.77423
R922 VSS.n753 VSS.t514 8.77423
R923 VSS.n757 VSS.t120 8.77423
R924 VSS.n263 VSS.t53 8.77423
R925 VSS.n765 VSS.t84 8.77423
R926 VSS.n770 VSS.t406 8.77423
R927 VSS.n774 VSS.t540 8.77423
R928 VSS.n255 VSS.t64 8.77423
R929 VSS.n782 VSS.t177 8.77423
R930 VSS.n787 VSS.t548 8.77423
R931 VSS.n791 VSS.t75 8.77423
R932 VSS.n247 VSS.t210 8.77423
R933 VSS.n799 VSS.t123 8.77423
R934 VSS.n804 VSS.t486 8.77423
R935 VSS.n808 VSS.t259 8.77423
R936 VSS.n239 VSS.t225 8.77423
R937 VSS.n816 VSS.t530 8.77423
R938 VSS.n823 VSS.t106 8.77423
R939 VSS.n4 VSS.t134 8.82841
R940 VSS.n461 VSS.t518 8.77323
R941 VSS.n476 VSS.t220 8.77323
R942 VSS.n491 VSS.t233 8.77323
R943 VSS.n493 VSS.t44 8.77323
R944 VSS.n499 VSS.t137 8.77323
R945 VSS.n514 VSS.t15 8.77323
R946 VSS.n529 VSS.t256 8.77323
R947 VSS.n373 VSS.t527 8.77323
R948 VSS.n5 VSS.t270 8.79211
R949 VSS.n497 VSS.t141 8.76678
R950 VSS.n851 VSS.t498 8.75731
R951 VSS.n849 VSS.t475 8.75731
R952 VSS.n429 VSS.t195 8.75631
R953 VSS.n431 VSS.t388 8.75631
R954 VSS.n125 VSS.n3 4.22409
R955 VSS.n533 VSS.n124 0.0180497
R956 VSS.n123 VSS.n531 0.0633111
R957 VSS.n524 VSS.n122 0.0435295
R958 VSS.n518 VSS.n121 0.0180497
R959 VSS.n120 VSS.n516 0.0633111
R960 VSS.n509 VSS.n119 0.0435295
R961 VSS.n118 VSS.n3 5.65652
R962 VSS.n117 VSS.n501 0.0633111
R963 VSS.n116 VSS.n3 4.22409
R964 VSS.n115 VSS.n3 5.65652
R965 VSS.n114 VSS.n478 0.0633111
R966 VSS.n113 VSS.n3 4.22409
R967 VSS.n465 VSS.n112 0.0180497
R968 VSS.n111 VSS.n463 0.0633111
R969 VSS.n110 VSS.n3 4.22409
R970 VSS.n450 VSS.n109 0.0180497
R971 VSS.n108 VSS.n448 0.0633111
R972 VSS.n107 VSS.n835 8.5005
R973 VSS.n107 VSS.n822 8.5005
R974 VSS.n107 VSS.n236 8.5005
R975 VSS.n107 VSS.n815 8.5005
R976 VSS.n107 VSS.n814 8.5005
R977 VSS.n107 VSS.n238 8.5005
R978 VSS.n107 VSS.n813 8.5005
R979 VSS.n107 VSS.n241 8.5005
R980 VSS.n107 VSS.n807 8.5005
R981 VSS.n107 VSS.n242 8.5005
R982 VSS.n107 VSS.n806 8.5005
R983 VSS.n107 VSS.n244 8.5005
R984 VSS.n107 VSS.n798 8.5005
R985 VSS.n107 VSS.n797 8.5005
R986 VSS.n107 VSS.n246 8.5005
R987 VSS.n107 VSS.n796 8.5005
R988 VSS.n107 VSS.n249 8.5005
R989 VSS.n107 VSS.n790 8.5005
R990 VSS.n107 VSS.n250 8.5005
R991 VSS.n107 VSS.n789 8.5005
R992 VSS.n107 VSS.n252 8.5005
R993 VSS.n107 VSS.n781 8.5005
R994 VSS.n107 VSS.n780 8.5005
R995 VSS.n107 VSS.n254 8.5005
R996 VSS.n107 VSS.n779 8.5005
R997 VSS.n107 VSS.n257 8.5005
R998 VSS.n107 VSS.n773 8.5005
R999 VSS.n107 VSS.n258 8.5005
R1000 VSS.n107 VSS.n772 8.5005
R1001 VSS.n107 VSS.n260 8.5005
R1002 VSS.n107 VSS.n764 8.5005
R1003 VSS.n107 VSS.n763 8.5005
R1004 VSS.n107 VSS.n262 8.5005
R1005 VSS.n107 VSS.n762 8.5005
R1006 VSS.n107 VSS.n265 8.5005
R1007 VSS.n107 VSS.n756 8.5005
R1008 VSS.n107 VSS.n266 8.5005
R1009 VSS.n107 VSS.n755 8.5005
R1010 VSS.n107 VSS.n268 8.5005
R1011 VSS.n107 VSS.n747 8.5005
R1012 VSS.n107 VSS.n746 8.5005
R1013 VSS.n107 VSS.n270 8.5005
R1014 VSS.n107 VSS.n745 8.5005
R1015 VSS.n107 VSS.n273 8.5005
R1016 VSS.n107 VSS.n739 8.5005
R1017 VSS.n107 VSS.n274 8.5005
R1018 VSS.n107 VSS.n738 8.5005
R1019 VSS.n107 VSS.n276 8.5005
R1020 VSS.n107 VSS.n730 8.5005
R1021 VSS.n107 VSS.n729 8.5005
R1022 VSS.n107 VSS.n278 8.5005
R1023 VSS.n107 VSS.n728 8.5005
R1024 VSS.n107 VSS.n281 8.5005
R1025 VSS.n107 VSS.n722 8.5005
R1026 VSS.n107 VSS.n282 8.5005
R1027 VSS.n107 VSS.n721 8.5005
R1028 VSS.n107 VSS.n284 8.5005
R1029 VSS.n107 VSS.n713 8.5005
R1030 VSS.n107 VSS.n712 8.5005
R1031 VSS.n107 VSS.n286 8.5005
R1032 VSS.n107 VSS.n711 8.5005
R1033 VSS.n107 VSS.n289 8.5005
R1034 VSS.n107 VSS.n705 8.5005
R1035 VSS.n107 VSS.n290 8.5005
R1036 VSS.n107 VSS.n704 8.5005
R1037 VSS.n107 VSS.n292 8.5005
R1038 VSS.n107 VSS.n696 8.5005
R1039 VSS.n107 VSS.n695 8.5005
R1040 VSS.n107 VSS.n294 8.5005
R1041 VSS.n107 VSS.n694 8.5005
R1042 VSS.n107 VSS.n297 8.5005
R1043 VSS.n107 VSS.n688 8.5005
R1044 VSS.n107 VSS.n298 8.5005
R1045 VSS.n107 VSS.n687 8.5005
R1046 VSS.n107 VSS.n300 8.5005
R1047 VSS.n107 VSS.n679 8.5005
R1048 VSS.n107 VSS.n678 8.5005
R1049 VSS.n107 VSS.n302 8.5005
R1050 VSS.n107 VSS.n677 8.5005
R1051 VSS.n107 VSS.n305 8.5005
R1052 VSS.n107 VSS.n671 8.5005
R1053 VSS.n107 VSS.n306 8.5005
R1054 VSS.n107 VSS.n670 8.5005
R1055 VSS.n107 VSS.n308 8.5005
R1056 VSS.n107 VSS.n662 8.5005
R1057 VSS.n107 VSS.n661 8.5005
R1058 VSS.n107 VSS.n310 8.5005
R1059 VSS.n107 VSS.n660 8.5005
R1060 VSS.n107 VSS.n313 8.5005
R1061 VSS.n107 VSS.n654 8.5005
R1062 VSS.n107 VSS.n314 8.5005
R1063 VSS.n107 VSS.n653 8.5005
R1064 VSS.n107 VSS.n316 8.5005
R1065 VSS.n107 VSS.n645 8.5005
R1066 VSS.n107 VSS.n644 8.5005
R1067 VSS.n107 VSS.n318 8.5005
R1068 VSS.n107 VSS.n643 8.5005
R1069 VSS.n107 VSS.n321 8.5005
R1070 VSS.n107 VSS.n637 8.5005
R1071 VSS.n107 VSS.n322 8.5005
R1072 VSS.n107 VSS.n636 8.5005
R1073 VSS.n107 VSS.n324 8.5005
R1074 VSS.n107 VSS.n628 8.5005
R1075 VSS.n107 VSS.n627 8.5005
R1076 VSS.n107 VSS.n326 8.5005
R1077 VSS.n107 VSS.n626 8.5005
R1078 VSS.n107 VSS.n329 8.5005
R1079 VSS.n107 VSS.n620 8.5005
R1080 VSS.n107 VSS.n330 8.5005
R1081 VSS.n107 VSS.n619 8.5005
R1082 VSS.n107 VSS.n332 8.5005
R1083 VSS.n107 VSS.n611 8.5005
R1084 VSS.n107 VSS.n610 8.5005
R1085 VSS.n107 VSS.n334 8.5005
R1086 VSS.n107 VSS.n609 8.5005
R1087 VSS.n107 VSS.n337 8.5005
R1088 VSS.n107 VSS.n603 8.5005
R1089 VSS.n107 VSS.n338 8.5005
R1090 VSS.n107 VSS.n602 8.5005
R1091 VSS.n107 VSS.n340 8.5005
R1092 VSS.n107 VSS.n594 8.5005
R1093 VSS.n107 VSS.n593 8.5005
R1094 VSS.n107 VSS.n342 8.5005
R1095 VSS.n107 VSS.n592 8.5005
R1096 VSS.n107 VSS.n345 8.5005
R1097 VSS.n107 VSS.n586 8.5005
R1098 VSS.n107 VSS.n346 8.5005
R1099 VSS.n107 VSS.n585 8.5005
R1100 VSS.n107 VSS.n348 8.5005
R1101 VSS.n107 VSS.n577 8.5005
R1102 VSS.n107 VSS.n576 8.5005
R1103 VSS.n107 VSS.n350 8.5005
R1104 VSS.n107 VSS.n575 8.5005
R1105 VSS.n107 VSS.n353 8.5005
R1106 VSS.n107 VSS.n569 8.5005
R1107 VSS.n107 VSS.n354 8.5005
R1108 VSS.n107 VSS.n568 8.5005
R1109 VSS.n107 VSS.n356 8.5005
R1110 VSS.n107 VSS.n560 8.5005
R1111 VSS.n107 VSS.n559 8.5005
R1112 VSS.n107 VSS.n358 8.5005
R1113 VSS.n107 VSS.n558 8.5005
R1114 VSS.n107 VSS.n361 8.5005
R1115 VSS.n107 VSS.n552 8.5005
R1116 VSS.n107 VSS.n362 8.5005
R1117 VSS.n107 VSS.n365 8.5005
R1118 VSS.n538 VSS.n3 8.49319
R1119 VSS.n523 VSS.n3 8.49319
R1120 VSS.n508 VSS.n3 8.49319
R1121 VSS.n485 VSS.n3 8.49319
R1122 VSS.n470 VSS.n3 8.49319
R1123 VSS.n455 VSS.n3 8.49319
R1124 VSS.n862 VSS.n107 8.47732
R1125 VSS.n107 VSS.n234 8.47732
R1126 VSS.n107 VSS.n821 8.47732
R1127 VSS.n107 VSS.n805 8.47732
R1128 VSS.n107 VSS.n788 8.47732
R1129 VSS.n107 VSS.n771 8.47732
R1130 VSS.n107 VSS.n754 8.47732
R1131 VSS.n107 VSS.n737 8.47732
R1132 VSS.n107 VSS.n720 8.47732
R1133 VSS.n107 VSS.n703 8.47732
R1134 VSS.n107 VSS.n686 8.47732
R1135 VSS.n107 VSS.n669 8.47732
R1136 VSS.n107 VSS.n652 8.47732
R1137 VSS.n107 VSS.n635 8.47732
R1138 VSS.n107 VSS.n618 8.47732
R1139 VSS.n107 VSS.n601 8.47732
R1140 VSS.n107 VSS.n584 8.47732
R1141 VSS.n107 VSS.n567 8.47732
R1142 VSS.n107 VSS.n131 8.47732
R1143 VSS.n107 VSS.n167 8.47732
R1144 VSS.n107 VSS.n166 8.47732
R1145 VSS.n125 VSS.n540 0.176279
R1146 VSS.n532 VSS.n3 8.47732
R1147 VSS.n3 VSS.n123 4.21421
R1148 VSS.n122 VSS.n3 4.22409
R1149 VSS.n517 VSS.n3 8.47732
R1150 VSS.n3 VSS.n120 4.21421
R1151 VSS.n119 VSS.n3 4.22409
R1152 VSS.n502 VSS.n3 8.47732
R1153 VSS.n3 VSS.n117 4.21421
R1154 VSS.n487 VSS.n116 0.176279
R1155 VSS.n479 VSS.n3 8.47732
R1156 VSS.n3 VSS.n114 4.21421
R1157 VSS.n472 VSS.n113 0.176279
R1158 VSS.n464 VSS.n3 8.47732
R1159 VSS.n3 VSS.n111 4.21421
R1160 VSS.n457 VSS.n110 0.176279
R1161 VSS.n449 VSS.n3 8.47732
R1162 VSS.n3 VSS.n108 4.21421
R1163 VSS.n442 VSS.n3 8.47732
R1164 VSS.n368 VSS.t376 8.46888
R1165 VSS.n544 VSS.t372 8.46888
R1166 VSS.n549 VSS.t373 8.46631
R1167 VSS.n555 VSS.t471 8.46631
R1168 VSS.n564 VSS.t417 8.46631
R1169 VSS.n572 VSS.t421 8.46631
R1170 VSS.n581 VSS.t465 8.46631
R1171 VSS.n589 VSS.t423 8.46631
R1172 VSS.n598 VSS.t469 8.46631
R1173 VSS.n606 VSS.t463 8.46631
R1174 VSS.n615 VSS.t467 8.46631
R1175 VSS.n623 VSS.t425 8.46631
R1176 VSS.n632 VSS.t459 8.46631
R1177 VSS.n640 VSS.t453 8.46631
R1178 VSS.n649 VSS.t461 8.46631
R1179 VSS.n657 VSS.t457 8.46631
R1180 VSS.n666 VSS.t455 8.46631
R1181 VSS.n674 VSS.t447 8.46631
R1182 VSS.n683 VSS.t451 8.46631
R1183 VSS.n691 VSS.t445 8.46631
R1184 VSS.n700 VSS.t449 8.46631
R1185 VSS.n708 VSS.t443 8.46631
R1186 VSS.n717 VSS.t441 8.46631
R1187 VSS.n725 VSS.t409 8.46631
R1188 VSS.n734 VSS.t439 8.46631
R1189 VSS.n742 VSS.t413 8.46631
R1190 VSS.n751 VSS.t433 8.46631
R1191 VSS.n759 VSS.t437 8.46631
R1192 VSS.n768 VSS.t435 8.46631
R1193 VSS.n776 VSS.t427 8.46631
R1194 VSS.n785 VSS.t431 8.46631
R1195 VSS.n793 VSS.t411 8.46631
R1196 VSS.n802 VSS.t415 8.46631
R1197 VSS.n810 VSS.t429 8.46631
R1198 VSS.n819 VSS.t419 8.46631
R1199 VSS.n830 VSS.t369 8.46519
R1200 VSS.n825 VSS.t365 8.46519
R1201 VSS.n838 VSS.t366 8.46519
R1202 VSS.n865 VSS.n126 6.99673
R1203 VSS.n107 VSS.n372 5.63777
R1204 VSS.n854 VSS.n107 5.62581
R1205 VSS.n858 VSS.n107 5.62581
R1206 VSS.n864 VSS.n107 5.62581
R1207 VSS.n107 VSS.n817 5.62581
R1208 VSS.n107 VSS.n243 5.62581
R1209 VSS.n107 VSS.n800 5.62581
R1210 VSS.n107 VSS.n251 5.62581
R1211 VSS.n107 VSS.n783 5.62581
R1212 VSS.n107 VSS.n259 5.62581
R1213 VSS.n107 VSS.n766 5.62581
R1214 VSS.n107 VSS.n267 5.62581
R1215 VSS.n107 VSS.n749 5.62581
R1216 VSS.n107 VSS.n275 5.62581
R1217 VSS.n107 VSS.n732 5.62581
R1218 VSS.n107 VSS.n283 5.62581
R1219 VSS.n107 VSS.n715 5.62581
R1220 VSS.n107 VSS.n291 5.62581
R1221 VSS.n107 VSS.n698 5.62581
R1222 VSS.n107 VSS.n299 5.62581
R1223 VSS.n107 VSS.n681 5.62581
R1224 VSS.n107 VSS.n307 5.62581
R1225 VSS.n107 VSS.n664 5.62581
R1226 VSS.n107 VSS.n315 5.62581
R1227 VSS.n107 VSS.n647 5.62581
R1228 VSS.n107 VSS.n323 5.62581
R1229 VSS.n107 VSS.n630 5.62581
R1230 VSS.n107 VSS.n331 5.62581
R1231 VSS.n107 VSS.n613 5.62581
R1232 VSS.n107 VSS.n339 5.62581
R1233 VSS.n107 VSS.n596 5.62581
R1234 VSS.n107 VSS.n347 5.62581
R1235 VSS.n107 VSS.n579 5.62581
R1236 VSS.n107 VSS.n355 5.62581
R1237 VSS.n107 VSS.n562 5.62581
R1238 VSS.n107 VSS.n231 5.62581
R1239 VSS.n107 VSS.n229 5.62581
R1240 VSS.n107 VSS.n227 5.62581
R1241 VSS.n107 VSS.n225 5.62581
R1242 VSS.n107 VSS.n223 5.62581
R1243 VSS.n107 VSS.n221 5.62581
R1244 VSS.n107 VSS.n219 5.62581
R1245 VSS.n107 VSS.n217 5.62581
R1246 VSS.n107 VSS.n215 5.62581
R1247 VSS.n107 VSS.n213 5.62581
R1248 VSS.n107 VSS.n211 5.62581
R1249 VSS.n107 VSS.n209 5.62581
R1250 VSS.n107 VSS.n207 5.62581
R1251 VSS.n107 VSS.n205 5.62581
R1252 VSS.n107 VSS.n203 5.62581
R1253 VSS.n107 VSS.n201 5.62581
R1254 VSS.n107 VSS.n199 5.62581
R1255 VSS.n107 VSS.n197 5.62581
R1256 VSS.n107 VSS.n195 5.62581
R1257 VSS.n107 VSS.n193 5.62581
R1258 VSS.n107 VSS.n191 5.62581
R1259 VSS.n107 VSS.n189 5.62581
R1260 VSS.n107 VSS.n187 5.62581
R1261 VSS.n107 VSS.n185 5.62581
R1262 VSS.n107 VSS.n183 5.62581
R1263 VSS.n107 VSS.n181 5.62581
R1264 VSS.n107 VSS.n179 5.62581
R1265 VSS.n107 VSS.n177 5.62581
R1266 VSS.n107 VSS.n175 5.62581
R1267 VSS.n107 VSS.n173 5.62581
R1268 VSS.n107 VSS.n171 5.62581
R1269 VSS.n107 VSS.n169 5.62581
R1270 VSS.n107 VSS.n164 5.62581
R1271 VSS.n3 VSS.n378 5.62581
R1272 VSS.n3 VSS.n382 5.62581
R1273 VSS.n526 VSS.n3 5.62581
R1274 VSS.n3 VSS.n390 5.62581
R1275 VSS.n511 VSS.n3 5.62581
R1276 VSS.n3 VSS.n398 5.62581
R1277 VSS.n496 VSS.n3 5.62581
R1278 VSS.n488 VSS.n3 5.62581
R1279 VSS.n3 VSS.n406 5.62581
R1280 VSS.n473 VSS.n3 5.62581
R1281 VSS.n3 VSS.n414 5.62581
R1282 VSS.n458 VSS.n3 5.62581
R1283 VSS.n3 VSS.n422 5.62581
R1284 VSS.n5 VSS.n3 0.761893
R1285 VSS.n446 VSS.n3 5.62581
R1286 VSS.n438 VSS.n3 5.62581
R1287 VSS.n434 VSS.n3 5.62581
R1288 VSS.n428 VSS.n126 4.28471
R1289 VSS.n3 VSS.n537 4.21914
R1290 VSS.n3 VSS.n522 4.21914
R1291 VSS.n3 VSS.n507 4.21914
R1292 VSS.n3 VSS.n484 4.21914
R1293 VSS.n3 VSS.n469 4.21914
R1294 VSS.n3 VSS.n454 4.21914
R1295 VSS.n107 VSS.n165 4.20662
R1296 VSS.n850 VSS.n107 4.19244
R1297 VSS.n107 VSS.n834 4.19244
R1298 VSS.n430 VSS.n3 4.19244
R1299 VSS VSS.n126 3.80469
R1300 VSS.n822 VSS.t418 3.34498
R1301 VSS.n814 VSS.t428 3.34498
R1302 VSS.n806 VSS.t414 3.34498
R1303 VSS.n797 VSS.t410 3.34498
R1304 VSS.n789 VSS.t430 3.34498
R1305 VSS.n780 VSS.t426 3.34498
R1306 VSS.n772 VSS.t434 3.34498
R1307 VSS.n763 VSS.t436 3.34498
R1308 VSS.n755 VSS.t432 3.34498
R1309 VSS.n746 VSS.t412 3.34498
R1310 VSS.n738 VSS.t438 3.34498
R1311 VSS.n729 VSS.t408 3.34498
R1312 VSS.n721 VSS.t440 3.34498
R1313 VSS.n712 VSS.t442 3.34498
R1314 VSS.n704 VSS.t448 3.34498
R1315 VSS.n695 VSS.t444 3.34498
R1316 VSS.n687 VSS.t450 3.34498
R1317 VSS.n678 VSS.t446 3.34498
R1318 VSS.n670 VSS.t454 3.34498
R1319 VSS.n661 VSS.t456 3.34498
R1320 VSS.n653 VSS.t460 3.34498
R1321 VSS.n644 VSS.t452 3.34498
R1322 VSS.n636 VSS.t458 3.34498
R1323 VSS.n627 VSS.t424 3.34498
R1324 VSS.n619 VSS.t466 3.34498
R1325 VSS.n610 VSS.t462 3.34498
R1326 VSS.n602 VSS.t468 3.34498
R1327 VSS.n593 VSS.t422 3.34498
R1328 VSS.n585 VSS.t464 3.34498
R1329 VSS.n576 VSS.t420 3.34498
R1330 VSS.n568 VSS.t416 3.34498
R1331 VSS.n559 VSS.t470 3.34498
R1332 VSS.n856 VSS.n107 3.3265
R1333 VSS.n860 VSS.n107 3.3265
R1334 VSS.n107 VSS.n812 3.3265
R1335 VSS.n107 VSS.n795 3.3265
R1336 VSS.n107 VSS.n778 3.3265
R1337 VSS.n107 VSS.n761 3.3265
R1338 VSS.n107 VSS.n744 3.3265
R1339 VSS.n107 VSS.n727 3.3265
R1340 VSS.n107 VSS.n710 3.3265
R1341 VSS.n107 VSS.n693 3.3265
R1342 VSS.n107 VSS.n676 3.3265
R1343 VSS.n107 VSS.n659 3.3265
R1344 VSS.n107 VSS.n642 3.3265
R1345 VSS.n107 VSS.n625 3.3265
R1346 VSS.n107 VSS.n608 3.3265
R1347 VSS.n107 VSS.n591 3.3265
R1348 VSS.n107 VSS.n574 3.3265
R1349 VSS.n107 VSS.n557 3.3265
R1350 VSS.n530 VSS.n3 3.3265
R1351 VSS.n515 VSS.n3 3.3265
R1352 VSS.n500 VSS.n3 3.3265
R1353 VSS.n477 VSS.n3 3.3265
R1354 VSS.n462 VSS.n3 3.3265
R1355 VSS.n448 VSS.n4 0.440892
R1356 VSS.n444 VSS.n3 3.3265
R1357 VSS.n440 VSS.n3 3.3265
R1358 VSS.n436 VSS.n3 3.3265
R1359 VSS.n841 VSS 3.16675
R1360 VSS.n542 VSS.n541 3.01826
R1361 VSS.n107 VSS.n80 2.83376
R1362 VSS.n852 VSS.n107 2.74446
R1363 VSS.n107 VSS.n237 2.74446
R1364 VSS.n107 VSS.n245 2.74446
R1365 VSS.n107 VSS.n253 2.74446
R1366 VSS.n107 VSS.n261 2.74446
R1367 VSS.n107 VSS.n269 2.74446
R1368 VSS.n107 VSS.n277 2.74446
R1369 VSS.n107 VSS.n285 2.74446
R1370 VSS.n107 VSS.n293 2.74446
R1371 VSS.n107 VSS.n301 2.74446
R1372 VSS.n107 VSS.n309 2.74446
R1373 VSS.n107 VSS.n317 2.74446
R1374 VSS.n107 VSS.n325 2.74446
R1375 VSS.n107 VSS.n333 2.74446
R1376 VSS.n107 VSS.n341 2.74446
R1377 VSS.n107 VSS.n349 2.74446
R1378 VSS.n107 VSS.n357 2.74446
R1379 VSS.n107 VSS.n232 2.74446
R1380 VSS.n432 VSS.n3 2.74446
R1381 VSS.n107 VSS.n133 2.32483
R1382 VSS.n107 VSS.n134 2.32483
R1383 VSS.n107 VSS.n135 2.32483
R1384 VSS.n107 VSS.n136 2.32483
R1385 VSS.n107 VSS.n137 2.32483
R1386 VSS.n107 VSS.n138 2.32483
R1387 VSS.n107 VSS.n139 2.32483
R1388 VSS.n107 VSS.n140 2.32483
R1389 VSS.n107 VSS.n141 2.32483
R1390 VSS.n107 VSS.n142 2.32483
R1391 VSS.n107 VSS.n143 2.32483
R1392 VSS.n107 VSS.n144 2.32483
R1393 VSS.n107 VSS.n145 2.32483
R1394 VSS.n107 VSS.n146 2.32483
R1395 VSS.n107 VSS.n147 2.32483
R1396 VSS.n107 VSS.n148 2.32483
R1397 VSS.n107 VSS.n149 2.32483
R1398 VSS.n107 VSS.n150 2.32483
R1399 VSS.n107 VSS.n151 2.32483
R1400 VSS.n107 VSS.n152 2.32483
R1401 VSS.n107 VSS.n153 2.32483
R1402 VSS.n107 VSS.n154 2.32483
R1403 VSS.n107 VSS.n155 2.32483
R1404 VSS.n107 VSS.n156 2.32483
R1405 VSS.n107 VSS.n157 2.32483
R1406 VSS.n107 VSS.n158 2.32483
R1407 VSS.n107 VSS.n159 2.32483
R1408 VSS.n107 VSS.n160 2.32483
R1409 VSS.n107 VSS.n161 2.32483
R1410 VSS.n107 VSS.n162 2.32483
R1411 VSS.n107 VSS.n163 2.32483
R1412 VSS.n494 VSS.n3 2.00687
R1413 VSS.n107 VSS.n6 1.64417
R1414 VSS.n107 VSS.n847 1.64417
R1415 VSS.n107 VSS.n129 1.64417
R1416 VSS.n107 VSS.n130 1.64417
R1417 VSS.n107 VSS.n843 1.64417
R1418 VSS.n3 VSS.n375 1.56144
R1419 VSS.n528 VSS.n3 1.56144
R1420 VSS.n513 VSS.n3 1.56144
R1421 VSS.n490 VSS.n3 1.56144
R1422 VSS.n475 VSS.n3 1.56144
R1423 VSS.n460 VSS.n3 1.56144
R1424 VSS.n498 VSS.n3 1.12565
R1425 VSS.n541 VSS.n3 0.92982
R1426 VSS.n4 VSS.n3 0.665344
R1427 VSS.n492 VSS.n3 0.849178
R1428 VSS.n492 VSS.n491 0.728316
R1429 VSS.n493 VSS.n492 0.69965
R1430 VSS.n541 VSS.n373 0.69304
R1431 VSS.n3 VSS.n0 0.613782
R1432 VSS.n7 VSS.t128 154.007
R1433 VSS.n3 VSS.n2 0.613782
R1434 VSS.n3 VSS.n6 4666.38
R1435 VSS.n498 VSS.n497 0.603496
R1436 VSS.n107 VSS.n81 0.00101512
R1437 VSS.n107 VSS.n103 0.556705
R1438 VSS.n499 VSS.n498 0.540438
R1439 VSS VSS.n865 0.48296
R1440 VSS.n550 VSS.n549 0.419816
R1441 VSS.n556 VSS.n555 0.419816
R1442 VSS.n565 VSS.n564 0.419816
R1443 VSS.n573 VSS.n572 0.419816
R1444 VSS.n582 VSS.n581 0.419816
R1445 VSS.n590 VSS.n589 0.419816
R1446 VSS.n599 VSS.n598 0.419816
R1447 VSS.n607 VSS.n606 0.419816
R1448 VSS.n616 VSS.n615 0.419816
R1449 VSS.n624 VSS.n623 0.419816
R1450 VSS.n633 VSS.n632 0.419816
R1451 VSS.n641 VSS.n640 0.419816
R1452 VSS.n650 VSS.n649 0.419816
R1453 VSS.n658 VSS.n657 0.419816
R1454 VSS.n667 VSS.n666 0.419816
R1455 VSS.n675 VSS.n674 0.419816
R1456 VSS.n684 VSS.n683 0.419816
R1457 VSS.n692 VSS.n691 0.419816
R1458 VSS.n701 VSS.n700 0.419816
R1459 VSS.n709 VSS.n708 0.419816
R1460 VSS.n718 VSS.n717 0.419816
R1461 VSS.n726 VSS.n725 0.419816
R1462 VSS.n735 VSS.n734 0.419816
R1463 VSS.n743 VSS.n742 0.419816
R1464 VSS.n752 VSS.n751 0.419816
R1465 VSS.n760 VSS.n759 0.419816
R1466 VSS.n769 VSS.n768 0.419816
R1467 VSS.n777 VSS.n776 0.419816
R1468 VSS.n786 VSS.n785 0.419816
R1469 VSS.n794 VSS.n793 0.419816
R1470 VSS.n803 VSS.n802 0.419816
R1471 VSS.n811 VSS.n810 0.419816
R1472 VSS.n820 VSS.n819 0.419816
R1473 VSS.n461 VSS.n460 0.413418
R1474 VSS.n476 VSS.n475 0.413418
R1475 VSS.n491 VSS.n490 0.413418
R1476 VSS.n514 VSS.n513 0.413418
R1477 VSS.n529 VSS.n528 0.413418
R1478 VSS.n375 VSS.n373 0.413418
R1479 VSS.n830 VSS.n829 0.385697
R1480 VSS.n825 VSS.n824 0.385697
R1481 VSS.n549 VSS.n548 0.383459
R1482 VSS.n555 VSS.n554 0.383459
R1483 VSS.n564 VSS.n563 0.383459
R1484 VSS.n572 VSS.n571 0.383459
R1485 VSS.n581 VSS.n580 0.383459
R1486 VSS.n589 VSS.n588 0.383459
R1487 VSS.n598 VSS.n597 0.383459
R1488 VSS.n606 VSS.n605 0.383459
R1489 VSS.n615 VSS.n614 0.383459
R1490 VSS.n623 VSS.n622 0.383459
R1491 VSS.n632 VSS.n631 0.383459
R1492 VSS.n640 VSS.n639 0.383459
R1493 VSS.n649 VSS.n648 0.383459
R1494 VSS.n657 VSS.n656 0.383459
R1495 VSS.n666 VSS.n665 0.383459
R1496 VSS.n674 VSS.n673 0.383459
R1497 VSS.n683 VSS.n682 0.383459
R1498 VSS.n691 VSS.n690 0.383459
R1499 VSS.n700 VSS.n699 0.383459
R1500 VSS.n708 VSS.n707 0.383459
R1501 VSS.n717 VSS.n716 0.383459
R1502 VSS.n725 VSS.n724 0.383459
R1503 VSS.n734 VSS.n733 0.383459
R1504 VSS.n742 VSS.n741 0.383459
R1505 VSS.n751 VSS.n750 0.383459
R1506 VSS.n759 VSS.n758 0.383459
R1507 VSS.n768 VSS.n767 0.383459
R1508 VSS.n776 VSS.n775 0.383459
R1509 VSS.n785 VSS.n784 0.383459
R1510 VSS.n793 VSS.n792 0.383459
R1511 VSS.n802 VSS.n801 0.383459
R1512 VSS.n810 VSS.n809 0.383459
R1513 VSS.n819 VSS.n818 0.383459
R1514 VSS.n495 VSS.n494 0.380519
R1515 VSS.n839 VSS.n838 0.379351
R1516 VSS.n545 VSS.n544 0.37817
R1517 VSS.n494 VSS.n493 0.359515
R1518 VSS.n230 VSS.n133 0.351341
R1519 VSS.n228 VSS.n134 0.351341
R1520 VSS.n226 VSS.n135 0.351341
R1521 VSS.n224 VSS.n136 0.351341
R1522 VSS.n222 VSS.n137 0.351341
R1523 VSS.n220 VSS.n138 0.351341
R1524 VSS.n218 VSS.n139 0.351341
R1525 VSS.n216 VSS.n140 0.351341
R1526 VSS.n214 VSS.n141 0.351341
R1527 VSS.n212 VSS.n142 0.351341
R1528 VSS.n210 VSS.n143 0.351341
R1529 VSS.n208 VSS.n144 0.351341
R1530 VSS.n206 VSS.n145 0.351341
R1531 VSS.n204 VSS.n146 0.351341
R1532 VSS.n202 VSS.n147 0.351341
R1533 VSS.n200 VSS.n148 0.351341
R1534 VSS.n198 VSS.n149 0.351341
R1535 VSS.n196 VSS.n150 0.351341
R1536 VSS.n194 VSS.n151 0.351341
R1537 VSS.n192 VSS.n152 0.351341
R1538 VSS.n190 VSS.n153 0.351341
R1539 VSS.n188 VSS.n154 0.351341
R1540 VSS.n186 VSS.n155 0.351341
R1541 VSS.n184 VSS.n156 0.351341
R1542 VSS.n182 VSS.n157 0.351341
R1543 VSS.n180 VSS.n158 0.351341
R1544 VSS.n178 VSS.n159 0.351341
R1545 VSS.n176 VSS.n160 0.351341
R1546 VSS.n174 VSS.n161 0.351341
R1547 VSS.n172 VSS.n162 0.351341
R1548 VSS.n170 VSS.n163 0.351341
R1549 VSS.n368 VSS.n367 0.345929
R1550 VSS.n544 VSS.n543 0.345929
R1551 VSS.n377 VSS.n375 0.340858
R1552 VSS.n528 VSS.n527 0.340858
R1553 VSS.n513 VSS.n512 0.340858
R1554 VSS.n490 VSS.n489 0.340858
R1555 VSS.n475 VSS.n474 0.340858
R1556 VSS.n460 VSS.n459 0.340858
R1557 VSS.n853 VSS.n852 0.318018
R1558 VSS.n433 VSS.n432 0.316299
R1559 VSS.n809 VSS.n133 0.311066
R1560 VSS.n801 VSS.n134 0.311066
R1561 VSS.n792 VSS.n135 0.311066
R1562 VSS.n784 VSS.n136 0.311066
R1563 VSS.n775 VSS.n137 0.311066
R1564 VSS.n767 VSS.n138 0.311066
R1565 VSS.n758 VSS.n139 0.311066
R1566 VSS.n750 VSS.n140 0.311066
R1567 VSS.n741 VSS.n141 0.311066
R1568 VSS.n733 VSS.n142 0.311066
R1569 VSS.n724 VSS.n143 0.311066
R1570 VSS.n716 VSS.n144 0.311066
R1571 VSS.n707 VSS.n145 0.311066
R1572 VSS.n699 VSS.n146 0.311066
R1573 VSS.n690 VSS.n147 0.311066
R1574 VSS.n682 VSS.n148 0.311066
R1575 VSS.n673 VSS.n149 0.311066
R1576 VSS.n665 VSS.n150 0.311066
R1577 VSS.n656 VSS.n151 0.311066
R1578 VSS.n648 VSS.n152 0.311066
R1579 VSS.n639 VSS.n153 0.311066
R1580 VSS.n631 VSS.n154 0.311066
R1581 VSS.n622 VSS.n155 0.311066
R1582 VSS.n614 VSS.n156 0.311066
R1583 VSS.n605 VSS.n157 0.311066
R1584 VSS.n597 VSS.n158 0.311066
R1585 VSS.n588 VSS.n159 0.311066
R1586 VSS.n580 VSS.n160 0.311066
R1587 VSS.n571 VSS.n161 0.311066
R1588 VSS.n563 VSS.n162 0.311066
R1589 VSS.n554 VSS.n163 0.311066
R1590 VSS.n239 VSS.n237 0.284268
R1591 VSS.n247 VSS.n245 0.284268
R1592 VSS.n255 VSS.n253 0.284268
R1593 VSS.n263 VSS.n261 0.284268
R1594 VSS.n271 VSS.n269 0.284268
R1595 VSS.n279 VSS.n277 0.284268
R1596 VSS.n287 VSS.n285 0.284268
R1597 VSS.n295 VSS.n293 0.284268
R1598 VSS.n303 VSS.n301 0.284268
R1599 VSS.n311 VSS.n309 0.284268
R1600 VSS.n319 VSS.n317 0.284268
R1601 VSS.n327 VSS.n325 0.284268
R1602 VSS.n335 VSS.n333 0.284268
R1603 VSS.n343 VSS.n341 0.284268
R1604 VSS.n351 VSS.n349 0.284268
R1605 VSS.n359 VSS.n357 0.284268
R1606 VSS.n838 VSS.n837 0.279928
R1607 VSS.n432 VSS.n431 0.274268
R1608 VSS.n440 VSS.n439 0.274227
R1609 VSS.n462 VSS.n461 0.274227
R1610 VSS.n477 VSS.n476 0.274227
R1611 VSS.n500 VSS.n499 0.274227
R1612 VSS.n515 VSS.n514 0.274227
R1613 VSS.n530 VSS.n529 0.274227
R1614 VSS.n860 VSS.n859 0.272997
R1615 VSS.n852 VSS.n851 0.272549
R1616 VSS.n829 VSS.n232 0.271299
R1617 VSS.n107 VSS.n19 0.267794
R1618 VSS.n107 VSS.n20 0.267794
R1619 VSS.n107 VSS.n21 0.267794
R1620 VSS.n107 VSS.n76 0.267794
R1621 VSS.n107 VSS.n74 0.267794
R1622 VSS.n107 VSS.n22 0.267794
R1623 VSS.n107 VSS.n73 0.267794
R1624 VSS.n107 VSS.n72 0.267794
R1625 VSS.n107 VSS.n71 0.267794
R1626 VSS.n107 VSS.n70 0.267794
R1627 VSS.n107 VSS.n25 0.267794
R1628 VSS.n107 VSS.n69 0.267794
R1629 VSS.n107 VSS.n68 0.267794
R1630 VSS.n107 VSS.n67 0.267794
R1631 VSS.n107 VSS.n26 0.267794
R1632 VSS.n107 VSS.n27 0.267794
R1633 VSS.n107 VSS.n28 0.267794
R1634 VSS.n107 VSS.n30 0.267794
R1635 VSS.n107 VSS.n31 0.267794
R1636 VSS.n107 VSS.n32 0.267794
R1637 VSS.n107 VSS.n33 0.267794
R1638 VSS.n107 VSS.n34 0.267794
R1639 VSS.n107 VSS.n64 0.267794
R1640 VSS.n107 VSS.n63 0.267794
R1641 VSS.n107 VSS.n62 0.267794
R1642 VSS.n107 VSS.n36 0.267794
R1643 VSS.n107 VSS.n60 0.267794
R1644 VSS.n107 VSS.n59 0.267794
R1645 VSS.n107 VSS.n38 0.267794
R1646 VSS.n107 VSS.n58 0.267794
R1647 VSS.n107 VSS.n57 0.267794
R1648 VSS.n107 VSS.n39 0.267794
R1649 VSS.n107 VSS.n40 0.267794
R1650 VSS.n107 VSS.n55 0.267794
R1651 VSS.n107 VSS.n41 0.267794
R1652 VSS.n107 VSS.n42 0.267794
R1653 VSS.n107 VSS.n54 0.267794
R1654 VSS.n107 VSS.n53 0.267794
R1655 VSS.n107 VSS.n52 0.267794
R1656 VSS.n107 VSS.n50 0.267794
R1657 VSS.n107 VSS.n44 0.267794
R1658 VSS.n107 VSS.n49 0.267794
R1659 VSS.n107 VSS.n47 0.267794
R1660 VSS.n107 VSS.n46 0.267794
R1661 VSS.n107 VSS.n102 0.267794
R1662 VSS.n107 VSS.n101 0.267794
R1663 VSS.n107 VSS.n100 0.267794
R1664 VSS.n107 VSS.n99 0.267794
R1665 VSS.n107 VSS.n98 0.267794
R1666 VSS.n107 VSS.n97 0.267794
R1667 VSS.n107 VSS.n96 0.267794
R1668 VSS.n107 VSS.n95 0.267794
R1669 VSS.n107 VSS.n94 0.267794
R1670 VSS.n107 VSS.n93 0.267794
R1671 VSS.n107 VSS.n92 0.267794
R1672 VSS.n107 VSS.n91 0.267794
R1673 VSS.n107 VSS.n90 0.267794
R1674 VSS.n107 VSS.n89 0.267794
R1675 VSS.n107 VSS.n88 0.267794
R1676 VSS.n107 VSS.n87 0.267794
R1677 VSS.n107 VSS.n86 0.267794
R1678 VSS.n107 VSS.n85 0.267794
R1679 VSS.n107 VSS.n84 0.267794
R1680 VSS.n107 VSS.n83 0.267794
R1681 VSS.n107 VSS.n82 0.267794
R1682 VSS.n818 VSS.n232 0.265518
R1683 VSS.n371 VSS.n165 0.259448
R1684 VSS.n369 VSS.n368 0.251101
R1685 VSS.n445 VSS.n444 0.245497
R1686 VSS.n812 VSS.n811 0.244247
R1687 VSS.n795 VSS.n794 0.244247
R1688 VSS.n778 VSS.n777 0.244247
R1689 VSS.n761 VSS.n760 0.244247
R1690 VSS.n744 VSS.n743 0.244247
R1691 VSS.n727 VSS.n726 0.244247
R1692 VSS.n710 VSS.n709 0.244247
R1693 VSS.n693 VSS.n692 0.244247
R1694 VSS.n676 VSS.n675 0.244247
R1695 VSS.n659 VSS.n658 0.244247
R1696 VSS.n642 VSS.n641 0.244247
R1697 VSS.n625 VSS.n624 0.244247
R1698 VSS.n608 VSS.n607 0.244247
R1699 VSS.n591 VSS.n590 0.244247
R1700 VSS.n574 VSS.n573 0.244247
R1701 VSS.n557 VSS.n556 0.244247
R1702 VSS.n816 VSS.n237 0.240049
R1703 VSS.n799 VSS.n245 0.240049
R1704 VSS.n782 VSS.n253 0.240049
R1705 VSS.n765 VSS.n261 0.240049
R1706 VSS.n748 VSS.n269 0.240049
R1707 VSS.n731 VSS.n277 0.240049
R1708 VSS.n714 VSS.n285 0.240049
R1709 VSS.n697 VSS.n293 0.240049
R1710 VSS.n680 VSS.n301 0.240049
R1711 VSS.n663 VSS.n309 0.240049
R1712 VSS.n646 VSS.n317 0.240049
R1713 VSS.n629 VSS.n325 0.240049
R1714 VSS.n612 VSS.n333 0.240049
R1715 VSS.n595 VSS.n341 0.240049
R1716 VSS.n578 VSS.n349 0.240049
R1717 VSS.n561 VSS.n357 0.240049
R1718 VSS.n463 VSS.n462 0.237997
R1719 VSS.n478 VSS.n477 0.237997
R1720 VSS.n501 VSS.n500 0.237997
R1721 VSS.n516 VSS.n515 0.237997
R1722 VSS.n531 VSS.n530 0.237997
R1723 VSS.n436 VSS.n435 0.234227
R1724 VSS.n856 VSS.n855 0.232997
R1725 VSS.n857 VSS.n856 0.231727
R1726 VSS.n437 VSS.n436 0.230497
R1727 VSS.n812 VSS.n808 0.224227
R1728 VSS.n795 VSS.n791 0.224227
R1729 VSS.n778 VSS.n774 0.224227
R1730 VSS.n761 VSS.n757 0.224227
R1731 VSS.n744 VSS.n740 0.224227
R1732 VSS.n727 VSS.n723 0.224227
R1733 VSS.n710 VSS.n706 0.224227
R1734 VSS.n693 VSS.n689 0.224227
R1735 VSS.n676 VSS.n672 0.224227
R1736 VSS.n659 VSS.n655 0.224227
R1737 VSS.n642 VSS.n638 0.224227
R1738 VSS.n625 VSS.n621 0.224227
R1739 VSS.n608 VSS.n604 0.224227
R1740 VSS.n591 VSS.n587 0.224227
R1741 VSS.n574 VSS.n570 0.224227
R1742 VSS.n557 VSS.n553 0.224227
R1743 VSS.n444 VSS.n443 0.219227
R1744 VSS.n831 VSS.n830 0.21012
R1745 VSS.n827 VSS.n825 0.21012
R1746 VSS.n372 VSS.n371 0.206787
R1747 VSS.n851 VSS.n850 0.201058
R1748 VSS.n431 VSS.n430 0.200293
R1749 VSS.n861 VSS.n860 0.191727
R1750 VSS.n441 VSS.n440 0.190497
R1751 VSS.n817 VSS.n816 0.186138
R1752 VSS.n800 VSS.n799 0.186138
R1753 VSS.n783 VSS.n782 0.186138
R1754 VSS.n766 VSS.n765 0.186138
R1755 VSS.n749 VSS.n748 0.186138
R1756 VSS.n732 VSS.n731 0.186138
R1757 VSS.n715 VSS.n714 0.186138
R1758 VSS.n698 VSS.n697 0.186138
R1759 VSS.n681 VSS.n680 0.186138
R1760 VSS.n664 VSS.n663 0.186138
R1761 VSS.n647 VSS.n646 0.186138
R1762 VSS.n630 VSS.n629 0.186138
R1763 VSS.n613 VSS.n612 0.186138
R1764 VSS.n596 VSS.n595 0.186138
R1765 VSS.n579 VSS.n578 0.186138
R1766 VSS.n562 VSS.n561 0.186138
R1767 VSS.n834 VSS.n833 0.179043
R1768 VSS.n367 VSS.n165 0.177116
R1769 VSS.n865 VSS.n864 0.167388
R1770 VSS.n168 VSS.n164 0.16705
R1771 VSS.n454 VSS.n453 0.166269
R1772 VSS.n469 VSS.n468 0.166269
R1773 VSS.n484 VSS.n483 0.166269
R1774 VSS.n507 VSS.n506 0.166269
R1775 VSS.n522 VSS.n521 0.166269
R1776 VSS.n537 VSS.n536 0.166269
R1777 VSS.n5 VSS.n447 0.318488
R1778 VSS.n818 VSS.n231 0.16205
R1779 VSS.n809 VSS.n229 0.16205
R1780 VSS.n801 VSS.n227 0.16205
R1781 VSS.n792 VSS.n225 0.16205
R1782 VSS.n784 VSS.n223 0.16205
R1783 VSS.n775 VSS.n221 0.16205
R1784 VSS.n767 VSS.n219 0.16205
R1785 VSS.n758 VSS.n217 0.16205
R1786 VSS.n750 VSS.n215 0.16205
R1787 VSS.n741 VSS.n213 0.16205
R1788 VSS.n733 VSS.n211 0.16205
R1789 VSS.n724 VSS.n209 0.16205
R1790 VSS.n716 VSS.n207 0.16205
R1791 VSS.n707 VSS.n205 0.16205
R1792 VSS.n699 VSS.n203 0.16205
R1793 VSS.n690 VSS.n201 0.16205
R1794 VSS.n682 VSS.n199 0.16205
R1795 VSS.n673 VSS.n197 0.16205
R1796 VSS.n665 VSS.n195 0.16205
R1797 VSS.n656 VSS.n193 0.16205
R1798 VSS.n648 VSS.n191 0.16205
R1799 VSS.n639 VSS.n189 0.16205
R1800 VSS.n631 VSS.n187 0.16205
R1801 VSS.n622 VSS.n185 0.16205
R1802 VSS.n614 VSS.n183 0.16205
R1803 VSS.n605 VSS.n181 0.16205
R1804 VSS.n597 VSS.n179 0.16205
R1805 VSS.n588 VSS.n177 0.16205
R1806 VSS.n580 VSS.n175 0.16205
R1807 VSS.n571 VSS.n173 0.16205
R1808 VSS.n563 VSS.n171 0.16205
R1809 VSS.n554 VSS.n169 0.16205
R1810 VSS.n107 VSS.n17 0.16137
R1811 VSS.n107 VSS.n105 0.16137
R1812 VSS.n107 VSS.n104 0.16137
R1813 VSS.n834 VSS.n823 0.161058
R1814 VSS.n430 VSS.n429 0.161058
R1815 VSS.n850 VSS.n849 0.160293
R1816 VSS.n808 VSS.n243 0.15705
R1817 VSS.n791 VSS.n251 0.15705
R1818 VSS.n774 VSS.n259 0.15705
R1819 VSS.n757 VSS.n267 0.15705
R1820 VSS.n740 VSS.n275 0.15705
R1821 VSS.n723 VSS.n283 0.15705
R1822 VSS.n706 VSS.n291 0.15705
R1823 VSS.n689 VSS.n299 0.15705
R1824 VSS.n672 VSS.n307 0.15705
R1825 VSS.n655 VSS.n315 0.15705
R1826 VSS.n638 VSS.n323 0.15705
R1827 VSS.n621 VSS.n331 0.15705
R1828 VSS.n604 VSS.n339 0.15705
R1829 VSS.n587 VSS.n347 0.15705
R1830 VSS.n570 VSS.n355 0.15705
R1831 VSS.n450 VSS.n423 0.155582
R1832 VSS.n421 VSS.n420 0.155582
R1833 VSS.n459 VSS.n418 0.155582
R1834 VSS.n465 VSS.n415 0.155582
R1835 VSS.n413 VSS.n412 0.155582
R1836 VSS.n474 VSS.n410 0.155582
R1837 VSS.n480 VSS.n407 0.155582
R1838 VSS.n405 VSS.n404 0.155582
R1839 VSS.n489 VSS.n402 0.155582
R1840 VSS.n503 VSS.n399 0.155582
R1841 VSS.n397 VSS.n396 0.155582
R1842 VSS.n512 VSS.n394 0.155582
R1843 VSS.n518 VSS.n391 0.155582
R1844 VSS.n389 VSS.n388 0.155582
R1845 VSS.n527 VSS.n386 0.155582
R1846 VSS.n533 VSS.n383 0.155582
R1847 VSS.n381 VSS.n380 0.155582
R1848 VSS.n377 VSS.n376 0.155582
R1849 VSS.n820 VSS.n817 0.1508
R1850 VSS.n803 VSS.n800 0.1508
R1851 VSS.n786 VSS.n783 0.1508
R1852 VSS.n769 VSS.n766 0.1508
R1853 VSS.n752 VSS.n749 0.1508
R1854 VSS.n735 VSS.n732 0.1508
R1855 VSS.n718 VSS.n715 0.1508
R1856 VSS.n701 VSS.n698 0.1508
R1857 VSS.n684 VSS.n681 0.1508
R1858 VSS.n667 VSS.n664 0.1508
R1859 VSS.n650 VSS.n647 0.1508
R1860 VSS.n633 VSS.n630 0.1508
R1861 VSS.n616 VSS.n613 0.1508
R1862 VSS.n599 VSS.n596 0.1508
R1863 VSS.n582 VSS.n579 0.1508
R1864 VSS.n565 VSS.n562 0.1508
R1865 VSS.n438 VSS.n437 0.149888
R1866 VSS.n858 VSS.n857 0.14955
R1867 VSS.n448 VSS.n427 0.149476
R1868 VSS.n452 VSS.n451 0.149476
R1869 VSS.n456 VSS.n419 0.149476
R1870 VSS.n463 VSS.n417 0.149476
R1871 VSS.n467 VSS.n466 0.149476
R1872 VSS.n471 VSS.n411 0.149476
R1873 VSS.n478 VSS.n409 0.149476
R1874 VSS.n482 VSS.n481 0.149476
R1875 VSS.n486 VSS.n403 0.149476
R1876 VSS.n501 VSS.n401 0.149476
R1877 VSS.n505 VSS.n504 0.149476
R1878 VSS.n509 VSS.n395 0.149476
R1879 VSS.n516 VSS.n393 0.149476
R1880 VSS.n520 VSS.n519 0.149476
R1881 VSS.n524 VSS.n387 0.149476
R1882 VSS.n531 VSS.n385 0.149476
R1883 VSS.n535 VSS.n534 0.149476
R1884 VSS.n539 VSS.n379 0.149476
R1885 VSS.n837 VSS.n836 0.148577
R1886 VSS.n855 VSS.n854 0.147388
R1887 VSS.n435 VSS.n434 0.14705
R1888 VSS.n862 VSS.n861 0.142118
R1889 VSS.n442 VSS.n441 0.142118
R1890 VSS.n372 VSS.n370 0.141022
R1891 VSS.n446 VSS.n445 0.134888
R1892 VSS.n496 VSS.n495 0.134888
R1893 VSS.n450 VSS.n449 0.129618
R1894 VSS.n465 VSS.n464 0.129618
R1895 VSS.n480 VSS.n479 0.129618
R1896 VSS.n503 VSS.n502 0.129618
R1897 VSS.n518 VSS.n517 0.129618
R1898 VSS.n533 VSS.n532 0.129618
R1899 VSS.n370 VSS.n369 0.127569
R1900 VSS.n453 VSS.n422 0.126138
R1901 VSS.n468 VSS.n414 0.126138
R1902 VSS.n483 VSS.n406 0.126138
R1903 VSS.n506 VSS.n398 0.126138
R1904 VSS.n521 VSS.n390 0.126138
R1905 VSS.n536 VSS.n382 0.126138
R1906 VSS.n823 VSS.n821 0.125868
R1907 VSS.n805 VSS.n804 0.125868
R1908 VSS.n788 VSS.n787 0.125868
R1909 VSS.n771 VSS.n770 0.125868
R1910 VSS.n754 VSS.n753 0.125868
R1911 VSS.n737 VSS.n736 0.125868
R1912 VSS.n720 VSS.n719 0.125868
R1913 VSS.n703 VSS.n702 0.125868
R1914 VSS.n686 VSS.n685 0.125868
R1915 VSS.n669 VSS.n668 0.125868
R1916 VSS.n652 VSS.n651 0.125868
R1917 VSS.n635 VSS.n634 0.125868
R1918 VSS.n618 VSS.n617 0.125868
R1919 VSS.n601 VSS.n600 0.125868
R1920 VSS.n584 VSS.n583 0.125868
R1921 VSS.n567 VSS.n566 0.125868
R1922 VSS.n108 VSS.n424 0.156005
R1923 VSS.n111 VSS.n416 0.156005
R1924 VSS.n114 VSS.n408 0.156005
R1925 VSS.n117 VSS.n400 0.156005
R1926 VSS.n120 VSS.n392 0.156005
R1927 VSS.n123 VSS.n384 0.156005
R1928 VSS.n548 VSS.n167 0.124618
R1929 VSS.n864 VSS.n863 0.12455
R1930 VSS.n543 VSS.n167 0.122118
R1931 VSS.n447 VSS.n446 0.12205
R1932 VSS.n459 VSS.n458 0.12205
R1933 VSS.n474 VSS.n473 0.12205
R1934 VSS.n489 VSS.n488 0.12205
R1935 VSS.n497 VSS.n496 0.12205
R1936 VSS.n512 VSS.n511 0.12205
R1937 VSS.n527 VSS.n526 0.12205
R1938 VSS.n378 VSS.n377 0.12205
R1939 VSS.n231 VSS.n230 0.119888
R1940 VSS.n229 VSS.n228 0.119888
R1941 VSS.n227 VSS.n226 0.119888
R1942 VSS.n225 VSS.n224 0.119888
R1943 VSS.n223 VSS.n222 0.119888
R1944 VSS.n221 VSS.n220 0.119888
R1945 VSS.n219 VSS.n218 0.119888
R1946 VSS.n217 VSS.n216 0.119888
R1947 VSS.n215 VSS.n214 0.119888
R1948 VSS.n213 VSS.n212 0.119888
R1949 VSS.n211 VSS.n210 0.119888
R1950 VSS.n209 VSS.n208 0.119888
R1951 VSS.n207 VSS.n206 0.119888
R1952 VSS.n205 VSS.n204 0.119888
R1953 VSS.n203 VSS.n202 0.119888
R1954 VSS.n201 VSS.n200 0.119888
R1955 VSS.n199 VSS.n198 0.119888
R1956 VSS.n197 VSS.n196 0.119888
R1957 VSS.n195 VSS.n194 0.119888
R1958 VSS.n193 VSS.n192 0.119888
R1959 VSS.n191 VSS.n190 0.119888
R1960 VSS.n189 VSS.n188 0.119888
R1961 VSS.n187 VSS.n186 0.119888
R1962 VSS.n185 VSS.n184 0.119888
R1963 VSS.n183 VSS.n182 0.119888
R1964 VSS.n181 VSS.n180 0.119888
R1965 VSS.n179 VSS.n178 0.119888
R1966 VSS.n177 VSS.n176 0.119888
R1967 VSS.n175 VSS.n174 0.119888
R1968 VSS.n173 VSS.n172 0.119888
R1969 VSS.n171 VSS.n170 0.119888
R1970 VSS.n169 VSS.n168 0.119888
R1971 VSS.n548 VSS.n164 0.114888
R1972 VSS.n863 VSS.n862 0.114618
R1973 VSS.n443 VSS.n442 0.114618
R1974 VSS.n804 VSS.n243 0.113638
R1975 VSS.n787 VSS.n251 0.113638
R1976 VSS.n770 VSS.n259 0.113638
R1977 VSS.n753 VSS.n267 0.113638
R1978 VSS.n736 VSS.n275 0.113638
R1979 VSS.n719 VSS.n283 0.113638
R1980 VSS.n702 VSS.n291 0.113638
R1981 VSS.n685 VSS.n299 0.113638
R1982 VSS.n668 VSS.n307 0.113638
R1983 VSS.n651 VSS.n315 0.113638
R1984 VSS.n634 VSS.n323 0.113638
R1985 VSS.n617 VSS.n331 0.113638
R1986 VSS.n600 VSS.n339 0.113638
R1987 VSS.n583 VSS.n347 0.113638
R1988 VSS.n566 VSS.n355 0.113638
R1989 VSS.n434 VSS.n433 0.109888
R1990 VSS.n854 VSS.n853 0.10955
R1991 VSS.n859 VSS.n858 0.107388
R1992 VSS.n439 VSS.n438 0.10705
R1993 VSS.n458 VSS.n457 0.106138
R1994 VSS.n473 VSS.n472 0.106138
R1995 VSS.n488 VSS.n487 0.106138
R1996 VSS.n511 VSS.n510 0.106138
R1997 VSS.n526 VSS.n525 0.106138
R1998 VSS.n540 VSS.n378 0.106138
R1999 VSS.n456 VSS.n455 0.105361
R2000 VSS.n471 VSS.n470 0.105361
R2001 VSS.n486 VSS.n485 0.105361
R2002 VSS.n509 VSS.n508 0.105361
R2003 VSS.n524 VSS.n523 0.105361
R2004 VSS.n539 VSS.n538 0.105361
R2005 VSS.n422 VSS.n421 0.10205
R2006 VSS.n414 VSS.n413 0.10205
R2007 VSS.n406 VSS.n405 0.10205
R2008 VSS.n398 VSS.n397 0.10205
R2009 VSS.n390 VSS.n389 0.10205
R2010 VSS.n382 VSS.n381 0.10205
R2011 VSS.n449 VSS.n424 0.0983676
R2012 VSS.n464 VSS.n416 0.0983676
R2013 VSS.n479 VSS.n408 0.0983676
R2014 VSS.n502 VSS.n400 0.0983676
R2015 VSS.n517 VSS.n392 0.0983676
R2016 VSS.n532 VSS.n384 0.0983676
R2017 VSS.n828 VSS.n827 0.094
R2018 VSS.n831 VSS.n828 0.094
R2019 VSS.n836 VSS.n233 0.08925
R2020 VSS.n821 VSS.n820 0.0883676
R2021 VSS.n805 VSS.n803 0.0883676
R2022 VSS.n788 VSS.n786 0.0883676
R2023 VSS.n771 VSS.n769 0.0883676
R2024 VSS.n754 VSS.n752 0.0883676
R2025 VSS.n737 VSS.n735 0.0883676
R2026 VSS.n720 VSS.n718 0.0883676
R2027 VSS.n703 VSS.n701 0.0883676
R2028 VSS.n686 VSS.n684 0.0883676
R2029 VSS.n669 VSS.n667 0.0883676
R2030 VSS.n652 VSS.n650 0.0883676
R2031 VSS.n635 VSS.n633 0.0883676
R2032 VSS.n618 VSS.n616 0.0883676
R2033 VSS.n601 VSS.n599 0.0883676
R2034 VSS.n584 VSS.n582 0.0883676
R2035 VSS.n567 VSS.n565 0.0883676
R2036 VSS.n551 VSS.n550 0.088
R2037 VSS.n110 VSS.n456 0.0435295
R2038 VSS.n113 VSS.n471 0.0435295
R2039 VSS.n116 VSS.n486 0.0435295
R2040 VSS.n510 VSS.n119 0.176279
R2041 VSS.n525 VSS.n122 0.176279
R2042 VSS.n125 VSS.n539 0.0435295
R2043 VSS.n827 VSS.n826 0.0851154
R2044 VSS.n833 VSS.n831 0.0851154
R2045 VSS.n546 VSS.n542 0.0805
R2046 VSS.n849 VSS.n848 0.078
R2047 VSS.n429 VSS.n428 0.078
R2048 VSS.n367 VSS.n166 0.0771176
R2049 VSS.n826 VSS.n234 0.0746176
R2050 VSS.n824 VSS.n131 0.0746176
R2051 VSS.n545 VSS.n364 0.07425
R2052 VSS.n543 VSS.n166 0.0696176
R2053 VSS.n826 VSS.n235 0.06925
R2054 VSS.n824 VSS.n132 0.06925
R2055 VSS.n452 VSS.n109 0.103847
R2056 VSS.n467 VSS.n112 0.103847
R2057 VSS.n482 VSS.n115 0.103847
R2058 VSS.n505 VSS.n118 0.103847
R2059 VSS.n520 VSS.n121 0.103847
R2060 VSS.n535 VSS.n124 0.103847
R2061 VSS.n553 VSS.n363 0.06175
R2062 VSS.n829 VSS.n132 0.05925
R2063 VSS.n842 VSS.n840 0.05675
R2064 VSS.n839 VSS.n234 0.0546176
R2065 VSS.n836 VSS.n131 0.0546176
R2066 VSS.n537 VSS.n535 0.0543074
R2067 VSS.n522 VSS.n520 0.0543074
R2068 VSS.n507 VSS.n505 0.0543074
R2069 VSS.n484 VSS.n482 0.0543074
R2070 VSS.n469 VSS.n467 0.0543074
R2071 VSS.n454 VSS.n452 0.0543074
R2072 VSS.n115 VSS.n480 0.0180497
R2073 VSS.n118 VSS.n503 0.0180497
R2074 VSS.n547 VSS.n364 0.04925
R2075 VSS.n240 VSS.n239 0.048
R2076 VSS.n248 VSS.n247 0.048
R2077 VSS.n256 VSS.n255 0.048
R2078 VSS.n264 VSS.n263 0.048
R2079 VSS.n272 VSS.n271 0.048
R2080 VSS.n280 VSS.n279 0.048
R2081 VSS.n288 VSS.n287 0.048
R2082 VSS.n296 VSS.n295 0.048
R2083 VSS.n304 VSS.n303 0.048
R2084 VSS.n312 VSS.n311 0.048
R2085 VSS.n320 VSS.n319 0.048
R2086 VSS.n328 VSS.n327 0.048
R2087 VSS.n336 VSS.n335 0.048
R2088 VSS.n344 VSS.n343 0.048
R2089 VSS.n352 VSS.n351 0.048
R2090 VSS.n360 VSS.n359 0.048
R2091 VSS.n551 VSS.n547 0.04675
R2092 VSS.n811 VSS.n240 0.0405
R2093 VSS.n794 VSS.n248 0.0405
R2094 VSS.n777 VSS.n256 0.0405
R2095 VSS.n760 VSS.n264 0.0405
R2096 VSS.n743 VSS.n272 0.0405
R2097 VSS.n726 VSS.n280 0.0405
R2098 VSS.n709 VSS.n288 0.0405
R2099 VSS.n692 VSS.n296 0.0405
R2100 VSS.n675 VSS.n304 0.0405
R2101 VSS.n658 VSS.n312 0.0405
R2102 VSS.n641 VSS.n320 0.0405
R2103 VSS.n624 VSS.n328 0.0405
R2104 VSS.n607 VSS.n336 0.0405
R2105 VSS.n590 VSS.n344 0.0405
R2106 VSS.n573 VSS.n352 0.0405
R2107 VSS.n556 VSS.n360 0.0405
R2108 VSS.n848 VSS 0.038
R2109 VSS.n840 VSS.n839 0.033
R2110 VSS.n833 VSS.n832 0.033
R2111 VSS.n370 VSS.n366 0.02925
R2112 VSS.n832 VSS.n235 0.02675
R2113 VSS.n546 VSS.n545 0.02175
R2114 VSS.n107 VSS.n16 0.0166972
R2115 VSS.n107 VSS.n106 0.0166972
R2116 VSS.n538 VSS.n381 0.0166107
R2117 VSS.n523 VSS.n389 0.0166107
R2118 VSS.n508 VSS.n397 0.0166107
R2119 VSS.n485 VSS.n405 0.0166107
R2120 VSS.n470 VSS.n413 0.0166107
R2121 VSS.n455 VSS.n421 0.0166107
R2122 VSS.n542 VSS.n366 0.0155
R2123 VSS.n841 VSS.n80 0.0112403
R2124 VSS.n865 VSS.n80 0.0095322
R2125 VSS.n107 VSS.n79 0.00938635
R2126 VSS.n107 VSS.n77 0.00938635
R2127 VSS.n107 VSS.n75 0.00938635
R2128 VSS.n107 VSS.n65 0.00938635
R2129 VSS.n107 VSS.n61 0.00938635
R2130 VSS.n107 VSS.n51 0.00938635
R2131 VSS.n107 VSS.n18 0.00937856
R2132 VSS.n107 VSS.n78 0.00937856
R2133 VSS.n107 VSS.n24 0.00937856
R2134 VSS.n107 VSS.n66 0.00937856
R2135 VSS.n107 VSS.n29 0.00937856
R2136 VSS.n107 VSS.n35 0.00937856
R2137 VSS.n107 VSS.n37 0.00937856
R2138 VSS.n107 VSS.n43 0.00937856
R2139 VSS.n107 VSS.n48 0.00937856
R2140 VSS.n107 VSS.n45 0.00937856
R2141 VSS.n107 VSS.n23 0.00937856
R2142 VSS.n107 VSS.n56 0.00937856
R2143 VSS.n550 VSS.n363 0.008
R2144 VSS.n842 VSS.n841 0.00675
R2145 VSS.n841 VSS.n233 0.00675
R2146 VSS.n3 VSS.t276 58.3221
R2147 VSS.n371 VSS.n81 8.47947
R2148 VSS.n3 VSS.t354 117.528
R2149 VSS.n3 VSS.t324 117.528
R2150 VSS.n3 VSS.n1 1.45356
R2151 a_3747_311.n0 a_3747_311.t2 52.0388
R2152 a_3747_311.t1 a_3747_311.n0 35.4491
R2153 a_3747_311.n0 a_3747_311.t3 33.5891
R2154 a_3747_311.t0 a_3747_311.t1 5.61942
R2155 a_3171_311.n0 a_3171_311.t2 51.8377
R2156 a_3171_311.n0 a_3171_311.t3 33.3881
R2157 a_3171_311.t1 a_3171_311.n0 31.8923
R2158 a_3171_311.t0 a_3171_311.t1 5.61777
R2159 a_2595_311.n0 a_2595_311.t2 51.6367
R2160 a_2595_311.n0 a_2595_311.t3 33.187
R2161 a_2595_311.t1 a_2595_311.n0 27.993
R2162 a_2595_311.t0 a_2595_311.t1 5.73018
R2163 a_3747_1047.n0 a_3747_1047.t2 38.0081
R2164 a_3747_1047.n0 a_3747_1047.t3 33.3957
R2165 a_3747_1047.n1 a_3747_1047.t4 33.3957
R2166 a_3747_1047.n2 a_3747_1047.t5 33.3957
R2167 a_3747_1047.n3 a_3747_1047.t6 33.3957
R2168 a_3747_1047.n4 a_3747_1047.t7 33.3957
R2169 a_3747_1047.n5 a_3747_1047.t8 33.3957
R2170 a_3747_1047.n6 a_3747_1047.t9 33.3957
R2171 a_3747_1047.t1 a_3747_1047.n6 23.2419
R2172 a_3747_1047.t0 a_3747_1047.t1 5.61942
R2173 a_3747_1047.n6 a_3747_1047.n5 4.61291
R2174 a_3747_1047.n5 a_3747_1047.n4 4.61291
R2175 a_3747_1047.n4 a_3747_1047.n3 4.61291
R2176 a_3747_1047.n3 a_3747_1047.n2 4.61291
R2177 a_3747_1047.n2 a_3747_1047.n1 4.61291
R2178 a_3747_1047.n1 a_3747_1047.n0 4.61291
R2179 a_3171_1047.n0 a_3171_1047.t2 37.8054
R2180 a_3171_1047.n0 a_3171_1047.t3 33.193
R2181 a_3171_1047.n1 a_3171_1047.t4 33.193
R2182 a_3171_1047.n2 a_3171_1047.t5 33.193
R2183 a_3171_1047.n3 a_3171_1047.t6 33.193
R2184 a_3171_1047.n4 a_3171_1047.t7 33.193
R2185 a_3171_1047.n5 a_3171_1047.t8 33.193
R2186 a_3171_1047.n6 a_3171_1047.t9 33.193
R2187 a_3171_1047.t1 a_3171_1047.n6 23.0313
R2188 a_3171_1047.t0 a_3171_1047.t1 5.61777
R2189 a_3171_1047.n6 a_3171_1047.n5 4.61291
R2190 a_3171_1047.n5 a_3171_1047.n4 4.61291
R2191 a_3171_1047.n4 a_3171_1047.n3 4.61291
R2192 a_3171_1047.n3 a_3171_1047.n2 4.61291
R2193 a_3171_1047.n2 a_3171_1047.n1 4.61291
R2194 a_3171_1047.n1 a_3171_1047.n0 4.61291
R2195 a_2595_1047.n0 a_2595_1047.t2 37.7691
R2196 a_2595_1047.n0 a_2595_1047.t3 33.1567
R2197 a_2595_1047.n1 a_2595_1047.t4 33.1567
R2198 a_2595_1047.n2 a_2595_1047.t5 33.1567
R2199 a_2595_1047.n3 a_2595_1047.t6 33.1567
R2200 a_2595_1047.n4 a_2595_1047.t7 33.1567
R2201 a_2595_1047.n5 a_2595_1047.t8 33.1567
R2202 a_2595_1047.n6 a_2595_1047.t9 33.1567
R2203 a_2595_1047.t1 a_2595_1047.n6 22.7941
R2204 a_2595_1047.t0 a_2595_1047.t1 5.65522
R2205 a_2595_1047.n6 a_2595_1047.n5 4.61291
R2206 a_2595_1047.n5 a_2595_1047.n4 4.61291
R2207 a_2595_1047.n4 a_2595_1047.n3 4.61291
R2208 a_2595_1047.n3 a_2595_1047.n2 4.61291
R2209 a_2595_1047.n2 a_2595_1047.n1 4.61291
R2210 a_2595_1047.n1 a_2595_1047.n0 4.61291
R2211 a_2019_1047.n0 a_2019_1047.t2 37.9701
R2212 a_2019_1047.n0 a_2019_1047.t3 33.3577
R2213 a_2019_1047.n1 a_2019_1047.t4 33.3577
R2214 a_2019_1047.n2 a_2019_1047.t5 33.3577
R2215 a_2019_1047.n3 a_2019_1047.t6 33.3577
R2216 a_2019_1047.n4 a_2019_1047.t7 33.3577
R2217 a_2019_1047.n5 a_2019_1047.t8 33.3577
R2218 a_2019_1047.t1 a_2019_1047.t9 22.5945
R2219 a_2019_1047.t0 a_2019_1047.t1 5.62052
R2220 a_2019_1047.t9 a_2019_1047.n5 4.61291
R2221 a_2019_1047.n5 a_2019_1047.n4 4.61291
R2222 a_2019_1047.n4 a_2019_1047.n3 4.61291
R2223 a_2019_1047.n3 a_2019_1047.n2 4.61291
R2224 a_2019_1047.n2 a_2019_1047.n1 4.61291
R2225 a_2019_1047.n1 a_2019_1047.n0 4.61291
C1105 MUX_OUT VSS 3.24058f
C1106 MUX_SEL4 VSS 1.60778f
C1107 MUX_SEL3 VSS 0.90686f
C1108 MUX_SEL2 VSS 1.81137f
C1109 MUX_SEL1 VSS 0.95076f
C1110 MUX_SEL0 VSS 1.55166f
C1111 DELAY_VBIASN VSS 12.41106f
C1112 DELAY_OUT_LAST VSS 0.39284f
C1113 DELAY_VBIASP VSS 4.13999f
C1114 DELAY_IN VSS 1.91954f
C1115 VDD VSS 46.2831f
C1116 a_26985_519# VSS 0.17928f ; **FLOATING
C1117 a_23945_519# VSS 0.17928f ; **FLOATING
C1118 a_20905_519# VSS 0.17928f ; **FLOATING
C1119 a_17865_519# VSS 0.17593f ; **FLOATING
C1120 a_16851_309# VSS 0.38699f ; **FLOATING
C1121 a_16108_289# VSS 3.85084f ; **FLOATING
C1122 a_15964_289# VSS 0.17613f ; **FLOATING
C1123 a_15765_463# VSS 0.36132f ; **FLOATING
C1124 a_14825_519# VSS 0.17928f ; **FLOATING
C1125 a_11785_519# VSS 0.17928f ; **FLOATING
C1126 a_8745_519# VSS 0.17928f ; **FLOATING
C1127 a_5731_289# VSS 3.39133f ; **FLOATING
C1128 a_2019_311# VSS 1.61601f ; **FLOATING
C1129 a_5705_519# VSS 0.17638f ; **FLOATING
C1130 a_3449_331# VSS 0.18478f ; **FLOATING
C1131 a_2873_331# VSS 0.18321f ; **FLOATING
C1132 a_2297_331# VSS 0.18321f ; **FLOATING
C1133 a_1721_331# VSS 0.17001f ; **FLOATING
C1134 a_1544_289# VSS 0.30014f ; **FLOATING
C1135 a_1256_289# VSS 0.84266f ; **FLOATING
C1136 a_27991_1008# VSS 0.18706f ; **FLOATING
C1137 a_27915_1044# VSS 0.10926f ; **FLOATING
C1138 a_27124_1008# VSS 0.17878f ; **FLOATING
C1139 a_27048_1044# VSS 0.12122f ; **FLOATING
C1140 a_26471_1008# VSS 0.18175f ; **FLOATING
C1141 a_26395_1044# VSS 0.11073f ; **FLOATING
C1142 a_25604_1008# VSS 0.18087f ; **FLOATING
C1143 a_25630_1044# VSS 0.34158f ; **FLOATING
C1144 a_25528_1044# VSS 0.12433f ; **FLOATING
C1145 a_24951_1008# VSS 0.18335f ; **FLOATING
C1146 a_24875_1044# VSS 0.11016f ; **FLOATING
C1147 a_24084_1008# VSS 0.17878f ; **FLOATING
C1148 a_24008_1044# VSS 0.12122f ; **FLOATING
C1149 a_23431_1008# VSS 0.18175f ; **FLOATING
C1150 a_23355_1044# VSS 0.11073f ; **FLOATING
C1151 a_22564_1008# VSS 0.18087f ; **FLOATING
C1152 a_22590_1044# VSS 0.33314f ; **FLOATING
C1153 a_22488_1044# VSS 0.12433f ; **FLOATING
C1154 a_21911_1008# VSS 0.18335f ; **FLOATING
C1155 a_21835_1044# VSS 0.11016f ; **FLOATING
C1156 a_21044_1008# VSS 0.17878f ; **FLOATING
C1157 a_20968_1044# VSS 0.12122f ; **FLOATING
C1158 a_20391_1008# VSS 0.18175f ; **FLOATING
C1159 a_20315_1044# VSS 0.11073f ; **FLOATING
C1160 a_19524_1008# VSS 0.18087f ; **FLOATING
C1161 a_19550_1044# VSS 0.33563f ; **FLOATING
C1162 a_19448_1044# VSS 0.12433f ; **FLOATING
C1163 a_18871_1008# VSS 0.18335f ; **FLOATING
C1164 a_18795_1044# VSS 0.11016f ; **FLOATING
C1165 a_18004_1008# VSS 0.17878f ; **FLOATING
C1166 a_17928_1044# VSS 0.12122f ; **FLOATING
C1167 a_17351_1008# VSS 0.18022f ; **FLOATING
C1168 a_17275_1044# VSS 0.10926f ; **FLOATING
C1169 a_16484_1008# VSS 0.18023f ; **FLOATING
C1170 a_16510_1044# VSS 0.28935f ; **FLOATING
C1171 a_16408_1044# VSS 0.1229f ; **FLOATING
C1172 a_15831_1008# VSS 0.17846f ; **FLOATING
C1173 a_15755_1044# VSS 0.10926f ; **FLOATING
C1174 a_14964_1008# VSS 0.17878f ; **FLOATING
C1175 a_14888_1044# VSS 0.12122f ; **FLOATING
C1176 a_14311_1008# VSS 0.18175f ; **FLOATING
C1177 a_14235_1044# VSS 0.11073f ; **FLOATING
C1178 a_13444_1008# VSS 0.18087f ; **FLOATING
C1179 a_13470_1044# VSS 0.30333f ; **FLOATING
C1180 a_13368_1044# VSS 0.12433f ; **FLOATING
C1181 a_12791_1008# VSS 0.18335f ; **FLOATING
C1182 a_12715_1044# VSS 0.11016f ; **FLOATING
C1183 a_11924_1008# VSS 0.17878f ; **FLOATING
C1184 a_11848_1044# VSS 0.12122f ; **FLOATING
C1185 a_11271_1008# VSS 0.18175f ; **FLOATING
C1186 a_11195_1044# VSS 0.11073f ; **FLOATING
C1187 a_10404_1008# VSS 0.18087f ; **FLOATING
C1188 a_10430_1044# VSS 0.31665f ; **FLOATING
C1189 a_10328_1044# VSS 0.12433f ; **FLOATING
C1190 a_9751_1008# VSS 0.18335f ; **FLOATING
C1191 a_9675_1044# VSS 0.11016f ; **FLOATING
C1192 a_8884_1008# VSS 0.17878f ; **FLOATING
C1193 a_8808_1044# VSS 0.12122f ; **FLOATING
C1194 a_8231_1008# VSS 0.18175f ; **FLOATING
C1195 a_8155_1044# VSS 0.11073f ; **FLOATING
C1196 a_7364_1008# VSS 0.18087f ; **FLOATING
C1197 a_7390_1044# VSS 0.31357f ; **FLOATING
C1198 a_7288_1044# VSS 0.12433f ; **FLOATING
C1199 a_6711_1008# VSS 0.18335f ; **FLOATING
C1200 a_6635_1044# VSS 0.11016f ; **FLOATING
C1201 a_5844_1008# VSS 0.17878f ; **FLOATING
C1202 a_5768_1044# VSS 0.12122f ; **FLOATING
C1203 a_5191_1008# VSS 0.18022f ; **FLOATING
C1204 a_5115_1044# VSS 0.10926f ; **FLOATING
C1205 a_4324_1008# VSS 0.18023f ; **FLOATING
C1206 a_4350_1044# VSS 0.26655f ; **FLOATING
C1207 a_4248_1044# VSS 0.12443f ; **FLOATING
C1208 a_27705_1044# VSS 0.25296f ; **FLOATING
C1209 a_26185_1044# VSS 0.23475f ; **FLOATING
C1210 a_24665_1044# VSS 0.25432f ; **FLOATING
C1211 a_23145_1044# VSS 0.23475f ; **FLOATING
C1212 a_21625_1044# VSS 0.25432f ; **FLOATING
C1213 a_20105_1044# VSS 0.23475f ; **FLOATING
C1214 a_18585_1044# VSS 0.25432f ; **FLOATING
C1215 a_17065_1044# VSS 0.23385f ; **FLOATING
C1216 a_15545_1044# VSS 0.25296f ; **FLOATING
C1217 a_14025_1044# VSS 0.23475f ; **FLOATING
C1218 a_12505_1044# VSS 0.25432f ; **FLOATING
C1219 a_10985_1044# VSS 0.23475f ; **FLOATING
C1220 a_9465_1044# VSS 0.25432f ; **FLOATING
C1221 a_7945_1044# VSS 0.23475f ; **FLOATING
C1222 a_6425_1044# VSS 0.25432f ; **FLOATING
C1223 a_4905_1044# VSS 0.23549f ; **FLOATING
C1224 a_4157_1313# VSS 0.32875f ; **FLOATING
C1225 a_3449_1395# VSS 0.18629f ; **FLOATING
C1226 a_2873_1395# VSS 0.18349f ; **FLOATING
C1227 a_2297_1395# VSS 0.18349f ; **FLOATING
C1228 a_1721_1395# VSS 0.17029f ; **FLOATING
C1229 a_1544_1044# VSS 0.29829f ; **FLOATING
C1230 a_1256_1044# VSS 0.82978f ; **FLOATING
C1231 a_27671_1842# VSS 0.01336f ; **FLOATING
C1232 a_26911_1842# VSS 0.01336f ; **FLOATING
C1233 a_26151_1842# VSS 0.01336f ; **FLOATING
C1234 a_25391_1842# VSS 0.01336f ; **FLOATING
C1235 a_24631_1842# VSS 0.01336f ; **FLOATING
C1236 a_23871_1842# VSS 0.01336f ; **FLOATING
C1237 a_23111_1842# VSS 0.01336f ; **FLOATING
C1238 a_22351_1842# VSS 0.01336f ; **FLOATING
C1239 a_21591_1842# VSS 0.01336f ; **FLOATING
C1240 a_20831_1842# VSS 0.01336f ; **FLOATING
C1241 a_20071_1842# VSS 0.01336f ; **FLOATING
C1242 a_19311_1842# VSS 0.01336f ; **FLOATING
C1243 a_18551_1842# VSS 0.01336f ; **FLOATING
C1244 a_17791_1842# VSS 0.01336f ; **FLOATING
C1245 a_17031_1842# VSS 0.01336f ; **FLOATING
C1246 a_16271_1842# VSS 0.01336f ; **FLOATING
C1247 a_15511_1842# VSS 0.01336f ; **FLOATING
C1248 a_14751_1842# VSS 0.01336f ; **FLOATING
C1249 a_13991_1842# VSS 0.01336f ; **FLOATING
C1250 a_13231_1842# VSS 0.01336f ; **FLOATING
C1251 a_12471_1842# VSS 0.01336f ; **FLOATING
C1252 a_11711_1842# VSS 0.01336f ; **FLOATING
C1253 a_10951_1842# VSS 0.01336f ; **FLOATING
C1254 a_10191_1842# VSS 0.01336f ; **FLOATING
C1255 a_9431_1842# VSS 0.01336f ; **FLOATING
C1256 a_8671_1842# VSS 0.01336f ; **FLOATING
C1257 a_7911_1842# VSS 0.01336f ; **FLOATING
C1258 a_7151_1842# VSS 0.01336f ; **FLOATING
C1259 a_6391_1842# VSS 0.01336f ; **FLOATING
C1260 a_5631_1842# VSS 0.01336f ; **FLOATING
C1261 a_4871_1842# VSS 0.01336f ; **FLOATING
C1262 a_4111_1842# VSS 0.0139f ; **FLOATING
C1263 a_27563_1842# VSS 0.51284f ; **FLOATING
C1264 a_27997_1842# VSS 0.6533f ; **FLOATING
C1265 a_27433_1842# VSS 0.45843f ; **FLOATING
C1266 a_26803_1842# VSS 0.50902f ; **FLOATING
C1267 a_27237_1842# VSS 0.93747f ; **FLOATING
C1268 a_26673_1842# VSS 0.45994f ; **FLOATING
C1269 a_26043_1842# VSS 0.51137f ; **FLOATING
C1270 a_26477_1842# VSS 0.96549f ; **FLOATING
C1271 a_25913_1842# VSS 0.46292f ; **FLOATING
C1272 a_25283_1842# VSS 0.50906f ; **FLOATING
C1273 a_25717_1842# VSS 0.87619f ; **FLOATING
C1274 a_25153_1842# VSS 0.45997f ; **FLOATING
C1275 a_24523_1842# VSS 0.51043f ; **FLOATING
C1276 a_24957_1842# VSS 0.97121f ; **FLOATING
C1277 a_24393_1842# VSS 0.45843f ; **FLOATING
C1278 a_23763_1842# VSS 0.50902f ; **FLOATING
C1279 a_24197_1842# VSS 0.93322f ; **FLOATING
C1280 a_23633_1842# VSS 0.45994f ; **FLOATING
C1281 a_23003_1842# VSS 0.51137f ; **FLOATING
C1282 a_23437_1842# VSS 0.96549f ; **FLOATING
C1283 a_22873_1842# VSS 0.46292f ; **FLOATING
C1284 a_22243_1842# VSS 0.50906f ; **FLOATING
C1285 a_22677_1842# VSS 0.87619f ; **FLOATING
C1286 a_22113_1842# VSS 0.45997f ; **FLOATING
C1287 a_21483_1842# VSS 0.51043f ; **FLOATING
C1288 a_21917_1842# VSS 0.97121f ; **FLOATING
C1289 a_21353_1842# VSS 0.45843f ; **FLOATING
C1290 a_20723_1842# VSS 0.50902f ; **FLOATING
C1291 a_21157_1842# VSS 0.93322f ; **FLOATING
C1292 a_20593_1842# VSS 0.45994f ; **FLOATING
C1293 a_19963_1842# VSS 0.51137f ; **FLOATING
C1294 a_20397_1842# VSS 0.96549f ; **FLOATING
C1295 a_19833_1842# VSS 0.46292f ; **FLOATING
C1296 a_19203_1842# VSS 0.50906f ; **FLOATING
C1297 a_19637_1842# VSS 0.87619f ; **FLOATING
C1298 a_19073_1842# VSS 0.45997f ; **FLOATING
C1299 a_18443_1842# VSS 0.51043f ; **FLOATING
C1300 a_18877_1842# VSS 0.97121f ; **FLOATING
C1301 a_18313_1842# VSS 0.45843f ; **FLOATING
C1302 a_17683_1842# VSS 0.50902f ; **FLOATING
C1303 a_18117_1842# VSS 0.93322f ; **FLOATING
C1304 a_17553_1842# VSS 0.45994f ; **FLOATING
C1305 a_16923_1842# VSS 0.51133f ; **FLOATING
C1306 a_17357_1842# VSS 0.96549f ; **FLOATING
C1307 a_16793_1842# VSS 0.46262f ; **FLOATING
C1308 a_16163_1842# VSS 0.50902f ; **FLOATING
C1309 a_16597_1842# VSS 0.87137f ; **FLOATING
C1310 a_16033_1842# VSS 0.45859f ; **FLOATING
C1311 a_15403_1842# VSS 0.51041f ; **FLOATING
C1312 a_15837_1842# VSS 0.9618f ; **FLOATING
C1313 a_15273_1842# VSS 0.45843f ; **FLOATING
C1314 a_14643_1842# VSS 0.50902f ; **FLOATING
C1315 a_15077_1842# VSS 0.93209f ; **FLOATING
C1316 a_14513_1842# VSS 0.45994f ; **FLOATING
C1317 a_13883_1842# VSS 0.51137f ; **FLOATING
C1318 a_14317_1842# VSS 0.96549f ; **FLOATING
C1319 a_13753_1842# VSS 0.46292f ; **FLOATING
C1320 a_13123_1842# VSS 0.50904f ; **FLOATING
C1321 a_13557_1842# VSS 0.87619f ; **FLOATING
C1322 a_12993_1842# VSS 0.45997f ; **FLOATING
C1323 a_12363_1842# VSS 0.51043f ; **FLOATING
C1324 a_12797_1842# VSS 0.96954f ; **FLOATING
C1325 a_12233_1842# VSS 0.45843f ; **FLOATING
C1326 a_11603_1842# VSS 0.50902f ; **FLOATING
C1327 a_12037_1842# VSS 0.93322f ; **FLOATING
C1328 a_11473_1842# VSS 0.45994f ; **FLOATING
C1329 a_10843_1842# VSS 0.51137f ; **FLOATING
C1330 a_11277_1842# VSS 0.96549f ; **FLOATING
C1331 a_10713_1842# VSS 0.46292f ; **FLOATING
C1332 a_10083_1842# VSS 0.50904f ; **FLOATING
C1333 a_10517_1842# VSS 0.87619f ; **FLOATING
C1334 a_9953_1842# VSS 0.45997f ; **FLOATING
C1335 a_9323_1842# VSS 0.51043f ; **FLOATING
C1336 a_9757_1842# VSS 0.96954f ; **FLOATING
C1337 a_9193_1842# VSS 0.45843f ; **FLOATING
C1338 a_8563_1842# VSS 0.50902f ; **FLOATING
C1339 a_8997_1842# VSS 0.93322f ; **FLOATING
C1340 a_8433_1842# VSS 0.45994f ; **FLOATING
C1341 a_7803_1842# VSS 0.51137f ; **FLOATING
C1342 a_8237_1842# VSS 0.96549f ; **FLOATING
C1343 a_7673_1842# VSS 0.46292f ; **FLOATING
C1344 a_7043_1842# VSS 0.50904f ; **FLOATING
C1345 a_7477_1842# VSS 0.87619f ; **FLOATING
C1346 a_6913_1842# VSS 0.45997f ; **FLOATING
C1347 a_6283_1842# VSS 0.51043f ; **FLOATING
C1348 a_6717_1842# VSS 0.96895f ; **FLOATING
C1349 a_6153_1842# VSS 0.45843f ; **FLOATING
C1350 a_5523_1842# VSS 0.50902f ; **FLOATING
C1351 a_5957_1842# VSS 0.93322f ; **FLOATING
C1352 a_5393_1842# VSS 0.45994f ; **FLOATING
C1353 a_4763_1842# VSS 0.51133f ; **FLOATING
C1354 a_5197_1842# VSS 0.96549f ; **FLOATING
C1355 a_4633_1842# VSS 0.4629f ; **FLOATING
C1356 a_4003_1842# VSS 0.58899f ; **FLOATING
C1357 a_4437_1842# VSS 0.87666f ; **FLOATING
C1358 a_2019_1047.t2 VSS 0.93017f ; **FLOATING
C1359 a_2019_1047.t3 VSS 0.70616f ; **FLOATING
C1360 a_2019_1047.n0 VSS 5.0083f ; **FLOATING
C1361 a_2019_1047.t4 VSS 0.70616f ; **FLOATING
C1362 a_2019_1047.n1 VSS 3.38825f ; **FLOATING
C1363 a_2019_1047.t5 VSS 0.70616f ; **FLOATING
C1364 a_2019_1047.n2 VSS 3.38825f ; **FLOATING
C1365 a_2019_1047.t6 VSS 0.70616f ; **FLOATING
C1366 a_2019_1047.n3 VSS 3.38825f ; **FLOATING
C1367 a_2019_1047.t7 VSS 0.70616f ; **FLOATING
C1368 a_2019_1047.n4 VSS 3.38825f ; **FLOATING
C1369 a_2019_1047.t8 VSS 0.70616f ; **FLOATING
C1370 a_2019_1047.n5 VSS 3.38825f ; **FLOATING
C1371 a_2019_1047.t9 VSS 5.45426f ; **FLOATING
C1372 a_2019_1047.t1 VSS 1.07246f ; **FLOATING
C1373 a_2019_1047.t0 VSS 0.30482f ; **FLOATING
C1374 a_2595_1047.t2 VSS 1.36702f ; **FLOATING
C1375 a_2595_1047.t3 VSS 1.02093f ; **FLOATING
C1376 a_2595_1047.n0 VSS 7.7612f ; **FLOATING
C1377 a_2595_1047.t4 VSS 1.02093f ; **FLOATING
C1378 a_2595_1047.n1 VSS 5.27337f ; **FLOATING
C1379 a_2595_1047.t5 VSS 1.02093f ; **FLOATING
C1380 a_2595_1047.n2 VSS 5.27337f ; **FLOATING
C1381 a_2595_1047.t6 VSS 1.02093f ; **FLOATING
C1382 a_2595_1047.n3 VSS 5.27337f ; **FLOATING
C1383 a_2595_1047.t7 VSS 1.02093f ; **FLOATING
C1384 a_2595_1047.n4 VSS 5.27337f ; **FLOATING
C1385 a_2595_1047.t8 VSS 1.02093f ; **FLOATING
C1386 a_2595_1047.n5 VSS 5.27337f ; **FLOATING
C1387 a_2595_1047.t9 VSS 1.02093f ; **FLOATING
C1388 a_2595_1047.n6 VSS 7.58543f ; **FLOATING
C1389 a_2595_1047.t1 VSS 1.75118f ; **FLOATING
C1390 a_2595_1047.t0 VSS 0.48227f ; **FLOATING
C1391 a_3171_1047.t2 VSS 1.38442f ; **FLOATING
C1392 a_3171_1047.t3 VSS 1.03733f ; **FLOATING
C1393 a_3171_1047.n0 VSS 7.77854f ; **FLOATING
C1394 a_3171_1047.t4 VSS 1.03733f ; **FLOATING
C1395 a_3171_1047.n1 VSS 5.28082f ; **FLOATING
C1396 a_3171_1047.t5 VSS 1.03733f ; **FLOATING
C1397 a_3171_1047.n2 VSS 5.28082f ; **FLOATING
C1398 a_3171_1047.t6 VSS 1.03733f ; **FLOATING
C1399 a_3171_1047.n3 VSS 5.28082f ; **FLOATING
C1400 a_3171_1047.t7 VSS 1.03733f ; **FLOATING
C1401 a_3171_1047.n4 VSS 5.28082f ; **FLOATING
C1402 a_3171_1047.t8 VSS 1.03733f ; **FLOATING
C1403 a_3171_1047.n5 VSS 5.28082f ; **FLOATING
C1404 a_3171_1047.t9 VSS 1.03733f ; **FLOATING
C1405 a_3171_1047.n6 VSS 7.68345f ; **FLOATING
C1406 a_3171_1047.t1 VSS 1.77026f ; **FLOATING
C1407 a_3171_1047.t0 VSS 0.48084f ; **FLOATING
C1408 a_3747_1047.t2 VSS 0.96886f ; **FLOATING
C1409 a_3747_1047.t3 VSS 0.73761f ; **FLOATING
C1410 a_3747_1047.n0 VSS 5.16753f ; **FLOATING
C1411 a_3747_1047.t4 VSS 0.73761f ; **FLOATING
C1412 a_3747_1047.n1 VSS 3.49318f ; **FLOATING
C1413 a_3747_1047.t5 VSS 0.73761f ; **FLOATING
C1414 a_3747_1047.n2 VSS 3.49318f ; **FLOATING
C1415 a_3747_1047.t6 VSS 0.73761f ; **FLOATING
C1416 a_3747_1047.n3 VSS 3.49318f ; **FLOATING
C1417 a_3747_1047.t7 VSS 0.73761f ; **FLOATING
C1418 a_3747_1047.n4 VSS 3.49318f ; **FLOATING
C1419 a_3747_1047.t8 VSS 0.73761f ; **FLOATING
C1420 a_3747_1047.n5 VSS 3.49318f ; **FLOATING
C1421 a_3747_1047.t9 VSS 0.73761f ; **FLOATING
C1422 a_3747_1047.n6 VSS 5.18697f ; **FLOATING
C1423 a_3747_1047.t1 VSS 1.18537f ; **FLOATING
C1424 a_3747_1047.t0 VSS 0.31338f ; **FLOATING
C1425 a_2595_311.t1 VSS 3.27037f ; **FLOATING
C1426 a_2595_311.t2 VSS 5.04145f ; **FLOATING
C1427 a_2595_311.t3 VSS 1.20632f ; **FLOATING
C1428 a_2595_311.n0 VSS 26.8668f ; **FLOATING
C1429 a_2595_311.t0 VSS 0.49572f ; **FLOATING
C1430 a_3171_311.t2 VSS 5.05009f ; **FLOATING
C1431 a_3171_311.t3 VSS 1.21149f ; **FLOATING
C1432 a_3171_311.n0 VSS 29.8499f ; **FLOATING
C1433 a_3171_311.t1 VSS 4.61154f ; **FLOATING
C1434 a_3171_311.t0 VSS 0.4973f ; **FLOATING
C1435 a_3747_311.t2 VSS 3.09203f ; **FLOATING
C1436 a_3747_311.t3 VSS 0.74422f ; **FLOATING
C1437 a_3747_311.n0 VSS 19.8885f ; **FLOATING
C1438 a_3747_311.t1 VSS 3.68893f ; **FLOATING
C1439 a_3747_311.t0 VSS 0.30537f ; **FLOATING
C1440 DELAY_VBIASP.n0 VSS 0.14465f ; **FLOATING
C1441 DELAY_VBIASP.t31 VSS 0.37042f ; **FLOATING
C1442 DELAY_VBIASP.t30 VSS 0.36213f ; **FLOATING
C1443 DELAY_VBIASP.n1 VSS 0.64895f ; **FLOATING
C1444 DELAY_VBIASP.t29 VSS 0.36213f ; **FLOATING
C1445 DELAY_VBIASP.n2 VSS 0.44908f ; **FLOATING
C1446 DELAY_VBIASP.t28 VSS 0.36213f ; **FLOATING
C1447 DELAY_VBIASP.n3 VSS 0.44908f ; **FLOATING
C1448 DELAY_VBIASP.t27 VSS 0.36213f ; **FLOATING
C1449 DELAY_VBIASP.n4 VSS 0.44908f ; **FLOATING
C1450 DELAY_VBIASP.t26 VSS 0.36213f ; **FLOATING
C1451 DELAY_VBIASP.n5 VSS 0.44908f ; **FLOATING
C1452 DELAY_VBIASP.t25 VSS 0.36213f ; **FLOATING
C1453 DELAY_VBIASP.n6 VSS 0.44908f ; **FLOATING
C1454 DELAY_VBIASP.t24 VSS 0.36213f ; **FLOATING
C1455 DELAY_VBIASP.n7 VSS 0.44908f ; **FLOATING
C1456 DELAY_VBIASP.t23 VSS 0.36213f ; **FLOATING
C1457 DELAY_VBIASP.n8 VSS 0.44908f ; **FLOATING
C1458 DELAY_VBIASP.t22 VSS 0.36213f ; **FLOATING
C1459 DELAY_VBIASP.n9 VSS 0.44908f ; **FLOATING
C1460 DELAY_VBIASP.t21 VSS 0.36213f ; **FLOATING
C1461 DELAY_VBIASP.n10 VSS 0.44908f ; **FLOATING
C1462 DELAY_VBIASP.t20 VSS 0.36213f ; **FLOATING
C1463 DELAY_VBIASP.n11 VSS 0.44908f ; **FLOATING
C1464 DELAY_VBIASP.t19 VSS 0.36213f ; **FLOATING
C1465 DELAY_VBIASP.n12 VSS 0.44908f ; **FLOATING
C1466 DELAY_VBIASP.t18 VSS 0.36213f ; **FLOATING
C1467 DELAY_VBIASP.n13 VSS 0.44908f ; **FLOATING
C1468 DELAY_VBIASP.t17 VSS 0.36213f ; **FLOATING
C1469 DELAY_VBIASP.n14 VSS 0.44908f ; **FLOATING
C1470 DELAY_VBIASP.t16 VSS 0.36213f ; **FLOATING
C1471 DELAY_VBIASP.n15 VSS 0.44908f ; **FLOATING
C1472 DELAY_VBIASP.t15 VSS 0.36213f ; **FLOATING
C1473 DELAY_VBIASP.n16 VSS 0.44908f ; **FLOATING
C1474 DELAY_VBIASP.t14 VSS 0.36213f ; **FLOATING
C1475 DELAY_VBIASP.n17 VSS 0.44908f ; **FLOATING
C1476 DELAY_VBIASP.t13 VSS 0.36213f ; **FLOATING
C1477 DELAY_VBIASP.n18 VSS 0.44908f ; **FLOATING
C1478 DELAY_VBIASP.t12 VSS 0.36213f ; **FLOATING
C1479 DELAY_VBIASP.n19 VSS 0.44908f ; **FLOATING
C1480 DELAY_VBIASP.t11 VSS 0.36213f ; **FLOATING
C1481 DELAY_VBIASP.n20 VSS 0.44908f ; **FLOATING
C1482 DELAY_VBIASP.t10 VSS 0.36213f ; **FLOATING
C1483 DELAY_VBIASP.n21 VSS 0.44908f ; **FLOATING
C1484 DELAY_VBIASP.t9 VSS 0.36213f ; **FLOATING
C1485 DELAY_VBIASP.n22 VSS 0.44908f ; **FLOATING
C1486 DELAY_VBIASP.t8 VSS 0.36213f ; **FLOATING
C1487 DELAY_VBIASP.n23 VSS 0.44908f ; **FLOATING
C1488 DELAY_VBIASP.t7 VSS 0.36213f ; **FLOATING
C1489 DELAY_VBIASP.n24 VSS 0.44908f ; **FLOATING
C1490 DELAY_VBIASP.t6 VSS 0.36213f ; **FLOATING
C1491 DELAY_VBIASP.n25 VSS 0.44908f ; **FLOATING
C1492 DELAY_VBIASP.t5 VSS 0.36213f ; **FLOATING
C1493 DELAY_VBIASP.n26 VSS 0.44908f ; **FLOATING
C1494 DELAY_VBIASP.t4 VSS 0.36213f ; **FLOATING
C1495 DELAY_VBIASP.n27 VSS 0.44908f ; **FLOATING
C1496 DELAY_VBIASP.t3 VSS 0.36213f ; **FLOATING
C1497 DELAY_VBIASP.n28 VSS 0.44908f ; **FLOATING
C1498 DELAY_VBIASP.t2 VSS 0.36213f ; **FLOATING
C1499 DELAY_VBIASP.n29 VSS 0.44908f ; **FLOATING
C1500 DELAY_VBIASP.t1 VSS 0.36213f ; **FLOATING
C1501 DELAY_VBIASP.n30 VSS 0.44908f ; **FLOATING
C1502 DELAY_VBIASP.t0 VSS 0.36213f ; **FLOATING
C1503 DELAY_VBIASN.n0 VSS 0.37703f ; **FLOATING
C1504 DELAY_VBIASN.t31 VSS 0.22492f ; **FLOATING
C1505 DELAY_VBIASN.t30 VSS 0.21832f ; **FLOATING
C1506 DELAY_VBIASN.n1 VSS 0.51667f ; **FLOATING
C1507 DELAY_VBIASN.t29 VSS 0.21832f ; **FLOATING
C1508 DELAY_VBIASN.n2 VSS 0.35838f ; **FLOATING
C1509 DELAY_VBIASN.t28 VSS 0.21832f ; **FLOATING
C1510 DELAY_VBIASN.n3 VSS 0.35838f ; **FLOATING
C1511 DELAY_VBIASN.t27 VSS 0.21832f ; **FLOATING
C1512 DELAY_VBIASN.n4 VSS 0.35838f ; **FLOATING
C1513 DELAY_VBIASN.t26 VSS 0.21832f ; **FLOATING
C1514 DELAY_VBIASN.n5 VSS 0.35838f ; **FLOATING
C1515 DELAY_VBIASN.t25 VSS 0.21832f ; **FLOATING
C1516 DELAY_VBIASN.n6 VSS 0.35838f ; **FLOATING
C1517 DELAY_VBIASN.t24 VSS 0.21832f ; **FLOATING
C1518 DELAY_VBIASN.n7 VSS 0.35838f ; **FLOATING
C1519 DELAY_VBIASN.t23 VSS 0.21832f ; **FLOATING
C1520 DELAY_VBIASN.n8 VSS 0.35838f ; **FLOATING
C1521 DELAY_VBIASN.t22 VSS 0.21832f ; **FLOATING
C1522 DELAY_VBIASN.n9 VSS 0.35838f ; **FLOATING
C1523 DELAY_VBIASN.t21 VSS 0.21832f ; **FLOATING
C1524 DELAY_VBIASN.n10 VSS 0.35838f ; **FLOATING
C1525 DELAY_VBIASN.t20 VSS 0.21832f ; **FLOATING
C1526 DELAY_VBIASN.n11 VSS 0.35838f ; **FLOATING
C1527 DELAY_VBIASN.t19 VSS 0.21832f ; **FLOATING
C1528 DELAY_VBIASN.n12 VSS 0.35838f ; **FLOATING
C1529 DELAY_VBIASN.t18 VSS 0.21832f ; **FLOATING
C1530 DELAY_VBIASN.n13 VSS 0.35838f ; **FLOATING
C1531 DELAY_VBIASN.t17 VSS 0.21832f ; **FLOATING
C1532 DELAY_VBIASN.n14 VSS 0.35838f ; **FLOATING
C1533 DELAY_VBIASN.t16 VSS 0.21832f ; **FLOATING
C1534 DELAY_VBIASN.n15 VSS 0.35838f ; **FLOATING
C1535 DELAY_VBIASN.t15 VSS 0.21832f ; **FLOATING
C1536 DELAY_VBIASN.n16 VSS 0.35838f ; **FLOATING
C1537 DELAY_VBIASN.t14 VSS 0.21832f ; **FLOATING
C1538 DELAY_VBIASN.n17 VSS 0.35838f ; **FLOATING
C1539 DELAY_VBIASN.t13 VSS 0.21832f ; **FLOATING
C1540 DELAY_VBIASN.n18 VSS 0.35838f ; **FLOATING
C1541 DELAY_VBIASN.t12 VSS 0.21832f ; **FLOATING
C1542 DELAY_VBIASN.n19 VSS 0.35838f ; **FLOATING
C1543 DELAY_VBIASN.t11 VSS 0.21832f ; **FLOATING
C1544 DELAY_VBIASN.n20 VSS 0.35838f ; **FLOATING
C1545 DELAY_VBIASN.t10 VSS 0.21832f ; **FLOATING
C1546 DELAY_VBIASN.n21 VSS 0.35838f ; **FLOATING
C1547 DELAY_VBIASN.t9 VSS 0.21832f ; **FLOATING
C1548 DELAY_VBIASN.n22 VSS 0.35838f ; **FLOATING
C1549 DELAY_VBIASN.t8 VSS 0.21832f ; **FLOATING
C1550 DELAY_VBIASN.n23 VSS 0.35838f ; **FLOATING
C1551 DELAY_VBIASN.t7 VSS 0.21832f ; **FLOATING
C1552 DELAY_VBIASN.n24 VSS 0.35838f ; **FLOATING
C1553 DELAY_VBIASN.t6 VSS 0.21832f ; **FLOATING
C1554 DELAY_VBIASN.n25 VSS 0.35838f ; **FLOATING
C1555 DELAY_VBIASN.t5 VSS 0.21832f ; **FLOATING
C1556 DELAY_VBIASN.n26 VSS 0.35838f ; **FLOATING
C1557 DELAY_VBIASN.t4 VSS 0.21832f ; **FLOATING
C1558 DELAY_VBIASN.n27 VSS 0.35838f ; **FLOATING
C1559 DELAY_VBIASN.t3 VSS 0.21832f ; **FLOATING
C1560 DELAY_VBIASN.n28 VSS 0.35838f ; **FLOATING
C1561 DELAY_VBIASN.t2 VSS 0.21832f ; **FLOATING
C1562 DELAY_VBIASN.n29 VSS 0.35838f ; **FLOATING
C1563 DELAY_VBIASN.t1 VSS 0.21832f ; **FLOATING
C1564 DELAY_VBIASN.n30 VSS 0.35838f ; **FLOATING
C1565 DELAY_VBIASN.t0 VSS 0.21832f ; **FLOATING
.ends
