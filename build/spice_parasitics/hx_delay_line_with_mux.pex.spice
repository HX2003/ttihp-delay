* NGSPICE file created from hx_delay_line_with_mux.ext - technology: ihp-sg13g2

.subckt hx_delay_line_with_mux VSS VDD DELAY_OUT_LAST DELAY_IN MUX_SEL0 MUX_SEL1 MUX_OUT
+ MUX_SEL4 MUX_SEL2 MUX_SEL3 DELAY_VBIASN DELAY_VBIASP
X0 VDD a_4003_1842# a_4437_1842# VDD sg13_lv_pmos ad=0.2128p pd=1.5u as=0.3808p ps=2.92u w=1.12u l=0.13u
X1 VSS.t112 a_15077_1842# a_15545_1044# VSS.t473 sg13_lv_nmos ad=0.1665p pd=1.19u as=0.2516p ps=2.16u w=0.74u l=0.13u
X2 a_27915_1044# a_27705_1044# VDD VDD sg13_lv_pmos ad=0.2128p pd=1.5u as=0.252p ps=1.57u w=1.12u l=0.13u
X3 VSS.t250 VDD VSS.t248 VSS.t249 sg13_lv_nmos ad=79.8f pd=0.8u as=0 ps=0 w=0.42u l=1u
X4 a_10951_2470# a_10713_1842# a_10843_1842# VDD sg13_lv_pmos ad=0.2128p pd=1.5u as=0.3808p ps=2.92u w=1.12u l=0.2u
X5 VSS.t232 a_3171_1047.t7 a_11924_1008# VSS.t231 sg13_lv_nmos ad=0.2516p pd=2.16u as=0.2516p ps=2.16u w=0.74u l=0.13u
X6 VDD VSS.t572 VDD VDD sg13_lv_pmos ad=0.34p pd=2.68u as=0.30484n ps=1.54979m w=1u l=1u
X7 VSS.t145 a_1256_1044# a_2967_1395# VSS.t234 sg13_lv_nmos ad=0.1331p pd=1.12u as=0.1216p ps=1.02u w=0.64u l=0.13u
X8 VSS.t253 VDD VSS.t252 VSS.t251 sg13_lv_nmos ad=0.1428p pd=1.52u as=0 ps=0 w=0.42u l=1u
X9 a_25153_1842# a_24957_1842# VSS.t223 VSS.t222 sg13_lv_nmos ad=0.2516p pd=2.16u as=0.1406p ps=1.12u w=0.74u l=0.13u
X10 VDD VSS.t586 VDD VDD sg13_lv_pmos ad=0.34p pd=2.68u as=0 ps=0 w=1u l=1u
X11 a_25630_1044# a_2019_1047.t2 a_25528_1044# VSS.t135 sg13_lv_nmos ad=0.2516p pd=2.16u as=0.1406p ps=1.12u w=0.74u l=0.13u
X12 VDD DELAY_VBIASP.t11 a_19311_2470# VDD sg13_lv_pmos ad=0.3808p pd=2.92u as=0.2128p ps=1.5u w=1.12u l=0.6u
X13 a_16108_289# a_2019_311# a_16510_1044# VSS.t177 sg13_lv_nmos ad=0.2516p pd=2.16u as=0.2516p ps=2.16u w=0.74u l=0.13u
X14 VDD DELAY_VBIASP.t24 a_9431_2470# VDD sg13_lv_pmos ad=0.3808p pd=2.92u as=0.2128p ps=1.5u w=1.12u l=0.6u
X15 VSS.t318 VDD VSS.t317 VSS.t316 sg13_lv_nmos ad=0.1428p pd=1.52u as=0 ps=0 w=0.42u l=1u
X16 VDD DELAY_VBIASP.t6 a_23111_2470# VDD sg13_lv_pmos ad=0.3808p pd=2.92u as=0.2128p ps=1.5u w=1.12u l=0.6u
X17 a_7390_1044# a_8231_1008# a_8155_1044# VDD sg13_lv_pmos ad=0.3808p pd=2.92u as=0.2128p ps=1.5u w=1.12u l=0.13u
X18 VSS.t74 a_2595_311.t3 a_8745_519# VSS.t73 sg13_lv_nmos ad=0.2516p pd=2.16u as=0.2516p ps=2.16u w=0.74u l=0.13u
X19 a_17791_1842# a_17553_1842# a_17683_1842# VSS.t542 sg13_lv_nmos ad=0.1406p pd=1.12u as=0.2516p ps=2.16u w=0.74u l=0.2u
X20 VDD a_12037_1842# a_12505_1044# VDD sg13_lv_pmos ad=0.252p pd=1.57u as=0.3808p ps=2.92u w=1.12u l=0.13u
X21 a_16510_1044# a_2019_1047.t5 a_16408_1044# VSS.t524 sg13_lv_nmos ad=0.2516p pd=2.16u as=0.1406p ps=1.12u w=0.74u l=0.13u
X22 a_21591_1842# a_21353_1842# a_21483_1842# VSS.t386 sg13_lv_nmos ad=0.1406p pd=1.12u as=0.2516p ps=2.16u w=0.74u l=0.2u
X23 a_6153_1842# a_5957_1842# VSS.t85 VSS.t480 sg13_lv_nmos ad=0.2516p pd=2.16u as=0.1406p ps=1.12u w=0.74u l=0.13u
X24 VSS.t9 a_16163_1842# a_16597_1842# VSS.t390 sg13_lv_nmos ad=0.1406p pd=1.12u as=0.2516p ps=2.16u w=0.74u l=0.13u
X25 VSS.t131 a_3171_1047.t2 a_27124_1008# VSS.t130 sg13_lv_nmos ad=0.2516p pd=2.16u as=0.2516p ps=2.16u w=0.74u l=0.13u
X26 VDD a_11603_1842# a_12037_1842# VDD sg13_lv_pmos ad=0.2128p pd=1.5u as=0.3808p ps=2.92u w=1.12u l=0.13u
X27 VDD a_3171_311.t3 a_11785_519# VDD sg13_lv_pmos ad=0.3808p pd=2.92u as=0.3808p ps=2.92u w=1.12u l=0.13u
X28 a_24393_1842# a_24197_1842# VDD VDD sg13_lv_pmos ad=0.3808p pd=2.92u as=0.2128p ps=1.5u w=1.12u l=0.13u
X29 a_5731_289# a_2595_311.t3 a_7390_1044# VSS.t72 sg13_lv_nmos ad=0.2516p pd=2.16u as=0.2516p ps=2.16u w=0.74u l=0.13u
X30 a_10430_1044# a_2595_1047.t7 a_11195_1044# VSS.t334 sg13_lv_nmos ad=0.2516p pd=2.16u as=0.1406p ps=1.12u w=0.74u l=0.13u
X31 a_23355_1044# a_23145_1044# VSS.t163 VSS.t539 sg13_lv_nmos ad=0.1406p pd=1.12u as=0.1665p ps=1.19u w=0.74u l=0.13u
X32 VDD DELAY_VBIASP.t17 a_14751_2470# VDD sg13_lv_pmos ad=0.3808p pd=2.92u as=0.2128p ps=1.5u w=1.12u l=0.6u
X33 VSS.t435 DELAY_VBIASN.t23 a_10191_1842# VSS.t434 sg13_lv_nmos ad=0.2516p pd=2.16u as=0.1406p ps=1.12u w=0.74u l=0.6u
X34 VSS.t529 a_3747_1047.t4 a_21911_1008# VSS.t528 sg13_lv_nmos ad=0.2516p pd=2.16u as=0.2516p ps=2.16u w=0.74u l=0.13u
X35 VSS.t377 a_19963_1842# a_20397_1842# VSS.t376 sg13_lv_nmos ad=0.1406p pd=1.12u as=0.2516p ps=2.16u w=0.74u l=0.13u
X36 VDD DELAY_VBIASP.t31 a_4111_2470# VDD sg13_lv_pmos ad=0.3808p pd=2.92u as=0.2128p ps=1.5u w=1.12u l=0.6u
X37 a_10328_1044# a_9757_1842# VDD VDD sg13_lv_pmos ad=0.2128p pd=1.5u as=0.3808p ps=2.92u w=1.12u l=0.13u
X38 a_20968_1044# a_20397_1842# VSS.t521 VSS.t520 sg13_lv_nmos ad=0.1406p pd=1.12u as=0.2516p ps=2.16u w=0.74u l=0.13u
X39 a_22590_1044# a_22564_1008# a_22488_1044# VDD sg13_lv_pmos ad=0.3808p pd=2.92u as=0.2128p ps=1.5u w=1.12u l=0.13u
X40 VDD VSS.t589 VDD VDD sg13_lv_pmos ad=0.19p pd=1.38u as=0 ps=0 w=1u l=1u
X41 a_8808_1044# a_8237_1842# VDD VDD sg13_lv_pmos ad=0.2128p pd=1.5u as=0.3808p ps=2.92u w=1.12u l=0.13u
X42 a_4157_1313# DELAY_IN VDD VDD sg13_lv_pmos ad=0.3808p pd=2.92u as=0.3808p ps=2.92u w=1.12u l=0.13u
X43 a_17031_2470# a_16793_1842# a_16923_1842# VDD sg13_lv_pmos ad=0.2128p pd=1.5u as=0.3808p ps=2.92u w=1.12u l=0.2u
X44 a_11473_1842# a_11277_1842# VSS.t46 VSS.t173 sg13_lv_nmos ad=0.2516p pd=2.16u as=0.1406p ps=1.12u w=0.74u l=0.13u
X45 VSS.t310 VDD VSS.t308 VSS.t309 sg13_lv_nmos ad=79.8f pd=0.8u as=0 ps=0 w=0.42u l=1u
X46 a_19448_1044# a_18877_1842# VSS.t512 VSS.t511 sg13_lv_nmos ad=0.1406p pd=1.12u as=0.2516p ps=2.16u w=0.74u l=0.13u
X47 a_10430_1044# a_3171_1047.t7 a_11848_1044# VSS.t230 sg13_lv_nmos ad=0.2516p pd=2.16u as=0.1406p ps=1.12u w=0.74u l=0.13u
X48 a_20831_2470# a_20593_1842# a_20723_1842# VDD sg13_lv_pmos ad=0.2128p pd=1.5u as=0.3808p ps=2.92u w=1.12u l=0.2u
X49 VSS.t275 VDD VSS.t273 VSS.t274 sg13_lv_nmos ad=79.8f pd=0.8u as=0 ps=0 w=0.42u l=1u
X50 VDD a_27237_1842# a_27705_1044# VDD sg13_lv_pmos ad=0.252p pd=1.57u as=0.3808p ps=2.92u w=1.12u l=0.13u
X51 a_5393_1842# a_5197_1842# VDD VDD sg13_lv_pmos ad=0.3808p pd=2.92u as=0.2128p ps=1.5u w=1.12u l=0.13u
X52 VDD DELAY_VBIASP.t14 a_17031_2470# VDD sg13_lv_pmos ad=0.3808p pd=2.92u as=0.2128p ps=1.5u w=1.12u l=0.6u
X53 VDD a_26803_1842# a_27237_1842# VDD sg13_lv_pmos ad=0.2128p pd=1.5u as=0.3808p ps=2.92u w=1.12u l=0.13u
X54 VDD MUX_SEL1 a_3449_1395# VDD sg13_lv_pmos ad=0.1918p pd=1.5u as=0.1596p ps=1.22u w=0.84u l=0.13u
X55 a_25630_1044# a_2595_1047.t2 a_26395_1044# VSS.t19 sg13_lv_nmos ad=0.2516p pd=2.16u as=0.1406p ps=1.12u w=0.74u l=0.13u
X56 VSS.t407 DELAY_VBIASN.t3 a_25391_1842# VSS.t406 sg13_lv_nmos ad=0.2516p pd=2.16u as=0.1406p ps=1.12u w=0.74u l=0.6u
X57 a_6635_1044# a_6425_1044# VDD VDD sg13_lv_pmos ad=0.2128p pd=1.5u as=0.252p ps=1.57u w=1.12u l=0.13u
X58 a_20315_1044# a_20105_1044# VDD VDD sg13_lv_pmos ad=0.2128p pd=1.5u as=0.252p ps=1.57u w=1.12u l=0.13u
X59 VDD a_2595_1047.t9 a_5191_1008# VDD sg13_lv_pmos ad=0.3808p pd=2.92u as=0.3808p ps=2.92u w=1.12u l=0.13u
X60 a_19311_2470# a_19073_1842# a_19203_1842# VDD sg13_lv_pmos ad=0.2128p pd=1.5u as=0.3808p ps=2.92u w=1.12u l=0.2u
X61 VSS.t143 a_1721_1395# a_2019_1047.t1 VSS.t142 sg13_lv_nmos ad=0.2812p pd=2.24u as=0.1406p ps=1.12u w=0.74u l=0.13u
X62 a_25528_1044# a_24957_1842# VDD VDD sg13_lv_pmos ad=0.2128p pd=1.5u as=0.3808p ps=2.92u w=1.12u l=0.13u
X63 VSS.t238 a_5957_1842# a_6425_1044# VSS.t479 sg13_lv_nmos ad=0.1665p pd=1.19u as=0.2516p ps=2.16u w=0.74u l=0.13u
X64 VSS.t30 a_2019_1047.t6 a_13444_1008# VSS.t29 sg13_lv_nmos ad=0.2516p pd=2.16u as=0.2516p ps=2.16u w=0.74u l=0.13u
X65 a_23111_2470# a_22873_1842# a_23003_1842# VDD sg13_lv_pmos ad=0.2128p pd=1.5u as=0.3808p ps=2.92u w=1.12u l=0.2u
X66 VSS.t248 VDD VSS.t247 VSS.t246 sg13_lv_nmos ad=0.1428p pd=1.52u as=0 ps=0 w=0.42u l=1u
X67 VSS.t92 a_15964_289# a_16851_309# VSS.t541 sg13_lv_nmos ad=0.1371p pd=1.12u as=0.2176p ps=1.96u w=0.64u l=0.13u
X68 a_10713_1842# a_10517_1842# VDD VDD sg13_lv_pmos ad=0.3808p pd=2.92u as=0.2128p ps=1.5u w=1.12u l=0.13u
X69 VDD a_17683_1842# a_18117_1842# VDD sg13_lv_pmos ad=0.2128p pd=1.5u as=0.3808p ps=2.92u w=1.12u l=0.13u
X70 a_16108_289# a_17865_519# a_16510_1044# VDD sg13_lv_pmos ad=0.3808p pd=2.92u as=0.3808p ps=2.92u w=1.12u l=0.13u
X71 a_26673_1842# a_26477_1842# VSS.t184 VSS.t197 sg13_lv_nmos ad=0.2516p pd=2.16u as=0.1406p ps=1.12u w=0.74u l=0.13u
X72 VDD a_7803_1842# a_8237_1842# VDD sg13_lv_pmos ad=0.2128p pd=1.5u as=0.3808p ps=2.92u w=1.12u l=0.13u
X73 a_4248_1044# a_4157_1313# VSS.t236 VSS.t235 sg13_lv_nmos ad=0.1406p pd=1.12u as=0.2516p ps=2.16u w=0.74u l=0.13u
X74 a_16108_289# a_3171_311.t2 a_22590_1044# VSS.t138 sg13_lv_nmos ad=0.2516p pd=2.16u as=0.2516p ps=2.16u w=0.74u l=0.13u
X75 VSS.t431 DELAY_VBIASN.t28 a_6391_1842# VSS.t430 sg13_lv_nmos ad=0.2516p pd=2.16u as=0.1406p ps=1.12u w=0.74u l=0.6u
X76 a_16408_1044# a_15837_1842# VDD VDD sg13_lv_pmos ad=0.2128p pd=1.5u as=0.3808p ps=2.92u w=1.12u l=0.13u
X77 a_19550_1044# a_3747_1047.t4 a_21835_1044# VSS.t527 sg13_lv_nmos ad=0.2516p pd=2.16u as=0.1406p ps=1.12u w=0.74u l=0.13u
X78 VSS.t455 DELAY_VBIASN.t9 a_20831_1842# VSS.t454 sg13_lv_nmos ad=0.2516p pd=2.16u as=0.1406p ps=1.12u w=0.74u l=0.6u
X79 a_3171_311.t0 a_2873_331# VDD VDD sg13_lv_pmos ad=0.2128p pd=1.5u as=0.1918p ps=1.5u w=1.12u l=0.13u
X80 a_3747_311.t0 a_3449_331# VDD VDD sg13_lv_pmos ad=0.2128p pd=1.5u as=0.1918p ps=1.5u w=1.12u l=0.13u
X81 a_7390_1044# a_9751_1008# a_9675_1044# VDD sg13_lv_pmos ad=0.3808p pd=2.92u as=0.2128p ps=1.5u w=1.12u l=0.13u
X82 a_10191_1842# a_9953_1842# a_10083_1842# VSS.t487 sg13_lv_nmos ad=0.1406p pd=1.12u as=0.2516p ps=2.16u w=0.74u l=0.2u
X83 VSS.t163 a_22677_1842# a_23145_1044# VSS.t162 sg13_lv_nmos ad=0.1665p pd=1.19u as=0.2516p ps=2.16u w=0.74u l=0.13u
X84 a_14751_2470# a_14513_1842# a_14643_1842# VDD sg13_lv_pmos ad=0.2128p pd=1.5u as=0.3808p ps=2.92u w=1.12u l=0.2u
X85 a_5731_289# a_8745_519# a_7390_1044# VDD sg13_lv_pmos ad=0.3808p pd=2.92u as=0.3808p ps=2.92u w=1.12u l=0.13u
X86 VDD VDD VDD VDD sg13_lv_pmos ad=0.2128p pd=1.5u as=0 ps=0 w=1.12u l=0.13u
X87 a_4111_2470# DELAY_IN a_4003_1842# VDD sg13_lv_pmos ad=0.2128p pd=1.5u as=0.3808p ps=2.92u w=1.12u l=0.2u
X88 a_7673_1842# a_7477_1842# VSS.t399 VSS.t470 sg13_lv_nmos ad=0.2516p pd=2.16u as=0.1406p ps=1.12u w=0.74u l=0.13u
X89 VDD a_3171_1047.t5 a_18004_1008# VDD sg13_lv_pmos ad=0.3808p pd=2.92u as=0.3808p ps=2.92u w=1.12u l=0.13u
X90 VDD a_13123_1842# a_13557_1842# VDD sg13_lv_pmos ad=0.2128p pd=1.5u as=0.3808p ps=2.92u w=1.12u l=0.13u
X91 VDD a_3747_311.t2 a_26985_519# VDD sg13_lv_pmos ad=0.3808p pd=2.92u as=0.3808p ps=2.92u w=1.12u l=0.13u
X92 a_25913_1842# a_25717_1842# VDD VDD sg13_lv_pmos ad=0.3808p pd=2.92u as=0.2128p ps=1.5u w=1.12u l=0.13u
X93 a_10430_1044# a_3747_1047.t7 a_12715_1044# VSS.t517 sg13_lv_nmos ad=0.2516p pd=2.16u as=0.1406p ps=1.12u w=0.74u l=0.13u
X94 a_14235_1044# a_14025_1044# VDD VDD sg13_lv_pmos ad=0.2128p pd=1.5u as=0.252p ps=1.57u w=1.12u l=0.13u
X95 a_24875_1044# a_24665_1044# VSS.t367 VSS.t538 sg13_lv_nmos ad=0.1406p pd=1.12u as=0.1665p ps=1.19u w=0.74u l=0.13u
X96 VSS.t443 DELAY_VBIASN.t21 a_11711_1842# VSS.t442 sg13_lv_nmos ad=0.2516p pd=2.16u as=0.1406p ps=1.12u w=0.74u l=0.6u
X97 VDD a_3747_1047.t7 a_12791_1008# VDD sg13_lv_pmos ad=0.3808p pd=2.92u as=0.3808p ps=2.92u w=1.12u l=0.13u
X98 VSS.t27 a_2595_1047.t3 a_23431_1008# VSS.t26 sg13_lv_nmos ad=0.2516p pd=2.16u as=0.2516p ps=2.16u w=0.74u l=0.13u
X99 VSS.t193 a_21483_1842# a_21917_1842# VSS.t192 sg13_lv_nmos ad=0.1406p pd=1.12u as=0.2516p ps=2.16u w=0.74u l=0.13u
X100 VSS.t50 a_13557_1842# a_14025_1044# VSS.t49 sg13_lv_nmos ad=0.1665p pd=1.19u as=0.2516p ps=2.16u w=0.74u l=0.13u
X101 a_11848_1044# a_11277_1842# VDD VDD sg13_lv_pmos ad=0.2128p pd=1.5u as=0.3808p ps=2.92u w=1.12u l=0.13u
X102 VDD VSS.t565 VDD VDD sg13_lv_pmos ad=0.19p pd=1.38u as=0 ps=0 w=1u l=1u
X103 a_25391_1842# a_25153_1842# a_25283_1842# VSS.t472 sg13_lv_nmos ad=0.1406p pd=1.12u as=0.2516p ps=2.16u w=0.74u l=0.2u
X104 a_12993_1842# a_12797_1842# VSS.t347 VSS.t346 sg13_lv_nmos ad=0.2516p pd=2.16u as=0.1406p ps=1.12u w=0.74u l=0.13u
X105 DELAY_OUT_LAST a_27997_1842# VDD VDD sg13_lv_pmos ad=0.3808p pd=2.92u as=0.2128p ps=1.5u w=1.12u l=0.13u
X106 VDD VSS.t564 VDD VDD sg13_lv_pmos ad=0.34p pd=2.68u as=0 ps=0 w=1u l=1u
X107 VDD a_19637_1842# a_20105_1044# VDD sg13_lv_pmos ad=0.252p pd=1.57u as=0.3808p ps=2.92u w=1.12u l=0.13u
X108 VSS.t445 DELAY_VBIASN.t18 a_13991_1842# VSS.t444 sg13_lv_nmos ad=0.2516p pd=2.16u as=0.1406p ps=1.12u w=0.74u l=0.6u
X109 VSS.t308 VDD VSS.t307 VSS.t306 sg13_lv_nmos ad=0.1428p pd=1.52u as=0 ps=0 w=0.42u l=1u
X110 a_22590_1044# a_3171_1047.t3 a_24008_1044# VSS.t13 sg13_lv_nmos ad=0.2516p pd=2.16u as=0.1406p ps=1.12u w=0.74u l=0.13u
X111 a_6913_1842# a_6717_1842# VDD VDD sg13_lv_pmos ad=0.3808p pd=2.92u as=0.2128p ps=1.5u w=1.12u l=0.13u
X112 VDD DELAY_VBIASP.t12 a_18551_2470# VDD sg13_lv_pmos ad=0.3808p pd=2.92u as=0.2128p ps=1.5u w=1.12u l=0.6u
X113 VSS.t369 a_23763_1842# a_24197_1842# VSS.t550 sg13_lv_nmos ad=0.1406p pd=1.12u as=0.2516p ps=2.16u w=0.74u l=0.13u
X114 VSS.t273 VDD VSS.t272 VSS.t271 sg13_lv_nmos ad=0.1428p pd=1.52u as=0 ps=0 w=0.42u l=1u
X115 VDD a_1256_1044# a_2873_1395# VDD sg13_lv_pmos ad=0.1918p pd=1.5u as=0.1596p ps=1.22u w=0.84u l=0.13u
X116 a_3171_311.t1 a_2873_331# VSS.t3 VSS.t2 sg13_lv_nmos ad=0.1406p pd=1.12u as=0.1331p ps=1.12u w=0.74u l=0.13u
X117 VDD a_2873_331# a_3171_311.t0 VDD sg13_lv_pmos ad=0.4256p pd=3u as=0.2128p ps=1.5u w=1.12u l=0.13u
X118 a_16510_1044# a_17351_1008# a_17275_1044# VDD sg13_lv_pmos ad=0.3808p pd=2.92u as=0.2128p ps=1.5u w=1.12u l=0.13u
X119 a_25630_1044# a_3747_1047.t2 a_27915_1044# VSS.t514 sg13_lv_nmos ad=0.2516p pd=2.16u as=0.1406p ps=1.12u w=0.74u l=0.13u
X120 VSS.t415 DELAY_VBIASN.t1 a_26911_1842# VSS.t414 sg13_lv_nmos ad=0.2516p pd=2.16u as=0.1406p ps=1.12u w=0.74u l=0.6u
X121 a_3747_311.t1 a_3449_331# VSS.t41 VSS.t40 sg13_lv_nmos ad=0.1406p pd=1.12u as=0.1331p ps=1.12u w=0.74u l=0.13u
X122 VDD a_3449_331# a_3747_311.t0 VDD sg13_lv_pmos ad=0.4256p pd=3u as=0.2128p ps=1.5u w=1.12u l=0.13u
X123 VDD DELAY_VBIASP.t7 a_22351_2470# VDD sg13_lv_pmos ad=0.3808p pd=2.92u as=0.2128p ps=1.5u w=1.12u l=0.6u
X124 VDD a_3747_1047.t2 a_27991_1008# VDD sg13_lv_pmos ad=0.3808p pd=2.92u as=0.3808p ps=2.92u w=1.12u l=0.13u
X125 VDD VSS.t597 VDD VDD sg13_lv_pmos ad=0.19p pd=1.38u as=0 ps=0 w=1u l=1u
X126 VDD a_3747_1047.t9 a_6711_1008# VDD sg13_lv_pmos ad=0.3808p pd=2.92u as=0.3808p ps=2.92u w=1.12u l=0.13u
X127 a_6391_1842# a_6153_1842# a_6283_1842# VSS.t499 sg13_lv_nmos ad=0.1406p pd=1.12u as=0.2516p ps=2.16u w=0.74u l=0.2u
X128 a_15273_1842# a_15077_1842# VSS.t379 VSS.t474 sg13_lv_nmos ad=0.2516p pd=2.16u as=0.1406p ps=1.12u w=0.74u l=0.13u
X129 a_19833_1842# a_19637_1842# VDD VDD sg13_lv_pmos ad=0.3808p pd=2.92u as=0.2128p ps=1.5u w=1.12u l=0.13u
X130 a_16108_289# a_23945_519# a_22590_1044# VDD sg13_lv_pmos ad=0.3808p pd=2.92u as=0.3808p ps=2.92u w=1.12u l=0.13u
X131 a_9193_1842# a_8997_1842# VDD VDD sg13_lv_pmos ad=0.3808p pd=2.92u as=0.2128p ps=1.5u w=1.12u l=0.13u
X132 a_24631_2470# a_24393_1842# a_24523_1842# VDD sg13_lv_pmos ad=0.2128p pd=1.5u as=0.3808p ps=2.92u w=1.12u l=0.2u
X133 VSS.t64 a_15403_1842# a_15837_1842# VSS.t211 sg13_lv_nmos ad=0.1406p pd=1.12u as=0.2516p ps=2.16u w=0.74u l=0.13u
X134 a_8155_1044# a_7945_1044# VSS.t240 VSS.t239 sg13_lv_nmos ad=0.1406p pd=1.12u as=0.1665p ps=1.19u w=0.74u l=0.13u
X135 a_23633_1842# a_23437_1842# VDD VDD sg13_lv_pmos ad=0.3808p pd=2.92u as=0.2128p ps=1.5u w=1.12u l=0.13u
X136 VSS.t76 a_4763_1842# a_5197_1842# VSS.t167 sg13_lv_nmos ad=0.1406p pd=1.12u as=0.2516p ps=2.16u w=0.74u l=0.13u
X137 a_27048_1044# a_26477_1842# VSS.t199 VSS.t198 sg13_lv_nmos ad=0.1406p pd=1.12u as=0.2516p ps=2.16u w=0.74u l=0.13u
X138 VDD a_9323_1842# a_9757_1842# VDD sg13_lv_pmos ad=0.2128p pd=1.5u as=0.3808p ps=2.92u w=1.12u l=0.13u
X139 a_5768_1044# a_5197_1842# VSS.t78 VSS.t77 sg13_lv_nmos ad=0.1406p pd=1.12u as=0.2516p ps=2.16u w=0.74u l=0.13u
X140 a_7390_1044# a_7364_1008# a_7288_1044# VDD sg13_lv_pmos ad=0.3808p pd=2.92u as=0.2128p ps=1.5u w=1.12u l=0.13u
X141 VSS.t409 DELAY_VBIASN.t26 a_7911_1842# VSS.t408 sg13_lv_nmos ad=0.2516p pd=2.16u as=0.1406p ps=1.12u w=0.74u l=0.6u
X142 VDD VSS.t581 VDD VDD sg13_lv_pmos ad=0.19p pd=1.38u as=0 ps=0 w=1u l=1u
X143 a_11711_1842# a_11473_1842# a_11603_1842# VSS.t190 sg13_lv_nmos ad=0.1406p pd=1.12u as=0.2516p ps=2.16u w=0.74u l=0.2u
X144 VSS.t367 a_24197_1842# a_24665_1044# VSS.t366 sg13_lv_nmos ad=0.1665p pd=1.19u as=0.2516p ps=2.16u w=0.74u l=0.13u
X145 a_16510_1044# a_3171_1047.t5 a_17928_1044# VSS.t530 sg13_lv_nmos ad=0.2516p pd=2.16u as=0.1406p ps=1.12u w=0.74u l=0.13u
X146 VSS.t265 VDD VSS.t263 VSS.t264 sg13_lv_nmos ad=79.8f pd=0.8u as=0 ps=0 w=0.42u l=1u
X147 a_5631_2470# a_5393_1842# a_5523_1842# VDD sg13_lv_pmos ad=0.2128p pd=1.5u as=0.3808p ps=2.92u w=1.12u l=0.2u
X148 a_14513_1842# a_14317_1842# VDD VDD sg13_lv_pmos ad=0.3808p pd=2.92u as=0.2128p ps=1.5u w=1.12u l=0.13u
X149 a_4633_1842# a_4437_1842# VDD VDD sg13_lv_pmos ad=0.3808p pd=2.92u as=0.2128p ps=1.5u w=1.12u l=0.13u
X150 VSS.t498 a_10083_1842# a_10517_1842# VSS.t497 sg13_lv_nmos ad=0.1406p pd=1.12u as=0.2516p ps=2.16u w=0.74u l=0.13u
X151 VDD a_2019_1047.t4 a_19524_1008# VDD sg13_lv_pmos ad=0.3808p pd=2.92u as=0.3808p ps=2.92u w=1.12u l=0.13u
X152 VSS.t18 a_3171_1047.t4 a_21044_1008# VSS.t17 sg13_lv_nmos ad=0.2516p pd=2.16u as=0.2516p ps=2.16u w=0.74u l=0.13u
X153 VSS.t5 a_2873_331# a_3171_311.t1 VSS.t4 sg13_lv_nmos ad=0.2812p pd=2.24u as=0.1406p ps=1.12u w=0.74u l=0.13u
X154 VSS.t43 a_3449_331# a_3747_311.t1 VSS.t42 sg13_lv_nmos ad=0.2812p pd=2.24u as=0.1406p ps=1.12u w=0.74u l=0.13u
X155 a_15755_1044# a_15545_1044# VDD VDD sg13_lv_pmos ad=0.2128p pd=1.5u as=0.252p ps=1.57u w=1.12u l=0.13u
X156 VDD a_2595_1047.t6 a_14311_1008# VDD sg13_lv_pmos ad=0.3808p pd=2.92u as=0.3808p ps=2.92u w=1.12u l=0.13u
X157 VSS.t465 DELAY_VBIASN.t4 a_24631_1842# VSS.t464 sg13_lv_nmos ad=0.2516p pd=2.16u as=0.1406p ps=1.12u w=0.74u l=0.6u
X158 a_5115_1044# a_4905_1044# VDD VDD sg13_lv_pmos ad=0.2128p pd=1.5u as=0.252p ps=1.57u w=1.12u l=0.13u
X159 a_18551_2470# a_18313_1842# a_18443_1842# VDD sg13_lv_pmos ad=0.2128p pd=1.5u as=0.3808p ps=2.92u w=1.12u l=0.2u
X160 VDD VSS.t573 VDD VDD sg13_lv_pmos ad=0.19p pd=1.38u as=0 ps=0 w=1u l=1u
X161 a_3171_1047.t1 a_2873_1395# VSS.t145 VSS.t144 sg13_lv_nmos ad=0.1406p pd=1.12u as=0.1331p ps=1.12u w=0.74u l=0.13u
X162 VSS.t69 a_2297_1395# a_2595_1047.t1 VSS.t68 sg13_lv_nmos ad=0.2812p pd=2.24u as=0.1406p ps=1.12u w=0.74u l=0.13u
X163 a_22351_2470# a_22113_1842# a_22243_1842# VDD sg13_lv_pmos ad=0.2128p pd=1.5u as=0.3808p ps=2.92u w=1.12u l=0.2u
X164 VSS.t354 VSS.t351 VSS.t353 VSS.t352 sg13_lv_nmos ad=0.2516p pd=2.16u as=0 ps=0 w=0.74u l=0.13u
X165 a_26911_1842# a_26673_1842# a_26803_1842# VSS.t200 sg13_lv_nmos ad=0.1406p pd=1.12u as=0.2516p ps=2.16u w=0.74u l=0.2u
X166 VSS.t81 a_3171_311.t3 a_11785_519# VSS.t80 sg13_lv_nmos ad=0.2516p pd=2.16u as=0.2516p ps=2.16u w=0.74u l=0.13u
X167 VDD a_1721_1395# a_2019_1047.t0 VDD sg13_lv_pmos ad=0.4256p pd=3u as=0.2128p ps=1.5u w=1.12u l=0.13u
X168 VDD a_16923_1842# a_17357_1842# VDD sg13_lv_pmos ad=0.2128p pd=1.5u as=0.3808p ps=2.92u w=1.12u l=0.13u
X169 a_2391_1395# MUX_SEL0 a_2297_1395# VSS.t477 sg13_lv_nmos ad=0.1216p pd=1.02u as=0.2176p ps=1.96u w=0.64u l=0.13u
X170 VSS.t58 a_1544_1044# a_1815_1395# VSS.t57 sg13_lv_nmos ad=0.1331p pd=1.12u as=0.1216p ps=1.02u w=0.64u l=0.13u
X171 a_13368_1044# a_12797_1842# VSS.t349 VSS.t348 sg13_lv_nmos ad=0.1406p pd=1.12u as=0.2516p ps=2.16u w=0.74u l=0.13u
X172 a_5731_289# a_3171_311.t3 a_10430_1044# VSS.t79 sg13_lv_nmos ad=0.2516p pd=2.16u as=0.2516p ps=2.16u w=0.74u l=0.13u
X173 VDD a_21157_1842# a_21625_1044# VDD sg13_lv_pmos ad=0.252p pd=1.57u as=0.3808p ps=2.92u w=1.12u l=0.13u
X174 VDD DELAY_VBIASP.t22 a_10951_2470# VDD sg13_lv_pmos ad=0.3808p pd=2.92u as=0.2128p ps=1.5u w=1.12u l=0.6u
X175 VSS.t449 DELAY_VBIASN.t16 a_15511_1842# VSS.t448 sg13_lv_nmos ad=0.2516p pd=2.16u as=0.1406p ps=1.12u w=0.74u l=0.6u
X176 VDD a_20723_1842# a_21157_1842# VDD sg13_lv_pmos ad=0.2128p pd=1.5u as=0.3808p ps=2.92u w=1.12u l=0.13u
X177 VSS.t375 a_25283_1842# a_25717_1842# VSS.t374 sg13_lv_nmos ad=0.1406p pd=1.12u as=0.2516p ps=2.16u w=0.74u l=0.13u
X178 a_4350_1044# a_3747_1047.t9 a_6635_1044# VSS.t227 sg13_lv_nmos ad=0.2516p pd=2.16u as=0.1406p ps=1.12u w=0.74u l=0.13u
X179 VSS.t411 DELAY_VBIASN.t29 a_5631_1842# VSS.t410 sg13_lv_nmos ad=0.2516p pd=2.16u as=0.1406p ps=1.12u w=0.74u l=0.6u
X180 VDD a_2019_1047.t9 a_4324_1008# VDD sg13_lv_pmos ad=0.3808p pd=2.92u as=0.3808p ps=2.92u w=1.12u l=0.13u
X181 a_16510_1044# a_18871_1008# a_18795_1044# VDD sg13_lv_pmos ad=0.3808p pd=2.92u as=0.2128p ps=1.5u w=1.12u l=0.13u
X182 a_19550_1044# a_2595_1047.t4 a_20315_1044# VSS.t120 sg13_lv_nmos ad=0.2516p pd=2.16u as=0.1406p ps=1.12u w=0.74u l=0.13u
X183 VDD DELAY_VBIASP.t5 a_23871_2470# VDD sg13_lv_pmos ad=0.3808p pd=2.92u as=0.2128p ps=1.5u w=1.12u l=0.6u
X184 VSS.t240 a_7477_1842# a_7945_1044# VSS.t469 sg13_lv_nmos ad=0.1665p pd=1.19u as=0.2516p ps=2.16u w=0.74u l=0.13u
X185 a_13231_2470# a_12993_1842# a_13123_1842# VDD sg13_lv_pmos ad=0.2128p pd=1.5u as=0.3808p ps=2.92u w=1.12u l=0.2u
X186 VDD VSS.t598 VDD VDD sg13_lv_pmos ad=0.34p pd=2.68u as=0 ps=0 w=1u l=1u
X187 a_12233_1842# a_12037_1842# VDD VDD sg13_lv_pmos ad=0.3808p pd=2.92u as=0.2128p ps=1.5u w=1.12u l=0.13u
X188 a_7911_1842# a_7673_1842# a_7803_1842# VSS.t488 sg13_lv_nmos ad=0.1406p pd=1.12u as=0.2516p ps=2.16u w=0.74u l=0.2u
X189 a_16793_1842# a_16597_1842# VSS.t9 VSS.t8 sg13_lv_nmos ad=0.2516p pd=2.16u as=0.1406p ps=1.12u w=0.74u l=0.13u
X190 VDD a_3747_311.t3 a_14825_519# VDD sg13_lv_pmos ad=0.3808p pd=2.92u as=0.3808p ps=2.92u w=1.12u l=0.13u
X191 VSS.t71 a_27563_1842# a_27997_1842# VSS.t70 sg13_lv_nmos ad=0.1406p pd=1.12u as=0.2516p ps=2.16u w=0.74u l=0.13u
X192 a_9675_1044# a_9465_1044# VSS.t149 VSS.t148 sg13_lv_nmos ad=0.1406p pd=1.12u as=0.1665p ps=1.19u w=0.74u l=0.13u
X193 a_20593_1842# a_20397_1842# VSS.t377 VSS.t522 sg13_lv_nmos ad=0.2516p pd=2.16u as=0.1406p ps=1.12u w=0.74u l=0.13u
X194 VSS.t56 a_2595_1047.t8 a_8231_1008# VSS.t55 sg13_lv_nmos ad=0.2516p pd=2.16u as=0.2516p ps=2.16u w=0.74u l=0.13u
X195 VSS.t388 a_6283_1842# a_6717_1842# VSS.t387 sg13_lv_nmos ad=0.1406p pd=1.12u as=0.2516p ps=2.16u w=0.74u l=0.13u
X196 a_10430_1044# a_10404_1008# a_10328_1044# VDD sg13_lv_pmos ad=0.3808p pd=2.92u as=0.2128p ps=1.5u w=1.12u l=0.13u
X197 VDD DELAY_VBIASP.t2 a_26151_2470# VDD sg13_lv_pmos ad=0.3808p pd=2.92u as=0.2128p ps=1.5u w=1.12u l=0.6u
X198 a_7390_1044# a_8884_1008# a_8808_1044# VDD sg13_lv_pmos ad=0.3808p pd=2.92u as=0.2128p ps=1.5u w=1.12u l=0.13u
X199 VDD DELAY_VBIASP.t30 a_4871_2470# VDD sg13_lv_pmos ad=0.3808p pd=2.92u as=0.2128p ps=1.5u w=1.12u l=0.6u
X200 a_3449_331# MUX_SEL2 VDD VDD sg13_lv_pmos ad=0.1596p pd=1.22u as=0.2856p ps=2.36u w=0.84u l=0.13u
X201 VDD VSS.t575 VDD VDD sg13_lv_pmos ad=0.19p pd=1.38u as=0 ps=0 w=1u l=1u
X202 a_19073_1842# a_18877_1842# VSS.t384 VSS.t513 sg13_lv_nmos ad=0.2516p pd=2.16u as=0.1406p ps=1.12u w=0.74u l=0.13u
X203 VDD a_15077_1842# a_15545_1044# VDD sg13_lv_pmos ad=0.252p pd=1.57u as=0.3808p ps=2.92u w=1.12u l=0.13u
X204 a_19550_1044# a_2019_1047.t4 a_19448_1044# VSS.t34 sg13_lv_nmos ad=0.2516p pd=2.16u as=0.1406p ps=1.12u w=0.74u l=0.13u
X205 VDD VDD VDD VDD sg13_lv_pmos ad=0.3808p pd=2.92u as=0 ps=0 w=1.12u l=0.6u
X206 VSS.t325 VDD VSS.t323 VSS.t324 sg13_lv_nmos ad=79.8f pd=0.8u as=0 ps=0 w=0.42u l=1u
X207 VSS.t186 a_19203_1842# a_19637_1842# VSS.t185 sg13_lv_nmos ad=0.1406p pd=1.12u as=0.2516p ps=2.16u w=0.74u l=0.13u
X208 VDD VSS.t577 VDD VDD sg13_lv_pmos ad=0.19p pd=1.38u as=0 ps=0 w=1u l=1u
X209 VDD VSS.t588 VDD VDD sg13_lv_pmos ad=0.34p pd=2.68u as=0 ps=0 w=1u l=1u
X210 a_27433_1842# a_27237_1842# VDD VDD sg13_lv_pmos ad=0.3808p pd=2.92u as=0.2128p ps=1.5u w=1.12u l=0.13u
X211 VDD a_1256_289# a_2873_331# VDD sg13_lv_pmos ad=0.1918p pd=1.5u as=0.1596p ps=1.22u w=0.84u l=0.13u
X212 a_13470_1044# a_2595_1047.t6 a_14235_1044# VSS.t22 sg13_lv_nmos ad=0.2516p pd=2.16u as=0.1406p ps=1.12u w=0.74u l=0.13u
X213 VSS.t382 a_8563_1842# a_8997_1842# VSS.t403 sg13_lv_nmos ad=0.1406p pd=1.12u as=0.2516p ps=2.16u w=0.74u l=0.13u
X214 VSS.t405 DELAY_VBIASN.t19 a_13231_1842# VSS.t404 sg13_lv_nmos ad=0.2516p pd=2.16u as=0.1406p ps=1.12u w=0.74u l=0.6u
X215 VDD a_3171_1047.t7 a_11924_1008# VDD sg13_lv_pmos ad=0.3808p pd=2.92u as=0.3808p ps=2.92u w=1.12u l=0.13u
X216 VSS.t33 a_2019_1047.t3 a_22564_1008# VSS.t32 sg13_lv_nmos ad=0.2516p pd=2.16u as=0.2516p ps=2.16u w=0.74u l=0.13u
X217 VSS.t104 a_23003_1842# a_23437_1842# VSS.t168 sg13_lv_nmos ad=0.1406p pd=1.12u as=0.2516p ps=2.16u w=0.74u l=0.13u
X218 VSS.t328 VDD VSS.t327 VSS.t326 sg13_lv_nmos ad=0.1428p pd=1.52u as=0 ps=0 w=0.42u l=1u
X219 VDD DELAY_VBIASP.t27 a_7151_2470# VDD sg13_lv_pmos ad=0.3808p pd=2.92u as=0.2128p ps=1.5u w=1.12u l=0.6u
X220 a_25630_1044# a_25604_1008# a_25528_1044# VDD sg13_lv_pmos ad=0.3808p pd=2.92u as=0.2128p ps=1.5u w=1.12u l=0.13u
X221 a_15511_1842# a_15273_1842# a_15403_1842# VSS.t206 sg13_lv_nmos ad=0.1406p pd=1.12u as=0.2516p ps=2.16u w=0.74u l=0.2u
X222 a_18313_1842# a_18117_1842# VDD VDD sg13_lv_pmos ad=0.3808p pd=2.92u as=0.2128p ps=1.5u w=1.12u l=0.13u
X223 a_5731_289# a_11785_519# a_10430_1044# VDD sg13_lv_pmos ad=0.3808p pd=2.92u as=0.3808p ps=2.92u w=1.12u l=0.13u
X224 VSS.t245 VDD VSS.t243 VSS.t244 sg13_lv_nmos ad=79.8f pd=0.8u as=0 ps=0 w=0.42u l=1u
X225 a_9431_2470# a_9193_1842# a_9323_1842# VDD sg13_lv_pmos ad=0.2128p pd=1.5u as=0.3808p ps=2.92u w=1.12u l=0.2u
X226 a_17275_1044# a_17065_1044# VSS.t7 VSS.t113 sg13_lv_nmos ad=0.1406p pd=1.12u as=0.1665p ps=1.19u w=0.74u l=0.13u
X227 VDD VSS.t574 VDD VDD sg13_lv_pmos ad=0.34p pd=2.68u as=0 ps=0 w=1u l=1u
X228 VSS.t217 a_3747_1047.t6 a_15831_1008# VSS.t216 sg13_lv_nmos ad=0.2516p pd=2.16u as=0.2516p ps=2.16u w=0.74u l=0.13u
X229 a_23871_2470# a_23633_1842# a_23763_1842# VDD sg13_lv_pmos ad=0.2128p pd=1.5u as=0.3808p ps=2.92u w=1.12u l=0.2u
X230 VSS.t170 a_13883_1842# a_14317_1842# VSS.t169 sg13_lv_nmos ad=0.1406p pd=1.12u as=0.2516p ps=2.16u w=0.74u l=0.13u
X231 VSS.t166 a_3747_311.t2 a_26985_519# VSS.t165 sg13_lv_nmos ad=0.2516p pd=2.16u as=0.2516p ps=2.16u w=0.74u l=0.13u
X232 a_8433_1842# a_8237_1842# VDD VDD sg13_lv_pmos ad=0.3808p pd=2.92u as=0.2128p ps=1.5u w=1.12u l=0.13u
X233 VDD a_18443_1842# a_18877_1842# VDD sg13_lv_pmos ad=0.2128p pd=1.5u as=0.3808p ps=2.92u w=1.12u l=0.13u
X234 a_22113_1842# a_21917_1842# VDD VDD sg13_lv_pmos ad=0.3808p pd=2.92u as=0.2128p ps=1.5u w=1.12u l=0.13u
X235 a_4350_1044# a_2019_1047.t9 a_4248_1044# VSS.t98 sg13_lv_nmos ad=0.2516p pd=2.16u as=0.1406p ps=1.12u w=0.74u l=0.13u
X236 a_14888_1044# a_14317_1842# VSS.t545 VSS.t544 sg13_lv_nmos ad=0.1406p pd=1.12u as=0.2516p ps=2.16u w=0.74u l=0.13u
X237 a_16108_289# a_3747_311.t2 a_25630_1044# VSS.t164 sg13_lv_nmos ad=0.2516p pd=2.16u as=0.2516p ps=2.16u w=0.74u l=0.13u
X238 VDD DELAY_VBIASP.t20 a_12471_2470# VDD sg13_lv_pmos ad=0.3808p pd=2.92u as=0.2128p ps=1.5u w=1.12u l=0.6u
X239 VSS.t87 a_4003_1842# a_4437_1842# VSS.t86 sg13_lv_nmos ad=0.1406p pd=1.12u as=0.2516p ps=2.16u w=0.74u l=0.13u
X240 a_16510_1044# a_16484_1008# a_16408_1044# VDD sg13_lv_pmos ad=0.3808p pd=2.92u as=0.2128p ps=1.5u w=1.12u l=0.13u
X241 VDD a_22243_1842# a_22677_1842# VDD sg13_lv_pmos ad=0.2128p pd=1.5u as=0.3808p ps=2.92u w=1.12u l=0.13u
X242 VDD a_3171_1047.t2 a_27124_1008# VDD sg13_lv_pmos ad=0.3808p pd=2.92u as=0.3808p ps=2.92u w=1.12u l=0.13u
X243 VDD MUX_SEL3 a_3449_331# VDD sg13_lv_pmos ad=0.1918p pd=1.5u as=0.1596p ps=1.22u w=0.84u l=0.13u
X244 a_2595_311.t0 a_2297_331# VDD VDD sg13_lv_pmos ad=0.2128p pd=1.5u as=0.1918p ps=1.5u w=1.12u l=0.13u
X245 a_10430_1044# a_11271_1008# a_11195_1044# VDD sg13_lv_pmos ad=0.3808p pd=2.92u as=0.2128p ps=1.5u w=1.12u l=0.13u
X246 a_23355_1044# a_23145_1044# VDD VDD sg13_lv_pmos ad=0.2128p pd=1.5u as=0.252p ps=1.57u w=1.12u l=0.13u
X247 VDD a_3747_1047.t4 a_21911_1008# VDD sg13_lv_pmos ad=0.3808p pd=2.92u as=0.3808p ps=2.92u w=1.12u l=0.13u
X248 VSS.t149 a_8997_1842# a_9465_1044# VSS.t380 sg13_lv_nmos ad=0.1665p pd=1.19u as=0.2516p ps=2.16u w=0.74u l=0.13u
X249 a_20968_1044# a_20397_1842# VDD VDD sg13_lv_pmos ad=0.2128p pd=1.5u as=0.3808p ps=2.92u w=1.12u l=0.13u
X250 a_10951_1842# a_10713_1842# a_10843_1842# VSS.t391 sg13_lv_nmos ad=0.1406p pd=1.12u as=0.2516p ps=2.16u w=0.74u l=0.2u
X251 VSS.t526 a_2019_1047.t5 a_16484_1008# VSS.t525 sg13_lv_nmos ad=0.2516p pd=2.16u as=0.2516p ps=2.16u w=0.74u l=0.13u
X252 a_26151_2470# a_25913_1842# a_26043_1842# VDD sg13_lv_pmos ad=0.2128p pd=1.5u as=0.3808p ps=2.92u w=1.12u l=0.2u
X253 a_13753_1842# a_13557_1842# VDD VDD sg13_lv_pmos ad=0.3808p pd=2.92u as=0.2128p ps=1.5u w=1.12u l=0.13u
X254 VDD a_1721_331# a_2019_311# VDD sg13_lv_pmos ad=0.4256p pd=3u as=0.2128p ps=1.5u w=1.12u l=0.13u
X255 a_4871_2470# a_4633_1842# a_4763_1842# VDD sg13_lv_pmos ad=0.2128p pd=1.5u as=0.3808p ps=2.92u w=1.12u l=0.2u
X256 VSS.t128 a_3171_1047.t9 a_5844_1008# VSS.t127 sg13_lv_nmos ad=0.2516p pd=2.16u as=0.2516p ps=2.16u w=0.74u l=0.13u
X257 VSS.t285 VDD VSS.t283 VSS.t284 sg13_lv_nmos ad=79.8f pd=0.8u as=0 ps=0 w=0.42u l=1u
X258 VDD a_2595_311.t2 a_20905_519# VDD sg13_lv_pmos ad=0.3808p pd=2.92u as=0.3808p ps=2.92u w=1.12u l=0.13u
X259 VDD a_2297_331# a_2595_311.t0 VDD sg13_lv_pmos ad=0.4256p pd=3u as=0.2128p ps=1.5u w=1.12u l=0.13u
X260 VSS.t336 a_2595_1047.t7 a_11271_1008# VSS.t335 sg13_lv_nmos ad=0.2516p pd=2.16u as=0.2516p ps=2.16u w=0.74u l=0.13u
X261 VSS.t423 DELAY_VBIASN.t11 a_19311_1842# VSS.t422 sg13_lv_nmos ad=0.2516p pd=2.16u as=0.1406p ps=1.12u w=0.74u l=0.6u
X262 VDD a_24523_1842# a_24957_1842# VDD sg13_lv_pmos ad=0.2128p pd=1.5u as=0.3808p ps=2.92u w=1.12u l=0.13u
X263 VSS.t134 a_3747_1047.t8 a_9751_1008# VSS.t133 sg13_lv_nmos ad=0.2516p pd=2.16u as=0.2516p ps=2.16u w=0.74u l=0.13u
X264 VSS.t439 DELAY_VBIASN.t24 a_9431_1842# VSS.t438 sg13_lv_nmos ad=0.2516p pd=2.16u as=0.1406p ps=1.12u w=0.74u l=0.6u
X265 a_19448_1044# a_18877_1842# VDD VDD sg13_lv_pmos ad=0.2128p pd=1.5u as=0.3808p ps=2.92u w=1.12u l=0.13u
X266 VSS.t413 DELAY_VBIASN.t6 a_23111_1842# VSS.t412 sg13_lv_nmos ad=0.2516p pd=2.16u as=0.1406p ps=1.12u w=0.74u l=0.6u
X267 a_10430_1044# a_11924_1008# a_11848_1044# VDD sg13_lv_pmos ad=0.3808p pd=2.92u as=0.2128p ps=1.5u w=1.12u l=0.13u
X268 VDD DELAY_VBIASP.t0 a_27671_2470# VDD sg13_lv_pmos ad=0.3808p pd=2.92u as=0.2128p ps=1.5u w=1.12u l=0.6u
X269 a_25630_1044# a_26471_1008# a_26395_1044# VDD sg13_lv_pmos ad=0.3808p pd=2.92u as=0.2128p ps=1.5u w=1.12u l=0.13u
X270 a_7151_2470# a_6913_1842# a_7043_1842# VDD sg13_lv_pmos ad=0.2128p pd=1.5u as=0.3808p ps=2.92u w=1.12u l=0.2u
X271 a_16033_1842# a_15837_1842# VDD VDD sg13_lv_pmos ad=0.3808p pd=2.92u as=0.2128p ps=1.5u w=1.12u l=0.13u
X272 VDD a_15964_289# a_16851_309# VDD sg13_lv_pmos ad=0.2086p pd=1.5u as=0.34p ps=2.68u w=1u l=0.13u
X273 VDD VSS.t576 VDD VDD sg13_lv_pmos ad=0.34p pd=2.68u as=0 ps=0 w=1u l=1u
X274 VSS.t181 a_11603_1842# a_12037_1842# VSS.t180 sg13_lv_nmos ad=0.1406p pd=1.12u as=0.2516p ps=2.16u w=0.74u l=0.13u
X275 VSS.t305 VDD VSS.t303 VSS.t304 sg13_lv_nmos ad=79.8f pd=0.8u as=0 ps=0 w=0.42u l=1u
X276 VDD VSS.t590 VDD VDD sg13_lv_pmos ad=0.34p pd=2.68u as=0 ps=0 w=1u l=1u
X277 VDD a_5957_1842# a_6425_1044# VDD sg13_lv_pmos ad=0.252p pd=1.57u as=0.3808p ps=2.92u w=1.12u l=0.13u
X278 a_24393_1842# a_24197_1842# VSS.t369 VSS.t368 sg13_lv_nmos ad=0.2516p pd=2.16u as=0.1406p ps=1.12u w=0.74u l=0.13u
X279 a_3747_1047.t1 a_3449_1395# VSS.t108 VSS.t107 sg13_lv_nmos ad=0.1406p pd=1.12u as=0.1331p ps=1.12u w=0.74u l=0.13u
X280 a_1544_1044# MUX_SEL1 VSS.t501 VSS.t500 sg13_lv_nmos ad=0.2516p pd=2.16u as=0.2516p ps=2.16u w=0.74u l=0.13u
X281 VDD VSS.t578 VDD VDD sg13_lv_pmos ad=0.34p pd=2.68u as=0 ps=0 w=1u l=1u
X282 a_3171_1047.t0 a_2873_1395# VDD VDD sg13_lv_pmos ad=0.2128p pd=1.5u as=0.1918p ps=1.5u w=1.12u l=0.13u
X283 a_13470_1044# a_3747_1047.t6 a_15755_1044# VSS.t215 sg13_lv_nmos ad=0.2516p pd=2.16u as=0.1406p ps=1.12u w=0.74u l=0.13u
X284 VDD a_5523_1842# a_5957_1842# VDD sg13_lv_pmos ad=0.2128p pd=1.5u as=0.3808p ps=2.92u w=1.12u l=0.13u
X285 VDD a_2297_1395# a_2595_1047.t0 VDD sg13_lv_pmos ad=0.4256p pd=3u as=0.2128p ps=1.5u w=1.12u l=0.13u
X286 VSS.t425 DELAY_VBIASN.t17 a_14751_1842# VSS.t424 sg13_lv_nmos ad=0.2516p pd=2.16u as=0.1406p ps=1.12u w=0.74u l=0.6u
X287 a_2967_1395# MUX_SEL1 a_2873_1395# VSS.t502 sg13_lv_nmos ad=0.1216p pd=1.02u as=0.2176p ps=1.96u w=0.64u l=0.13u
X288 a_4350_1044# a_2595_1047.t9 a_5115_1044# VSS.t95 sg13_lv_nmos ad=0.2516p pd=2.16u as=0.1406p ps=1.12u w=0.74u l=0.13u
X289 VDD a_2019_1047.t6 a_13444_1008# VDD sg13_lv_pmos ad=0.3808p pd=2.92u as=0.3808p ps=2.92u w=1.12u l=0.13u
X290 VSS.t21 a_2595_1047.t2 a_26471_1008# VSS.t20 sg13_lv_nmos ad=0.2516p pd=2.16u as=0.2516p ps=2.16u w=0.74u l=0.13u
X291 a_2595_311.t1 a_2297_331# VSS.t372 VSS.t560 sg13_lv_nmos ad=0.1406p pd=1.12u as=0.1331p ps=1.12u w=0.74u l=0.13u
X292 VSS.t417 DELAY_VBIASN.t31 a_4111_1842# VSS.t416 sg13_lv_nmos ad=0.2516p pd=2.16u as=0.1406p ps=1.12u w=0.74u l=0.6u
X293 a_2297_1395# MUX_SEL0 VDD VDD sg13_lv_pmos ad=0.1596p pd=1.22u as=0.2856p ps=2.36u w=0.84u l=0.13u
X294 VSS.t7 a_16597_1842# a_17065_1044# VSS.t6 sg13_lv_nmos ad=0.1665p pd=1.19u as=0.2516p ps=2.16u w=0.74u l=0.13u
X295 VDD DELAY_VBIASP.t25 a_8671_2470# VDD sg13_lv_pmos ad=0.3808p pd=2.92u as=0.2128p ps=1.5u w=1.12u l=0.6u
X296 VDD VSS.t591 VDD VDD sg13_lv_pmos ad=0.19p pd=1.38u as=0 ps=0 w=1u l=1u
X297 VDD a_1544_1044# a_1721_1395# VDD sg13_lv_pmos ad=0.1918p pd=1.5u as=0.1596p ps=1.22u w=0.84u l=0.13u
X298 a_4248_1044# a_4157_1313# VDD VDD sg13_lv_pmos ad=0.2128p pd=1.5u as=0.3808p ps=2.92u w=1.12u l=0.13u
X299 a_12471_2470# a_12233_1842# a_12363_1842# VDD sg13_lv_pmos ad=0.2128p pd=1.5u as=0.3808p ps=2.92u w=1.12u l=0.2u
X300 a_17031_1842# a_16793_1842# a_16923_1842# VSS.t350 sg13_lv_nmos ad=0.1406p pd=1.12u as=0.2516p ps=2.16u w=0.74u l=0.2u
X301 VSS.t157 a_1721_331# a_2019_311# VSS.t156 sg13_lv_nmos ad=0.2812p pd=2.24u as=0.1406p ps=1.12u w=0.74u l=0.13u
X302 a_19550_1044# a_21911_1008# a_21835_1044# VDD sg13_lv_pmos ad=0.3808p pd=2.92u as=0.2128p ps=1.5u w=1.12u l=0.13u
X303 a_16108_289# a_26985_519# a_25630_1044# VDD sg13_lv_pmos ad=0.3808p pd=2.92u as=0.3808p ps=2.92u w=1.12u l=0.13u
X304 VSS.t562 a_2297_331# a_2595_311.t1 VSS.t561 sg13_lv_nmos ad=0.2812p pd=2.24u as=0.1406p ps=1.12u w=0.74u l=0.13u
X305 a_18795_1044# a_18585_1044# VSS.t153 VSS.t152 sg13_lv_nmos ad=0.1406p pd=1.12u as=0.1665p ps=1.19u w=0.74u l=0.13u
X306 a_20831_1842# a_20593_1842# a_20723_1842# VSS.t385 sg13_lv_nmos ad=0.1406p pd=1.12u as=0.2516p ps=2.16u w=0.74u l=0.2u
X307 VSS.t243 VDD VSS.t242 VSS.t241 sg13_lv_nmos ad=0.1428p pd=1.52u as=0 ps=0 w=0.42u l=1u
X308 VDD a_22677_1842# a_23145_1044# VDD sg13_lv_pmos ad=0.252p pd=1.57u as=0.3808p ps=2.92u w=1.12u l=0.13u
X309 VSS.t53 a_2595_1047.t5 a_17351_1008# VSS.t52 sg13_lv_nmos ad=0.2516p pd=2.16u as=0.2516p ps=2.16u w=0.74u l=0.13u
X310 a_5393_1842# a_5197_1842# VSS.t76 VSS.t75 sg13_lv_nmos ad=0.2516p pd=2.16u as=0.1406p ps=1.12u w=0.74u l=0.13u
X311 VSS.t447 DELAY_VBIASN.t14 a_17031_1842# VSS.t446 sg13_lv_nmos ad=0.2516p pd=2.16u as=0.1406p ps=1.12u w=0.74u l=0.6u
X312 a_25630_1044# a_3171_1047.t2 a_27048_1044# VSS.t129 sg13_lv_nmos ad=0.2516p pd=2.16u as=0.1406p ps=1.12u w=0.74u l=0.13u
X313 a_9953_1842# a_9757_1842# VDD VDD sg13_lv_pmos ad=0.3808p pd=2.92u as=0.2128p ps=1.5u w=1.12u l=0.13u
X314 VDD a_10843_1842# a_11277_1842# VDD sg13_lv_pmos ad=0.2128p pd=1.5u as=0.3808p ps=2.92u w=1.12u l=0.13u
X315 VSS.t482 a_26803_1842# a_27237_1842# VSS.t481 sg13_lv_nmos ad=0.1406p pd=1.12u as=0.2516p ps=2.16u w=0.74u l=0.13u
X316 a_4350_1044# a_3171_1047.t9 a_5768_1044# VSS.t126 sg13_lv_nmos ad=0.2516p pd=2.16u as=0.1406p ps=1.12u w=0.74u l=0.13u
X317 a_10430_1044# a_12791_1008# a_12715_1044# VDD sg13_lv_pmos ad=0.3808p pd=2.92u as=0.2128p ps=1.5u w=1.12u l=0.13u
X318 a_19311_1842# a_19073_1842# a_19203_1842# VSS.t553 sg13_lv_nmos ad=0.1406p pd=1.12u as=0.2516p ps=2.16u w=0.74u l=0.2u
X319 a_24875_1044# a_24665_1044# VDD VDD sg13_lv_pmos ad=0.2128p pd=1.5u as=0.252p ps=1.57u w=1.12u l=0.13u
X320 VDD a_2595_1047.t3 a_23431_1008# VDD sg13_lv_pmos ad=0.3808p pd=2.92u as=0.3808p ps=2.92u w=1.12u l=0.13u
X321 VDD a_13557_1842# a_14025_1044# VDD sg13_lv_pmos ad=0.252p pd=1.57u as=0.3808p ps=2.92u w=1.12u l=0.13u
X322 a_23111_1842# a_22873_1842# a_23003_1842# VSS.t182 sg13_lv_nmos ad=0.1406p pd=1.12u as=0.2516p ps=2.16u w=0.74u l=0.2u
X323 a_27671_2470# a_27433_1842# a_27563_1842# VDD sg13_lv_pmos ad=0.2128p pd=1.5u as=0.3808p ps=2.92u w=1.12u l=0.2u
X324 VSS.t333 a_17683_1842# a_18117_1842# VSS.t365 sg13_lv_nmos ad=0.1406p pd=1.12u as=0.2516p ps=2.16u w=0.74u l=0.13u
X325 VSS.t300 VDD VSS.t298 VSS.t299 sg13_lv_nmos ad=79.8f pd=0.8u as=0 ps=0 w=0.42u l=1u
X326 a_10713_1842# a_10517_1842# VSS.t498 VSS.t507 sg13_lv_nmos ad=0.2516p pd=2.16u as=0.1406p ps=1.12u w=0.74u l=0.13u
X327 VSS.t116 a_2019_1047.t8 a_7364_1008# VSS.t115 sg13_lv_nmos ad=0.2516p pd=2.16u as=0.2516p ps=2.16u w=0.74u l=0.13u
X328 VSS.t338 a_7803_1842# a_8237_1842# VSS.t510 sg13_lv_nmos ad=0.1406p pd=1.12u as=0.2516p ps=2.16u w=0.74u l=0.13u
X329 VDD DELAY_VBIASP.t15 a_16271_2470# VDD sg13_lv_pmos ad=0.3808p pd=2.92u as=0.2128p ps=1.5u w=1.12u l=0.6u
X330 VSS.t295 VDD VSS.t293 VSS.t294 sg13_lv_nmos ad=79.8f pd=0.8u as=0 ps=0 w=0.42u l=1u
X331 VSS.t268 VDD VSS.t267 VSS.t266 sg13_lv_nmos ad=0.1428p pd=1.52u as=0 ps=0 w=0.42u l=1u
X332 VDD a_26043_1842# a_26477_1842# VDD sg13_lv_pmos ad=0.2128p pd=1.5u as=0.3808p ps=2.92u w=1.12u l=0.13u
X333 a_3543_331# MUX_SEL2 a_3449_331# VSS.t557 sg13_lv_nmos ad=0.1216p pd=1.02u as=0.2176p ps=1.96u w=0.64u l=0.13u
X334 a_22488_1044# a_21917_1842# VSS.t209 VSS.t208 sg13_lv_nmos ad=0.1406p pd=1.12u as=0.2516p ps=2.16u w=0.74u l=0.13u
X335 VDD VSS.t593 VDD VDD sg13_lv_pmos ad=0.19p pd=1.38u as=0 ps=0 w=1u l=1u
X336 a_22590_1044# a_24084_1008# a_24008_1044# VDD sg13_lv_pmos ad=0.3808p pd=2.92u as=0.2128p ps=1.5u w=1.12u l=0.13u
X337 VDD DELAY_VBIASP.t10 a_20071_2470# VDD sg13_lv_pmos ad=0.3808p pd=2.92u as=0.2128p ps=1.5u w=1.12u l=0.6u
X338 a_14751_1842# a_14513_1842# a_14643_1842# VSS.t201 sg13_lv_nmos ad=0.1406p pd=1.12u as=0.2516p ps=2.16u w=0.74u l=0.2u
X339 VSS.t147 a_2873_1395# a_3171_1047.t1 VSS.t146 sg13_lv_nmos ad=0.2812p pd=2.24u as=0.1406p ps=1.12u w=0.74u l=0.13u
X340 VDD VSS.t567 VDD VDD sg13_lv_pmos ad=0.19p pd=1.38u as=0 ps=0 w=1u l=1u
X341 a_25630_1044# a_27991_1008# a_27915_1044# VDD sg13_lv_pmos ad=0.3808p pd=2.92u as=0.2128p ps=1.5u w=1.12u l=0.13u
X342 VSS.t357 VSS.t355 VSS.t353 VSS.t356 sg13_lv_nmos ad=0.1406p pd=1.12u as=0 ps=0 w=0.74u l=0.13u
X343 a_4111_1842# DELAY_IN a_4003_1842# VSS.t343 sg13_lv_nmos ad=0.1406p pd=1.12u as=0.2516p ps=2.16u w=0.74u l=0.2u
X344 a_8671_2470# a_8433_1842# a_8563_1842# VDD sg13_lv_pmos ad=0.2128p pd=1.5u as=0.3808p ps=2.92u w=1.12u l=0.2u
X345 a_17553_1842# a_17357_1842# VDD VDD sg13_lv_pmos ad=0.3808p pd=2.92u as=0.2128p ps=1.5u w=1.12u l=0.13u
X346 VSS.t60 a_1544_1044# a_2391_1395# VSS.t59 sg13_lv_nmos ad=0.1331p pd=1.12u as=0.1216p ps=1.02u w=0.64u l=0.13u
X347 VSS.t90 a_3747_311.t3 a_14825_519# VSS.t89 sg13_lv_nmos ad=0.2516p pd=2.16u as=0.2516p ps=2.16u w=0.74u l=0.13u
X348 VSS.t3 a_1256_289# a_2967_331# VSS.t159 sg13_lv_nmos ad=0.1331p pd=1.12u as=0.1216p ps=1.02u w=0.64u l=0.13u
X349 a_2019_1047.t1 a_1721_1395# VSS.t58 VSS.t141 sg13_lv_nmos ad=0.1406p pd=1.12u as=0.1331p ps=1.12u w=0.74u l=0.13u
X350 a_15964_289# a_15765_463# a_5731_289# VSS.t44 sg13_lv_nmos ad=0.2183p pd=1.33u as=0.2516p ps=2.16u w=0.74u l=0.13u
X351 a_13470_1044# a_2019_1047.t6 a_13368_1044# VSS.t28 sg13_lv_nmos ad=0.2516p pd=2.16u as=0.1406p ps=1.12u w=0.74u l=0.13u
X352 VSS.t48 a_13123_1842# a_13557_1842# VSS.t471 sg13_lv_nmos ad=0.1406p pd=1.12u as=0.2516p ps=2.16u w=0.74u l=0.13u
X353 VDD VSS.t566 VDD VDD sg13_lv_pmos ad=0.34p pd=2.68u as=0 ps=0 w=1u l=1u
X354 VSS.t15 a_3171_1047.t3 a_24084_1008# VSS.t14 sg13_lv_nmos ad=0.2516p pd=2.16u as=0.2516p ps=2.16u w=0.74u l=0.13u
X355 a_25913_1842# a_25717_1842# VSS.t375 VSS.t496 sg13_lv_nmos ad=0.2516p pd=2.16u as=0.1406p ps=1.12u w=0.74u l=0.13u
X356 a_21353_1842# a_21157_1842# VDD VDD sg13_lv_pmos ad=0.3808p pd=2.92u as=0.2128p ps=1.5u w=1.12u l=0.13u
X357 VSS.t303 VDD VSS.t302 VSS.t301 sg13_lv_nmos ad=0.1428p pd=1.52u as=0 ps=0 w=0.42u l=1u
X358 a_2297_331# MUX_SEL2 VDD VDD sg13_lv_pmos ad=0.1596p pd=1.22u as=0.2856p ps=2.36u w=0.84u l=0.13u
X359 VDD a_7043_1842# a_7477_1842# VDD sg13_lv_pmos ad=0.2128p pd=1.5u as=0.3808p ps=2.92u w=1.12u l=0.13u
X360 a_2873_331# MUX_SEL3 VDD VDD sg13_lv_pmos ad=0.1596p pd=1.22u as=0.2856p ps=2.36u w=0.84u l=0.13u
X361 a_8155_1044# a_7945_1044# VDD VDD sg13_lv_pmos ad=0.2128p pd=1.5u as=0.252p ps=1.57u w=1.12u l=0.13u
X362 VSS.t153 a_18117_1842# a_18585_1044# VSS.t331 sg13_lv_nmos ad=0.1665p pd=1.19u as=0.2516p ps=2.16u w=0.74u l=0.13u
X363 a_27048_1044# a_26477_1842# VDD VDD sg13_lv_pmos ad=0.2128p pd=1.5u as=0.3808p ps=2.92u w=1.12u l=0.13u
X364 a_5768_1044# a_5197_1842# VDD VDD sg13_lv_pmos ad=0.2128p pd=1.5u as=0.3808p ps=2.92u w=1.12u l=0.13u
X365 a_13991_2470# a_13753_1842# a_13883_1842# VDD sg13_lv_pmos ad=0.2128p pd=1.5u as=0.3808p ps=2.92u w=1.12u l=0.2u
X366 VSS.t12 a_3171_1047.t6 a_14964_1008# VSS.t11 sg13_lv_nmos ad=0.2516p pd=2.16u as=0.2516p ps=2.16u w=0.74u l=0.13u
X367 VDD a_2019_311# a_17865_519# VDD sg13_lv_pmos ad=0.3808p pd=2.92u as=0.3808p ps=2.92u w=1.12u l=0.13u
X368 DELAY_OUT_LAST a_27997_1842# VSS.t71 VSS.t558 sg13_lv_nmos ad=0.2516p pd=2.16u as=0.1406p ps=1.12u w=0.74u l=0.13u
X369 a_11195_1044# a_10985_1044# VSS.t509 VSS.t537 sg13_lv_nmos ad=0.1406p pd=1.12u as=0.1665p ps=1.19u w=0.74u l=0.13u
X370 VDD a_24197_1842# a_24665_1044# VDD sg13_lv_pmos ad=0.252p pd=1.57u as=0.3808p ps=2.92u w=1.12u l=0.13u
X371 a_6913_1842# a_6717_1842# VSS.t388 VSS.t394 sg13_lv_nmos ad=0.2516p pd=2.16u as=0.1406p ps=1.12u w=0.74u l=0.13u
X372 VSS.t453 DELAY_VBIASN.t12 a_18551_1842# VSS.t452 sg13_lv_nmos ad=0.2516p pd=2.16u as=0.1406p ps=1.12u w=0.74u l=0.6u
X373 a_16510_1044# a_18004_1008# a_17928_1044# VDD sg13_lv_pmos ad=0.3808p pd=2.92u as=0.2128p ps=1.5u w=1.12u l=0.13u
X374 VDD a_12363_1842# a_12797_1842# VDD sg13_lv_pmos ad=0.2128p pd=1.5u as=0.3808p ps=2.92u w=1.12u l=0.13u
X375 VSS.t41 MUX_SEL3 a_3543_331# VSS.t549 sg13_lv_nmos ad=0.1331p pd=1.12u as=0.1216p ps=1.02u w=0.64u l=0.13u
X376 a_22590_1044# a_2595_1047.t3 a_23355_1044# VSS.t25 sg13_lv_nmos ad=0.2516p pd=2.16u as=0.1406p ps=1.12u w=0.74u l=0.13u
X377 VSS.t463 DELAY_VBIASN.t7 a_22351_1842# VSS.t462 sg13_lv_nmos ad=0.2516p pd=2.16u as=0.1406p ps=1.12u w=0.74u l=0.6u
X378 VDD a_3171_1047.t4 a_21044_1008# VDD sg13_lv_pmos ad=0.3808p pd=2.92u as=0.3808p ps=2.92u w=1.12u l=0.13u
X379 VDD VSS.t569 VDD VDD sg13_lv_pmos ad=0.19p pd=1.38u as=0 ps=0 w=1u l=1u
X380 a_16271_2470# a_16033_1842# a_16163_1842# VDD sg13_lv_pmos ad=0.2128p pd=1.5u as=0.3808p ps=2.92u w=1.12u l=0.2u
X381 VDD VSS.t583 VDD VDD sg13_lv_pmos ad=0.19p pd=1.38u as=0 ps=0 w=1u l=1u
X382 a_19833_1842# a_19637_1842# VSS.t186 VSS.t194 sg13_lv_nmos ad=0.2516p pd=2.16u as=0.1406p ps=1.12u w=0.74u l=0.13u
X383 VDD a_2019_311# a_5705_519# VDD sg13_lv_pmos ad=0.3808p pd=2.92u as=0.3808p ps=2.92u w=1.12u l=0.13u
X384 a_20071_2470# a_19833_1842# a_19963_1842# VDD sg13_lv_pmos ad=0.2128p pd=1.5u as=0.3808p ps=2.92u w=1.12u l=0.2u
X385 a_9193_1842# a_8997_1842# VSS.t382 VSS.t381 sg13_lv_nmos ad=0.2516p pd=2.16u as=0.1406p ps=1.12u w=0.74u l=0.13u
X386 a_24631_1842# a_24393_1842# a_24523_1842# VSS.t559 sg13_lv_nmos ad=0.1406p pd=1.12u as=0.2516p ps=2.16u w=0.74u l=0.2u
X387 VDD VSS.t582 VDD VDD sg13_lv_pmos ad=0.34p pd=2.68u as=0 ps=0 w=1u l=1u
X388 VSS.t39 a_2019_1047.t7 a_10404_1008# VSS.t38 sg13_lv_nmos ad=0.2516p pd=2.16u as=0.2516p ps=2.16u w=0.74u l=0.13u
X389 VDD a_14643_1842# a_15077_1842# VDD sg13_lv_pmos ad=0.2128p pd=1.5u as=0.3808p ps=2.92u w=1.12u l=0.13u
X390 VDD a_1544_289# a_2297_331# VDD sg13_lv_pmos ad=0.1918p pd=1.5u as=0.1596p ps=1.22u w=0.84u l=0.13u
X391 a_23633_1842# a_23437_1842# VSS.t104 VSS.t103 sg13_lv_nmos ad=0.2516p pd=2.16u as=0.1406p ps=1.12u w=0.74u l=0.13u
X392 VSS.t298 VDD VSS.t297 VSS.t296 sg13_lv_nmos ad=0.1428p pd=1.52u as=0 ps=0 w=0.42u l=1u
X393 a_2019_311# a_1721_331# VDD VDD sg13_lv_pmos ad=0.2128p pd=1.5u as=0.1918p ps=1.5u w=1.12u l=0.13u
X394 VSS.t205 a_9323_1842# a_9757_1842# VSS.t393 sg13_lv_nmos ad=0.1406p pd=1.12u as=0.2516p ps=2.16u w=0.74u l=0.13u
X395 a_26395_1044# a_26185_1044# VSS.t219 VSS.t218 sg13_lv_nmos ad=0.1406p pd=1.12u as=0.1665p ps=1.19u w=0.74u l=0.13u
X396 VDD DELAY_VBIASP.t13 a_17791_2470# VDD sg13_lv_pmos ad=0.3808p pd=2.92u as=0.2128p ps=1.5u w=1.12u l=0.6u
X397 VSS.t226 a_3747_1047.t3 a_24951_1008# VSS.t225 sg13_lv_nmos ad=0.2516p pd=2.16u as=0.2516p ps=2.16u w=0.74u l=0.13u
X398 VSS.t263 VDD VSS.t262 VSS.t261 sg13_lv_nmos ad=0.1428p pd=1.52u as=0 ps=0 w=0.42u l=1u
X399 VSS.t293 VDD VSS.t292 VSS.t291 sg13_lv_nmos ad=0.1428p pd=1.52u as=0 ps=0 w=0.42u l=1u
X400 a_3747_1047.t0 a_3449_1395# VDD VDD sg13_lv_pmos ad=0.2128p pd=1.5u as=0.1918p ps=1.5u w=1.12u l=0.13u
X401 a_13368_1044# a_12797_1842# VDD VDD sg13_lv_pmos ad=0.2128p pd=1.5u as=0.3808p ps=2.92u w=1.12u l=0.13u
X402 a_24008_1044# a_23437_1842# VSS.t106 VSS.t105 sg13_lv_nmos ad=0.1406p pd=1.12u as=0.2516p ps=2.16u w=0.74u l=0.13u
X403 VDD DELAY_VBIASP.t8 a_21591_2470# VDD sg13_lv_pmos ad=0.3808p pd=2.92u as=0.2128p ps=1.5u w=1.12u l=0.6u
X404 a_15964_289# MUX_SEL4 a_5731_289# VDD sg13_lv_pmos ad=0.3304p pd=1.71u as=0.3808p ps=2.92u w=1.12u l=0.13u
X405 a_4350_1044# a_6711_1008# a_6635_1044# VDD sg13_lv_pmos ad=0.3808p pd=2.92u as=0.2128p ps=1.5u w=1.12u l=0.13u
X406 a_2873_1395# MUX_SEL1 VDD VDD sg13_lv_pmos ad=0.1596p pd=1.22u as=0.2856p ps=2.36u w=0.84u l=0.13u
X407 a_1256_1044# MUX_SEL0 VSS.t476 VSS.t475 sg13_lv_nmos ad=0.2516p pd=2.16u as=0.2516p ps=2.16u w=0.74u l=0.13u
X408 VSS.t260 VDD VSS.t258 VSS.t259 sg13_lv_nmos ad=79.8f pd=0.8u as=0 ps=0 w=0.42u l=1u
X409 a_19550_1044# a_20391_1008# a_20315_1044# VDD sg13_lv_pmos ad=0.3808p pd=2.92u as=0.2128p ps=1.5u w=1.12u l=0.13u
X410 VDD VDD VDD VDD sg13_lv_pmos ad=0.2128p pd=1.5u as=0 ps=0 w=1.12u l=0.2u
X411 a_5631_1842# a_5393_1842# a_5523_1842# VSS.t341 sg13_lv_nmos ad=0.1406p pd=1.12u as=0.2516p ps=2.16u w=0.74u l=0.2u
X412 a_14513_1842# a_14317_1842# VSS.t170 VSS.t543 sg13_lv_nmos ad=0.2516p pd=2.16u as=0.1406p ps=1.12u w=0.74u l=0.13u
X413 VSS.t119 a_2595_311.t2 a_20905_519# VSS.t118 sg13_lv_nmos ad=0.2516p pd=2.16u as=0.2516p ps=2.16u w=0.74u l=0.13u
X414 VDD a_7477_1842# a_7945_1044# VDD sg13_lv_pmos ad=0.252p pd=1.57u as=0.3808p ps=2.92u w=1.12u l=0.13u
X415 a_13470_1044# a_3171_1047.t6 a_14888_1044# VSS.t10 sg13_lv_nmos ad=0.2516p pd=2.16u as=0.1406p ps=1.12u w=0.74u l=0.13u
X416 a_4633_1842# a_4437_1842# VSS.t87 VSS.t552 sg13_lv_nmos ad=0.2516p pd=2.16u as=0.1406p ps=1.12u w=0.74u l=0.13u
X417 a_1256_289# MUX_SEL2 VSS.t555 VSS.t554 sg13_lv_nmos ad=0.2516p pd=2.16u as=0.2516p ps=2.16u w=0.74u l=0.13u
X418 VSS.t137 a_2019_1047.t2 a_25604_1008# VSS.t136 sg13_lv_nmos ad=0.2516p pd=2.16u as=0.2516p ps=2.16u w=0.74u l=0.13u
X419 a_16108_289# MUX_SEL4 a_15964_289# VSS.t504 sg13_lv_nmos ad=0.2516p pd=2.16u as=0.2183p ps=1.33u w=0.74u l=0.13u
X420 a_22873_1842# a_22677_1842# VDD VDD sg13_lv_pmos ad=0.3808p pd=2.92u as=0.2128p ps=1.5u w=1.12u l=0.13u
X421 a_21835_1044# a_21625_1044# VSS.t151 VSS.t150 sg13_lv_nmos ad=0.1406p pd=1.12u as=0.1665p ps=1.19u w=0.74u l=0.13u
X422 VSS.t122 a_2595_1047.t4 a_20391_1008# VSS.t121 sg13_lv_nmos ad=0.2516p pd=2.16u as=0.2516p ps=2.16u w=0.74u l=0.13u
X423 a_9675_1044# a_9465_1044# VDD VDD sg13_lv_pmos ad=0.2128p pd=1.5u as=0.252p ps=1.57u w=1.12u l=0.13u
X424 VSS.t509 a_10517_1842# a_10985_1044# VSS.t508 sg13_lv_nmos ad=0.1665p pd=1.19u as=0.2516p ps=2.16u w=0.74u l=0.13u
X425 VDD a_2595_1047.t8 a_8231_1008# VDD sg13_lv_pmos ad=0.3808p pd=2.92u as=0.3808p ps=2.92u w=1.12u l=0.13u
X426 a_18551_1842# a_18313_1842# a_18443_1842# VSS.t489 sg13_lv_nmos ad=0.1406p pd=1.12u as=0.2516p ps=2.16u w=0.74u l=0.2u
X427 a_22351_1842# a_22113_1842# a_22243_1842# VSS.t401 sg13_lv_nmos ad=0.1406p pd=1.12u as=0.2516p ps=2.16u w=0.74u l=0.2u
X428 VSS.t125 a_3747_1047.t5 a_18871_1008# VSS.t124 sg13_lv_nmos ad=0.2516p pd=2.16u as=0.2516p ps=2.16u w=0.74u l=0.13u
X429 VSS.t486 a_16923_1842# a_17357_1842# VSS.t494 sg13_lv_nmos ad=0.1406p pd=1.12u as=0.2516p ps=2.16u w=0.74u l=0.13u
X430 VDD a_3171_311.t2 a_23945_519# VDD sg13_lv_pmos ad=0.3808p pd=2.92u as=0.3808p ps=2.92u w=1.12u l=0.13u
X431 a_2019_311# a_1721_331# VSS.t155 VSS.t154 sg13_lv_nmos ad=0.1406p pd=1.12u as=0.1331p ps=1.12u w=0.74u l=0.13u
X432 a_25153_1842# a_24957_1842# VDD VDD sg13_lv_pmos ad=0.3808p pd=2.92u as=0.2128p ps=1.5u w=1.12u l=0.13u
X433 a_17928_1044# a_17357_1842# VSS.t484 VSS.t483 sg13_lv_nmos ad=0.1406p pd=1.12u as=0.2516p ps=2.16u w=0.74u l=0.13u
X434 a_12715_1044# a_12505_1044# VSS.t83 VSS.t82 sg13_lv_nmos ad=0.1406p pd=1.12u as=0.1665p ps=1.19u w=0.74u l=0.13u
X435 VDD MUX_SEL4 a_15765_463# VDD sg13_lv_pmos ad=0.3808p pd=2.92u as=0.3808p ps=2.92u w=1.12u l=0.13u
X436 a_19550_1044# a_3171_1047.t4 a_20968_1044# VSS.t16 sg13_lv_nmos ad=0.2516p pd=2.16u as=0.1406p ps=1.12u w=0.74u l=0.13u
X437 VSS.t441 DELAY_VBIASN.t22 a_10951_1842# VSS.t440 sg13_lv_nmos ad=0.2516p pd=2.16u as=0.1406p ps=1.12u w=0.74u l=0.6u
X438 a_19550_1044# a_19524_1008# a_19448_1044# VDD sg13_lv_pmos ad=0.3808p pd=2.92u as=0.2128p ps=1.5u w=1.12u l=0.13u
X439 a_7288_1044# a_6717_1842# VSS.t396 VSS.t395 sg13_lv_nmos ad=0.1406p pd=1.12u as=0.2516p ps=2.16u w=0.74u l=0.13u
X440 VSS.t66 a_20723_1842# a_21157_1842# VSS.t65 sg13_lv_nmos ad=0.1406p pd=1.12u as=0.2516p ps=2.16u w=0.74u l=0.13u
X441 a_1544_289# MUX_SEL3 VSS.t547 VSS.t546 sg13_lv_nmos ad=0.2516p pd=2.16u as=0.2516p ps=2.16u w=0.74u l=0.13u
X442 a_13470_1044# a_14311_1008# a_14235_1044# VDD sg13_lv_pmos ad=0.3808p pd=2.92u as=0.2128p ps=1.5u w=1.12u l=0.13u
X443 a_22590_1044# a_3747_1047.t3 a_24875_1044# VSS.t224 sg13_lv_nmos ad=0.2516p pd=2.16u as=0.1406p ps=1.12u w=0.74u l=0.13u
X444 VSS.t461 DELAY_VBIASN.t5 a_23871_1842# VSS.t460 sg13_lv_nmos ad=0.2516p pd=2.16u as=0.1406p ps=1.12u w=0.74u l=0.6u
X445 VDD a_2019_1047.t3 a_22564_1008# VDD sg13_lv_pmos ad=0.3808p pd=2.92u as=0.3808p ps=2.92u w=1.12u l=0.13u
X446 VSS.t219 a_25717_1842# a_26185_1044# VSS.t495 sg13_lv_nmos ad=0.1665p pd=1.19u as=0.2516p ps=2.16u w=0.74u l=0.13u
X447 a_13231_1842# a_12993_1842# a_13123_1842# VSS.t207 sg13_lv_nmos ad=0.1406p pd=1.12u as=0.2516p ps=2.16u w=0.74u l=0.2u
X448 VSS.t255 VDD VSS.t253 VSS.t254 sg13_lv_nmos ad=79.8f pd=0.8u as=0 ps=0 w=0.42u l=1u
X449 a_17791_2470# a_17553_1842# a_17683_1842# VDD sg13_lv_pmos ad=0.2128p pd=1.5u as=0.3808p ps=2.92u w=1.12u l=0.2u
X450 VSS.t1 a_4437_1842# a_4905_1044# VSS.t551 sg13_lv_nmos ad=0.1665p pd=1.19u as=0.2516p ps=2.16u w=0.74u l=0.13u
X451 VDD VSS.t570 VDD VDD sg13_lv_pmos ad=0.34p pd=2.68u as=0 ps=0 w=1u l=1u
X452 a_12233_1842# a_12037_1842# VSS.t181 VSS.t213 sg13_lv_nmos ad=0.2516p pd=2.16u as=0.1406p ps=1.12u w=0.74u l=0.13u
X453 VSS.t110 a_3449_1395# a_3747_1047.t1 VSS.t109 sg13_lv_nmos ad=0.2812p pd=2.24u as=0.1406p ps=1.12u w=0.74u l=0.13u
X454 VDD VSS.t584 VDD VDD sg13_lv_pmos ad=0.34p pd=2.68u as=0 ps=0 w=1u l=1u
X455 VDD VSS.t579 VDD VDD sg13_lv_pmos ad=0.19p pd=1.38u as=0 ps=0 w=1u l=1u
X456 VSS.t320 VDD VSS.t318 VSS.t319 sg13_lv_nmos ad=79.8f pd=0.8u as=0 ps=0 w=0.42u l=1u
X457 VSS.t535 a_3171_1047.t8 a_8884_1008# VSS.t534 sg13_lv_nmos ad=0.2516p pd=2.16u as=0.2516p ps=2.16u w=0.74u l=0.13u
X458 a_21591_2470# a_21353_1842# a_21483_1842# VDD sg13_lv_pmos ad=0.2128p pd=1.5u as=0.3808p ps=2.92u w=1.12u l=0.2u
X459 VDD a_2873_1395# a_3171_1047.t0 VDD sg13_lv_pmos ad=0.4256p pd=3u as=0.2128p ps=1.5u w=1.12u l=0.13u
X460 a_6153_1842# a_5957_1842# VDD VDD sg13_lv_pmos ad=0.3808p pd=2.92u as=0.2128p ps=1.5u w=1.12u l=0.13u
X461 VDD a_16163_1842# a_16597_1842# VDD sg13_lv_pmos ad=0.2128p pd=1.5u as=0.3808p ps=2.92u w=1.12u l=0.13u
X462 a_3543_1395# MUX_SEL0 a_3449_1395# VSS.t478 sg13_lv_nmos ad=0.1216p pd=1.02u as=0.2176p ps=1.96u w=0.64u l=0.13u
X463 VDD a_1544_1044# a_2297_1395# VDD sg13_lv_pmos ad=0.1918p pd=1.5u as=0.1596p ps=1.22u w=0.84u l=0.13u
X464 VDD DELAY_VBIASP.t23 a_10191_2470# VDD sg13_lv_pmos ad=0.3808p pd=2.92u as=0.2128p ps=1.5u w=1.12u l=0.6u
X465 a_17275_1044# a_17065_1044# VDD VDD sg13_lv_pmos ad=0.2128p pd=1.5u as=0.252p ps=1.57u w=1.12u l=0.13u
X466 a_2019_1047.t0 a_1721_1395# VDD VDD sg13_lv_pmos ad=0.2128p pd=1.5u as=0.1918p ps=1.5u w=1.12u l=0.13u
X467 a_27915_1044# a_27705_1044# VSS.t189 VSS.t188 sg13_lv_nmos ad=0.1406p pd=1.12u as=0.1665p ps=1.19u w=0.74u l=0.13u
X468 VSS.t467 DELAY_VBIASN.t2 a_26151_1842# VSS.t466 sg13_lv_nmos ad=0.2516p pd=2.16u as=0.1406p ps=1.12u w=0.74u l=0.6u
X469 VDD a_3747_1047.t6 a_15831_1008# VDD sg13_lv_pmos ad=0.3808p pd=2.92u as=0.3808p ps=2.92u w=1.12u l=0.13u
X470 VDD a_19963_1842# a_20397_1842# VDD sg13_lv_pmos ad=0.2128p pd=1.5u as=0.3808p ps=2.92u w=1.12u l=0.13u
X471 VSS.t323 VDD VSS.t322 VSS.t321 sg13_lv_nmos ad=0.1428p pd=1.52u as=0 ps=0 w=0.42u l=1u
X472 VSS.t429 DELAY_VBIASN.t30 a_4871_1842# VSS.t428 sg13_lv_nmos ad=0.2516p pd=2.16u as=0.1406p ps=1.12u w=0.74u l=0.6u
X473 a_14888_1044# a_14317_1842# VDD VDD sg13_lv_pmos ad=0.2128p pd=1.5u as=0.3808p ps=2.92u w=1.12u l=0.13u
X474 a_4350_1044# a_4324_1008# a_4248_1044# VDD sg13_lv_pmos ad=0.3808p pd=2.92u as=0.2128p ps=1.5u w=1.12u l=0.13u
X475 a_1256_289# MUX_SEL2 VDD VDD sg13_lv_pmos ad=0.3808p pd=2.92u as=0.3808p ps=2.92u w=1.12u l=0.13u
X476 VSS.t361 VSS.t358 VSS.t360 VSS.t359 sg13_lv_nmos ad=0.2516p pd=2.16u as=0 ps=0 w=0.74u l=0.6u
X477 a_16108_289# a_15765_463# a_15964_289# VDD sg13_lv_pmos ad=0.3808p pd=2.92u as=0.3304p ps=1.71u w=1.12u l=0.13u
X478 a_11473_1842# a_11277_1842# VDD VDD sg13_lv_pmos ad=0.3808p pd=2.92u as=0.2128p ps=1.5u w=1.12u l=0.13u
X479 VDD a_8997_1842# a_9465_1044# VDD sg13_lv_pmos ad=0.252p pd=1.57u as=0.3808p ps=2.92u w=1.12u l=0.13u
X480 a_27433_1842# a_27237_1842# VSS.t482 VSS.t492 sg13_lv_nmos ad=0.2516p pd=2.16u as=0.1406p ps=1.12u w=0.74u l=0.13u
X481 a_2391_331# MUX_SEL2 a_2297_331# VSS.t556 sg13_lv_nmos ad=0.1216p pd=1.02u as=0.2176p ps=1.96u w=0.64u l=0.13u
X482 a_2967_331# MUX_SEL3 a_2873_331# VSS.t548 sg13_lv_nmos ad=0.1216p pd=1.02u as=0.2176p ps=1.96u w=0.64u l=0.13u
X483 VDD a_2019_1047.t5 a_16484_1008# VDD sg13_lv_pmos ad=0.3808p pd=2.92u as=0.3808p ps=2.92u w=1.12u l=0.13u
X484 a_7390_1044# a_2595_1047.t8 a_8155_1044# VSS.t54 sg13_lv_nmos ad=0.2516p pd=2.16u as=0.1406p ps=1.12u w=0.74u l=0.13u
X485 VSS.t433 DELAY_VBIASN.t27 a_7151_1842# VSS.t432 sg13_lv_nmos ad=0.2516p pd=2.16u as=0.1406p ps=1.12u w=0.74u l=0.6u
X486 VDD a_3171_1047.t9 a_5844_1008# VDD sg13_lv_pmos ad=0.3808p pd=2.92u as=0.3808p ps=2.92u w=1.12u l=0.13u
X487 VDD DELAY_VBIASP.t3 a_25391_2470# VDD sg13_lv_pmos ad=0.3808p pd=2.92u as=0.2128p ps=1.5u w=1.12u l=0.6u
X488 VDD a_2595_1047.t7 a_11271_1008# VDD sg13_lv_pmos ad=0.3808p pd=2.92u as=0.3808p ps=2.92u w=1.12u l=0.13u
X489 VDD VSS.t587 VDD VDD sg13_lv_pmos ad=0.19p pd=1.38u as=0 ps=0 w=1u l=1u
X490 VSS.t83 a_12037_1842# a_12505_1044# VSS.t212 sg13_lv_nmos ad=0.1665p pd=1.19u as=0.2516p ps=2.16u w=0.74u l=0.13u
X491 VDD a_3747_1047.t8 a_9751_1008# VDD sg13_lv_pmos ad=0.3808p pd=2.92u as=0.3808p ps=2.92u w=1.12u l=0.13u
X492 a_9431_1842# a_9193_1842# a_9323_1842# VSS.t187 sg13_lv_nmos ad=0.1406p pd=1.12u as=0.2516p ps=2.16u w=0.74u l=0.2u
X493 a_18313_1842# a_18117_1842# VSS.t333 VSS.t332 sg13_lv_nmos ad=0.2516p pd=2.16u as=0.1406p ps=1.12u w=0.74u l=0.13u
X494 MUX_OUT a_16851_309# VSS.t92 VSS.t91 sg13_lv_nmos ad=0.1406p pd=1.12u as=0.1371p ps=1.12u w=0.74u l=0.13u
X495 VSS.t315 VDD VSS.t313 VSS.t314 sg13_lv_nmos ad=79.8f pd=0.8u as=0 ps=0 w=0.42u l=1u
X496 a_23871_1842# a_23633_1842# a_23763_1842# VSS.t397 sg13_lv_nmos ad=0.1406p pd=1.12u as=0.2516p ps=2.16u w=0.74u l=0.2u
X497 a_8433_1842# a_8237_1842# VSS.t338 VSS.t337 sg13_lv_nmos ad=0.2516p pd=2.16u as=0.1406p ps=1.12u w=0.74u l=0.13u
X498 VSS.t384 a_18443_1842# a_18877_1842# VSS.t383 sg13_lv_nmos ad=0.1406p pd=1.12u as=0.2516p ps=2.16u w=0.74u l=0.13u
X499 VSS.t280 VDD VSS.t278 VSS.t279 sg13_lv_nmos ad=79.8f pd=0.8u as=0 ps=0 w=0.42u l=1u
X500 a_22113_1842# a_21917_1842# VSS.t193 VSS.t210 sg13_lv_nmos ad=0.2516p pd=2.16u as=0.1406p ps=1.12u w=0.74u l=0.13u
X501 a_1544_289# MUX_SEL3 VDD VDD sg13_lv_pmos ad=0.3808p pd=2.92u as=0.3808p ps=2.92u w=1.12u l=0.13u
X502 a_26673_1842# a_26477_1842# VDD VDD sg13_lv_pmos ad=0.3808p pd=2.92u as=0.2128p ps=1.5u w=1.12u l=0.13u
X503 a_10328_1044# a_9757_1842# VSS.t203 VSS.t202 sg13_lv_nmos ad=0.1406p pd=1.12u as=0.2516p ps=2.16u w=0.74u l=0.13u
X504 VSS.t283 VDD VSS.t282 VSS.t281 sg13_lv_nmos ad=0.1428p pd=1.52u as=0 ps=0 w=0.42u l=1u
X505 a_22590_1044# a_2019_1047.t3 a_22488_1044# VSS.t31 sg13_lv_nmos ad=0.2516p pd=2.16u as=0.1406p ps=1.12u w=0.74u l=0.13u
X506 VSS.t427 DELAY_VBIASN.t20 a_12471_1842# VSS.t426 sg13_lv_nmos ad=0.2516p pd=2.16u as=0.1406p ps=1.12u w=0.74u l=0.6u
X507 a_8808_1044# a_8237_1842# VSS.t340 VSS.t339 sg13_lv_nmos ad=0.1406p pd=1.12u as=0.2516p ps=2.16u w=0.74u l=0.13u
X508 VSS.t161 a_22243_1842# a_22677_1842# VSS.t392 sg13_lv_nmos ad=0.1406p pd=1.12u as=0.2516p ps=2.16u w=0.74u l=0.13u
X509 VDD DELAY_VBIASP.t28 a_6391_2470# VDD sg13_lv_pmos ad=0.3808p pd=2.92u as=0.2128p ps=1.5u w=1.12u l=0.6u
X510 a_13470_1044# a_15831_1008# a_15755_1044# VDD sg13_lv_pmos ad=0.3808p pd=2.92u as=0.2128p ps=1.5u w=1.12u l=0.13u
X511 a_1544_1044# MUX_SEL1 VDD VDD sg13_lv_pmos ad=0.3808p pd=2.92u as=0.3808p ps=2.92u w=1.12u l=0.13u
X512 VDD DELAY_VBIASP.t9 a_20831_2470# VDD sg13_lv_pmos ad=0.3808p pd=2.92u as=0.2128p ps=1.5u w=1.12u l=0.6u
X513 VDD a_2595_1047.t2 a_26471_1008# VDD sg13_lv_pmos ad=0.3808p pd=2.92u as=0.3808p ps=2.92u w=1.12u l=0.13u
X514 a_4350_1044# a_5191_1008# a_5115_1044# VDD sg13_lv_pmos ad=0.3808p pd=2.92u as=0.2128p ps=1.5u w=1.12u l=0.13u
X515 VDD a_16597_1842# a_17065_1044# VDD sg13_lv_pmos ad=0.252p pd=1.57u as=0.3808p ps=2.92u w=1.12u l=0.13u
X516 VSS.t189 a_27237_1842# a_27705_1044# VSS.t493 sg13_lv_nmos ad=0.1665p pd=1.19u as=0.2516p ps=2.16u w=0.74u l=0.13u
X517 a_10191_2470# a_9953_1842# a_10083_1842# VDD sg13_lv_pmos ad=0.2128p pd=1.5u as=0.3808p ps=2.92u w=1.12u l=0.2u
X518 a_2595_1047.t1 a_2297_1395# VSS.t60 VSS.t67 sg13_lv_nmos ad=0.1406p pd=1.12u as=0.1331p ps=1.12u w=0.74u l=0.13u
X519 a_26151_1842# a_25913_1842# a_26043_1842# VSS.t342 sg13_lv_nmos ad=0.1406p pd=1.12u as=0.2516p ps=2.16u w=0.74u l=0.2u
X520 VSS.t179 a_2019_311# a_17865_519# VSS.t178 sg13_lv_nmos ad=0.2516p pd=2.16u as=0.2516p ps=2.16u w=0.74u l=0.13u
X521 VSS.t372 a_1544_289# a_2391_331# VSS.t371 sg13_lv_nmos ad=0.1331p pd=1.12u as=0.1216p ps=1.02u w=0.64u l=0.13u
X522 a_4871_1842# a_4633_1842# a_4763_1842# VSS.t101 sg13_lv_nmos ad=0.1406p pd=1.12u as=0.2516p ps=2.16u w=0.74u l=0.2u
X523 a_13753_1842# a_13557_1842# VSS.t48 VSS.t47 sg13_lv_nmos ad=0.2516p pd=2.16u as=0.1406p ps=1.12u w=0.74u l=0.13u
X524 a_1815_1395# a_1256_1044# a_1721_1395# VSS.t233 sg13_lv_nmos ad=0.1216p pd=1.02u as=0.2176p ps=1.96u w=0.64u l=0.13u
X525 a_7673_1842# a_7477_1842# VDD VDD sg13_lv_pmos ad=0.3808p pd=2.92u as=0.2128p ps=1.5u w=1.12u l=0.13u
X526 VDD VSS.t580 VDD VDD sg13_lv_pmos ad=0.34p pd=2.68u as=0 ps=0 w=1u l=1u
X527 a_1721_331# a_1256_289# VDD VDD sg13_lv_pmos ad=0.1596p pd=1.22u as=0.2856p ps=2.36u w=0.84u l=0.13u
X528 VSS.t223 a_24523_1842# a_24957_1842# VSS.t523 sg13_lv_nmos ad=0.1406p pd=1.12u as=0.2516p ps=2.16u w=0.74u l=0.13u
X529 a_6635_1044# a_6425_1044# VSS.t238 VSS.t237 sg13_lv_nmos ad=0.1406p pd=1.12u as=0.1665p ps=1.19u w=0.74u l=0.13u
X530 VSS.t97 a_2595_1047.t9 a_5191_1008# VSS.t96 sg13_lv_nmos ad=0.2516p pd=2.16u as=0.2516p ps=2.16u w=0.74u l=0.13u
X531 a_20315_1044# a_20105_1044# VSS.t196 VSS.t540 sg13_lv_nmos ad=0.1406p pd=1.12u as=0.1665p ps=1.19u w=0.74u l=0.13u
X532 VDD DELAY_VBIASP.t21 a_11711_2470# VDD sg13_lv_pmos ad=0.3808p pd=2.92u as=0.2128p ps=1.5u w=1.12u l=0.6u
X533 a_18795_1044# a_18585_1044# VDD VDD sg13_lv_pmos ad=0.2128p pd=1.5u as=0.252p ps=1.57u w=1.12u l=0.13u
X534 a_25528_1044# a_24957_1842# VSS.t221 VSS.t220 sg13_lv_nmos ad=0.1406p pd=1.12u as=0.2516p ps=2.16u w=0.74u l=0.13u
X535 VSS.t459 DELAY_VBIASN.t0 a_27671_1842# VSS.t458 sg13_lv_nmos ad=0.2516p pd=2.16u as=0.1406p ps=1.12u w=0.74u l=0.6u
X536 a_5731_289# a_3747_311.t3 a_13470_1044# VSS.t88 sg13_lv_nmos ad=0.2516p pd=2.16u as=0.2516p ps=2.16u w=0.74u l=0.13u
X537 a_25630_1044# a_27124_1008# a_27048_1044# VDD sg13_lv_pmos ad=0.3808p pd=2.92u as=0.2128p ps=1.5u w=1.12u l=0.13u
X538 VDD a_2595_1047.t5 a_17351_1008# VDD sg13_lv_pmos ad=0.3808p pd=2.92u as=0.3808p ps=2.92u w=1.12u l=0.13u
X539 VDD a_21483_1842# a_21917_1842# VDD sg13_lv_pmos ad=0.2128p pd=1.5u as=0.3808p ps=2.92u w=1.12u l=0.13u
X540 a_4350_1044# a_5844_1008# a_5768_1044# VDD sg13_lv_pmos ad=0.3808p pd=2.92u as=0.2128p ps=1.5u w=1.12u l=0.13u
X541 VSS.t94 a_16851_309# MUX_OUT VSS.t93 sg13_lv_nmos ad=0.2516p pd=2.16u as=0.1406p ps=1.12u w=0.74u l=0.13u
X542 VSS.t176 a_2019_311# a_5705_519# VSS.t175 sg13_lv_nmos ad=0.2516p pd=2.16u as=0.2516p ps=2.16u w=0.74u l=0.13u
X543 VDD a_1544_289# a_1721_331# VDD sg13_lv_pmos ad=0.1918p pd=1.5u as=0.1596p ps=1.22u w=0.84u l=0.13u
X544 a_7151_1842# a_6913_1842# a_7043_1842# VSS.t389 sg13_lv_nmos ad=0.1406p pd=1.12u as=0.2516p ps=2.16u w=0.74u l=0.2u
X545 a_16033_1842# a_15837_1842# VSS.t64 VSS.t63 sg13_lv_nmos ad=0.2516p pd=2.16u as=0.1406p ps=1.12u w=0.74u l=0.13u
X546 MUX_OUT a_16851_309# VDD VDD sg13_lv_pmos ad=0.2128p pd=1.5u as=0.2086p ps=1.5u w=1.12u l=0.13u
X547 a_25391_2470# a_25153_1842# a_25283_1842# VDD sg13_lv_pmos ad=0.2128p pd=1.5u as=0.3808p ps=2.92u w=1.12u l=0.2u
X548 VDD VSS.t592 VDD VDD sg13_lv_pmos ad=0.34p pd=2.68u as=0 ps=0 w=1u l=1u
X549 a_12993_1842# a_12797_1842# VDD VDD sg13_lv_pmos ad=0.3808p pd=2.92u as=0.2128p ps=1.5u w=1.12u l=0.13u
X550 a_16408_1044# a_15837_1842# VSS.t62 VSS.t61 sg13_lv_nmos ad=0.1406p pd=1.12u as=0.2516p ps=2.16u w=0.74u l=0.13u
X551 VSS.t85 a_5523_1842# a_5957_1842# VSS.t84 sg13_lv_nmos ad=0.1406p pd=1.12u as=0.2516p ps=2.16u w=0.74u l=0.13u
X552 VDD DELAY_VBIASP.t18 a_13991_2470# VDD sg13_lv_pmos ad=0.3808p pd=2.92u as=0.2128p ps=1.5u w=1.12u l=0.6u
X553 a_5731_289# a_2019_311# a_4350_1044# VSS.t174 sg13_lv_nmos ad=0.2516p pd=2.16u as=0.2516p ps=2.16u w=0.74u l=0.13u
X554 a_7390_1044# a_3747_1047.t8 a_9675_1044# VSS.t132 sg13_lv_nmos ad=0.2516p pd=2.16u as=0.1406p ps=1.12u w=0.74u l=0.13u
X555 VDD a_23763_1842# a_24197_1842# VDD sg13_lv_pmos ad=0.2128p pd=1.5u as=0.3808p ps=2.92u w=1.12u l=0.13u
X556 VSS.t437 DELAY_VBIASN.t25 a_8671_1842# VSS.t436 sg13_lv_nmos ad=0.2516p pd=2.16u as=0.1406p ps=1.12u w=0.74u l=0.6u
X557 VDD a_2019_1047.t8 a_7364_1008# VDD sg13_lv_pmos ad=0.3808p pd=2.92u as=0.3808p ps=2.92u w=1.12u l=0.13u
X558 VDD DELAY_VBIASP.t1 a_26911_2470# VDD sg13_lv_pmos ad=0.3808p pd=2.92u as=0.2128p ps=1.5u w=1.12u l=0.6u
X559 VDD VSS.t563 VDD VDD sg13_lv_pmos ad=0.19p pd=1.38u as=0 ps=0 w=1u l=1u
X560 a_12471_1842# a_12233_1842# a_12363_1842# VSS.t402 sg13_lv_nmos ad=0.1406p pd=1.12u as=0.2516p ps=2.16u w=0.74u l=0.2u
X561 a_22488_1044# a_21917_1842# VDD VDD sg13_lv_pmos ad=0.2128p pd=1.5u as=0.3808p ps=2.92u w=1.12u l=0.13u
X562 VDD a_2595_311.t3 a_8745_519# VDD sg13_lv_pmos ad=0.3808p pd=2.92u as=0.3808p ps=2.92u w=1.12u l=0.13u
X563 VSS.t532 a_3171_1047.t5 a_18004_1008# VSS.t531 sg13_lv_nmos ad=0.2516p pd=2.16u as=0.2516p ps=2.16u w=0.74u l=0.13u
X564 a_6391_2470# a_6153_1842# a_6283_1842# VDD sg13_lv_pmos ad=0.2128p pd=1.5u as=0.3808p ps=2.92u w=1.12u l=0.2u
X565 a_15273_1842# a_15077_1842# VDD VDD sg13_lv_pmos ad=0.3808p pd=2.92u as=0.2128p ps=1.5u w=1.12u l=0.13u
X566 a_14235_1044# a_14025_1044# VSS.t50 VSS.t536 sg13_lv_nmos ad=0.1406p pd=1.12u as=0.1665p ps=1.19u w=0.74u l=0.13u
X567 VSS.t519 a_3747_1047.t7 a_12791_1008# VSS.t518 sg13_lv_nmos ad=0.2516p pd=2.16u as=0.2516p ps=2.16u w=0.74u l=0.13u
X568 a_9953_1842# a_9757_1842# VSS.t205 VSS.t204 sg13_lv_nmos ad=0.2516p pd=2.16u as=0.1406p ps=1.12u w=0.74u l=0.13u
X569 VSS.t46 a_10843_1842# a_11277_1842# VSS.t45 sg13_lv_nmos ad=0.1406p pd=1.12u as=0.2516p ps=2.16u w=0.74u l=0.13u
X570 VSS.t313 VDD VSS.t312 VSS.t311 sg13_lv_nmos ad=0.1428p pd=1.52u as=0 ps=0 w=0.42u l=1u
X571 VDD a_15403_1842# a_15837_1842# VDD sg13_lv_pmos ad=0.2128p pd=1.5u as=0.3808p ps=2.92u w=1.12u l=0.13u
X572 VSS.t278 VDD VSS.t277 VSS.t276 sg13_lv_nmos ad=0.1428p pd=1.52u as=0 ps=0 w=0.42u l=1u
X573 a_11848_1044# a_11277_1842# VSS.t172 VSS.t171 sg13_lv_nmos ad=0.1406p pd=1.12u as=0.2516p ps=2.16u w=0.74u l=0.13u
X574 VDD a_4763_1842# a_5197_1842# VDD sg13_lv_pmos ad=0.2128p pd=1.5u as=0.3808p ps=2.92u w=1.12u l=0.13u
X575 VSS.t290 VDD VSS.t288 VSS.t289 sg13_lv_nmos ad=79.8f pd=0.8u as=0 ps=0 w=0.42u l=1u
X576 a_13470_1044# a_13444_1008# a_13368_1044# VDD sg13_lv_pmos ad=0.3808p pd=2.92u as=0.2128p ps=1.5u w=1.12u l=0.13u
X577 VDD a_3449_1395# a_3747_1047.t0 VDD sg13_lv_pmos ad=0.4256p pd=3u as=0.2128p ps=1.5u w=1.12u l=0.13u
X578 VDD a_3171_1047.t3 a_24084_1008# VDD sg13_lv_pmos ad=0.3808p pd=2.92u as=0.3808p ps=2.92u w=1.12u l=0.13u
X579 a_3449_1395# MUX_SEL0 VDD VDD sg13_lv_pmos ad=0.1596p pd=1.22u as=0.2856p ps=2.36u w=0.84u l=0.13u
X580 VDD DELAY_VBIASP.t26 a_7911_2470# VDD sg13_lv_pmos ad=0.3808p pd=2.92u as=0.2128p ps=1.5u w=1.12u l=0.6u
X581 VDD VSS.t595 VDD VDD sg13_lv_pmos ad=0.19p pd=1.38u as=0 ps=0 w=1u l=1u
X582 VDD VSS.t594 VDD VDD sg13_lv_pmos ad=0.34p pd=2.68u as=0 ps=0 w=1u l=1u
X583 VDD a_16851_309# MUX_OUT VDD sg13_lv_pmos ad=0.7336p pd=3.55u as=0.2128p ps=1.5u w=1.12u l=0.13u
X584 VSS.t140 a_3171_311.t2 a_23945_519# VSS.t139 sg13_lv_nmos ad=0.2516p pd=2.16u as=0.2516p ps=2.16u w=0.74u l=0.13u
X585 VDD a_18117_1842# a_18585_1044# VDD sg13_lv_pmos ad=0.252p pd=1.57u as=0.3808p ps=2.92u w=1.12u l=0.13u
X586 VSS.t196 a_19637_1842# a_20105_1044# VSS.t195 sg13_lv_nmos ad=0.1665p pd=1.19u as=0.2516p ps=2.16u w=0.74u l=0.13u
X587 a_11711_2470# a_11473_1842# a_11603_1842# VDD sg13_lv_pmos ad=0.2128p pd=1.5u as=0.3808p ps=2.92u w=1.12u l=0.2u
X588 a_27671_1842# a_27433_1842# a_27563_1842# VSS.t102 sg13_lv_nmos ad=0.1406p pd=1.12u as=0.2516p ps=2.16u w=0.74u l=0.2u
X589 VSS.t506 MUX_SEL4 a_15765_463# VSS.t505 sg13_lv_nmos ad=0.2516p pd=2.16u as=0.2516p ps=2.16u w=0.74u l=0.13u
X590 a_5731_289# a_14825_519# a_13470_1044# VDD sg13_lv_pmos ad=0.3808p pd=2.92u as=0.3808p ps=2.92u w=1.12u l=0.13u
X591 a_16510_1044# a_2595_1047.t5 a_17275_1044# VSS.t51 sg13_lv_nmos ad=0.2516p pd=2.16u as=0.1406p ps=1.12u w=0.74u l=0.13u
X592 VSS.t451 DELAY_VBIASN.t15 a_16271_1842# VSS.t450 sg13_lv_nmos ad=0.2516p pd=2.16u as=0.1406p ps=1.12u w=0.74u l=0.6u
X593 VDD VSS.t568 VDD VDD sg13_lv_pmos ad=0.34p pd=2.68u as=0 ps=0 w=1u l=1u
X594 VDD a_3171_1047.t6 a_14964_1008# VDD sg13_lv_pmos ad=0.3808p pd=2.92u as=0.3808p ps=2.92u w=1.12u l=0.13u
X595 VDD a_10083_1842# a_10517_1842# VDD sg13_lv_pmos ad=0.2128p pd=1.5u as=0.3808p ps=2.92u w=1.12u l=0.13u
X596 VSS.t516 a_3747_1047.t2 a_27991_1008# VSS.t515 sg13_lv_nmos ad=0.2516p pd=2.16u as=0.2516p ps=2.16u w=0.74u l=0.13u
X597 VSS.t184 a_26043_1842# a_26477_1842# VSS.t183 sg13_lv_nmos ad=0.1406p pd=1.12u as=0.2516p ps=2.16u w=0.74u l=0.13u
X598 a_11195_1044# a_10985_1044# VDD VDD sg13_lv_pmos ad=0.2128p pd=1.5u as=0.252p ps=1.57u w=1.12u l=0.13u
X599 VSS.t229 a_3747_1047.t9 a_6711_1008# VSS.t228 sg13_lv_nmos ad=0.2516p pd=2.16u as=0.2516p ps=2.16u w=0.74u l=0.13u
X600 a_16108_289# a_2595_311.t2 a_19550_1044# VSS.t117 sg13_lv_nmos ad=0.2516p pd=2.16u as=0.2516p ps=2.16u w=0.74u l=0.13u
X601 VSS.t457 DELAY_VBIASN.t10 a_20071_1842# VSS.t456 sg13_lv_nmos ad=0.2516p pd=2.16u as=0.1406p ps=1.12u w=0.74u l=0.6u
X602 VDD DELAY_VBIASP.t4 a_24631_2470# VDD sg13_lv_pmos ad=0.3808p pd=2.92u as=0.2128p ps=1.5u w=1.12u l=0.6u
X603 a_22590_1044# a_23431_1008# a_23355_1044# VDD sg13_lv_pmos ad=0.3808p pd=2.92u as=0.2128p ps=1.5u w=1.12u l=0.13u
X604 VSS.t270 VDD VSS.t268 VSS.t269 sg13_lv_nmos ad=79.8f pd=0.8u as=0 ps=0 w=0.42u l=1u
X605 a_8671_1842# a_8433_1842# a_8563_1842# VSS.t370 sg13_lv_nmos ad=0.1406p pd=1.12u as=0.2516p ps=2.16u w=0.74u l=0.2u
X606 a_17553_1842# a_17357_1842# VSS.t486 VSS.t485 sg13_lv_nmos ad=0.2516p pd=2.16u as=0.1406p ps=1.12u w=0.74u l=0.13u
X607 a_5731_289# a_5705_519# a_4350_1044# VDD sg13_lv_pmos ad=0.3808p pd=2.92u as=0.3808p ps=2.92u w=1.12u l=0.13u
X608 VDD VDD VDD VDD sg13_lv_pmos ad=0.3808p pd=2.92u as=0 ps=0 w=1.12u l=0.13u
X609 a_26911_2470# a_26673_1842# a_26803_1842# VDD sg13_lv_pmos ad=0.2128p pd=1.5u as=0.3808p ps=2.92u w=1.12u l=0.2u
X610 a_7390_1044# a_2019_1047.t8 a_7288_1044# VSS.t114 sg13_lv_nmos ad=0.2516p pd=2.16u as=0.1406p ps=1.12u w=0.74u l=0.13u
X611 a_21353_1842# a_21157_1842# VSS.t66 VSS.t491 sg13_lv_nmos ad=0.2516p pd=2.16u as=0.1406p ps=1.12u w=0.74u l=0.13u
X612 VSS.t399 a_7043_1842# a_7477_1842# VSS.t398 sg13_lv_nmos ad=0.1406p pd=1.12u as=0.2516p ps=2.16u w=0.74u l=0.13u
X613 VDD DELAY_VBIASP.t16 a_15511_2470# VDD sg13_lv_pmos ad=0.3808p pd=2.92u as=0.2128p ps=1.5u w=1.12u l=0.6u
X614 VDD a_2019_1047.t7 a_10404_1008# VDD sg13_lv_pmos ad=0.3808p pd=2.92u as=0.3808p ps=2.92u w=1.12u l=0.13u
X615 VDD a_25283_1842# a_25717_1842# VDD sg13_lv_pmos ad=0.2128p pd=1.5u as=0.3808p ps=2.92u w=1.12u l=0.13u
X616 VDD DELAY_VBIASP.t29 a_5631_2470# VDD sg13_lv_pmos ad=0.3808p pd=2.92u as=0.2128p ps=1.5u w=1.12u l=0.6u
X617 a_26395_1044# a_26185_1044# VDD VDD sg13_lv_pmos ad=0.2128p pd=1.5u as=0.252p ps=1.57u w=1.12u l=0.13u
X618 VDD a_3747_1047.t3 a_24951_1008# VDD sg13_lv_pmos ad=0.3808p pd=2.92u as=0.3808p ps=2.92u w=1.12u l=0.13u
X619 VDD VSS.t571 VDD VDD sg13_lv_pmos ad=0.19p pd=1.38u as=0 ps=0 w=1u l=1u
X620 a_13991_1842# a_13753_1842# a_13883_1842# VSS.t191 sg13_lv_nmos ad=0.1406p pd=1.12u as=0.2516p ps=2.16u w=0.74u l=0.2u
X621 a_24008_1044# a_23437_1842# VDD VDD sg13_lv_pmos ad=0.2128p pd=1.5u as=0.3808p ps=2.92u w=1.12u l=0.13u
X622 VDD VSS.t585 VDD VDD sg13_lv_pmos ad=0.19p pd=1.38u as=0 ps=0 w=1u l=1u
X623 VSS.t36 a_2019_1047.t4 a_19524_1008# VSS.t35 sg13_lv_nmos ad=0.2516p pd=2.16u as=0.2516p ps=2.16u w=0.74u l=0.13u
X624 a_7911_2470# a_7673_1842# a_7803_1842# VDD sg13_lv_pmos ad=0.2128p pd=1.5u as=0.3808p ps=2.92u w=1.12u l=0.2u
X625 a_16793_1842# a_16597_1842# VDD VDD sg13_lv_pmos ad=0.3808p pd=2.92u as=0.2128p ps=1.5u w=1.12u l=0.13u
X626 VSS.t108 MUX_SEL1 a_3543_1395# VSS.t503 sg13_lv_nmos ad=0.1331p pd=1.12u as=0.1216p ps=1.02u w=0.64u l=0.13u
X627 a_15755_1044# a_15545_1044# VSS.t112 VSS.t111 sg13_lv_nmos ad=0.1406p pd=1.12u as=0.1665p ps=1.19u w=0.74u l=0.13u
X628 a_2595_1047.t0 a_2297_1395# VDD VDD sg13_lv_pmos ad=0.2128p pd=1.5u as=0.1918p ps=1.5u w=1.12u l=0.13u
X629 VSS.t24 a_2595_1047.t6 a_14311_1008# VSS.t23 sg13_lv_nmos ad=0.2516p pd=2.16u as=0.2516p ps=2.16u w=0.74u l=0.13u
X630 VSS.t347 a_12363_1842# a_12797_1842# VSS.t400 sg13_lv_nmos ad=0.1406p pd=1.12u as=0.2516p ps=2.16u w=0.74u l=0.13u
X631 a_5115_1044# a_4905_1044# VSS.t1 VSS.t0 sg13_lv_nmos ad=0.1406p pd=1.12u as=0.1665p ps=1.19u w=0.74u l=0.13u
X632 a_1256_1044# MUX_SEL0 VDD VDD sg13_lv_pmos ad=0.3808p pd=2.92u as=0.3808p ps=2.92u w=1.12u l=0.13u
X633 VDD a_27563_1842# a_27997_1842# VDD sg13_lv_pmos ad=0.2128p pd=1.5u as=0.3808p ps=2.92u w=1.12u l=0.13u
X634 a_20593_1842# a_20397_1842# VDD VDD sg13_lv_pmos ad=0.3808p pd=2.92u as=0.2128p ps=1.5u w=1.12u l=0.13u
X635 a_1721_1395# a_1256_1044# VDD VDD sg13_lv_pmos ad=0.1596p pd=1.22u as=0.2856p ps=2.36u w=0.84u l=0.13u
X636 VDD a_6283_1842# a_6717_1842# VDD sg13_lv_pmos ad=0.2128p pd=1.5u as=0.3808p ps=2.92u w=1.12u l=0.13u
X637 a_13470_1044# a_14964_1008# a_14888_1044# VDD sg13_lv_pmos ad=0.3808p pd=2.92u as=0.2128p ps=1.5u w=1.12u l=0.13u
X638 VSS.t288 VDD VSS.t287 VSS.t286 sg13_lv_nmos ad=0.1428p pd=1.52u as=0 ps=0 w=0.42u l=1u
X639 VDD a_2019_1047.t2 a_25604_1008# VDD sg13_lv_pmos ad=0.3808p pd=2.92u as=0.3808p ps=2.92u w=1.12u l=0.13u
X640 a_16271_1842# a_16033_1842# a_16163_1842# VSS.t468 sg13_lv_nmos ad=0.1406p pd=1.12u as=0.2516p ps=2.16u w=0.74u l=0.2u
X641 a_21835_1044# a_21625_1044# VDD VDD sg13_lv_pmos ad=0.2128p pd=1.5u as=0.252p ps=1.57u w=1.12u l=0.13u
X642 VDD VSS.t596 VDD VDD sg13_lv_pmos ad=0.34p pd=2.68u as=0 ps=0 w=1u l=1u
X643 VDD a_2595_1047.t4 a_20391_1008# VDD sg13_lv_pmos ad=0.3808p pd=2.92u as=0.3808p ps=2.92u w=1.12u l=0.13u
X644 a_19073_1842# a_18877_1842# VDD VDD sg13_lv_pmos ad=0.3808p pd=2.92u as=0.2128p ps=1.5u w=1.12u l=0.13u
X645 VDD a_10517_1842# a_10985_1044# VDD sg13_lv_pmos ad=0.252p pd=1.57u as=0.3808p ps=2.92u w=1.12u l=0.13u
X646 VSS.t151 a_21157_1842# a_21625_1044# VSS.t490 sg13_lv_nmos ad=0.1665p pd=1.19u as=0.2516p ps=2.16u w=0.74u l=0.13u
X647 a_20071_1842# a_19833_1842# a_19963_1842# VSS.t214 sg13_lv_nmos ad=0.1406p pd=1.12u as=0.2516p ps=2.16u w=0.74u l=0.2u
X648 VSS.t379 a_14643_1842# a_15077_1842# VSS.t378 sg13_lv_nmos ad=0.1406p pd=1.12u as=0.2516p ps=2.16u w=0.74u l=0.13u
X649 a_1815_331# a_1256_289# a_1721_331# VSS.t158 sg13_lv_nmos ad=0.1216p pd=1.02u as=0.2176p ps=1.96u w=0.64u l=0.13u
X650 VDD a_19203_1842# a_19637_1842# VDD sg13_lv_pmos ad=0.2128p pd=1.5u as=0.3808p ps=2.92u w=1.12u l=0.13u
X651 VSS.t100 a_2019_1047.t9 a_4324_1008# VSS.t99 sg13_lv_nmos ad=0.2516p pd=2.16u as=0.2516p ps=2.16u w=0.74u l=0.13u
X652 a_16108_289# a_20905_519# a_19550_1044# VDD sg13_lv_pmos ad=0.3808p pd=2.92u as=0.3808p ps=2.92u w=1.12u l=0.13u
X653 a_16510_1044# a_3747_1047.t5 a_18795_1044# VSS.t123 sg13_lv_nmos ad=0.2516p pd=2.16u as=0.1406p ps=1.12u w=0.74u l=0.13u
X654 VDD a_8563_1842# a_8997_1842# VDD sg13_lv_pmos ad=0.2128p pd=1.5u as=0.3808p ps=2.92u w=1.12u l=0.13u
X655 VDD DELAY_VBIASP.t19 a_13231_2470# VDD sg13_lv_pmos ad=0.3808p pd=2.92u as=0.2128p ps=1.5u w=1.12u l=0.6u
X656 VSS.t419 DELAY_VBIASN.t13 a_17791_1842# VSS.t418 sg13_lv_nmos ad=0.2516p pd=2.16u as=0.1406p ps=1.12u w=0.74u l=0.6u
X657 VSS.t258 VDD VSS.t257 VSS.t256 sg13_lv_nmos ad=0.1428p pd=1.52u as=0 ps=0 w=0.42u l=1u
X658 VDD a_3747_1047.t5 a_18871_1008# VDD sg13_lv_pmos ad=0.3808p pd=2.92u as=0.3808p ps=2.92u w=1.12u l=0.13u
X659 VDD a_23003_1842# a_23437_1842# VDD sg13_lv_pmos ad=0.2128p pd=1.5u as=0.3808p ps=2.92u w=1.12u l=0.13u
X660 a_12715_1044# a_12505_1044# VDD VDD sg13_lv_pmos ad=0.2128p pd=1.5u as=0.252p ps=1.57u w=1.12u l=0.13u
X661 a_19550_1044# a_21044_1008# a_20968_1044# VDD sg13_lv_pmos ad=0.3808p pd=2.92u as=0.2128p ps=1.5u w=1.12u l=0.13u
X662 a_17928_1044# a_17357_1842# VDD VDD sg13_lv_pmos ad=0.2128p pd=1.5u as=0.3808p ps=2.92u w=1.12u l=0.13u
X663 VSS.t421 DELAY_VBIASN.t8 a_21591_1842# VSS.t420 sg13_lv_nmos ad=0.2516p pd=2.16u as=0.1406p ps=1.12u w=0.74u l=0.6u
X664 VSS.t155 a_1544_289# a_1815_331# VSS.t373 sg13_lv_nmos ad=0.1331p pd=1.12u as=0.1216p ps=1.02u w=0.64u l=0.13u
X665 a_7288_1044# a_6717_1842# VDD VDD sg13_lv_pmos ad=0.2128p pd=1.5u as=0.3808p ps=2.92u w=1.12u l=0.13u
X666 a_15511_2470# a_15273_1842# a_15403_1842# VDD sg13_lv_pmos ad=0.2128p pd=1.5u as=0.3808p ps=2.92u w=1.12u l=0.2u
X667 VSS.t360 VSS.t362 VSS.t364 VSS.t363 sg13_lv_nmos ad=0.1406p pd=1.12u as=0 ps=0 w=0.74u l=0.2u
X668 a_22590_1044# a_24951_1008# a_24875_1044# VDD sg13_lv_pmos ad=0.3808p pd=2.92u as=0.2128p ps=1.5u w=1.12u l=0.13u
X669 VSS.t330 VDD VSS.t328 VSS.t329 sg13_lv_nmos ad=79.8f pd=0.8u as=0 ps=0 w=0.42u l=1u
X670 a_10430_1044# a_2019_1047.t7 a_10328_1044# VSS.t37 sg13_lv_nmos ad=0.2516p pd=2.16u as=0.1406p ps=1.12u w=0.74u l=0.13u
X671 VDD a_25717_1842# a_26185_1044# VDD sg13_lv_pmos ad=0.252p pd=1.57u as=0.3808p ps=2.92u w=1.12u l=0.13u
X672 VDD a_13883_1842# a_14317_1842# VDD sg13_lv_pmos ad=0.2128p pd=1.5u as=0.3808p ps=2.92u w=1.12u l=0.13u
X673 VDD a_4437_1842# a_4905_1044# VDD sg13_lv_pmos ad=0.252p pd=1.57u as=0.3808p ps=2.92u w=1.12u l=0.13u
X674 a_4157_1313# DELAY_IN VSS.t345 VSS.t344 sg13_lv_nmos ad=0.2516p pd=2.16u as=0.2553p ps=2.17u w=0.74u l=0.13u
X675 a_7390_1044# a_3171_1047.t8 a_8808_1044# VSS.t533 sg13_lv_nmos ad=0.2516p pd=2.16u as=0.1406p ps=1.12u w=0.74u l=0.13u
X676 a_22873_1842# a_22677_1842# VSS.t161 VSS.t160 sg13_lv_nmos ad=0.2516p pd=2.16u as=0.1406p ps=1.12u w=0.74u l=0.13u
X677 VDD a_3171_1047.t8 a_8884_1008# VDD sg13_lv_pmos ad=0.3808p pd=2.92u as=0.3808p ps=2.92u w=1.12u l=0.13u
C0 VDD a_18313_1842# 0.49285f
C1 a_17928_1044# a_18004_1008# 0.01176f
C2 a_15831_1008# a_15545_1044# 0.01885f
C3 VDD a_3449_1395# 0.46731f
C4 a_4350_1044# a_4437_1842# 0.1088f
C5 a_5115_1044# VDD 0.15389f
C6 a_15837_1842# a_16408_1044# 0.10864f
C7 a_14643_1842# a_14751_2470# 0.01697f
C8 a_22677_1842# a_22873_1842# 0.73897f
C9 a_6717_1842# VDD 0.87726f
C10 a_23431_1008# a_23437_1842# 0.02349f
C11 a_22590_1044# a_24197_1842# 0.05231f
C12 a_3449_331# MUX_SEL4 0.05166f
C13 a_14888_1044# a_14317_1842# 0.10863f
C14 a_24951_1008# VDD 0.2822f
C15 a_16510_1044# a_16484_1008# 0.277f
C16 a_15964_289# MUX_OUT 0.01307f
C17 a_16108_289# MUX_SEL4 0.1283f
C18 DELAY_VBIASP DELAY_OUT_LAST 0.21225f
C19 DELAY_IN DELAY_VBIASN 0.07156f
C20 a_26673_1842# VDD 0.49417f
C21 a_10430_1044# a_10985_1044# 0.03209f
C22 VDD a_9757_1842# 0.87771f
C23 DELAY_VBIASP a_8563_1842# 0.06627f
C24 DELAY_VBIASN a_24957_1842# 0.09992f
C25 a_21917_1842# a_21157_1842# 0.02912f
C26 a_21353_1842# a_21483_1842# 0.70845f
C27 a_6283_1842# a_6391_1842# 0.01163f
C28 a_2019_311# a_1256_289# 0.02904f
C29 VDD a_24631_2470# 0.01806f
C30 a_15837_1842# DELAY_VBIASN 0.09992f
C31 a_16033_1842# DELAY_VBIASP 0.11222f
C32 a_7477_1842# a_6717_1842# 0.06198f
C33 VDD a_8808_1044# 0.17499f
C34 DELAY_IN a_3449_331# 0.01017f
C35 a_24631_1842# a_24523_1842# 0.01163f
C36 DELAY_VBIASN a_18877_1842# 0.09992f
C37 MUX_SEL0 a_3449_1395# 0.10753f
C38 a_15964_289# a_5731_289# 0.2778f
C39 DELAY_VBIASP a_23437_1842# 0.0414f
C40 VDD a_12471_2470# 0.01806f
C41 a_16108_289# a_26985_519# 0.27952f
C42 a_4763_1842# a_4871_1842# 0.01163f
C43 a_16108_289# a_24957_1842# 0.0157f
C44 a_17928_1044# a_17357_1842# 0.10863f
C45 DELAY_VBIASP a_13123_1842# 0.06627f
C46 a_7390_1044# a_7364_1008# 0.277f
C47 VDD a_21483_1842# 0.4973f
C48 a_24197_1842# a_23763_1842# 0.6972f
C49 a_27433_1842# a_27997_1842# 0.0114f
C50 a_15837_1842# a_16597_1842# 0.06198f
C51 a_8745_519# a_5731_289# 0.28635f
C52 a_6283_1842# DELAY_VBIASN 0.07254f
C53 a_15964_289# a_15765_463# 0.061f
C54 a_19448_1044# a_19550_1044# 0.37183f
C55 a_14317_1842# a_15077_1842# 0.03319f
C56 a_26043_1842# a_26151_2470# 0.01697f
C57 a_4350_1044# a_5197_1842# 0.08038f
C58 DELAY_VBIASP a_17357_1842# 0.0414f
C59 a_23111_1842# a_23003_1842# 0.01163f
C60 a_19524_1008# a_18877_1842# 0.02011f
C61 a_16108_289# a_18877_1842# 0.0157f
C62 a_6283_1842# a_6391_2470# 0.01697f
C63 a_11271_1008# a_10430_1044# 0.28268f
C64 a_27237_1842# DELAY_VBIASN 0.09456f
C65 a_5197_1842# a_5523_1842# 0.01427f
C66 DELAY_VBIASN a_9323_1842# 0.07254f
C67 DELAY_VBIASP a_10517_1842# 0.0414f
C68 VDD a_19073_1842# 0.49426f
C69 a_25630_1044# a_27048_1044# 0.38994f
C70 VDD a_4437_1842# 0.86998f
C71 a_4763_1842# DELAY_VBIASP 0.06627f
C72 a_27237_1842# a_27124_1008# 0.02055f
C73 a_13557_1842# a_13123_1842# 0.69698f
C74 VDD a_9465_1044# 0.29722f
C75 a_18117_1842# a_17683_1842# 0.6972f
C76 a_6717_1842# a_7288_1044# 0.10864f
C77 a_4763_1842# a_4871_2470# 0.01697f
C78 a_25717_1842# DELAY_VBIASP 0.0414f
C79 a_22488_1044# a_21917_1842# 0.10864f
C80 VDD a_12363_1842# 0.4973f
C81 a_12505_1044# a_12037_1842# 0.2079f
C82 a_25283_1842# a_24957_1842# 0.01427f
C83 a_26673_1842# a_26803_1842# 0.70845f
C84 a_25283_1842# a_25391_1842# 0.01163f
C85 DELAY_VBIASP a_22243_1842# 0.06627f
C86 DELAY_VBIASN a_22113_1842# 0.0961f
C87 a_4350_1044# a_4324_1008# 0.277f
C88 a_7673_1842# VDD 0.49294f
C89 a_11785_519# a_10430_1044# 0.02058f
C90 a_12233_1842# a_12363_1842# 0.70845f
C91 a_25630_1044# a_25604_1008# 0.277f
C92 a_12715_1044# a_12505_1044# 0.09424f
C93 a_21911_1008# a_21917_1842# 0.02354f
C94 VDD a_14311_1008# 0.28336f
C95 a_21157_1842# a_21625_1044# 0.2079f
C96 VDD a_22590_1044# 0.89557f
C97 a_25630_1044# a_27705_1044# 0.03208f
C98 a_13470_1044# a_14025_1044# 0.03209f
C99 VDD a_26911_2470# 0.01806f
C100 DELAY_VBIASN a_19637_1842# 0.08375f
C101 DELAY_VBIASP a_19833_1842# 0.11222f
C102 a_5957_1842# a_6717_1842# 0.02912f
C103 a_12797_1842# a_12993_1842# 0.76914f
C104 a_11195_1044# VDD 0.15389f
C105 a_9953_1842# a_10517_1842# 0.0114f
C106 DELAY_VBIASN a_4003_1842# 0.06486f
C107 a_14235_1044# a_14025_1044# 0.09424f
C108 VDD MUX_SEL2 0.50938f
C109 a_22677_1842# a_23437_1842# 0.01669f
C110 a_7477_1842# a_7673_1842# 0.73897f
C111 VDD a_16484_1008# 0.28597f
C112 a_25630_1044# a_25717_1842# 0.1088f
C113 a_13470_1044# a_14235_1044# 0.39037f
C114 VDD a_23145_1044# 0.30409f
C115 VDD a_1256_289# 0.40292f
C116 a_5197_1842# VDD 0.86909f
C117 a_19524_1008# a_19637_1842# 0.05157f
C118 a_26477_1842# a_26043_1842# 0.6972f
C119 a_25717_1842# a_26185_1044# 0.19203f
C120 MUX_SEL4 a_4157_1313# 0.08229f
C121 VDD a_20968_1044# 0.17499f
C122 VDD a_20905_519# 0.29292f
C123 a_8237_1842# DELAY_VBIASN 0.09974f
C124 a_8433_1842# DELAY_VBIASP 0.11222f
C125 VDD a_23763_1842# 0.49671f
C126 VDD a_7364_1008# 0.28633f
C127 VDD a_27997_1842# 0.76025f
C128 VDD a_14513_1842# 0.49417f
C129 a_9675_1044# a_9751_1008# 0.01194f
C130 a_7390_1044# a_7945_1044# 0.03209f
C131 DELAY_VBIASP a_11473_1842# 0.11222f
C132 a_2297_331# MUX_OUT 0.01179f
C133 a_25153_1842# a_25717_1842# 0.0114f
C134 VDD a_13231_2470# 0.01806f
C135 DELAY_IN a_4157_1313# 0.50642f
C136 VDD a_17683_1842# 0.49671f
C137 a_9431_2470# a_9323_1842# 0.01697f
C138 a_5731_289# MUX_OUT 1.04829f
C139 a_8237_1842# a_8231_1008# 0.02349f
C140 a_15755_1044# a_15545_1044# 0.09424f
C141 MUX_SEL0 MUX_SEL2 0.01204f
C142 a_14643_1842# a_15077_1842# 0.6972f
C143 a_15837_1842# a_15831_1008# 0.02354f
C144 a_7477_1842# a_7364_1008# 0.05157f
C145 a_4324_1008# VDD 0.28597f
C146 a_13470_1044# a_13883_1842# 0.01012f
C147 a_5191_1008# a_4905_1044# 0.01885f
C148 a_22677_1842# a_22243_1842# 0.69698f
C149 a_6153_1842# VDD 0.49285f
C150 a_4763_1842# a_4633_1842# 0.70845f
C151 a_3449_331# MUX_SEL3 0.28429f
C152 a_2873_331# MUX_SEL4 0.04916f
C153 a_14311_1008# a_14317_1842# 0.02349f
C154 a_15403_1842# a_15511_1842# 0.01163f
C155 a_24875_1044# VDD 0.15406f
C156 a_15964_289# MUX_SEL4 0.5544f
C157 a_26911_2470# a_26803_1842# 0.01697f
C158 a_21911_1008# a_21625_1044# 0.01885f
C159 a_17351_1008# a_17065_1044# 0.01885f
C160 a_17791_1842# a_17683_1842# 0.01163f
C161 a_26043_1842# VDD 0.4973f
C162 VDD a_9193_1842# 0.49285f
C163 a_20593_1842# a_21157_1842# 0.0114f
C164 DELAY_VBIASN a_24393_1842# 0.0961f
C165 DELAY_VBIASP a_24523_1842# 0.06627f
C166 a_21353_1842# a_21157_1842# 0.77122f
C167 DELAY_VBIASN a_27563_1842# 0.07259f
C168 DELAY_VBIASN a_15077_1842# 0.09156f
C169 a_8745_519# MUX_SEL4 0.04472f
C170 a_21353_1842# a_21917_1842# 0.0114f
C171 a_2019_311# a_16510_1044# 0.03139f
C172 a_17865_519# a_16510_1044# 0.02165f
C173 a_10430_1044# a_12363_1842# 0.01012f
C174 a_15765_463# a_5731_289# 0.23301f
C175 VDD a_23871_2470# 0.01806f
C176 a_15273_1842# DELAY_VBIASN 0.0961f
C177 a_15403_1842# DELAY_VBIASP 0.06627f
C178 a_19550_1044# a_21835_1044# 0.39036f
C179 DELAY_VBIASN a_18313_1842# 0.0961f
C180 DELAY_VBIASP a_18443_1842# 0.06627f
C181 a_8997_1842# a_8884_1008# 0.02055f
C182 a_17865_519# a_2019_311# 0.13959f
C183 a_19637_1842# a_20397_1842# 0.01669f
C184 a_8231_1008# a_8155_1044# 0.01194f
C185 a_16108_289# a_23945_519# 0.2906f
C186 VDD a_11711_2470# 0.01806f
C187 DELAY_VBIASP a_13557_1842# 0.0414f
C188 a_16510_1044# a_18117_1842# 0.05231f
C189 a_17351_1008# a_17357_1842# 0.02349f
C190 a_7288_1044# a_7364_1008# 0.01176f
C191 VDD a_21157_1842# 0.85848f
C192 VDD a_21917_1842# 0.87825f
C193 a_23633_1842# a_23763_1842# 0.70845f
C194 a_15837_1842# a_16033_1842# 0.76914f
C195 a_15403_1842# a_15511_2470# 0.01697f
C196 a_6717_1842# DELAY_VBIASN 0.09992f
C197 a_14317_1842# a_14513_1842# 0.76914f
C198 a_17791_2470# a_17683_1842# 0.01697f
C199 a_15837_1842# a_15964_289# 0.02f
C200 a_25630_1044# DELAY_VBIASP 0.01522f
C201 a_11195_1044# a_10430_1044# 0.39037f
C202 a_26673_1842# DELAY_VBIASN 0.0961f
C203 a_5197_1842# a_5957_1842# 0.03319f
C204 a_25604_1008# a_24957_1842# 0.02011f
C205 DELAY_VBIASP a_9953_1842# 0.11222f
C206 DELAY_VBIASN a_9757_1842# 0.09992f
C207 a_4350_1044# a_2019_311# 0.02042f
C208 VDD a_7945_1044# 0.30409f
C209 a_6717_1842# a_6711_1008# 0.02354f
C210 a_17553_1842# a_17683_1842# 0.70845f
C211 a_25153_1842# DELAY_VBIASP 0.11222f
C212 VDD a_12797_1842# 0.87771f
C213 VDD a_14025_1044# 0.30409f
C214 a_25717_1842# a_24957_1842# 0.06198f
C215 DELAY_VBIASN a_21483_1842# 0.07254f
C216 DELAY_VBIASP a_22677_1842# 0.0414f
C217 a_6913_1842# DELAY_VBIASP 0.11222f
C218 a_4248_1044# a_4324_1008# 0.01176f
C219 a_7043_1842# VDD 0.49723f
C220 a_13470_1044# VDD 0.87936f
C221 a_12233_1842# a_12797_1842# 0.0114f
C222 a_7477_1842# a_7945_1044# 0.19203f
C223 a_25528_1044# a_25604_1008# 0.01176f
C224 VDD a_12993_1842# 0.49426f
C225 a_8237_1842# a_8997_1842# 0.03319f
C226 VDD a_14235_1044# 0.15389f
C227 VDD a_22488_1044# 0.17274f
C228 a_25630_1044# a_26185_1044# 0.03209f
C229 VDD a_1721_1395# 0.4533f
C230 a_13368_1044# a_12797_1842# 0.10864f
C231 VDD a_26151_2470# 0.01806f
C232 DELAY_VBIASP a_19203_1842# 0.06627f
C233 a_5957_1842# a_6153_1842# 0.77122f
C234 DELAY_VBIASN a_19073_1842# 0.0961f
C235 a_21044_1008# a_20397_1842# 0.02312f
C236 a_27237_1842# a_27705_1044# 0.2079f
C237 a_13444_1008# a_12797_1842# 0.02011f
C238 DELAY_VBIASN a_4437_1842# 0.08375f
C239 DELAY_VBIASP a_4633_1842# 0.11222f
C240 a_9757_1842# a_10083_1842# 0.01427f
C241 VDD MUX_SEL1 0.50267f
C242 a_22590_1044# a_24084_1008# 0.28279f
C243 a_7477_1842# a_7043_1842# 0.69698f
C244 a_23355_1044# a_23431_1008# 0.01194f
C245 a_13368_1044# a_13470_1044# 0.37183f
C246 VDD a_21911_1008# 0.2822f
C247 VDD a_16510_1044# 0.8795f
C248 a_13470_1044# a_13444_1008# 0.277f
C249 VDD a_21625_1044# 0.29722f
C250 VDD a_27991_1008# 0.28201f
C251 DELAY_VBIASN a_12363_1842# 0.07254f
C252 a_19550_1044# a_19637_1842# 0.1088f
C253 a_25913_1842# a_26043_1842# 0.70845f
C254 a_10328_1044# a_9757_1842# 0.10864f
C255 MUX_SEL4 MUX_OUT 0.91933f
C256 VDD a_18551_2470# 0.01806f
C257 a_16793_1842# VDD 0.49277f
C258 VDD a_20391_1008# 0.28336f
C259 a_16484_1008# a_16408_1044# 0.01176f
C260 VDD a_2019_311# 1.43004f
C261 a_11848_1044# a_11924_1008# 0.01176f
C262 VDD a_17865_519# 0.29444f
C263 a_7803_1842# DELAY_VBIASP 0.06627f
C264 a_7673_1842# DELAY_VBIASN 0.0961f
C265 VDD a_24197_1842# 0.85848f
C266 VDD a_7390_1044# 0.8686f
C267 VDD a_27433_1842# 0.49285f
C268 a_8237_1842# a_8563_1842# 0.01427f
C269 a_10191_1842# a_10083_1842# 0.01163f
C270 VDD a_13883_1842# 0.4973f
C271 a_1544_1044# a_1721_1395# 0.38063f
C272 a_2297_331# MUX_SEL4 0.04338f
C273 DELAY_VBIASP a_10843_1842# 0.06627f
C274 DELAY_VBIASN a_22590_1044# 0.02115f
C275 MUX_SEL1 a_1544_1044# 0.1672f
C276 MUX_SEL0 a_1721_1395# 0.01315f
C277 VDD a_18117_1842# 0.85848f
C278 a_5731_289# MUX_SEL4 4.60702f
C279 a_16510_1044# a_18871_1008# 0.26208f
C280 MUX_SEL0 MUX_SEL1 3.14917f
C281 a_14643_1842# a_14513_1842# 0.70845f
C282 a_4350_1044# VDD 0.87635f
C283 a_7477_1842# a_7390_1044# 0.1088f
C284 a_13470_1044# a_14317_1842# 0.08038f
C285 a_15765_463# MUX_SEL4 0.65508f
C286 a_5115_1044# a_4905_1044# 0.09424f
C287 a_10985_1044# a_10517_1842# 0.19203f
C288 a_22113_1842# a_22243_1842# 0.70845f
C289 a_22590_1044# a_16108_289# 0.58202f
C290 a_5523_1842# VDD 0.49671f
C291 a_5197_1842# DELAY_VBIASN 0.09974f
C292 a_21591_2470# a_21483_1842# 0.01697f
C293 a_2873_331# MUX_SEL3 0.12606f
C294 a_22590_1044# a_23003_1842# 0.01012f
C295 DELAY_IN DELAY_VBIASP 0.07719f
C296 a_27671_1842# a_27563_1842# 0.01163f
C297 VDD a_10404_1008# 0.28633f
C298 a_17275_1044# a_17065_1044# 0.09424f
C299 a_26477_1842# VDD 0.86909f
C300 MUX_SEL2 a_3449_331# 0.10741f
C301 a_27915_1044# a_27991_1008# 0.01194f
C302 DELAY_VBIASP a_24957_1842# 0.0414f
C303 a_20723_1842# a_21157_1842# 0.6972f
C304 DELAY_VBIASN a_23763_1842# 0.07254f
C305 a_16597_1842# a_16484_1008# 0.05157f
C306 DELAY_VBIASN a_27997_1842# 0.04176f
C307 DELAY_VBIASN a_14513_1842# 0.0961f
C308 a_8997_1842# a_9757_1842# 0.02912f
C309 a_16851_309# a_16510_1044# 0.02131f
C310 a_20391_1008# a_20105_1044# 0.01885f
C311 a_10430_1044# a_12797_1842# 0.02479f
C312 a_24957_1842# a_24523_1842# 0.6972f
C313 VDD a_23111_2470# 0.01806f
C314 a_14825_519# a_5731_289# 0.28056f
C315 a_15837_1842# DELAY_VBIASP 0.0414f
C316 a_20315_1044# a_20391_1008# 0.01194f
C317 a_19550_1044# a_21044_1008# 0.28279f
C318 a_5705_519# a_2019_311# 0.13872f
C319 DELAY_VBIASN a_17683_1842# 0.07254f
C320 DELAY_VBIASP a_18877_1842# 0.0414f
C321 VDD a_11277_1842# 0.86909f
C322 MUX_SEL1 a_2873_1395# 0.13092f
C323 a_16851_309# a_2019_311# 0.01299f
C324 a_19637_1842# a_19833_1842# 0.73897f
C325 a_16108_289# a_20905_519# 0.2906f
C326 VDD a_10951_2470# 0.01806f
C327 VDD a_20593_1842# 0.49417f
C328 a_7288_1044# a_7390_1044# 0.37183f
C329 VDD a_21353_1842# 0.49285f
C330 a_23633_1842# a_24197_1842# 0.0114f
C331 a_15837_1842# a_15403_1842# 0.6972f
C332 a_6153_1842# DELAY_VBIASN 0.0961f
C333 a_6283_1842# DELAY_VBIASP 0.06627f
C334 a_14317_1842# a_13883_1842# 0.6972f
C335 a_11711_2470# a_11603_1842# 0.01697f
C336 a_19448_1044# a_18877_1842# 0.10864f
C337 a_18877_1842# a_18443_1842# 0.6972f
C338 a_25630_1044# a_26985_519# 0.02195f
C339 a_27237_1842# DELAY_VBIASP 0.06189f
C340 a_26043_1842# DELAY_VBIASN 0.07254f
C341 DELAY_VBIASN a_9193_1842# 0.0961f
C342 a_5197_1842# a_5393_1842# 0.76914f
C343 DELAY_VBIASP a_9323_1842# 0.06627f
C344 a_5768_1044# a_5844_1008# 0.01176f
C345 a_4350_1044# a_5705_519# 0.02005f
C346 a_7803_1842# a_7911_2470# 0.01697f
C347 a_4905_1044# a_4437_1842# 0.19203f
C348 a_17553_1842# a_18117_1842# 0.0114f
C349 a_8997_1842# a_9465_1044# 0.2079f
C350 VDD a_12233_1842# 0.49285f
C351 a_26477_1842# a_26803_1842# 0.01427f
C352 a_25153_1842# a_24957_1842# 0.76914f
C353 DELAY_VBIASN a_21157_1842# 0.09156f
C354 DELAY_VBIASP a_22113_1842# 0.11222f
C355 DELAY_VBIASN a_21917_1842# 0.09992f
C356 a_4157_1313# a_4437_1842# 0.01771f
C357 a_13368_1044# VDD 0.17274f
C358 a_7477_1842# VDD 0.86707f
C359 a_4248_1044# a_4350_1044# 0.37183f
C360 a_25528_1044# a_25630_1044# 0.37183f
C361 a_8237_1842# a_8433_1842# 0.76914f
C362 a_4350_1044# a_5957_1842# 0.05231f
C363 VDD a_13444_1008# 0.28633f
C364 VDD a_18871_1008# 0.2822f
C365 a_26471_1008# a_26477_1842# 0.02349f
C366 a_25630_1044# a_27237_1842# 0.05253f
C367 a_22243_1842# a_22351_1842# 0.01163f
C368 a_12791_1008# a_12797_1842# 0.02354f
C369 VDD a_25391_2470# 0.01806f
C370 VDD a_1544_1044# 0.45079f
C371 a_5957_1842# a_5523_1842# 0.6972f
C372 DELAY_VBIASP a_19637_1842# 0.0414f
C373 a_20968_1044# a_20397_1842# 0.10863f
C374 a_21483_1842# a_19550_1044# 0.01012f
C375 a_9757_1842# a_10517_1842# 0.06198f
C376 DELAY_VBIASP a_4003_1842# 0.05992f
C377 a_16108_289# a_21917_1842# 0.0157f
C378 VDD MUX_SEL0 0.56365f
C379 a_22590_1044# a_24008_1044# 0.38994f
C380 a_20723_1842# a_20831_1842# 0.01163f
C381 a_10430_1044# a_10404_1008# 0.277f
C382 VDD a_27915_1044# 0.15389f
C383 a_13368_1044# a_13444_1008# 0.01176f
C384 VDD a_20105_1044# 0.30409f
C385 DELAY_VBIASN a_12797_1842# 0.09992f
C386 a_25913_1842# a_26477_1842# 0.0114f
C387 MUX_SEL3 MUX_OUT 0.79533f
C388 a_9751_1008# a_9757_1842# 0.02354f
C389 a_18877_1842# a_19203_1842# 0.01427f
C390 VDD a_17791_2470# 0.01806f
C391 a_11277_1842# a_10713_1842# 0.0114f
C392 a_16163_1842# VDD 0.4973f
C393 VDD a_20315_1044# 0.15389f
C394 VDD a_5705_519# 0.29556f
C395 a_16510_1044# a_16408_1044# 0.37183f
C396 VDD a_16851_309# 0.51536f
C397 a_8231_1008# a_7945_1044# 0.01885f
C398 a_8237_1842# DELAY_VBIASP 0.0414f
C399 a_13470_1044# DELAY_VBIASN 0.02115f
C400 VDD a_7288_1044# 0.17274f
C401 a_7043_1842# DELAY_VBIASN 0.07254f
C402 VDD a_23633_1842# 0.49417f
C403 VDD a_26803_1842# 0.49671f
C404 VDD a_14317_1842# 0.86909f
C405 DELAY_VBIASN a_12993_1842# 0.0961f
C406 a_1256_1044# a_1721_1395# 0.13421f
C407 a_2297_331# MUX_SEL3 0.01595f
C408 a_1721_331# MUX_SEL4 0.05813f
C409 a_10430_1044# a_11277_1842# 0.08038f
C410 a_1544_289# MUX_OUT 0.69943f
C411 MUX_SEL0 a_1544_1044# 0.07603f
C412 MUX_SEL1 a_1256_1044# 1.44243f
C413 DELAY_IN MUX_SEL4 0.0663f
C414 VDD a_17553_1842# 0.49417f
C415 a_24084_1008# a_24197_1842# 0.02055f
C416 a_26471_1008# VDD 0.28336f
C417 VDD a_2873_1395# 0.46517f
C418 a_16510_1044# a_18795_1044# 0.39036f
C419 a_1544_289# a_2297_331# 0.27303f
C420 a_4248_1044# VDD 0.17587f
C421 VDD a_10713_1842# 0.49294f
C422 a_4350_1044# a_6425_1044# 0.03208f
C423 a_14825_519# MUX_SEL4 0.03307f
C424 DELAY_VBIASN a_16510_1044# 0.02115f
C425 a_22113_1842# a_22677_1842# 0.0114f
C426 a_5957_1842# VDD 0.85848f
C427 a_22590_1044# a_23437_1842# 0.08038f
C428 a_16793_1842# DELAY_VBIASN 0.0961f
C429 VDD a_10430_1044# 0.88416f
C430 MUX_SEL2 a_2873_331# 0.01422f
C431 a_25913_1842# VDD 0.49294f
C432 a_16510_1044# a_18585_1044# 0.03208f
C433 a_9751_1008# a_9465_1044# 0.01885f
C434 DELAY_VBIASN a_7390_1044# 0.02115f
C435 a_16597_1842# a_16510_1044# 0.1088f
C436 a_20397_1842# a_21157_1842# 0.03319f
C437 DELAY_OUT_LAST a_27997_1842# 0.70955f
C438 DELAY_VBIASP a_24393_1842# 0.11222f
C439 DELAY_VBIASN a_24197_1842# 0.09156f
C440 DELAY_VBIASN a_27433_1842# 0.0961f
C441 a_4324_1008# a_4157_1313# 0.02463f
C442 DELAY_VBIASP a_27563_1842# 0.06629f
C443 a_20723_1842# a_20593_1842# 0.70845f
C444 a_13231_1842# a_13123_1842# 0.01163f
C445 DELAY_VBIASN a_13883_1842# 0.07254f
C446 a_8997_1842# a_9193_1842# 0.77122f
C447 DELAY_VBIASP a_15077_1842# 0.04141f
C448 a_19311_2470# a_19203_1842# 0.01697f
C449 a_2873_331# a_1256_289# 0.27926f
C450 a_16108_289# a_16510_1044# 0.56108f
C451 a_20315_1044# a_20105_1044# 0.09424f
C452 a_24393_1842# a_24523_1842# 0.70845f
C453 a_16597_1842# a_16793_1842# 0.73897f
C454 VDD a_22351_2470# 0.01806f
C455 a_11785_519# a_5731_289# 0.28056f
C456 a_15273_1842# DELAY_VBIASP 0.11222f
C457 a_19550_1044# a_20968_1044# 0.38994f
C458 DELAY_VBIASN a_18117_1842# 0.09156f
C459 DELAY_VBIASP a_18313_1842# 0.11222f
C460 a_3449_331# a_2019_311# 0.01176f
C461 a_15545_1044# a_15077_1842# 0.2079f
C462 a_20905_519# a_19550_1044# 0.02165f
C463 a_19637_1842# a_19203_1842# 0.69698f
C464 a_16108_289# a_2019_311# 0.33889f
C465 MUX_SEL0 a_2873_1395# 0.01504f
C466 a_16108_289# a_17865_519# 0.29564f
C467 a_8231_1008# a_7390_1044# 0.28268f
C468 VDD a_10191_2470# 0.01806f
C469 a_12471_1842# a_12363_1842# 0.01163f
C470 a_4350_1044# DELAY_VBIASN 0.02115f
C471 a_16510_1044# a_16923_1842# 0.01012f
C472 VDD a_19963_1842# 0.4973f
C473 VDD a_20723_1842# 0.49671f
C474 a_23437_1842# a_23763_1842# 0.01427f
C475 a_15273_1842# a_15403_1842# 0.70845f
C476 a_18117_1842# a_18585_1044# 0.2079f
C477 a_11277_1842# a_11603_1842# 0.01427f
C478 a_6717_1842# DELAY_VBIASP 0.0414f
C479 a_5523_1842# DELAY_VBIASN 0.07254f
C480 a_16793_1842# a_16923_1842# 0.70845f
C481 a_13753_1842# a_13883_1842# 0.70845f
C482 a_18313_1842# a_18443_1842# 0.70845f
C483 a_22564_1008# a_22677_1842# 0.05157f
C484 a_10951_1842# a_10843_1842# 0.01163f
C485 a_13231_2470# a_13123_1842# 0.01697f
C486 a_26673_1842# DELAY_VBIASP 0.11222f
C487 a_26477_1842# DELAY_VBIASN 0.10224f
C488 DELAY_VBIASP a_9757_1842# 0.0414f
C489 a_5197_1842# a_4763_1842# 0.6972f
C490 a_25528_1044# a_24957_1842# 0.10864f
C491 a_25630_1044# a_27563_1842# 0.01024f
C492 a_4350_1044# a_6711_1008# 0.26208f
C493 a_7043_1842# a_7151_1842# 0.01163f
C494 a_26477_1842# a_27124_1008# 0.02312f
C495 VDD a_6425_1044# 0.29722f
C496 a_17357_1842# a_17683_1842# 0.01427f
C497 DELAY_VBIASN a_11277_1842# 0.09974f
C498 VDD a_16408_1044# 0.17274f
C499 VDD a_11603_1842# 0.49671f
C500 a_24631_2470# a_24523_1842# 0.01697f
C501 VDD a_24084_1008# 0.28225f
C502 a_14643_1842# VDD 0.49671f
C503 a_4111_1842# a_4003_1842# 0.01163f
C504 DELAY_VBIASN a_20593_1842# 0.0961f
C505 DELAY_VBIASN a_21353_1842# 0.0961f
C506 DELAY_VBIASP a_21483_1842# 0.06627f
C507 a_12791_1008# VDD 0.2822f
C508 a_12037_1842# a_12797_1842# 0.02912f
C509 a_8237_1842# a_7803_1842# 0.6972f
C510 a_23111_2470# a_23003_1842# 0.01697f
C511 VDD a_18795_1044# 0.15406f
C512 a_13470_1044# a_15831_1008# 0.26208f
C513 VDD a_1256_1044# 0.475f
C514 a_5393_1842# a_5523_1842# 0.70845f
C515 DELAY_VBIASP a_19073_1842# 0.11222f
C516 a_19550_1044# a_21157_1842# 0.05231f
C517 a_20391_1008# a_20397_1842# 0.02349f
C518 a_21917_1842# a_19550_1044# 0.02479f
C519 a_9757_1842# a_9953_1842# 0.76914f
C520 DELAY_VBIASP a_4437_1842# 0.0414f
C521 VDD DELAY_VBIASN 0.9333f
C522 a_14888_1044# a_14964_1008# 0.01176f
C523 DELAY_IN a_4003_1842# 0.54998f
C524 a_22590_1044# a_23431_1008# 0.28268f
C525 a_4111_2470# a_4003_1842# 0.01697f
C526 VDD a_6391_2470# 0.01806f
C527 a_20071_1842# a_19963_1842# 0.01163f
C528 VDD a_27124_1008# 0.28225f
C529 a_10328_1044# a_10404_1008# 0.01176f
C530 DELAY_VBIASN a_12233_1842# 0.0961f
C531 VDD a_18585_1044# 0.29722f
C532 DELAY_VBIASP a_12363_1842# 0.06627f
C533 MUX_SEL3 MUX_SEL4 0.75489f
C534 a_18877_1842# a_19637_1842# 0.06198f
C535 a_16597_1842# VDD 0.86876f
C536 a_6913_1842# a_6717_1842# 0.76914f
C537 VDD a_17031_2470# 0.01806f
C538 VDD a_8231_1008# 0.28336f
C539 VDD a_19524_1008# 0.28633f
C540 VDD a_3449_331# 0.46596f
C541 MUX_SEL2 MUX_OUT 0.08497f
C542 VDD a_16108_289# 1.22378f
C543 a_18795_1044# a_18871_1008# 0.01194f
C544 VDD a_6711_1008# 0.2822f
C545 a_7673_1842# DELAY_VBIASP 0.11222f
C546 a_7477_1842# DELAY_VBIASN 0.08375f
C547 VDD a_23003_1842# 0.4973f
C548 a_23431_1008# a_23145_1044# 0.01885f
C549 VDD a_13753_1842# 0.49294f
C550 a_8997_1842# a_7390_1044# 0.05231f
C551 a_1256_1044# a_1544_1044# 1.26509f
C552 a_1544_289# MUX_SEL4 0.47529f
C553 a_1256_289# MUX_OUT 0.1134f
C554 MUX_SEL2 a_2297_331# 0.10655f
C555 MUX_SEL0 a_1256_1044# 0.3314f
C556 a_22590_1044# a_24523_1842# 0.01012f
C557 a_12797_1842# a_13123_1842# 0.01427f
C558 VDD a_16923_1842# 0.4973f
C559 a_2019_311# a_4157_1313# 0.01018f
C560 a_16510_1044# a_18004_1008# 0.28279f
C561 a_26395_1044# VDD 0.15389f
C562 a_17275_1044# a_17351_1008# 0.01194f
C563 a_14964_1008# a_15077_1842# 0.02055f
C564 a_18871_1008# a_18585_1044# 0.01885f
C565 a_14643_1842# a_14317_1842# 0.01427f
C566 a_1256_289# a_2297_331# 0.04261f
C567 a_1544_289# a_1721_331# 0.36963f
C568 VDD a_10083_1842# 0.49727f
C569 a_4350_1044# a_4905_1044# 0.03209f
C570 a_11785_519# MUX_SEL4 0.03255f
C571 a_21917_1842# a_22243_1842# 0.01427f
C572 a_5393_1842# VDD 0.49417f
C573 a_5197_1842# DELAY_VBIASP 0.0414f
C574 a_12993_1842# a_13123_1842# 0.70845f
C575 a_5957_1842# a_6425_1044# 0.2079f
C576 a_16163_1842# DELAY_VBIASN 0.07254f
C577 VDD a_10328_1044# 0.17274f
C578 a_16510_1044# a_17065_1044# 0.03209f
C579 a_25283_1842# VDD 0.49737f
C580 a_9675_1044# a_9465_1044# 0.09424f
C581 a_20397_1842# a_20593_1842# 0.76914f
C582 DELAY_VBIASP a_23763_1842# 0.06627f
C583 DELAY_VBIASN a_26803_1842# 0.07254f
C584 DELAY_VBIASP a_27997_1842# 0.04001f
C585 DELAY_VBIASN a_23633_1842# 0.0961f
C586 a_4350_1044# a_4157_1313# 0.04624f
C587 a_21911_1008# a_19550_1044# 0.26208f
C588 DELAY_VBIASN a_14317_1842# 0.09974f
C589 DELAY_VBIASP a_14513_1842# 0.11222f
C590 a_18004_1008# a_18117_1842# 0.02055f
C591 a_5523_1842# a_5631_1842# 0.01163f
C592 VDD a_22873_1842# 0.49294f
C593 a_15964_289# a_16510_1044# 0.05416f
C594 a_19550_1044# a_21625_1044# 0.03208f
C595 a_6717_1842# MUX_SEL4 0.0195f
C596 a_24393_1842# a_24957_1842# 0.0114f
C597 a_16597_1842# a_16163_1842# 0.69698f
C598 VDD a_21591_2470# 0.01806f
C599 a_5197_1842# a_5844_1008# 0.02312f
C600 a_1256_1044# a_2873_1395# 0.28892f
C601 a_19550_1044# a_20391_1008# 0.28268f
C602 DELAY_VBIASN a_17553_1842# 0.0961f
C603 DELAY_VBIASP a_17683_1842# 0.06627f
C604 a_23871_1842# a_23763_1842# 0.01163f
C605 a_15964_289# a_2019_311# 0.02413f
C606 a_12791_1008# a_10430_1044# 0.26208f
C607 a_19073_1842# a_19203_1842# 0.70845f
C608 a_8237_1842# a_8884_1008# 0.02312f
C609 MUX_SEL4 a_9757_1842# 0.01829f
C610 DELAY_IN a_3449_1395# 0.01058f
C611 a_16108_289# a_16851_309# 0.06181f
C612 VDD a_9431_2470# 0.01806f
C613 a_15837_1842# a_15077_1842# 0.02912f
C614 DELAY_VBIASN a_10713_1842# 0.0961f
C615 a_16510_1044# a_17357_1842# 0.08038f
C616 VDD a_20397_1842# 0.86909f
C617 a_23437_1842# a_24197_1842# 0.03319f
C618 a_15273_1842# a_15837_1842# 0.0114f
C619 a_4437_1842# a_4633_1842# 0.73897f
C620 a_11277_1842# a_12037_1842# 0.03319f
C621 a_5957_1842# DELAY_VBIASN 0.09156f
C622 a_6153_1842# DELAY_VBIASP 0.11222f
C623 a_16793_1842# a_17357_1842# 0.0114f
C624 a_13753_1842# a_14317_1842# 0.0114f
C625 a_25283_1842# a_25391_2470# 0.01697f
C626 a_8745_519# a_7390_1044# 0.01756f
C627 a_27705_1044# a_27991_1008# 0.01885f
C628 a_18313_1842# a_18877_1842# 0.0114f
C629 DELAY_VBIASN a_10430_1044# 0.02115f
C630 a_5523_1842# a_5631_2470# 0.01697f
C631 a_22590_1044# a_22677_1842# 0.1088f
C632 a_26043_1842# DELAY_VBIASP 0.06627f
C633 a_25913_1842# DELAY_VBIASN 0.0961f
C634 DELAY_VBIASP a_9193_1842# 0.11222f
C635 a_24951_1008# a_24957_1842# 0.02354f
C636 a_4350_1044# a_6635_1044# 0.39036f
C637 VDD a_4905_1044# 0.30126f
C638 a_26477_1842# a_27048_1044# 0.10863f
C639 a_5115_1044# a_5191_1008# 0.01194f
C640 a_8997_1842# VDD 0.85848f
C641 a_17357_1842# a_18117_1842# 0.03319f
C642 a_26395_1044# a_26471_1008# 0.01194f
C643 VDD a_12037_1842# 0.85848f
C644 VDD a_15831_1008# 0.2816f
C645 VDD a_24008_1044# 0.17499f
C646 a_9751_1008# a_7390_1044# 0.26208f
C647 a_22677_1842# a_23145_1044# 0.19203f
C648 a_6717_1842# a_6283_1842# 0.6972f
C649 DELAY_VBIASP a_21157_1842# 0.04141f
C650 DELAY_VBIASN a_19963_1842# 0.07254f
C651 DELAY_VBIASP a_21917_1842# 0.0414f
C652 VDD a_4157_1313# 0.48935f
C653 DELAY_VBIASN a_20723_1842# 0.07254f
C654 a_12715_1044# VDD 0.15406f
C655 a_12037_1842# a_12233_1842# 0.77122f
C656 a_11271_1008# a_10985_1044# 0.01885f
C657 a_8671_1842# a_8563_1842# 0.01163f
C658 a_7673_1842# a_7803_1842# 0.70845f
C659 a_4350_1044# a_4763_1842# 0.01012f
C660 VDD a_18004_1008# 0.28225f
C661 a_25630_1044# a_26043_1842# 0.01012f
C662 a_5197_1842# a_4633_1842# 0.0114f
C663 a_13470_1044# a_15755_1044# 0.39036f
C664 a_5393_1842# a_5957_1842# 0.0114f
C665 a_26673_1842# a_27237_1842# 0.0114f
C666 a_10404_1008# a_10517_1842# 0.05157f
C667 a_9757_1842# a_9323_1842# 0.6972f
C668 DELAY_IN a_4437_1842# 0.05007f
C669 VDD DELAY_OUT_LAST 0.46312f
C670 a_22590_1044# a_23355_1044# 0.39037f
C671 VDD a_8563_1842# 0.49671f
C672 VDD a_5631_2470# 0.01806f
C673 VDD a_27048_1044# 0.17499f
C674 a_10328_1044# a_10430_1044# 0.37183f
C675 VDD a_17065_1044# 0.30218f
C676 DELAY_VBIASP a_12797_1842# 0.0414f
C677 DELAY_VBIASN a_11603_1842# 0.07254f
C678 a_25717_1842# a_26477_1842# 0.01669f
C679 a_18877_1842# a_19073_1842# 0.76914f
C680 VDD a_16271_2470# 0.01806f
C681 a_14643_1842# DELAY_VBIASN 0.07254f
C682 a_11277_1842# a_10517_1842# 0.01669f
C683 a_16033_1842# VDD 0.49413f
C684 VDD a_19550_1044# 0.89766f
C685 MUX_SEL1 MUX_OUT 0.09357f
C686 MUX_SEL2 MUX_SEL4 0.01978f
C687 VDD a_2873_331# 0.46491f
C688 a_10191_2470# a_10083_1842# 0.01697f
C689 VDD a_15964_289# 0.31312f
C690 a_7043_1842# DELAY_VBIASP 0.06627f
C691 VDD a_6635_1044# 0.15406f
C692 a_13470_1044# a_5731_289# 0.41365f
C693 VDD a_23437_1842# 0.86909f
C694 a_23355_1044# a_23145_1044# 0.09424f
C695 a_6711_1008# a_6425_1044# 0.01885f
C696 DELAY_VBIASP a_12993_1842# 0.11222f
C697 VDD a_13123_1842# 0.49727f
C698 a_8808_1044# a_8884_1008# 0.01176f
C699 a_1256_289# MUX_SEL4 0.65005f
C700 a_1544_289# MUX_SEL3 0.15976f
C701 VDD a_8745_519# 0.29292f
C702 MUX_SEL2 a_1721_331# 0.01315f
C703 a_13470_1044# a_15545_1044# 0.03208f
C704 VDD a_17357_1842# 0.86909f
C705 a_22590_1044# a_24957_1842# 0.02479f
C706 a_12797_1842# a_13557_1842# 0.06198f
C707 a_25604_1008# VDD 0.28633f
C708 a_14025_1044# a_13557_1842# 0.19203f
C709 a_2019_311# MUX_OUT 8.45486f
C710 a_16510_1044# a_17928_1044# 0.38994f
C711 a_16163_1842# a_16271_1842# 0.01163f
C712 a_15403_1842# a_13470_1044# 0.01012f
C713 a_27671_2470# a_27563_1842# 0.01697f
C714 a_18795_1044# a_18585_1044# 0.09424f
C715 a_18551_1842# a_18443_1842# 0.01163f
C716 a_1256_289# a_1721_331# 0.13421f
C717 a_27705_1044# VDD 0.29918f
C718 VDD a_10517_1842# 0.86707f
C719 a_21917_1842# a_22677_1842# 0.06198f
C720 a_13470_1044# a_13557_1842# 0.1088f
C721 a_4763_1842# VDD 0.4973f
C722 a_2019_311# a_2297_331# 0.04011f
C723 a_12993_1842# a_13557_1842# 0.0114f
C724 a_16793_1842# DELAY_VBIASP 0.11222f
C725 a_16597_1842# DELAY_VBIASN 0.08375f
C726 a_17031_1842# a_16923_1842# 0.01163f
C727 VDD a_9751_1008# 0.2822f
C728 a_2019_311# a_5731_289# 1.15781f
C729 a_25717_1842# VDD 0.86707f
C730 a_15837_1842# a_16484_1008# 0.02011f
C731 a_20397_1842# a_19963_1842# 0.6972f
C732 a_4248_1044# a_4157_1313# 0.11672f
C733 a_5731_289# a_7390_1044# 0.41331f
C734 DELAY_VBIASN a_23003_1842# 0.07254f
C735 a_20723_1842# a_20397_1842# 0.01427f
C736 DELAY_VBIASP a_24197_1842# 0.04141f
C737 DELAY_VBIASP a_27433_1842# 0.11222f
C738 DELAY_VBIASN a_13753_1842# 0.0961f
C739 DELAY_VBIASP a_13883_1842# 0.06627f
C740 a_16510_1044# a_18443_1842# 0.01012f
C741 VDD a_22243_1842# 0.49737f
C742 a_19550_1044# a_20105_1044# 0.03209f
C743 a_10430_1044# a_12037_1842# 0.05231f
C744 a_16033_1842# a_16163_1842# 0.70845f
C745 a_16163_1842# a_16271_2470# 0.01697f
C746 VDD a_20831_2470# 0.01806f
C747 a_15765_463# a_2019_311# 0.05969f
C748 a_5197_1842# a_5768_1044# 0.10863f
C749 a_19550_1044# a_20315_1044# 0.39037f
C750 a_18551_2470# a_18443_1842# 0.01697f
C751 DELAY_VBIASP a_18117_1842# 0.04141f
C752 DELAY_VBIASN a_16923_1842# 0.07254f
C753 a_5191_1008# a_5197_1842# 0.02349f
C754 a_19073_1842# a_19637_1842# 0.0114f
C755 a_12715_1044# a_10430_1044# 0.39036f
C756 a_8237_1842# a_8808_1044# 0.10863f
C757 MUX_SEL1 a_2297_1395# 0.01995f
C758 VDD a_8671_2470# 0.01806f
C759 a_15964_289# a_16851_309# 0.16757f
C760 a_15273_1842# a_15077_1842# 0.77122f
C761 DELAY_VBIASN a_10083_1842# 0.07254f
C762 VDD a_19833_1842# 0.49294f
C763 a_4350_1044# a_5731_289# 0.41099f
C764 a_23437_1842# a_23633_1842# 0.76914f
C765 a_4437_1842# a_4003_1842# 0.69698f
C766 a_25630_1044# a_27991_1008# 0.26208f
C767 a_11277_1842# a_11473_1842# 0.76914f
C768 a_24951_1008# a_24665_1044# 0.01885f
C769 a_5393_1842# DELAY_VBIASN 0.0961f
C770 a_5523_1842# DELAY_VBIASP 0.06627f
C771 a_17031_2470# a_16923_1842# 0.01697f
C772 a_6913_1842# a_7043_1842# 0.70845f
C773 a_26043_1842# a_26151_1842# 0.01163f
C774 a_27705_1044# a_27915_1044# 0.09424f
C775 a_11924_1008# a_11277_1842# 0.02312f
C776 a_25283_1842# DELAY_VBIASN 0.07254f
C777 a_26477_1842# DELAY_VBIASP 0.04144f
C778 a_4350_1044# a_5844_1008# 0.28279f
C779 DELAY_VBIASN a_22873_1842# 0.0961f
C780 a_8433_1842# VDD 0.49417f
C781 a_17357_1842# a_17553_1842# 0.76914f
C782 VDD a_11473_1842# 0.49417f
C783 DELAY_VBIASP a_11277_1842# 0.0414f
C784 VDD a_15755_1044# 0.15389f
C785 VDD a_23431_1008# 0.28336f
C786 a_9675_1044# a_7390_1044# 0.39036f
C787 a_6153_1842# a_6283_1842# 0.70845f
C788 DELAY_VBIASN a_20397_1842# 0.09974f
C789 VDD MUX_OUT 0.35871f
C790 DELAY_VBIASP a_20593_1842# 0.11222f
C791 DELAY_VBIASP a_21353_1842# 0.11222f
C792 a_12037_1842# a_11603_1842# 0.6972f
C793 a_10517_1842# a_10713_1842# 0.73897f
C794 a_11924_1008# VDD 0.28225f
C795 a_11195_1044# a_10985_1044# 0.09424f
C796 a_24008_1044# a_24084_1008# 0.01176f
C797 a_7673_1842# a_8237_1842# 0.0114f
C798 a_22873_1842# a_23003_1842# 0.70845f
C799 MUX_SEL4 a_12797_1842# 0.01829f
C800 VDD a_17928_1044# 0.17499f
C801 a_25630_1044# a_26477_1842# 0.08038f
C802 a_13470_1044# a_14964_1008# 0.28279f
C803 VDD a_2297_331# 0.46496f
C804 a_19550_1044# a_19963_1842# 0.01012f
C805 a_10430_1044# a_10517_1842# 0.1088f
C806 a_9193_1842# a_9323_1842# 0.70845f
C807 VDD DELAY_VBIASP 13.3418f
C808 a_13470_1044# MUX_SEL4 0.256f
C809 VDD a_5731_289# 0.6143f
C810 a_22590_1044# a_22564_1008# 0.277f
C811 a_8997_1842# DELAY_VBIASN 0.09156f
C812 a_12715_1044# a_12791_1008# 0.01194f
C813 VDD a_4871_2470# 0.01806f
C814 VDD a_24523_1842# 0.4973f
C815 VDD a_15545_1044# 0.29918f
C816 DELAY_VBIASN a_12037_1842# 0.09156f
C817 DELAY_VBIASP a_12233_1842# 0.11222f
C818 MUX_OUT a_1544_1044# 0.04258f
C819 VDD a_15765_463# 0.35368f
C820 a_25717_1842# a_25913_1842# 0.73897f
C821 VDD a_15511_2470# 0.01806f
C822 a_15403_1842# VDD 0.4973f
C823 VDD a_19448_1044# 0.17274f
C824 MUX_SEL2 MUX_SEL3 3.21891f
C825 MUX_SEL1 MUX_SEL4 0.03574f
C826 VDD a_18443_1842# 0.4973f
C827 DELAY_VBIASN a_4157_1313# 0.01202f
C828 a_7477_1842# DELAY_VBIASP 0.0414f
C829 a_11195_1044# a_11271_1008# 0.01194f
C830 VDD a_5844_1008# 0.28225f
C831 a_22590_1044# a_24665_1044# 0.03208f
C832 a_9431_1842# a_9323_1842# 0.01163f
C833 VDD a_13557_1842# 0.86707f
C834 a_6635_1044# a_6425_1044# 0.09424f
C835 a_7803_1842# a_7390_1044# 0.01012f
C836 a_1256_289# MUX_SEL3 1.41161f
C837 a_22590_1044# a_23945_519# 0.02165f
C838 a_22351_2470# a_22243_1842# 0.01697f
C839 MUX_SEL2 a_1544_289# 0.07405f
C840 a_13470_1044# a_14825_519# 0.02058f
C841 a_2019_311# MUX_SEL4 0.90276f
C842 a_25630_1044# VDD 0.89531f
C843 a_15837_1842# a_13470_1044# 0.02479f
C844 a_24084_1008# a_23437_1842# 0.02312f
C845 a_16510_1044# a_17351_1008# 0.28268f
C846 a_16851_309# MUX_OUT 0.45865f
C847 VDD a_2297_1395# 0.46536f
C848 DELAY_OUT_LAST DELAY_VBIASN 0.04786f
C849 MUX_SEL4 a_7390_1044# 0.34655f
C850 DELAY_IN MUX_SEL1 0.01858f
C851 DELAY_VBIASN a_8563_1842# 0.07254f
C852 a_1256_289# a_1544_289# 1.25711f
C853 a_26185_1044# VDD 0.30409f
C854 VDD a_9953_1842# 0.49426f
C855 a_21911_1008# a_21835_1044# 0.01194f
C856 a_21917_1842# a_22113_1842# 0.76914f
C857 a_20831_2470# a_20723_1842# 0.01697f
C858 a_21835_1044# a_21625_1044# 0.09424f
C859 a_2019_311# a_1721_331# 0.18452f
C860 a_13444_1008# a_13557_1842# 0.05157f
C861 a_16033_1842# DELAY_VBIASN 0.0961f
C862 a_16163_1842# DELAY_VBIASP 0.06627f
C863 VDD a_9675_1044# 0.15406f
C864 DELAY_VBIASN a_19550_1044# 0.02115f
C865 a_20968_1044# a_21044_1008# 0.01176f
C866 a_26911_1842# a_26803_1842# 0.01163f
C867 a_5705_519# a_5731_289# 0.28954f
C868 a_25153_1842# VDD 0.49426f
C869 a_27048_1044# a_27124_1008# 0.01176f
C870 a_19833_1842# a_19963_1842# 0.70845f
C871 a_4350_1044# MUX_SEL4 0.31434f
C872 DELAY_VBIASN a_23437_1842# 0.09974f
C873 DELAY_VBIASP a_23633_1842# 0.11222f
C874 DELAY_VBIASP a_26803_1842# 0.06627f
C875 DELAY_VBIASN a_13123_1842# 0.07254f
C876 a_16597_1842# a_17065_1044# 0.19203f
C877 DELAY_VBIASP a_14317_1842# 0.0414f
C878 a_16510_1044# a_18877_1842# 0.02479f
C879 a_24951_1008# a_22590_1044# 0.26208f
C880 VDD a_22677_1842# 0.86707f
C881 a_24197_1842# a_24957_1842# 0.02912f
C882 VDD a_20071_2470# 0.01806f
C883 a_27997_1842# a_27563_1842# 0.69646f
C884 a_6913_1842# VDD 0.49426f
C885 a_16033_1842# a_16597_1842# 0.0114f
C886 a_1544_1044# a_2297_1395# 0.28651f
C887 a_14513_1842# a_15077_1842# 0.0114f
C888 a_12471_2470# a_12363_1842# 0.01697f
C889 a_19550_1044# a_19524_1008# 0.277f
C890 DELAY_VBIASN a_17357_1842# 0.09974f
C891 DELAY_VBIASP a_17553_1842# 0.11222f
C892 a_16108_289# a_19550_1044# 0.58202f
C893 a_11924_1008# a_10430_1044# 0.28279f
C894 MUX_SEL0 a_2297_1395# 0.10655f
C895 a_15964_289# a_16108_289# 0.42202f
C896 VDD a_7911_2470# 0.01806f
C897 VDD a_19203_1842# 0.49737f
C898 DELAY_VBIASN a_10517_1842# 0.08375f
C899 DELAY_VBIASP a_10713_1842# 0.11222f
C900 a_6635_1044# a_6711_1008# 0.01194f
C901 a_23437_1842# a_23003_1842# 0.6972f
C902 a_25630_1044# a_27915_1044# 0.39036f
C903 a_11277_1842# a_10843_1842# 0.6972f
C904 VDD a_4633_1842# 0.49285f
C905 a_24875_1044# a_24665_1044# 0.09424f
C906 a_5957_1842# DELAY_VBIASP 0.04141f
C907 a_4763_1842# DELAY_VBIASN 0.07254f
C908 a_16597_1842# a_17357_1842# 0.01669f
C909 a_10951_2470# a_10843_1842# 0.01697f
C910 a_6913_1842# a_7477_1842# 0.0114f
C911 a_13557_1842# a_14317_1842# 0.01669f
C912 VDD a_12505_1044# 0.29722f
C913 a_18117_1842# a_18877_1842# 0.02912f
C914 a_6717_1842# a_7364_1008# 0.02011f
C915 a_22564_1008# a_21917_1842# 0.02011f
C916 a_11848_1044# a_11277_1842# 0.10863f
C917 a_5731_289# a_10430_1044# 0.41176f
C918 a_25717_1842# DELAY_VBIASN 0.08411f
C919 a_25913_1842# DELAY_VBIASP 0.11222f
C920 a_7043_1842# a_7151_2470# 0.01697f
C921 a_27237_1842# a_27433_1842# 0.77122f
C922 a_4350_1044# a_5768_1044# 0.38994f
C923 a_7390_1044# a_9323_1842# 0.01012f
C924 DELAY_VBIASN a_22243_1842# 0.07254f
C925 a_4350_1044# a_5191_1008# 0.28268f
C926 a_7803_1842# VDD 0.4973f
C927 a_5957_1842# a_5844_1008# 0.02055f
C928 a_17357_1842# a_16923_1842# 0.6972f
C929 a_25630_1044# a_26471_1008# 0.28268f
C930 a_4350_1044# a_6283_1842# 0.01012f
C931 VDD a_14964_1008# 0.28225f
C932 VDD a_10843_1842# 0.4973f
C933 VDD a_23355_1044# 0.15389f
C934 a_8884_1008# a_7390_1044# 0.28279f
C935 a_26471_1008# a_26185_1044# 0.01885f
C936 a_6153_1842# a_6717_1842# 0.0114f
C937 VDD MUX_SEL4 2.63176f
C938 a_21044_1008# a_21157_1842# 0.02055f
C939 DELAY_VBIASP a_19963_1842# 0.06627f
C940 DELAY_VBIASN a_19833_1842# 0.0961f
C941 DELAY_VBIASP a_20723_1842# 0.06627f
C942 a_11473_1842# a_11603_1842# 0.70845f
C943 a_11848_1044# VDD 0.17499f
C944 a_10517_1842# a_10083_1842# 0.69698f
C945 a_24875_1044# a_24951_1008# 0.01194f
C946 a_22873_1842# a_23437_1842# 0.0114f
C947 VDD a_17351_1008# 0.28565f
C948 a_5197_1842# a_4437_1842# 0.01669f
C949 VDD a_1721_331# 0.45259f
C950 a_13470_1044# a_14888_1044# 0.38994f
C951 a_21483_1842# a_21591_1842# 0.01163f
C952 a_26477_1842# a_27237_1842# 0.03319f
C953 a_19550_1044# a_20397_1842# 0.08038f
C954 a_9193_1842# a_9757_1842# 0.0114f
C955 VDD a_21835_1044# 0.15406f
C956 VDD DELAY_IN 1.33375f
C957 VDD a_26985_519# 0.29292f
C958 a_22488_1044# a_22564_1008# 0.01176f
C959 a_8433_1842# DELAY_VBIASN 0.0961f
C960 VDD a_24957_1842# 0.87825f
C961 VDD a_4111_2470# 0.01866f
C962 a_8155_1044# a_7945_1044# 0.09424f
C963 a_8997_1842# a_8563_1842# 0.6972f
C964 DELAY_VBIASP a_11603_1842# 0.06627f
C965 DELAY_VBIASN a_11473_1842# 0.0961f
C966 a_25717_1842# a_25283_1842# 0.69698f
C967 MUX_SEL4 a_1544_1044# 0.03407f
C968 MUX_OUT a_1256_1044# 0.02466f
C969 VDD a_14825_519# 0.29292f
C970 VDD a_14751_2470# 0.01806f
C971 a_14643_1842# DELAY_VBIASP 0.06627f
C972 a_15837_1842# VDD 0.87963f
C973 VDD a_18877_1842# 0.87825f
C974 VDD a_5768_1044# 0.17499f
C975 a_22590_1044# a_23145_1044# 0.03209f
C976 a_4324_1008# a_4437_1842# 0.05157f
C977 a_8237_1842# a_7390_1044# 0.08038f
C978 a_5191_1008# VDD 0.28565f
C979 a_13470_1044# a_15077_1842# 0.05231f
C980 a_6283_1842# VDD 0.4973f
C981 MUX_SEL2 a_1256_289# 0.33134f
C982 a_5705_519# MUX_SEL4 0.03556f
C983 a_24008_1044# a_23437_1842# 0.10863f
C984 a_2019_311# MUX_SEL3 0.06209f
C985 a_14964_1008# a_14317_1842# 0.02312f
C986 a_25528_1044# VDD 0.17274f
C987 a_16108_289# MUX_OUT 0.24265f
C988 a_16510_1044# a_17275_1044# 0.39037f
C989 DELAY_VBIASP DELAY_VBIASN 3.50557f
C990 DELAY_IN MUX_SEL0 0.14089f
C991 a_27237_1842# VDD 0.85969f
C992 VDD a_9323_1842# 0.4973f
C993 a_10430_1044# a_12505_1044# 0.03208f
C994 DELAY_VBIASN a_24523_1842# 0.07254f
C995 a_13991_1842# a_13883_1842# 0.01163f
C996 a_21917_1842# a_21483_1842# 0.6972f
C997 a_20071_2470# a_19963_1842# 0.01697f
C998 a_18871_1008# a_18877_1842# 0.02354f
C999 a_2019_311# a_1544_289# 0.01747f
C1000 a_16597_1842# DELAY_VBIASP 0.0414f
C1001 a_10843_1842# a_10713_1842# 0.70845f
C1002 a_15403_1842# DELAY_VBIASN 0.07254f
C1003 a_7043_1842# a_6717_1842# 0.01427f
C1004 a_24197_1842# a_24665_1044# 0.2079f
C1005 VDD a_8884_1008# 0.28225f
C1006 DELAY_VBIASN a_18443_1842# 0.07254f
C1007 a_19833_1842# a_20397_1842# 0.0114f
C1008 MUX_SEL1 a_3449_1395# 0.29404f
C1009 a_16108_289# a_5731_289# 0.01334f
C1010 DELAY_VBIASP a_23003_1842# 0.06627f
C1011 DELAY_VBIASN a_13557_1842# 0.08375f
C1012 DELAY_VBIASP a_13753_1842# 0.11222f
C1013 a_24875_1044# a_22590_1044# 0.39036f
C1014 a_18004_1008# a_17357_1842# 0.02312f
C1015 a_7390_1044# a_8155_1044# 0.39037f
C1016 a_10430_1044# a_10843_1842# 0.01012f
C1017 VDD a_22113_1842# 0.49426f
C1018 a_24197_1842# a_24393_1842# 0.77122f
C1019 VDD a_19311_2470# 0.01806f
C1020 a_15837_1842# a_16163_1842# 0.01427f
C1021 a_27433_1842# a_27563_1842# 0.70845f
C1022 a_1256_1044# a_2297_1395# 0.04619f
C1023 a_16108_289# a_15765_463# 0.42004f
C1024 a_10430_1044# MUX_SEL4 0.24983f
C1025 a_19448_1044# a_19524_1008# 0.01176f
C1026 DELAY_VBIASP a_16923_1842# 0.06627f
C1027 a_25630_1044# DELAY_VBIASN 0.02756f
C1028 a_11848_1044# a_10430_1044# 0.38994f
C1029 a_13991_2470# a_13883_1842# 0.01697f
C1030 a_11711_1842# a_11603_1842# 0.01163f
C1031 VDD a_7151_2470# 0.01806f
C1032 VDD a_19637_1842# 0.86707f
C1033 DELAY_VBIASP a_10083_1842# 0.06627f
C1034 DELAY_VBIASN a_9953_1842# 0.0961f
C1035 a_25630_1044# a_27124_1008# 0.28279f
C1036 VDD a_4003_1842# 0.61559f
C1037 a_5393_1842# DELAY_VBIASP 0.11222f
C1038 a_7803_1842# a_7911_1842# 0.01163f
C1039 VDD a_10985_1044# 0.30409f
C1040 a_13557_1842# a_13753_1842# 0.73897f
C1041 a_18117_1842# a_18313_1842# 0.77122f
C1042 a_25630_1044# a_16108_289# 0.52614f
C1043 a_11271_1008# a_11277_1842# 0.02349f
C1044 a_25283_1842# DELAY_VBIASP 0.06627f
C1045 a_25153_1842# DELAY_VBIASN 0.0961f
C1046 a_27237_1842# a_26803_1842# 0.6972f
C1047 a_7390_1044# a_9757_1842# 0.02479f
C1048 DELAY_VBIASN a_22677_1842# 0.08375f
C1049 DELAY_VBIASP a_22873_1842# 0.11222f
C1050 a_8237_1842# VDD 0.86909f
C1051 a_4350_1044# a_5115_1044# 0.39037f
C1052 a_6913_1842# DELAY_VBIASN 0.0961f
C1053 a_12797_1842# a_12363_1842# 0.6972f
C1054 a_12791_1008# a_12505_1044# 0.01885f
C1055 a_25630_1044# a_26395_1044# 0.39037f
C1056 a_8433_1842# a_8997_1842# 0.0114f
C1057 VDD a_14888_1044# 0.17499f
C1058 a_4350_1044# a_6717_1842# 0.02479f
C1059 a_23871_2470# a_23763_1842# 0.01697f
C1060 VDD a_22564_1008# 0.28633f
C1061 a_8808_1044# a_7390_1044# 0.38994f
C1062 a_26395_1044# a_26185_1044# 0.09424f
C1063 VDD a_27671_2470# 0.01806f
C1064 VDD MUX_SEL3 0.4053f
C1065 DELAY_VBIASN a_19203_1842# 0.07254f
C1066 DELAY_VBIASP a_20397_1842# 0.0414f
C1067 a_8671_2470# a_8563_1842# 0.01697f
C1068 a_11271_1008# VDD 0.28336f
C1069 a_11473_1842# a_12037_1842# 0.0114f
C1070 DELAY_VBIASN a_4633_1842# 0.0961f
C1071 a_15755_1044# a_15831_1008# 0.01194f
C1072 a_14311_1008# a_14025_1044# 0.01885f
C1073 a_9953_1842# a_10083_1842# 0.70845f
C1074 a_7477_1842# a_8237_1842# 0.01669f
C1075 a_19637_1842# a_20105_1044# 0.19203f
C1076 a_25604_1008# a_25717_1842# 0.05157f
C1077 VDD a_17275_1044# 0.15389f
C1078 VDD a_1544_289# 0.39113f
C1079 a_13470_1044# a_14311_1008# 0.28268f
C1080 a_11924_1008# a_12037_1842# 0.02055f
C1081 VDD a_24665_1044# 0.29722f
C1082 a_26477_1842# a_26673_1842# 0.76914f
C1083 a_10404_1008# a_9757_1842# 0.02011f
C1084 a_14643_1842# a_14751_1842# 0.01163f
C1085 a_14235_1044# a_14311_1008# 0.01194f
C1086 VDD a_21044_1008# 0.28225f
C1087 a_22488_1044# a_22590_1044# 0.37183f
C1088 VDD a_23945_519# 0.29292f
C1089 a_8997_1842# DELAY_VBIASP 0.04141f
C1090 a_7803_1842# DELAY_VBIASN 0.07254f
C1091 VDD a_8155_1044# 0.15389f
C1092 VDD a_24393_1842# 0.49285f
C1093 VDD a_27563_1842# 0.49811f
C1094 a_19311_1842# a_19203_1842# 0.01163f
C1095 VDD a_15077_1842# 0.85963f
C1096 a_7390_1044# a_9465_1044# 0.03208f
C1097 a_8433_1842# a_8563_1842# 0.70845f
C1098 DELAY_VBIASN a_10843_1842# 0.07254f
C1099 DELAY_VBIASP a_12037_1842# 0.04141f
C1100 a_25153_1842# a_25283_1842# 0.70845f
C1101 MUX_SEL4 a_1256_1044# 0.04908f
C1102 VDD a_11785_519# 0.29292f
C1103 a_15273_1842# VDD 0.49285f
C1104 VDD a_13991_2470# 0.01806f
R0 DELAY_VBIASN.n1 DELAY_VBIASN.t31 34.3755
R1 DELAY_VBIASN.n1 DELAY_VBIASN.t30 33.0005
R2 DELAY_VBIASN.n2 DELAY_VBIASN.t29 33.0005
R3 DELAY_VBIASN.n3 DELAY_VBIASN.t28 33.0005
R4 DELAY_VBIASN.n4 DELAY_VBIASN.t27 33.0005
R5 DELAY_VBIASN.n5 DELAY_VBIASN.t26 33.0005
R6 DELAY_VBIASN.n6 DELAY_VBIASN.t25 33.0005
R7 DELAY_VBIASN.n7 DELAY_VBIASN.t24 33.0005
R8 DELAY_VBIASN.n8 DELAY_VBIASN.t23 33.0005
R9 DELAY_VBIASN.n9 DELAY_VBIASN.t22 33.0005
R10 DELAY_VBIASN.n10 DELAY_VBIASN.t21 33.0005
R11 DELAY_VBIASN.n11 DELAY_VBIASN.t20 33.0005
R12 DELAY_VBIASN.n12 DELAY_VBIASN.t19 33.0005
R13 DELAY_VBIASN.n13 DELAY_VBIASN.t18 33.0005
R14 DELAY_VBIASN.n14 DELAY_VBIASN.t17 33.0005
R15 DELAY_VBIASN.n15 DELAY_VBIASN.t16 33.0005
R16 DELAY_VBIASN.n16 DELAY_VBIASN.t15 33.0005
R17 DELAY_VBIASN.n17 DELAY_VBIASN.t14 33.0005
R18 DELAY_VBIASN.n18 DELAY_VBIASN.t13 33.0005
R19 DELAY_VBIASN.n19 DELAY_VBIASN.t12 33.0005
R20 DELAY_VBIASN.n20 DELAY_VBIASN.t11 33.0005
R21 DELAY_VBIASN.n21 DELAY_VBIASN.t10 33.0005
R22 DELAY_VBIASN.n22 DELAY_VBIASN.t9 33.0005
R23 DELAY_VBIASN.n23 DELAY_VBIASN.t8 33.0005
R24 DELAY_VBIASN.n24 DELAY_VBIASN.t7 33.0005
R25 DELAY_VBIASN.n25 DELAY_VBIASN.t6 33.0005
R26 DELAY_VBIASN.n26 DELAY_VBIASN.t5 33.0005
R27 DELAY_VBIASN.n27 DELAY_VBIASN.t4 33.0005
R28 DELAY_VBIASN.n28 DELAY_VBIASN.t3 33.0005
R29 DELAY_VBIASN.n29 DELAY_VBIASN.t2 33.0005
R30 DELAY_VBIASN.n30 DELAY_VBIASN.t1 33.0005
R31 DELAY_VBIASN.n0 DELAY_VBIASN.t0 33.0005
R32 DELAY_VBIASN DELAY_VBIASN.n0 1.55517
R33 DELAY_VBIASN.n0 DELAY_VBIASN.n30 1.3755
R34 DELAY_VBIASN.n30 DELAY_VBIASN.n29 1.3755
R35 DELAY_VBIASN.n29 DELAY_VBIASN.n28 1.3755
R36 DELAY_VBIASN.n28 DELAY_VBIASN.n27 1.3755
R37 DELAY_VBIASN.n27 DELAY_VBIASN.n26 1.3755
R38 DELAY_VBIASN.n26 DELAY_VBIASN.n25 1.3755
R39 DELAY_VBIASN.n25 DELAY_VBIASN.n24 1.3755
R40 DELAY_VBIASN.n24 DELAY_VBIASN.n23 1.3755
R41 DELAY_VBIASN.n23 DELAY_VBIASN.n22 1.3755
R42 DELAY_VBIASN.n22 DELAY_VBIASN.n21 1.3755
R43 DELAY_VBIASN.n21 DELAY_VBIASN.n20 1.3755
R44 DELAY_VBIASN.n20 DELAY_VBIASN.n19 1.3755
R45 DELAY_VBIASN.n19 DELAY_VBIASN.n18 1.3755
R46 DELAY_VBIASN.n18 DELAY_VBIASN.n17 1.3755
R47 DELAY_VBIASN.n17 DELAY_VBIASN.n16 1.3755
R48 DELAY_VBIASN.n16 DELAY_VBIASN.n15 1.3755
R49 DELAY_VBIASN.n15 DELAY_VBIASN.n14 1.3755
R50 DELAY_VBIASN.n14 DELAY_VBIASN.n13 1.3755
R51 DELAY_VBIASN.n13 DELAY_VBIASN.n12 1.3755
R52 DELAY_VBIASN.n12 DELAY_VBIASN.n11 1.3755
R53 DELAY_VBIASN.n11 DELAY_VBIASN.n10 1.3755
R54 DELAY_VBIASN.n10 DELAY_VBIASN.n9 1.3755
R55 DELAY_VBIASN.n9 DELAY_VBIASN.n8 1.3755
R56 DELAY_VBIASN.n8 DELAY_VBIASN.n7 1.3755
R57 DELAY_VBIASN.n7 DELAY_VBIASN.n6 1.3755
R58 DELAY_VBIASN.n6 DELAY_VBIASN.n5 1.3755
R59 DELAY_VBIASN.n5 DELAY_VBIASN.n4 1.3755
R60 DELAY_VBIASN.n4 DELAY_VBIASN.n3 1.3755
R61 DELAY_VBIASN.n3 DELAY_VBIASN.n2 1.3755
R62 DELAY_VBIASN.n2 DELAY_VBIASN.n1 1.3755
R63 DELAY_VBIASP.n1 DELAY_VBIASP.t31 34.3685
R64 DELAY_VBIASP.n1 DELAY_VBIASP.t30 33.0005
R65 DELAY_VBIASP.n2 DELAY_VBIASP.t29 33.0005
R66 DELAY_VBIASP.n3 DELAY_VBIASP.t28 33.0005
R67 DELAY_VBIASP.n4 DELAY_VBIASP.t27 33.0005
R68 DELAY_VBIASP.n5 DELAY_VBIASP.t26 33.0005
R69 DELAY_VBIASP.n6 DELAY_VBIASP.t25 33.0005
R70 DELAY_VBIASP.n7 DELAY_VBIASP.t24 33.0005
R71 DELAY_VBIASP.n8 DELAY_VBIASP.t23 33.0005
R72 DELAY_VBIASP.n9 DELAY_VBIASP.t22 33.0005
R73 DELAY_VBIASP.n10 DELAY_VBIASP.t21 33.0005
R74 DELAY_VBIASP.n11 DELAY_VBIASP.t20 33.0005
R75 DELAY_VBIASP.n12 DELAY_VBIASP.t19 33.0005
R76 DELAY_VBIASP.n13 DELAY_VBIASP.t18 33.0005
R77 DELAY_VBIASP.n14 DELAY_VBIASP.t17 33.0005
R78 DELAY_VBIASP.n15 DELAY_VBIASP.t16 33.0005
R79 DELAY_VBIASP.n16 DELAY_VBIASP.t15 33.0005
R80 DELAY_VBIASP.n17 DELAY_VBIASP.t14 33.0005
R81 DELAY_VBIASP.n18 DELAY_VBIASP.t13 33.0005
R82 DELAY_VBIASP.n19 DELAY_VBIASP.t12 33.0005
R83 DELAY_VBIASP.n20 DELAY_VBIASP.t11 33.0005
R84 DELAY_VBIASP.n21 DELAY_VBIASP.t10 33.0005
R85 DELAY_VBIASP.n22 DELAY_VBIASP.t9 33.0005
R86 DELAY_VBIASP.n23 DELAY_VBIASP.t8 33.0005
R87 DELAY_VBIASP.n24 DELAY_VBIASP.t7 33.0005
R88 DELAY_VBIASP.n25 DELAY_VBIASP.t6 33.0005
R89 DELAY_VBIASP.n26 DELAY_VBIASP.t5 33.0005
R90 DELAY_VBIASP.n27 DELAY_VBIASP.t4 33.0005
R91 DELAY_VBIASP.n28 DELAY_VBIASP.t3 33.0005
R92 DELAY_VBIASP.n29 DELAY_VBIASP.t2 33.0005
R93 DELAY_VBIASP.n30 DELAY_VBIASP.t1 33.0005
R94 DELAY_VBIASP.n0 DELAY_VBIASP.t0 33.0005
R95 DELAY_VBIASP DELAY_VBIASP.n0 1.70586
R96 DELAY_VBIASP.n0 DELAY_VBIASP.n30 1.36852
R97 DELAY_VBIASP.n30 DELAY_VBIASP.n29 1.36852
R98 DELAY_VBIASP.n29 DELAY_VBIASP.n28 1.36852
R99 DELAY_VBIASP.n28 DELAY_VBIASP.n27 1.36852
R100 DELAY_VBIASP.n27 DELAY_VBIASP.n26 1.36852
R101 DELAY_VBIASP.n26 DELAY_VBIASP.n25 1.36852
R102 DELAY_VBIASP.n25 DELAY_VBIASP.n24 1.36852
R103 DELAY_VBIASP.n24 DELAY_VBIASP.n23 1.36852
R104 DELAY_VBIASP.n23 DELAY_VBIASP.n22 1.36852
R105 DELAY_VBIASP.n22 DELAY_VBIASP.n21 1.36852
R106 DELAY_VBIASP.n21 DELAY_VBIASP.n20 1.36852
R107 DELAY_VBIASP.n20 DELAY_VBIASP.n19 1.36852
R108 DELAY_VBIASP.n19 DELAY_VBIASP.n18 1.36852
R109 DELAY_VBIASP.n18 DELAY_VBIASP.n17 1.36852
R110 DELAY_VBIASP.n17 DELAY_VBIASP.n16 1.36852
R111 DELAY_VBIASP.n16 DELAY_VBIASP.n15 1.36852
R112 DELAY_VBIASP.n15 DELAY_VBIASP.n14 1.36852
R113 DELAY_VBIASP.n14 DELAY_VBIASP.n13 1.36852
R114 DELAY_VBIASP.n13 DELAY_VBIASP.n12 1.36852
R115 DELAY_VBIASP.n12 DELAY_VBIASP.n11 1.36852
R116 DELAY_VBIASP.n11 DELAY_VBIASP.n10 1.36852
R117 DELAY_VBIASP.n10 DELAY_VBIASP.n9 1.36852
R118 DELAY_VBIASP.n9 DELAY_VBIASP.n8 1.36852
R119 DELAY_VBIASP.n8 DELAY_VBIASP.n7 1.36852
R120 DELAY_VBIASP.n7 DELAY_VBIASP.n6 1.36852
R121 DELAY_VBIASP.n6 DELAY_VBIASP.n5 1.36852
R122 DELAY_VBIASP.n5 DELAY_VBIASP.n4 1.36852
R123 DELAY_VBIASP.n4 DELAY_VBIASP.n3 1.36852
R124 DELAY_VBIASP.n3 DELAY_VBIASP.n2 1.36852
R125 DELAY_VBIASP.n2 DELAY_VBIASP.n1 1.36852
R126 VSS.n35 VSS.n372 7907.02
R127 VSS.n39 VSS.n34 469.783
R128 VSS.n8 VSS.n14 0.00322223
R129 VSS.n17 VSS.n8 0.0027768
R130 VSS.t274 VSS.n18 101.74
R131 VSS.n8 VSS.t291 58.3191
R132 VSS.t304 VSS.n16 101.742
R133 VSS.t319 VSS.n41 321.57
R134 VSS.n13 VSS.n8 0.00596637
R135 VSS.n29 VSS.n7 0.00596634
R136 VSS.n8 VSS.t505 21.1052
R137 VSS.t4 VSS.n3 442.469
R138 VSS.n8 VSS.n47 0.547872
R139 VSS.n33 VSS.t326 413.695
R140 VSS.t311 VSS.n19 49.8619
R141 VSS.t296 VSS.n43 413.695
R142 VSS.t281 VSS.n21 49.8619
R143 VSS.t266 VSS.n22 49.8619
R144 VSS.t251 VSS.n45 413.695
R145 VSS.n426 VSS.t549 403.072
R146 VSS.t44 VSS.n12 21.009
R147 VSS.n25 VSS.t156 59.6836
R148 VSS.t373 VSS.n424 357.007
R149 VSS.t371 VSS.n26 343.118
R150 VSS.n28 VSS.t546 97.2225
R151 VSS.n45 VSS.t254 97.2238
R152 VSS.n22 VSS.t269 97.2306
R153 VSS.n43 VSS.t299 97.2238
R154 VSS.n8 VSS.t244 101.74
R155 VSS.n8 VSS.n10 0.00192738
R156 VSS.n425 VSS.t2 299.425
R157 VSS.t241 VSS.n8 105.686
R158 VSS.t256 VSS.n42 310.053
R159 VSS.n18 VSS.n8 0.00251295
R160 VSS.t286 VSS.n10 105.688
R161 VSS.t301 VSS.n7 105.686
R162 VSS.t316 VSS.n7 310.053
R163 VSS.t165 VSS.n32 116.469
R164 VSS.t138 VSS.n30 110.547
R165 VSS.t117 VSS.n29 110.547
R166 VSS.t177 VSS.n31 110.547
R167 VSS.n44 VSS.t89 116.469
R168 VSS.t79 VSS.n20 110.547
R169 VSS.t72 VSS.n46 110.543
R170 VSS.t174 VSS.n13 110.547
R171 VSS.n425 VSS.t159 287.909
R172 VSS.n8 VSS.t344 114.148
R173 VSS.t557 VSS.n3 269.724
R174 VSS.n11 VSS.t40 332.017
R175 VSS.t91 VSS.n36 332.017
R176 VSS.n20 VSS.n8 0.00596634
R177 VSS.t73 VSS.n42 258.235
R178 VSS.n31 VSS.n8 0.00596635
R179 VSS.n30 VSS.n7 0.00596633
R180 VSS.t561 VSS.n23 107.335
R181 VSS.n217 VSS.t499 252.375
R182 VSS.t489 VSS.n296 252.375
R183 VSS.t214 VSS.n306 252.375
R184 VSS.n335 VSS.t559 252.375
R185 VSS.t342 VSS.n344 252.375
R186 VSS.n871 VSS.t343 252.375
R187 VSS.n849 VSS.t101 252.375
R188 VSS.n227 VSS.t488 252.375
R189 VSS.t187 VSS.n237 252.375
R190 VSS.t391 VSS.n247 252.375
R191 VSS.n256 VSS.t402 252.375
R192 VSS.n736 VSS.t191 252.375
R193 VSS.t206 VSS.n276 252.375
R194 VSS.t350 VSS.n286 252.375
R195 VSS.n641 VSS.t386 252.375
R196 VSS.n621 VSS.t182 252.375
R197 VSS.n566 VSS.t102 252.375
R198 VSS.t542 VSS.n293 252.117
R199 VSS.t397 VSS.n331 252.117
R200 VSS.n839 VSS.t341 252.115
R201 VSS.t389 VSS.n86 252.115
R202 VSS.n802 VSS.t370 252.115
R203 VSS.t487 VSS.n92 252.115
R204 VSS.t190 VSS.n96 252.115
R205 VSS.n747 VSS.t207 252.115
R206 VSS.n727 VSS.t201 252.115
R207 VSS.t468 VSS.n107 252.115
R208 VSS.t553 VSS.n113 252.115
R209 VSS.t385 VSS.n116 252.115
R210 VSS.t401 VSS.n120 252.115
R211 VSS.t472 VSS.n126 252.115
R212 VSS.t200 VSS.n130 252.115
R213 VSS.t416 VSS.n207 250.837
R214 VSS.t428 VSS.n209 250.837
R215 VSS.t410 VSS.n215 250.837
R216 VSS.t430 VSS.n219 250.837
R217 VSS.t432 VSS.n226 250.837
R218 VSS.t408 VSS.n229 250.837
R219 VSS.t436 VSS.n235 250.837
R220 VSS.t438 VSS.n239 250.837
R221 VSS.t434 VSS.n245 250.837
R222 VSS.t440 VSS.n249 250.837
R223 VSS.t442 VSS.n255 250.837
R224 VSS.t426 VSS.n258 250.837
R225 VSS.t404 VSS.n264 250.837
R226 VSS.t444 VSS.n268 250.837
R227 VSS.t424 VSS.n275 250.837
R228 VSS.t448 VSS.n279 250.837
R229 VSS.t450 VSS.n285 250.837
R230 VSS.t446 VSS.n288 250.837
R231 VSS.t418 VSS.n295 250.837
R232 VSS.t452 VSS.n299 250.837
R233 VSS.t422 VSS.n305 250.837
R234 VSS.t456 VSS.n308 250.837
R235 VSS.t454 VSS.n314 250.837
R236 VSS.t420 VSS.n317 250.837
R237 VSS.t462 VSS.n323 250.837
R238 VSS.t412 VSS.n326 250.837
R239 VSS.t460 VSS.n333 250.837
R240 VSS.t464 VSS.n337 250.837
R241 VSS.t406 VSS.n343 250.837
R242 VSS.t466 VSS.n347 250.837
R243 VSS.t414 VSS.n353 250.837
R244 VSS.t458 VSS.n355 250.837
R245 VSS.n8 VSS.n27 0.315147
R246 VSS.n0 VSS.t264 117.529
R247 VSS.n38 VSS.t324 240.956
R248 VSS.n840 VSS.t75 234.114
R249 VSS.n821 VSS.t394 234.114
R250 VSS.n803 VSS.t337 234.114
R251 VSS.n783 VSS.t204 234.114
R252 VSS.n765 VSS.t173 234.114
R253 VSS.n748 VSS.t346 234.114
R254 VSS.n728 VSS.t543 234.114
R255 VSS.n710 VSS.t63 234.114
R256 VSS.n691 VSS.t485 234.114
R257 VSS.n672 VSS.t513 234.114
R258 VSS.n652 VSS.t522 234.114
R259 VSS.n633 VSS.t210 234.114
R260 VSS.n613 VSS.t103 234.114
R261 VSS.n595 VSS.t222 234.114
R262 VSS.n577 VSS.t197 234.114
R263 VSS.n557 VSS.t558 234.114
R264 VSS.t154 VSS.n424 230.327
R265 VSS.t249 VSS.n1 229.441
R266 VSS.t279 VSS.n8 117.529
R267 VSS.t294 VSS.n9 117.526
R268 VSS.t324 VSS.n39 229.44
R269 VSS.t554 VSS.n27 117.216
R270 VSS.t395 VSS.n225 225.361
R271 VSS.t544 VSS.n274 225.361
R272 VSS.t235 VSS.n80 225.359
R273 VSS.n838 VSS.t77 225.359
R274 VSS.n801 VSS.t339 225.359
R275 VSS.t202 VSS.n93 225.359
R276 VSS.t171 VSS.n97 225.359
R277 VSS.n746 VSS.t348 225.359
R278 VSS.n709 VSS.t61 225.359
R279 VSS.n690 VSS.t483 225.359
R280 VSS.n671 VSS.t511 225.359
R281 VSS.t520 VSS.n117 225.359
R282 VSS.n632 VSS.t208 225.359
R283 VSS.n612 VSS.t105 225.359
R284 VSS.n594 VSS.t220 225.359
R285 VSS.t198 VSS.n131 225.359
R286 VSS.t230 VSS.n98 211.982
R287 VSS.t10 VSS.n104 211.982
R288 VSS.t524 VSS.n108 211.982
R289 VSS.t135 VSS.n127 211.982
R290 VSS.n853 VSS.t98 211.982
R291 VSS.n814 VSS.t114 211.982
R292 VSS.n683 VSS.t530 211.982
R293 VSS.n664 VSS.t34 211.982
R294 VSS.n645 VSS.t16 211.982
R295 VSS.n625 VSS.t31 211.982
R296 VSS.n570 VSS.t129 211.982
R297 VSS.n216 VSS.t126 211.982
R298 VSS.n236 VSS.t533 211.982
R299 VSS.n246 VSS.t37 211.982
R300 VSS.n265 VSS.t28 211.982
R301 VSS.n334 VSS.t13 211.982
R302 VSS.n25 VSS.t154 221.012
R303 VSS.n26 VSS.t556 107.931
R304 VSS.t560 VSS.n23 398.622
R305 VSS.t49 VSS.n267 195.26
R306 VSS.t473 VSS.n278 195.26
R307 VSS.t331 VSS.n298 195.26
R308 VSS.t490 VSS.n316 195.26
R309 VSS.t162 VSS.n325 195.26
R310 VSS.t495 VSS.n346 195.26
R311 VSS.n848 VSS.t551 195.26
R312 VSS.t479 VSS.n84 195.26
R313 VSS.t469 VSS.n88 195.26
R314 VSS.n791 VSS.t380 195.26
R315 VSS.n773 VSS.t508 195.26
R316 VSS.t212 VSS.n100 195.26
R317 VSS.n699 VSS.t6 195.26
R318 VSS.n660 VSS.t195 195.26
R319 VSS.t366 VSS.n124 195.26
R320 VSS.n565 VSS.t493 195.26
R321 VSS.t93 VSS.n36 106.362
R322 VSS.n11 VSS.t42 106.362
R323 VSS.n846 VSS.t0 187.292
R324 VSS.n827 VSS.t237 187.292
R325 VSS.n809 VSS.t239 187.292
R326 VSS.n789 VSS.t148 187.292
R327 VSS.n771 VSS.t537 187.292
R328 VSS.n754 VSS.t82 187.292
R329 VSS.n734 VSS.t536 187.292
R330 VSS.n716 VSS.t111 187.292
R331 VSS.n697 VSS.t113 187.292
R332 VSS.n678 VSS.t152 187.292
R333 VSS.n658 VSS.t540 187.292
R334 VSS.n639 VSS.t150 187.292
R335 VSS.n619 VSS.t539 187.292
R336 VSS.n601 VSS.t538 187.292
R337 VSS.n583 VSS.t218 187.292
R338 VSS.n563 VSS.t188 187.292
R339 VSS.n426 VSS.t557 184.262
R340 VSS.n8 VSS.n46 0.00954671
R341 VSS.n44 VSS.t88 110.546
R342 VSS.t164 VSS.n32 110.546
R343 VSS.t96 VSS.n213 173.913
R344 VSS.n223 VSS.t228 173.913
R345 VSS.t55 VSS.n233 173.913
R346 VSS.n243 VSS.t133 173.913
R347 VSS.n253 VSS.t335 173.913
R348 VSS.t518 VSS.n262 173.913
R349 VSS.t23 VSS.n272 173.913
R350 VSS.n283 VSS.t216 173.913
R351 VSS.t52 VSS.n292 173.913
R352 VSS.n303 VSS.t124 173.913
R353 VSS.n312 VSS.t121 173.913
R354 VSS.n321 VSS.t528 173.913
R355 VSS.t26 VSS.n330 173.913
R356 VSS.n341 VSS.t225 173.913
R357 VSS.n351 VSS.t20 173.913
R358 VSS.t515 VSS.n359 173.913
R359 VSS.n372 VSS.n363 173.913
R360 VSS.t99 VSS.t552 163.881
R361 VSS.t127 VSS.t480 163.881
R362 VSS.t115 VSS.t470 163.881
R363 VSS.t534 VSS.t381 163.881
R364 VSS.t38 VSS.t507 163.881
R365 VSS.t231 VSS.t213 163.881
R366 VSS.t29 VSS.t47 163.881
R367 VSS.t11 VSS.t474 163.881
R368 VSS.t525 VSS.t8 163.881
R369 VSS.t531 VSS.t332 163.881
R370 VSS.t35 VSS.t194 163.881
R371 VSS.t17 VSS.t491 163.881
R372 VSS.t32 VSS.t160 163.881
R373 VSS.t14 VSS.t368 163.881
R374 VSS.t136 VSS.t496 163.881
R375 VSS.t130 VSS.t492 163.881
R376 VSS.n18 VSS.t271 105.688
R377 VSS.t289 VSS.n10 101.74
R378 VSS.n37 VSS.t316 160.341
R379 VSS.t502 VSS.n74 157.062
R380 VSS.t478 VSS.n76 156.429
R381 VSS.t84 VSS.n216 155.126
R382 VSS.t403 VSS.n236 155.126
R383 VSS.t497 VSS.n246 155.126
R384 VSS.t471 VSS.n265 155.126
R385 VSS.t550 VSS.n334 155.126
R386 VSS.n853 VSS.t86 155.125
R387 VSS.n814 VSS.t398 155.125
R388 VSS.t180 VSS.n98 155.125
R389 VSS.t378 VSS.n104 155.125
R390 VSS.t390 VSS.n108 155.125
R391 VSS.n683 VSS.t365 155.125
R392 VSS.n664 VSS.t185 155.125
R393 VSS.n645 VSS.t65 155.125
R394 VSS.n625 VSS.t392 155.125
R395 VSS.t374 VSS.n127 155.125
R396 VSS.n570 VSS.t481 155.125
R397 VSS.t2 VSS.n4 153.971
R398 VSS.n872 VSS.t109 153.846
R399 VSS.n846 VSS.t95 153.846
R400 VSS.n827 VSS.t227 153.846
R401 VSS.n809 VSS.t54 153.846
R402 VSS.n789 VSS.t132 153.846
R403 VSS.n771 VSS.t334 153.846
R404 VSS.n754 VSS.t517 153.846
R405 VSS.n734 VSS.t22 153.846
R406 VSS.n716 VSS.t215 153.846
R407 VSS.n697 VSS.t51 153.846
R408 VSS.n678 VSS.t123 153.846
R409 VSS.n658 VSS.t120 153.846
R410 VSS.n639 VSS.t527 153.846
R411 VSS.n619 VSS.t25 153.846
R412 VSS.n601 VSS.t224 153.846
R413 VSS.n583 VSS.t19 153.846
R414 VSS.n563 VSS.t514 153.846
R415 VSS.t146 VSS.n76 153.327
R416 VSS.t503 VSS.n77 153.236
R417 VSS.t159 VSS.n24 165.508
R418 VSS.t259 VSS.n17 101.74
R419 VSS.t319 VSS.n37 148.826
R420 VSS.t167 VSS.n212 147.157
R421 VSS.t387 VSS.n222 147.157
R422 VSS.t510 VSS.n232 147.157
R423 VSS.t393 VSS.n242 147.157
R424 VSS.t45 VSS.n252 147.157
R425 VSS.t400 VSS.n261 147.157
R426 VSS.t169 VSS.n271 147.157
R427 VSS.t211 VSS.n282 147.157
R428 VSS.t494 VSS.n291 147.157
R429 VSS.t383 VSS.n302 147.157
R430 VSS.t376 VSS.n311 147.157
R431 VSS.t192 VSS.n320 147.157
R432 VSS.t168 VSS.n329 147.157
R433 VSS.t523 VSS.n340 147.157
R434 VSS.t183 VSS.n350 147.157
R435 VSS.t70 VSS.n358 147.157
R436 VSS.t363 VSS.n136 145.093
R437 VSS.t359 VSS.n136 138.404
R438 VSS.t329 VSS.n33 97.2238
R439 VSS.t314 VSS.n19 97.2306
R440 VSS.n43 VSS.n7 0.00760728
R441 VSS.t284 VSS.n21 97.2306
R442 VSS.n45 VSS.n8 0.00760728
R443 VSS.n28 VSS.n8 0.00760717
R444 VSS.n885 VSS.t233 134.661
R445 VSS.n360 VSS.t359 131.974
R446 VSS.n2 VSS.t40 130.939
R447 VSS.n47 VSS.t91 131.005
R448 VSS.n882 VSS.t67 126.945
R449 VSS.n883 VSS.t142 123.212
R450 VSS.n77 VSS.t478 120.691
R451 VSS.n6 VSS.t371 119.422
R452 VSS.t500 VSS.n885 117.858
R453 VSS.n363 VSS.t363 117.058
R454 VSS.t57 VSS.n70 115.745
R455 VSS.t59 VSS.n72 108.276
R456 VSS.t86 VSS.n850 107.023
R457 VSS.n840 VSS.t167 107.023
R458 VSS.n829 VSS.t84 107.023
R459 VSS.n821 VSS.t387 107.023
R460 VSS.t398 VSS.n811 107.023
R461 VSS.n803 VSS.t510 107.023
R462 VSS.n792 VSS.t403 107.023
R463 VSS.n783 VSS.t393 107.023
R464 VSS.n774 VSS.t497 107.023
R465 VSS.n765 VSS.t45 107.023
R466 VSS.n756 VSS.t180 107.023
R467 VSS.n748 VSS.t400 107.023
R468 VSS.n737 VSS.t471 107.023
R469 VSS.n728 VSS.t169 107.023
R470 VSS.n718 VSS.t378 107.023
R471 VSS.n710 VSS.t211 107.023
R472 VSS.n700 VSS.t390 107.023
R473 VSS.n691 VSS.t494 107.023
R474 VSS.t365 VSS.n680 107.023
R475 VSS.n672 VSS.t383 107.023
R476 VSS.t185 VSS.n661 107.023
R477 VSS.n652 VSS.t376 107.023
R478 VSS.t65 VSS.n642 107.023
R479 VSS.n633 VSS.t192 107.023
R480 VSS.t392 VSS.n622 107.023
R481 VSS.n613 VSS.t168 107.023
R482 VSS.n603 VSS.t550 107.023
R483 VSS.n595 VSS.t523 107.023
R484 VSS.n585 VSS.t374 107.023
R485 VSS.n577 VSS.t183 107.023
R486 VSS.t481 VSS.n567 107.023
R487 VSS.n557 VSS.t70 107.023
R488 VSS.n872 VSS.t352 100.335
R489 VSS.t95 VSS.n212 100.335
R490 VSS.t227 VSS.n222 100.335
R491 VSS.t54 VSS.n232 100.335
R492 VSS.t132 VSS.n242 100.335
R493 VSS.t334 VSS.n252 100.335
R494 VSS.t517 VSS.n261 100.335
R495 VSS.t22 VSS.n271 100.335
R496 VSS.t215 VSS.n282 100.335
R497 VSS.t51 VSS.n291 100.335
R498 VSS.t123 VSS.n302 100.335
R499 VSS.t120 VSS.n311 100.335
R500 VSS.t527 VSS.n320 100.335
R501 VSS.t25 VSS.n329 100.335
R502 VSS.t224 VSS.n340 100.335
R503 VSS.t19 VSS.n350 100.335
R504 VSS.t514 VSS.n358 100.335
R505 VSS.n881 VSS.t144 97.0758
R506 VSS.n5 VSS.t373 96.3896
R507 VSS.t68 VSS.n74 93.5889
R508 VSS.n881 VSS.t234 93.3421
R509 VSS.n360 VSS.t515 88.4945
R510 VSS.t228 VSS.n86 88.2366
R511 VSS.t133 VSS.n92 88.2366
R512 VSS.t335 VSS.n96 88.2366
R513 VSS.t216 VSS.n107 88.2366
R514 VSS.t124 VSS.n113 88.2366
R515 VSS.t121 VSS.n116 88.2366
R516 VSS.t528 VSS.n120 88.2366
R517 VSS.t225 VSS.n126 88.2366
R518 VSS.t20 VSS.n130 88.2366
R519 VSS.n839 VSS.t96 88.2366
R520 VSS.n802 VSS.t55 88.2366
R521 VSS.n747 VSS.t518 88.2366
R522 VSS.n727 VSS.t23 88.2366
R523 VSS.n293 VSS.t52 88.2359
R524 VSS.n331 VSS.t26 88.2359
R525 VSS.n886 VSS.t475 88.133
R526 VSS.t352 VSS.t107 86.957
R527 VSS.t109 VSS.t356 86.957
R528 VSS.t158 VSS.n5 84.8733
R529 VSS.t475 VSS.n69 82.7875
R530 VSS.n72 VSS.t477 82.1411
R531 VSS.t477 VSS.n71 75.0671
R532 VSS.t107 VSS.n204 74.8587
R533 VSS.t141 VSS.n70 74.6738
R534 VSS.n25 VSS.n8 2.67074
R535 VSS.n850 VSS.t99 70.2346
R536 VSS.n829 VSS.t127 70.2346
R537 VSS.n811 VSS.t115 70.2346
R538 VSS.n792 VSS.t534 70.2346
R539 VSS.n774 VSS.t38 70.2346
R540 VSS.n756 VSS.t231 70.2346
R541 VSS.n737 VSS.t29 70.2346
R542 VSS.n718 VSS.t11 70.2346
R543 VSS.n700 VSS.t525 70.2346
R544 VSS.n680 VSS.t531 70.2346
R545 VSS.n661 VSS.t35 70.2346
R546 VSS.n642 VSS.t17 70.2346
R547 VSS.n622 VSS.t32 70.2346
R548 VSS.n603 VSS.t14 70.2346
R549 VSS.n585 VSS.t136 70.2346
R550 VSS.n567 VSS.t130 70.2346
R551 VSS.t246 VSS.n14 58.3203
R552 VSS.t276 VSS.n8 58.3216
R553 VSS.n8 VSS.n9 0.00721128
R554 VSS.t306 VSS.n15 68.213
R555 VSS.t321 VSS.n38 68.211
R556 VSS.n883 VSS.t141 67.2065
R557 VSS.t551 VSS.n847 66.8901
R558 VSS.t0 VSS.n209 66.8901
R559 VSS.n828 VSS.t479 66.8901
R560 VSS.t237 VSS.n219 66.8901
R561 VSS.n810 VSS.t469 66.8901
R562 VSS.t239 VSS.n229 66.8901
R563 VSS.t380 VSS.n790 66.8901
R564 VSS.t148 VSS.n239 66.8901
R565 VSS.t508 VSS.n772 66.8901
R566 VSS.t537 VSS.n249 66.8901
R567 VSS.n755 VSS.t212 66.8901
R568 VSS.t82 VSS.n258 66.8901
R569 VSS.n735 VSS.t49 66.8901
R570 VSS.t536 VSS.n268 66.8901
R571 VSS.n717 VSS.t473 66.8901
R572 VSS.t111 VSS.n279 66.8901
R573 VSS.t6 VSS.n698 66.8901
R574 VSS.t113 VSS.n288 66.8901
R575 VSS.n679 VSS.t331 66.8901
R576 VSS.t152 VSS.n299 66.8901
R577 VSS.t195 VSS.n659 66.8901
R578 VSS.t540 VSS.n308 66.8901
R579 VSS.n640 VSS.t490 66.8901
R580 VSS.t150 VSS.n317 66.8901
R581 VSS.n620 VSS.t162 66.8901
R582 VSS.t539 VSS.n326 66.8901
R583 VSS.n602 VSS.t366 66.8901
R584 VSS.t538 VSS.n337 66.8901
R585 VSS.n584 VSS.t495 66.8901
R586 VSS.t218 VSS.n347 66.8901
R587 VSS.t493 VSS.n564 66.8901
R588 VSS.t188 VSS.n355 66.8901
R589 VSS.n882 VSS.t68 63.4728
R590 VSS.t234 VSS.n75 62.2523
R591 VSS.t560 VSS.n6 61.8407
R592 VSS.t144 VSS.n880 58.5186
R593 VSS.t504 VSS.n12 49.7663
R594 VSS.n1 VSS.t251 56.6955
R595 VSS.n396 VSS.t296 56.0825
R596 VSS.n7 VSS.n19 0.00185661
R597 VSS.t326 VSS.n34 56.0825
R598 VSS.n886 VSS.t500 54.532
R599 VSS.t549 VSS.n2 50.3244
R600 VSS.t541 VSS.n47 44.8755
R601 VSS.t98 VSS.n207 50.1677
R602 VSS.t126 VSS.n215 50.1677
R603 VSS.t114 VSS.n226 50.1677
R604 VSS.t533 VSS.n235 50.1677
R605 VSS.t37 VSS.n245 50.1677
R606 VSS.n255 VSS.t230 50.1677
R607 VSS.t28 VSS.n264 50.1677
R608 VSS.n275 VSS.t10 50.1677
R609 VSS.n285 VSS.t524 50.1677
R610 VSS.t530 VSS.n295 50.1677
R611 VSS.t34 VSS.n305 50.1677
R612 VSS.t16 VSS.n314 50.1677
R613 VSS.t31 VSS.n323 50.1677
R614 VSS.t13 VSS.n333 50.1677
R615 VSS.n343 VSS.t135 50.1677
R616 VSS.t129 VSS.n353 50.1677
R617 VSS.n73 VSS.t59 47.3176
R618 VSS.n884 VSS.t57 39.8503
R619 VSS.n858 VSS.t235 36.7898
R620 VSS.t77 VSS.n837 36.7898
R621 VSS.n820 VSS.t395 36.7898
R622 VSS.t339 VSS.n800 36.7898
R623 VSS.n782 VSS.t202 36.7898
R624 VSS.n764 VSS.t171 36.7898
R625 VSS.t348 VSS.n745 36.7898
R626 VSS.n726 VSS.t544 36.7898
R627 VSS.t61 VSS.n708 36.7898
R628 VSS.t483 VSS.n689 36.7898
R629 VSS.t511 VSS.n670 36.7898
R630 VSS.n651 VSS.t520 36.7898
R631 VSS.t208 VSS.n631 36.7898
R632 VSS.t105 VSS.n611 36.7898
R633 VSS.t220 VSS.n593 36.7898
R634 VSS.n576 VSS.t198 36.7898
R635 VSS.t233 VSS.n884 36.1166
R636 VSS.t142 VSS.n71 33.9948
R637 VSS.t67 VSS.n73 28.6493
R638 VSS.t552 VSS.n849 28.2938
R639 VSS.t470 VSS.n227 28.2938
R640 VSS.t381 VSS.n237 28.2938
R641 VSS.t507 VSS.n247 28.2938
R642 VSS.t213 VSS.n256 28.2938
R643 VSS.t47 VSS.n736 28.2938
R644 VSS.t474 VSS.n276 28.2938
R645 VSS.t8 VSS.n286 28.2938
R646 VSS.t491 VSS.n641 28.2938
R647 VSS.t160 VSS.n621 28.2938
R648 VSS.t492 VSS.n566 28.2938
R649 VSS.t480 VSS.n217 28.2928
R650 VSS.t332 VSS.n296 28.2928
R651 VSS.t194 VSS.n306 28.2928
R652 VSS.t368 VSS.n335 28.2928
R653 VSS.t496 VSS.n344 28.2928
R654 VSS.n204 VSS.t503 28.0352
R655 VSS.n4 VSS.t4 27.2918
R656 VSS.t356 VSS.n871 21.6048
R657 VSS.t75 VSS.n213 20.0674
R658 VSS.t394 VSS.n223 20.0674
R659 VSS.t337 VSS.n233 20.0674
R660 VSS.t204 VSS.n243 20.0674
R661 VSS.t173 VSS.n253 20.0674
R662 VSS.t346 VSS.n262 20.0674
R663 VSS.t543 VSS.n272 20.0674
R664 VSS.t63 VSS.n283 20.0674
R665 VSS.t485 VSS.n292 20.0674
R666 VSS.t513 VSS.n303 20.0674
R667 VSS.t522 VSS.n312 20.0674
R668 VSS.t210 VSS.n321 20.0674
R669 VSS.t103 VSS.n330 20.0674
R670 VSS.t222 VSS.n341 20.0674
R671 VSS.t197 VSS.n351 20.0674
R672 VSS.t558 VSS.n359 20.0674
R673 VSS.t343 VSS.n80 18.0025
R674 VSS.t499 VSS.n84 18.0025
R675 VSS.t488 VSS.n88 18.0025
R676 VSS.n93 VSS.t487 18.0025
R677 VSS.n97 VSS.t190 18.0025
R678 VSS.t402 VSS.n100 18.0025
R679 VSS.n117 VSS.t385 18.0025
R680 VSS.t559 VSS.n124 18.0025
R681 VSS.n131 VSS.t200 18.0025
R682 VSS.t101 VSS.n848 18.0025
R683 VSS.t341 VSS.n838 18.0025
R684 VSS.t370 VSS.n801 18.0025
R685 VSS.n791 VSS.t187 18.0025
R686 VSS.n773 VSS.t391 18.0025
R687 VSS.t207 VSS.n746 18.0025
R688 VSS.n709 VSS.t468 18.0025
R689 VSS.n699 VSS.t350 18.0025
R690 VSS.n690 VSS.t542 18.0025
R691 VSS.n671 VSS.t553 18.0025
R692 VSS.n660 VSS.t214 18.0025
R693 VSS.n632 VSS.t401 18.0025
R694 VSS.n612 VSS.t397 18.0025
R695 VSS.n594 VSS.t472 18.0025
R696 VSS.t102 VSS.n565 18.0025
R697 VSS.n225 VSS.t389 18.0017
R698 VSS.t191 VSS.n267 18.0017
R699 VSS.t201 VSS.n274 18.0017
R700 VSS.n278 VSS.t206 18.0017
R701 VSS.n298 VSS.t489 18.0017
R702 VSS.t386 VSS.n316 18.0017
R703 VSS.t182 VSS.n325 18.0017
R704 VSS.n346 VSS.t342 18.0017
R705 VSS.n880 VSS.t146 17.4483
R706 VSS.n901 VSS.t145 17.3368
R707 VSS.n897 VSS.t60 17.3368
R708 VSS.n893 VSS.t58 17.3368
R709 VSS.n433 VSS.t155 17.3368
R710 VSS.n437 VSS.t372 17.3368
R711 VSS.n441 VSS.t3 17.3368
R712 VSS.n445 VSS.t41 17.3368
R713 VSS.n877 VSS.t108 17.3368
R714 VSS.n500 VSS.t92 17.2607
R715 VSS.n423 VSS.t243 17.2313
R716 VSS.n458 VSS.t248 17.2313
R717 VSS.n462 VSS.t253 17.2313
R718 VSS.n415 VSS.t258 17.2313
R719 VSS.n473 VSS.t263 17.2313
R720 VSS.n477 VSS.t268 17.2313
R721 VSS.n407 VSS.t273 17.2313
R722 VSS.n488 VSS.t278 17.2313
R723 VSS.n492 VSS.t283 17.2313
R724 VSS.n399 VSS.t288 17.2313
R725 VSS.n511 VSS.t293 17.2313
R726 VSS.n515 VSS.t298 17.2313
R727 VSS.n390 VSS.t303 17.2313
R728 VSS.n526 VSS.t308 17.2313
R729 VSS.n530 VSS.t313 17.2313
R730 VSS.n382 VSS.t318 17.2313
R731 VSS.n541 VSS.t323 17.2313
R732 VSS.n545 VSS.t328 17.2313
R733 VSS.n888 VSS.n887 17.0005
R734 VSS.n887 VSS.n70 17.0005
R735 VSS.n887 VSS.n883 17.0005
R736 VSS.n887 VSS.n72 17.0005
R737 VSS.n887 VSS.n882 17.0005
R738 VSS.n887 VSS.n881 17.0005
R739 VSS.n887 VSS.n879 17.0005
R740 VSS.n887 VSS.n206 17.0005
R741 VSS.n887 VSS.n211 17.0005
R742 VSS.n887 VSS.n221 17.0005
R743 VSS.n887 VSS.n231 17.0005
R744 VSS.n887 VSS.n241 17.0005
R745 VSS.n887 VSS.n251 17.0005
R746 VSS.n887 VSS.n260 17.0005
R747 VSS.n887 VSS.n270 17.0005
R748 VSS.n887 VSS.n281 17.0005
R749 VSS.n887 VSS.n290 17.0005
R750 VSS.n887 VSS.n301 17.0005
R751 VSS.n887 VSS.n310 17.0005
R752 VSS.n887 VSS.n319 17.0005
R753 VSS.n887 VSS.n328 17.0005
R754 VSS.n887 VSS.n339 17.0005
R755 VSS.n887 VSS.n349 17.0005
R756 VSS.n887 VSS.n357 17.0005
R757 VSS.n887 VSS.n361 17.0005
R758 VSS.n887 VSS.n556 17.0005
R759 VSS.n887 VSS.n362 17.0005
R760 VSS.n887 VSS.n551 17.0005
R761 VSS.n887 VSS.n364 17.0005
R762 VSS.n887 VSS.n203 17.0005
R763 VSS.n887 VSS.n79 17.0005
R764 VSS.n40 VSS.n65 5.65652
R765 VSS.n40 VSS.n41 0.00104691
R766 VSS.n7 VSS.n62 5.65652
R767 VSS.n7 VSS.n16 0.00103768
R768 VSS.n36 VSS.n8 6.82739
R769 VSS.n12 VSS.n8 0.0973986
R770 VSS.n8 VSS.n11 6.82737
R771 VSS.n8 VSS.n426 17.0005
R772 VSS.n8 VSS.n425 17.0005
R773 VSS.n8 VSS.n24 0.592458
R774 VSS.n8 VSS.n23 9.32125
R775 VSS.n8 VSS.n26 7.24297
R776 VSS.n8 VSS.n424 17.0005
R777 VSS.n428 VSS.n8 17.0005
R778 VSS.n427 VSS.t242 17.0005
R779 VSS.n422 VSS.t245 17.0005
R780 VSS.n456 VSS.t247 17.0005
R781 VSS.n419 VSS.t250 17.0005
R782 VSS.n418 VSS.t252 17.0005
R783 VSS.n417 VSS.t255 17.0005
R784 VSS.n416 VSS.t257 17.0005
R785 VSS.n414 VSS.t260 17.0005
R786 VSS.n471 VSS.t262 17.0005
R787 VSS.n411 VSS.t265 17.0005
R788 VSS.n410 VSS.t267 17.0005
R789 VSS.n409 VSS.t270 17.0005
R790 VSS.n408 VSS.t272 17.0005
R791 VSS.n406 VSS.t275 17.0005
R792 VSS.n486 VSS.t277 17.0005
R793 VSS.n403 VSS.t280 17.0005
R794 VSS.n402 VSS.t282 17.0005
R795 VSS.n401 VSS.t285 17.0005
R796 VSS.n400 VSS.t287 17.0005
R797 VSS.n398 VSS.t290 17.0005
R798 VSS.n509 VSS.t292 17.0005
R799 VSS.n394 VSS.t295 17.0005
R800 VSS.n393 VSS.t297 17.0005
R801 VSS.n392 VSS.t300 17.0005
R802 VSS.n391 VSS.t302 17.0005
R803 VSS.n389 VSS.t305 17.0005
R804 VSS.n524 VSS.t307 17.0005
R805 VSS.n386 VSS.t310 17.0005
R806 VSS.n385 VSS.t312 17.0005
R807 VSS.n384 VSS.t315 17.0005
R808 VSS.n383 VSS.t317 17.0005
R809 VSS.n381 VSS.t320 17.0005
R810 VSS.n539 VSS.t322 17.0005
R811 VSS.n378 VSS.t325 17.0005
R812 VSS.n377 VSS.t327 17.0005
R813 VSS.n374 VSS.t330 17.0005
R814 VSS.n24 VSS.t548 15.2265
R815 VSS.n422 VSS.t597 15.3099
R816 VSS.n419 VSS.t595 15.3099
R817 VSS.n417 VSS.t593 15.3099
R818 VSS.n414 VSS.t591 15.3099
R819 VSS.n411 VSS.t589 15.3099
R820 VSS.n409 VSS.t587 15.3099
R821 VSS.n406 VSS.t585 15.3099
R822 VSS.n403 VSS.t583 15.3099
R823 VSS.n401 VSS.t581 15.3099
R824 VSS.n398 VSS.t579 15.3099
R825 VSS.n394 VSS.t577 15.3099
R826 VSS.n392 VSS.t575 15.3099
R827 VSS.n389 VSS.t573 15.3099
R828 VSS.n386 VSS.t571 15.3099
R829 VSS.n384 VSS.t569 15.3099
R830 VSS.n381 VSS.t567 15.3099
R831 VSS.n378 VSS.t565 15.3099
R832 VSS.n374 VSS.t563 15.3099
R833 VSS.n427 VSS.t598 15.2696
R834 VSS.n456 VSS.t596 15.2696
R835 VSS.n418 VSS.t594 15.2696
R836 VSS.n416 VSS.t592 15.2696
R837 VSS.n471 VSS.t590 15.2696
R838 VSS.n410 VSS.t588 15.2696
R839 VSS.n408 VSS.t586 15.2696
R840 VSS.n486 VSS.t584 15.2696
R841 VSS.n402 VSS.t582 15.2696
R842 VSS.n400 VSS.t580 15.2696
R843 VSS.n509 VSS.t578 15.2696
R844 VSS.n393 VSS.t576 15.2696
R845 VSS.n391 VSS.t574 15.2696
R846 VSS.n524 VSS.t572 15.2696
R847 VSS.n385 VSS.t570 15.2696
R848 VSS.n383 VSS.t568 15.2696
R849 VSS.n539 VSS.t566 15.2696
R850 VSS.n377 VSS.t564 15.2696
R851 VSS.n552 VSS.t358 15.1276
R852 VSS.n367 VSS.t362 15.0005
R853 VSS.n864 VSS.t355 15.0005
R854 VSS.n874 VSS.t351 15.0005
R855 VSS.n75 VSS.t502 13.7147
R856 VSS.n138 VSS.t71 8.85039
R857 VSS.n140 VSS.t482 8.85039
R858 VSS.n142 VSS.t184 8.85039
R859 VSS.n144 VSS.t375 8.85039
R860 VSS.n146 VSS.t223 8.85039
R861 VSS.n148 VSS.t369 8.85039
R862 VSS.n150 VSS.t104 8.85039
R863 VSS.n152 VSS.t161 8.85039
R864 VSS.n154 VSS.t193 8.85039
R865 VSS.n156 VSS.t66 8.85039
R866 VSS.n158 VSS.t377 8.85039
R867 VSS.n160 VSS.t186 8.85039
R868 VSS.n162 VSS.t384 8.85039
R869 VSS.n164 VSS.t333 8.85039
R870 VSS.n166 VSS.t486 8.85039
R871 VSS.n168 VSS.t9 8.85039
R872 VSS.n170 VSS.t64 8.85039
R873 VSS.n172 VSS.t379 8.85039
R874 VSS.n174 VSS.t170 8.85039
R875 VSS.n176 VSS.t48 8.85039
R876 VSS.n178 VSS.t347 8.85039
R877 VSS.n180 VSS.t181 8.85039
R878 VSS.n182 VSS.t46 8.85039
R879 VSS.n184 VSS.t498 8.85039
R880 VSS.n186 VSS.t205 8.85039
R881 VSS.n188 VSS.t382 8.85039
R882 VSS.n190 VSS.t338 8.85039
R883 VSS.n192 VSS.t399 8.85039
R884 VSS.n194 VSS.t388 8.85039
R885 VSS.n196 VSS.t85 8.85039
R886 VSS.n198 VSS.t76 8.85039
R887 VSS.n200 VSS.t87 8.85039
R888 VSS.n903 VSS.t147 8.80385
R889 VSS.n899 VSS.t69 8.80385
R890 VSS.n895 VSS.t143 8.80385
R891 VSS.n868 VSS.t110 8.80385
R892 VSS.n435 VSS.t157 8.80285
R893 VSS.n439 VSS.t562 8.80285
R894 VSS.n443 VSS.t5 8.80285
R895 VSS.n447 VSS.t43 8.80285
R896 VSS.n558 VSS.t516 8.77423
R897 VSS.n356 VSS.t189 8.77423
R898 VSS.n568 VSS.t131 8.77423
R899 VSS.n574 VSS.t199 8.77423
R900 VSS.n578 VSS.t21 8.77423
R901 VSS.n348 VSS.t219 8.77423
R902 VSS.n586 VSS.t137 8.77423
R903 VSS.n591 VSS.t221 8.77423
R904 VSS.n596 VSS.t226 8.77423
R905 VSS.n338 VSS.t367 8.77423
R906 VSS.n604 VSS.t15 8.77423
R907 VSS.n609 VSS.t106 8.77423
R908 VSS.n614 VSS.t27 8.77423
R909 VSS.n327 VSS.t163 8.77423
R910 VSS.n623 VSS.t33 8.77423
R911 VSS.n629 VSS.t209 8.77423
R912 VSS.n634 VSS.t529 8.77423
R913 VSS.n318 VSS.t151 8.77423
R914 VSS.n643 VSS.t18 8.77423
R915 VSS.n649 VSS.t521 8.77423
R916 VSS.n653 VSS.t122 8.77423
R917 VSS.n309 VSS.t196 8.77423
R918 VSS.n662 VSS.t36 8.77423
R919 VSS.n668 VSS.t512 8.77423
R920 VSS.n673 VSS.t125 8.77423
R921 VSS.n300 VSS.t153 8.77423
R922 VSS.n681 VSS.t532 8.77423
R923 VSS.n687 VSS.t484 8.77423
R924 VSS.n692 VSS.t53 8.77423
R925 VSS.n289 VSS.t7 8.77423
R926 VSS.n701 VSS.t526 8.77423
R927 VSS.n706 VSS.t62 8.77423
R928 VSS.n711 VSS.t217 8.77423
R929 VSS.n280 VSS.t112 8.77423
R930 VSS.n719 VSS.t12 8.77423
R931 VSS.n724 VSS.t545 8.77423
R932 VSS.n729 VSS.t24 8.77423
R933 VSS.n269 VSS.t50 8.77423
R934 VSS.n738 VSS.t30 8.77423
R935 VSS.n743 VSS.t349 8.77423
R936 VSS.n749 VSS.t519 8.77423
R937 VSS.n259 VSS.t83 8.77423
R938 VSS.n757 VSS.t232 8.77423
R939 VSS.n762 VSS.t172 8.77423
R940 VSS.n766 VSS.t336 8.77423
R941 VSS.n250 VSS.t509 8.77423
R942 VSS.n775 VSS.t39 8.77423
R943 VSS.n780 VSS.t203 8.77423
R944 VSS.n784 VSS.t134 8.77423
R945 VSS.n240 VSS.t149 8.77423
R946 VSS.n793 VSS.t535 8.77423
R947 VSS.n798 VSS.t340 8.77423
R948 VSS.n804 VSS.t56 8.77423
R949 VSS.n230 VSS.t240 8.77423
R950 VSS.n812 VSS.t116 8.77423
R951 VSS.n818 VSS.t396 8.77423
R952 VSS.n822 VSS.t229 8.77423
R953 VSS.n220 VSS.t238 8.77423
R954 VSS.n830 VSS.t128 8.77423
R955 VSS.n835 VSS.t78 8.77423
R956 VSS.n841 VSS.t97 8.77423
R957 VSS.n210 VSS.t1 8.77423
R958 VSS.n851 VSS.t100 8.77423
R959 VSS.n859 VSS.t236 8.77423
R960 VSS.n451 VSS.t176 8.77323
R961 VSS.n466 VSS.t74 8.77323
R962 VSS.n481 VSS.t81 8.77323
R963 VSS.n496 VSS.t90 8.77323
R964 VSS.n498 VSS.t506 8.77323
R965 VSS.n504 VSS.t179 8.77323
R966 VSS.n519 VSS.t119 8.77323
R967 VSS.n534 VSS.t140 8.77323
R968 VSS.n371 VSS.t166 8.77323
R969 VSS.n449 VSS.t345 8.76689
R970 VSS.n502 VSS.t94 8.76678
R971 VSS.n891 VSS.t501 8.75731
R972 VSS.n889 VSS.t476 8.75731
R973 VSS.n429 VSS.t555 8.75631
R974 VSS.n431 VSS.t547 8.75631
R975 VSS.n372 VSS.n48 88.4708
R976 VSS.n544 VSS.n66 0.0435295
R977 VSS.n538 VSS.n65 0.0180497
R978 VSS.n64 VSS.n536 0.0633111
R979 VSS.n63 VSS.n7 4.22409
R980 VSS.n523 VSS.n62 0.0180497
R981 VSS.n61 VSS.n521 0.0633111
R982 VSS.n514 VSS.n60 0.0435295
R983 VSS.n59 VSS.n8 5.65652
R984 VSS.n58 VSS.n506 0.0633111
R985 VSS.n491 VSS.n57 0.0435295
R986 VSS.n56 VSS.n8 5.65652
R987 VSS.n55 VSS.n483 0.0633111
R988 VSS.n54 VSS.n8 4.22409
R989 VSS.n53 VSS.n8 5.65652
R990 VSS.n52 VSS.n468 0.0633111
R991 VSS.n51 VSS.n8 4.22409
R992 VSS.n50 VSS.n8 5.65652
R993 VSS.n49 VSS.n453 0.0633111
R994 VSS.n887 VSS.n872 8.5005
R995 VSS.n887 VSS.n858 8.5005
R996 VSS.n887 VSS.n207 8.5005
R997 VSS.n887 VSS.n850 8.5005
R998 VSS.n887 VSS.n847 8.5005
R999 VSS.n887 VSS.n209 8.5005
R1000 VSS.n887 VSS.n846 8.5005
R1001 VSS.n887 VSS.n212 8.5005
R1002 VSS.n887 VSS.n840 8.5005
R1003 VSS.n887 VSS.n213 8.5005
R1004 VSS.n887 VSS.n837 8.5005
R1005 VSS.n887 VSS.n215 8.5005
R1006 VSS.n887 VSS.n829 8.5005
R1007 VSS.n887 VSS.n828 8.5005
R1008 VSS.n887 VSS.n219 8.5005
R1009 VSS.n887 VSS.n827 8.5005
R1010 VSS.n887 VSS.n222 8.5005
R1011 VSS.n887 VSS.n821 8.5005
R1012 VSS.n887 VSS.n223 8.5005
R1013 VSS.n887 VSS.n820 8.5005
R1014 VSS.n887 VSS.n226 8.5005
R1015 VSS.n887 VSS.n811 8.5005
R1016 VSS.n887 VSS.n810 8.5005
R1017 VSS.n887 VSS.n229 8.5005
R1018 VSS.n887 VSS.n809 8.5005
R1019 VSS.n887 VSS.n232 8.5005
R1020 VSS.n887 VSS.n803 8.5005
R1021 VSS.n887 VSS.n233 8.5005
R1022 VSS.n887 VSS.n800 8.5005
R1023 VSS.n887 VSS.n235 8.5005
R1024 VSS.n887 VSS.n792 8.5005
R1025 VSS.n887 VSS.n790 8.5005
R1026 VSS.n887 VSS.n239 8.5005
R1027 VSS.n887 VSS.n789 8.5005
R1028 VSS.n887 VSS.n242 8.5005
R1029 VSS.n887 VSS.n783 8.5005
R1030 VSS.n887 VSS.n243 8.5005
R1031 VSS.n887 VSS.n782 8.5005
R1032 VSS.n887 VSS.n245 8.5005
R1033 VSS.n887 VSS.n774 8.5005
R1034 VSS.n887 VSS.n772 8.5005
R1035 VSS.n887 VSS.n249 8.5005
R1036 VSS.n887 VSS.n771 8.5005
R1037 VSS.n887 VSS.n252 8.5005
R1038 VSS.n887 VSS.n765 8.5005
R1039 VSS.n887 VSS.n253 8.5005
R1040 VSS.n887 VSS.n764 8.5005
R1041 VSS.n887 VSS.n255 8.5005
R1042 VSS.n887 VSS.n756 8.5005
R1043 VSS.n887 VSS.n755 8.5005
R1044 VSS.n887 VSS.n258 8.5005
R1045 VSS.n887 VSS.n754 8.5005
R1046 VSS.n887 VSS.n261 8.5005
R1047 VSS.n887 VSS.n748 8.5005
R1048 VSS.n887 VSS.n262 8.5005
R1049 VSS.n887 VSS.n745 8.5005
R1050 VSS.n887 VSS.n264 8.5005
R1051 VSS.n887 VSS.n737 8.5005
R1052 VSS.n887 VSS.n735 8.5005
R1053 VSS.n887 VSS.n268 8.5005
R1054 VSS.n887 VSS.n734 8.5005
R1055 VSS.n887 VSS.n271 8.5005
R1056 VSS.n887 VSS.n728 8.5005
R1057 VSS.n887 VSS.n272 8.5005
R1058 VSS.n887 VSS.n726 8.5005
R1059 VSS.n887 VSS.n275 8.5005
R1060 VSS.n887 VSS.n718 8.5005
R1061 VSS.n887 VSS.n717 8.5005
R1062 VSS.n887 VSS.n279 8.5005
R1063 VSS.n887 VSS.n716 8.5005
R1064 VSS.n887 VSS.n282 8.5005
R1065 VSS.n887 VSS.n710 8.5005
R1066 VSS.n887 VSS.n283 8.5005
R1067 VSS.n887 VSS.n708 8.5005
R1068 VSS.n887 VSS.n285 8.5005
R1069 VSS.n887 VSS.n700 8.5005
R1070 VSS.n887 VSS.n698 8.5005
R1071 VSS.n887 VSS.n288 8.5005
R1072 VSS.n887 VSS.n697 8.5005
R1073 VSS.n887 VSS.n291 8.5005
R1074 VSS.n887 VSS.n691 8.5005
R1075 VSS.n887 VSS.n292 8.5005
R1076 VSS.n887 VSS.n689 8.5005
R1077 VSS.n887 VSS.n295 8.5005
R1078 VSS.n887 VSS.n680 8.5005
R1079 VSS.n887 VSS.n679 8.5005
R1080 VSS.n887 VSS.n299 8.5005
R1081 VSS.n887 VSS.n678 8.5005
R1082 VSS.n887 VSS.n302 8.5005
R1083 VSS.n887 VSS.n672 8.5005
R1084 VSS.n887 VSS.n303 8.5005
R1085 VSS.n887 VSS.n670 8.5005
R1086 VSS.n887 VSS.n305 8.5005
R1087 VSS.n887 VSS.n661 8.5005
R1088 VSS.n887 VSS.n659 8.5005
R1089 VSS.n887 VSS.n308 8.5005
R1090 VSS.n887 VSS.n658 8.5005
R1091 VSS.n887 VSS.n311 8.5005
R1092 VSS.n887 VSS.n652 8.5005
R1093 VSS.n887 VSS.n312 8.5005
R1094 VSS.n887 VSS.n651 8.5005
R1095 VSS.n887 VSS.n314 8.5005
R1096 VSS.n887 VSS.n642 8.5005
R1097 VSS.n887 VSS.n640 8.5005
R1098 VSS.n887 VSS.n317 8.5005
R1099 VSS.n887 VSS.n639 8.5005
R1100 VSS.n887 VSS.n320 8.5005
R1101 VSS.n887 VSS.n633 8.5005
R1102 VSS.n887 VSS.n321 8.5005
R1103 VSS.n887 VSS.n631 8.5005
R1104 VSS.n887 VSS.n323 8.5005
R1105 VSS.n887 VSS.n622 8.5005
R1106 VSS.n887 VSS.n620 8.5005
R1107 VSS.n887 VSS.n326 8.5005
R1108 VSS.n887 VSS.n619 8.5005
R1109 VSS.n887 VSS.n329 8.5005
R1110 VSS.n887 VSS.n613 8.5005
R1111 VSS.n887 VSS.n330 8.5005
R1112 VSS.n887 VSS.n611 8.5005
R1113 VSS.n887 VSS.n333 8.5005
R1114 VSS.n887 VSS.n603 8.5005
R1115 VSS.n887 VSS.n602 8.5005
R1116 VSS.n887 VSS.n337 8.5005
R1117 VSS.n887 VSS.n601 8.5005
R1118 VSS.n887 VSS.n340 8.5005
R1119 VSS.n887 VSS.n595 8.5005
R1120 VSS.n887 VSS.n341 8.5005
R1121 VSS.n887 VSS.n593 8.5005
R1122 VSS.n887 VSS.n343 8.5005
R1123 VSS.n887 VSS.n585 8.5005
R1124 VSS.n887 VSS.n584 8.5005
R1125 VSS.n887 VSS.n347 8.5005
R1126 VSS.n887 VSS.n583 8.5005
R1127 VSS.n887 VSS.n350 8.5005
R1128 VSS.n887 VSS.n577 8.5005
R1129 VSS.n887 VSS.n351 8.5005
R1130 VSS.n887 VSS.n576 8.5005
R1131 VSS.n887 VSS.n353 8.5005
R1132 VSS.n887 VSS.n567 8.5005
R1133 VSS.n887 VSS.n564 8.5005
R1134 VSS.n887 VSS.n355 8.5005
R1135 VSS.n887 VSS.n563 8.5005
R1136 VSS.n887 VSS.n358 8.5005
R1137 VSS.n887 VSS.n557 8.5005
R1138 VSS.n887 VSS.n359 8.5005
R1139 VSS.n887 VSS.n363 8.5005
R1140 VSS.n543 VSS.n40 8.49319
R1141 VSS.n528 VSS.n7 8.49319
R1142 VSS.n513 VSS.n8 8.49319
R1143 VSS.n490 VSS.n8 8.49319
R1144 VSS.n475 VSS.n8 8.49319
R1145 VSS.n460 VSS.n8 8.49319
R1146 VSS.n902 VSS.n887 8.47732
R1147 VSS.n887 VSS.n205 8.47732
R1148 VSS.n887 VSS.n857 8.47732
R1149 VSS.n887 VSS.n836 8.47732
R1150 VSS.n887 VSS.n819 8.47732
R1151 VSS.n887 VSS.n799 8.47732
R1152 VSS.n887 VSS.n781 8.47732
R1153 VSS.n887 VSS.n763 8.47732
R1154 VSS.n887 VSS.n744 8.47732
R1155 VSS.n887 VSS.n725 8.47732
R1156 VSS.n887 VSS.n707 8.47732
R1157 VSS.n887 VSS.n688 8.47732
R1158 VSS.n887 VSS.n669 8.47732
R1159 VSS.n887 VSS.n650 8.47732
R1160 VSS.n887 VSS.n630 8.47732
R1161 VSS.n887 VSS.n610 8.47732
R1162 VSS.n887 VSS.n592 8.47732
R1163 VSS.n887 VSS.n575 8.47732
R1164 VSS.n887 VSS.n78 8.47732
R1165 VSS.n887 VSS.n137 8.47732
R1166 VSS.n887 VSS.n135 8.47732
R1167 VSS.n369 VSS.n48 8.48044
R1168 VSS.n35 VSS.n66 4.22409
R1169 VSS.n537 VSS.n40 8.47732
R1170 VSS.n40 VSS.n64 4.21421
R1171 VSS.n530 VSS.n63 0.176279
R1172 VSS.n522 VSS.n7 8.47732
R1173 VSS.n7 VSS.n61 4.21421
R1174 VSS.n60 VSS.n7 4.22409
R1175 VSS.n507 VSS.n8 8.47732
R1176 VSS.n8 VSS.n58 4.21421
R1177 VSS.n57 VSS.n8 4.22409
R1178 VSS.n484 VSS.n8 8.47732
R1179 VSS.n8 VSS.n55 4.21421
R1180 VSS.n477 VSS.n54 0.176279
R1181 VSS.n469 VSS.n8 8.47732
R1182 VSS.n8 VSS.n52 4.21421
R1183 VSS.n462 VSS.n51 0.176279
R1184 VSS.n454 VSS.n8 8.47732
R1185 VSS.n8 VSS.n49 4.21421
R1186 VSS.n442 VSS.n8 8.47732
R1187 VSS.n366 VSS.t364 8.46888
R1188 VSS.n549 VSS.t360 8.46888
R1189 VSS.n554 VSS.t361 8.46631
R1190 VSS.n560 VSS.t459 8.46631
R1191 VSS.n572 VSS.t415 8.46631
R1192 VSS.n580 VSS.t467 8.46631
R1193 VSS.n589 VSS.t407 8.46631
R1194 VSS.n598 VSS.t465 8.46631
R1195 VSS.n607 VSS.t461 8.46631
R1196 VSS.n616 VSS.t413 8.46631
R1197 VSS.n627 VSS.t463 8.46631
R1198 VSS.n636 VSS.t421 8.46631
R1199 VSS.n647 VSS.t455 8.46631
R1200 VSS.n655 VSS.t457 8.46631
R1201 VSS.n666 VSS.t423 8.46631
R1202 VSS.n675 VSS.t453 8.46631
R1203 VSS.n685 VSS.t419 8.46631
R1204 VSS.n694 VSS.t447 8.46631
R1205 VSS.n704 VSS.t451 8.46631
R1206 VSS.n713 VSS.t449 8.46631
R1207 VSS.n722 VSS.t425 8.46631
R1208 VSS.n731 VSS.t445 8.46631
R1209 VSS.n741 VSS.t405 8.46631
R1210 VSS.n751 VSS.t427 8.46631
R1211 VSS.n760 VSS.t443 8.46631
R1212 VSS.n768 VSS.t441 8.46631
R1213 VSS.n778 VSS.t435 8.46631
R1214 VSS.n786 VSS.t439 8.46631
R1215 VSS.n796 VSS.t437 8.46631
R1216 VSS.n806 VSS.t409 8.46631
R1217 VSS.n816 VSS.t433 8.46631
R1218 VSS.n824 VSS.t431 8.46631
R1219 VSS.n833 VSS.t411 8.46631
R1220 VSS.n843 VSS.t429 8.46631
R1221 VSS.n855 VSS.t417 8.46631
R1222 VSS.n866 VSS.t357 8.46519
R1223 VSS.n861 VSS.t353 8.46519
R1224 VSS.n875 VSS.t354 8.46519
R1225 VSS.n905 VSS.n67 6.99673
R1226 VSS.n887 VSS.n370 5.63777
R1227 VSS.n894 VSS.n887 5.62581
R1228 VSS.n898 VSS.n887 5.62581
R1229 VSS.n904 VSS.n887 5.62581
R1230 VSS.n887 VSS.n852 5.62581
R1231 VSS.n887 VSS.n214 5.62581
R1232 VSS.n887 VSS.n831 5.62581
R1233 VSS.n887 VSS.n224 5.62581
R1234 VSS.n887 VSS.n813 5.62581
R1235 VSS.n887 VSS.n234 5.62581
R1236 VSS.n887 VSS.n794 5.62581
R1237 VSS.n887 VSS.n244 5.62581
R1238 VSS.n887 VSS.n776 5.62581
R1239 VSS.n887 VSS.n254 5.62581
R1240 VSS.n887 VSS.n758 5.62581
R1241 VSS.n887 VSS.n263 5.62581
R1242 VSS.n887 VSS.n739 5.62581
R1243 VSS.n887 VSS.n273 5.62581
R1244 VSS.n887 VSS.n720 5.62581
R1245 VSS.n887 VSS.n284 5.62581
R1246 VSS.n887 VSS.n702 5.62581
R1247 VSS.n887 VSS.n294 5.62581
R1248 VSS.n887 VSS.n682 5.62581
R1249 VSS.n887 VSS.n304 5.62581
R1250 VSS.n887 VSS.n663 5.62581
R1251 VSS.n887 VSS.n313 5.62581
R1252 VSS.n887 VSS.n644 5.62581
R1253 VSS.n887 VSS.n322 5.62581
R1254 VSS.n887 VSS.n624 5.62581
R1255 VSS.n887 VSS.n332 5.62581
R1256 VSS.n887 VSS.n605 5.62581
R1257 VSS.n887 VSS.n342 5.62581
R1258 VSS.n887 VSS.n587 5.62581
R1259 VSS.n887 VSS.n352 5.62581
R1260 VSS.n887 VSS.n569 5.62581
R1261 VSS.n887 VSS.n201 5.62581
R1262 VSS.n887 VSS.n199 5.62581
R1263 VSS.n887 VSS.n197 5.62581
R1264 VSS.n887 VSS.n195 5.62581
R1265 VSS.n887 VSS.n193 5.62581
R1266 VSS.n887 VSS.n191 5.62581
R1267 VSS.n887 VSS.n189 5.62581
R1268 VSS.n887 VSS.n187 5.62581
R1269 VSS.n887 VSS.n185 5.62581
R1270 VSS.n887 VSS.n183 5.62581
R1271 VSS.n887 VSS.n181 5.62581
R1272 VSS.n887 VSS.n179 5.62581
R1273 VSS.n887 VSS.n177 5.62581
R1274 VSS.n887 VSS.n175 5.62581
R1275 VSS.n887 VSS.n173 5.62581
R1276 VSS.n887 VSS.n171 5.62581
R1277 VSS.n887 VSS.n169 5.62581
R1278 VSS.n887 VSS.n167 5.62581
R1279 VSS.n887 VSS.n165 5.62581
R1280 VSS.n887 VSS.n163 5.62581
R1281 VSS.n887 VSS.n161 5.62581
R1282 VSS.n887 VSS.n159 5.62581
R1283 VSS.n887 VSS.n157 5.62581
R1284 VSS.n887 VSS.n155 5.62581
R1285 VSS.n887 VSS.n153 5.62581
R1286 VSS.n887 VSS.n151 5.62581
R1287 VSS.n887 VSS.n149 5.62581
R1288 VSS.n887 VSS.n147 5.62581
R1289 VSS.n887 VSS.n145 5.62581
R1290 VSS.n887 VSS.n143 5.62581
R1291 VSS.n887 VSS.n141 5.62581
R1292 VSS.n887 VSS.n139 5.62581
R1293 VSS.n887 VSS.n133 5.62581
R1294 VSS.n35 VSS.n376 5.62581
R1295 VSS.n40 VSS.n380 5.62581
R1296 VSS.n531 VSS.n7 5.62581
R1297 VSS.n7 VSS.n388 5.62581
R1298 VSS.n516 VSS.n7 5.62581
R1299 VSS.n8 VSS.n397 5.62581
R1300 VSS.n501 VSS.n8 5.62581
R1301 VSS.n493 VSS.n8 5.62581
R1302 VSS.n8 VSS.n405 5.62581
R1303 VSS.n478 VSS.n8 5.62581
R1304 VSS.n8 VSS.n413 5.62581
R1305 VSS.n463 VSS.n8 5.62581
R1306 VSS.n8 VSS.n421 5.62581
R1307 VSS.n448 VSS.n8 5.62581
R1308 VSS.n446 VSS.n8 5.62581
R1309 VSS.n438 VSS.n8 5.62581
R1310 VSS.n434 VSS.n8 5.62581
R1311 VSS.n428 VSS.n67 4.28471
R1312 VSS.n40 VSS.n542 4.21914
R1313 VSS.n7 VSS.n527 4.21914
R1314 VSS.n8 VSS.n512 4.21914
R1315 VSS.n8 VSS.n489 4.21914
R1316 VSS.n8 VSS.n474 4.21914
R1317 VSS.n8 VSS.n459 4.21914
R1318 VSS.n887 VSS.n134 4.20662
R1319 VSS.n890 VSS.n887 4.19244
R1320 VSS.n887 VSS.n870 4.19244
R1321 VSS.n430 VSS.n8 4.19244
R1322 VSS VSS.n67 3.80469
R1323 VSS.n858 VSS.t416 3.34498
R1324 VSS.n847 VSS.t428 3.34498
R1325 VSS.n837 VSS.t410 3.34498
R1326 VSS.n828 VSS.t430 3.34498
R1327 VSS.n820 VSS.t432 3.34498
R1328 VSS.n810 VSS.t408 3.34498
R1329 VSS.n800 VSS.t436 3.34498
R1330 VSS.n790 VSS.t438 3.34498
R1331 VSS.n782 VSS.t434 3.34498
R1332 VSS.n772 VSS.t440 3.34498
R1333 VSS.n764 VSS.t442 3.34498
R1334 VSS.n755 VSS.t426 3.34498
R1335 VSS.n745 VSS.t404 3.34498
R1336 VSS.n735 VSS.t444 3.34498
R1337 VSS.n726 VSS.t424 3.34498
R1338 VSS.n717 VSS.t448 3.34498
R1339 VSS.n708 VSS.t450 3.34498
R1340 VSS.n698 VSS.t446 3.34498
R1341 VSS.n689 VSS.t418 3.34498
R1342 VSS.n679 VSS.t452 3.34498
R1343 VSS.n670 VSS.t422 3.34498
R1344 VSS.n659 VSS.t456 3.34498
R1345 VSS.n651 VSS.t454 3.34498
R1346 VSS.n640 VSS.t420 3.34498
R1347 VSS.n631 VSS.t462 3.34498
R1348 VSS.n620 VSS.t412 3.34498
R1349 VSS.n611 VSS.t460 3.34498
R1350 VSS.n602 VSS.t464 3.34498
R1351 VSS.n593 VSS.t406 3.34498
R1352 VSS.n584 VSS.t466 3.34498
R1353 VSS.n576 VSS.t414 3.34498
R1354 VSS.n564 VSS.t458 3.34498
R1355 VSS.n896 VSS.n887 3.3265
R1356 VSS.n900 VSS.n887 3.3265
R1357 VSS.n887 VSS.n845 3.3265
R1358 VSS.n887 VSS.n826 3.3265
R1359 VSS.n887 VSS.n808 3.3265
R1360 VSS.n887 VSS.n788 3.3265
R1361 VSS.n887 VSS.n770 3.3265
R1362 VSS.n887 VSS.n753 3.3265
R1363 VSS.n887 VSS.n733 3.3265
R1364 VSS.n887 VSS.n715 3.3265
R1365 VSS.n887 VSS.n696 3.3265
R1366 VSS.n887 VSS.n677 3.3265
R1367 VSS.n887 VSS.n657 3.3265
R1368 VSS.n887 VSS.n638 3.3265
R1369 VSS.n887 VSS.n618 3.3265
R1370 VSS.n887 VSS.n600 3.3265
R1371 VSS.n887 VSS.n582 3.3265
R1372 VSS.n887 VSS.n562 3.3265
R1373 VSS.n535 VSS.n7 3.3265
R1374 VSS.n520 VSS.n7 3.3265
R1375 VSS.n505 VSS.n8 3.3265
R1376 VSS.n482 VSS.n8 3.3265
R1377 VSS.n467 VSS.n8 3.3265
R1378 VSS.n452 VSS.n8 3.3265
R1379 VSS.n444 VSS.n8 3.3265
R1380 VSS.n440 VSS.n8 3.3265
R1381 VSS.n436 VSS.n8 3.3265
R1382 VSS.n878 VSS 3.16675
R1383 VSS.n547 VSS.n546 3.01826
R1384 VSS.n887 VSS.n68 2.83376
R1385 VSS.n892 VSS.n887 2.74446
R1386 VSS.n887 VSS.n208 2.74446
R1387 VSS.n887 VSS.n218 2.74446
R1388 VSS.n887 VSS.n228 2.74446
R1389 VSS.n887 VSS.n238 2.74446
R1390 VSS.n887 VSS.n248 2.74446
R1391 VSS.n887 VSS.n257 2.74446
R1392 VSS.n887 VSS.n266 2.74446
R1393 VSS.n887 VSS.n277 2.74446
R1394 VSS.n887 VSS.n287 2.74446
R1395 VSS.n887 VSS.n297 2.74446
R1396 VSS.n887 VSS.n307 2.74446
R1397 VSS.n887 VSS.n315 2.74446
R1398 VSS.n887 VSS.n324 2.74446
R1399 VSS.n887 VSS.n336 2.74446
R1400 VSS.n887 VSS.n345 2.74446
R1401 VSS.n887 VSS.n354 2.74446
R1402 VSS.n887 VSS.n202 2.74446
R1403 VSS.n432 VSS.n8 2.74446
R1404 VSS.n887 VSS.n81 2.32483
R1405 VSS.n887 VSS.n82 2.32483
R1406 VSS.n887 VSS.n83 2.32483
R1407 VSS.n887 VSS.n85 2.32483
R1408 VSS.n887 VSS.n87 2.32483
R1409 VSS.n887 VSS.n89 2.32483
R1410 VSS.n887 VSS.n90 2.32483
R1411 VSS.n887 VSS.n91 2.32483
R1412 VSS.n887 VSS.n94 2.32483
R1413 VSS.n887 VSS.n95 2.32483
R1414 VSS.n887 VSS.n99 2.32483
R1415 VSS.n887 VSS.n101 2.32483
R1416 VSS.n887 VSS.n102 2.32483
R1417 VSS.n887 VSS.n103 2.32483
R1418 VSS.n887 VSS.n105 2.32483
R1419 VSS.n887 VSS.n106 2.32483
R1420 VSS.n887 VSS.n109 2.32483
R1421 VSS.n887 VSS.n110 2.32483
R1422 VSS.n887 VSS.n111 2.32483
R1423 VSS.n887 VSS.n112 2.32483
R1424 VSS.n887 VSS.n114 2.32483
R1425 VSS.n887 VSS.n115 2.32483
R1426 VSS.n887 VSS.n118 2.32483
R1427 VSS.n887 VSS.n119 2.32483
R1428 VSS.n887 VSS.n121 2.32483
R1429 VSS.n887 VSS.n122 2.32483
R1430 VSS.n887 VSS.n123 2.32483
R1431 VSS.n887 VSS.n125 2.32483
R1432 VSS.n887 VSS.n128 2.32483
R1433 VSS.n887 VSS.n129 2.32483
R1434 VSS.n887 VSS.n132 2.32483
R1435 VSS.n499 VSS.n8 2.00687
R1436 VSS.n887 VSS.n69 1.64417
R1437 VSS.n887 VSS.n884 1.64417
R1438 VSS.n887 VSS.n73 1.64417
R1439 VSS.n887 VSS.n75 1.64417
R1440 VSS.n887 VSS.n880 1.64417
R1441 VSS.n35 VSS.n373 1.56144
R1442 VSS.n533 VSS.n7 1.56144
R1443 VSS.n518 VSS.n7 1.56144
R1444 VSS.n495 VSS.n8 1.56144
R1445 VSS.n480 VSS.n8 1.56144
R1446 VSS.n465 VSS.n8 1.56144
R1447 VSS.n503 VSS.n8 1.12565
R1448 VSS.n546 VSS.n35 0.92982
R1449 VSS.n450 VSS.n449 0.909006
R1450 VSS.n451 VSS.n450 0.898984
R1451 VSS.n497 VSS.n8 0.849178
R1452 VSS.n497 VSS.n496 0.728316
R1453 VSS.n498 VSS.n497 0.69965
R1454 VSS.n546 VSS.n371 0.69304
R1455 VSS.n35 VSS.n34 0.613782
R1456 VSS.n396 VSS.n7 0.613782
R1457 VSS.n8 VSS.n2 0.613782
R1458 VSS.n8 VSS.n4 0.613782
R1459 VSS.n8 VSS.n6 0.613782
R1460 VSS.n8 VSS.n5 0.613782
R1461 VSS.n27 VSS.n69 4666.38
R1462 VSS.n503 VSS.n502 0.603496
R1463 VSS.n887 VSS.n48 0.00104694
R1464 VSS.n887 VSS.n77 0.556705
R1465 VSS.n504 VSS.n503 0.540438
R1466 VSS VSS.n905 0.48296
R1467 VSS.n555 VSS.n554 0.419816
R1468 VSS.n561 VSS.n560 0.419816
R1469 VSS.n573 VSS.n572 0.419816
R1470 VSS.n581 VSS.n580 0.419816
R1471 VSS.n590 VSS.n589 0.419816
R1472 VSS.n599 VSS.n598 0.419816
R1473 VSS.n608 VSS.n607 0.419816
R1474 VSS.n617 VSS.n616 0.419816
R1475 VSS.n628 VSS.n627 0.419816
R1476 VSS.n637 VSS.n636 0.419816
R1477 VSS.n648 VSS.n647 0.419816
R1478 VSS.n656 VSS.n655 0.419816
R1479 VSS.n667 VSS.n666 0.419816
R1480 VSS.n676 VSS.n675 0.419816
R1481 VSS.n686 VSS.n685 0.419816
R1482 VSS.n695 VSS.n694 0.419816
R1483 VSS.n705 VSS.n704 0.419816
R1484 VSS.n714 VSS.n713 0.419816
R1485 VSS.n723 VSS.n722 0.419816
R1486 VSS.n732 VSS.n731 0.419816
R1487 VSS.n742 VSS.n741 0.419816
R1488 VSS.n752 VSS.n751 0.419816
R1489 VSS.n761 VSS.n760 0.419816
R1490 VSS.n769 VSS.n768 0.419816
R1491 VSS.n779 VSS.n778 0.419816
R1492 VSS.n787 VSS.n786 0.419816
R1493 VSS.n797 VSS.n796 0.419816
R1494 VSS.n807 VSS.n806 0.419816
R1495 VSS.n817 VSS.n816 0.419816
R1496 VSS.n825 VSS.n824 0.419816
R1497 VSS.n834 VSS.n833 0.419816
R1498 VSS.n844 VSS.n843 0.419816
R1499 VSS.n856 VSS.n855 0.419816
R1500 VSS.n466 VSS.n465 0.413418
R1501 VSS.n481 VSS.n480 0.413418
R1502 VSS.n496 VSS.n495 0.413418
R1503 VSS.n519 VSS.n518 0.413418
R1504 VSS.n534 VSS.n533 0.413418
R1505 VSS.n373 VSS.n371 0.413418
R1506 VSS.n450 VSS.n8 0.405836
R1507 VSS.n866 VSS.n865 0.385697
R1508 VSS.n861 VSS.n860 0.385697
R1509 VSS.n554 VSS.n553 0.383459
R1510 VSS.n560 VSS.n559 0.383459
R1511 VSS.n572 VSS.n571 0.383459
R1512 VSS.n580 VSS.n579 0.383459
R1513 VSS.n589 VSS.n588 0.383459
R1514 VSS.n598 VSS.n597 0.383459
R1515 VSS.n607 VSS.n606 0.383459
R1516 VSS.n616 VSS.n615 0.383459
R1517 VSS.n627 VSS.n626 0.383459
R1518 VSS.n636 VSS.n635 0.383459
R1519 VSS.n647 VSS.n646 0.383459
R1520 VSS.n655 VSS.n654 0.383459
R1521 VSS.n666 VSS.n665 0.383459
R1522 VSS.n675 VSS.n674 0.383459
R1523 VSS.n685 VSS.n684 0.383459
R1524 VSS.n694 VSS.n693 0.383459
R1525 VSS.n704 VSS.n703 0.383459
R1526 VSS.n713 VSS.n712 0.383459
R1527 VSS.n722 VSS.n721 0.383459
R1528 VSS.n731 VSS.n730 0.383459
R1529 VSS.n741 VSS.n740 0.383459
R1530 VSS.n751 VSS.n750 0.383459
R1531 VSS.n760 VSS.n759 0.383459
R1532 VSS.n768 VSS.n767 0.383459
R1533 VSS.n778 VSS.n777 0.383459
R1534 VSS.n786 VSS.n785 0.383459
R1535 VSS.n796 VSS.n795 0.383459
R1536 VSS.n806 VSS.n805 0.383459
R1537 VSS.n816 VSS.n815 0.383459
R1538 VSS.n824 VSS.n823 0.383459
R1539 VSS.n833 VSS.n832 0.383459
R1540 VSS.n843 VSS.n842 0.383459
R1541 VSS.n855 VSS.n854 0.383459
R1542 VSS.n500 VSS.n499 0.380519
R1543 VSS.n876 VSS.n875 0.379351
R1544 VSS.n550 VSS.n549 0.37817
R1545 VSS.n499 VSS.n498 0.359515
R1546 VSS.n200 VSS.n81 0.351341
R1547 VSS.n198 VSS.n82 0.351341
R1548 VSS.n196 VSS.n83 0.351341
R1549 VSS.n194 VSS.n85 0.351341
R1550 VSS.n192 VSS.n87 0.351341
R1551 VSS.n190 VSS.n89 0.351341
R1552 VSS.n188 VSS.n90 0.351341
R1553 VSS.n186 VSS.n91 0.351341
R1554 VSS.n184 VSS.n94 0.351341
R1555 VSS.n182 VSS.n95 0.351341
R1556 VSS.n180 VSS.n99 0.351341
R1557 VSS.n178 VSS.n101 0.351341
R1558 VSS.n176 VSS.n102 0.351341
R1559 VSS.n174 VSS.n103 0.351341
R1560 VSS.n172 VSS.n105 0.351341
R1561 VSS.n170 VSS.n106 0.351341
R1562 VSS.n168 VSS.n109 0.351341
R1563 VSS.n166 VSS.n110 0.351341
R1564 VSS.n164 VSS.n111 0.351341
R1565 VSS.n162 VSS.n112 0.351341
R1566 VSS.n160 VSS.n114 0.351341
R1567 VSS.n158 VSS.n115 0.351341
R1568 VSS.n156 VSS.n118 0.351341
R1569 VSS.n154 VSS.n119 0.351341
R1570 VSS.n152 VSS.n121 0.351341
R1571 VSS.n150 VSS.n122 0.351341
R1572 VSS.n148 VSS.n123 0.351341
R1573 VSS.n146 VSS.n125 0.351341
R1574 VSS.n144 VSS.n128 0.351341
R1575 VSS.n142 VSS.n129 0.351341
R1576 VSS.n140 VSS.n132 0.351341
R1577 VSS.n366 VSS.n365 0.345929
R1578 VSS.n549 VSS.n548 0.345929
R1579 VSS.n375 VSS.n373 0.340858
R1580 VSS.n533 VSS.n532 0.340858
R1581 VSS.n518 VSS.n517 0.340858
R1582 VSS.n495 VSS.n494 0.340858
R1583 VSS.n480 VSS.n479 0.340858
R1584 VSS.n465 VSS.n464 0.340858
R1585 VSS.n893 VSS.n892 0.318018
R1586 VSS.n433 VSS.n432 0.316299
R1587 VSS.n842 VSS.n81 0.311066
R1588 VSS.n832 VSS.n82 0.311066
R1589 VSS.n823 VSS.n83 0.311066
R1590 VSS.n815 VSS.n85 0.311066
R1591 VSS.n805 VSS.n87 0.311066
R1592 VSS.n795 VSS.n89 0.311066
R1593 VSS.n785 VSS.n90 0.311066
R1594 VSS.n777 VSS.n91 0.311066
R1595 VSS.n767 VSS.n94 0.311066
R1596 VSS.n759 VSS.n95 0.311066
R1597 VSS.n750 VSS.n99 0.311066
R1598 VSS.n740 VSS.n101 0.311066
R1599 VSS.n730 VSS.n102 0.311066
R1600 VSS.n721 VSS.n103 0.311066
R1601 VSS.n712 VSS.n105 0.311066
R1602 VSS.n703 VSS.n106 0.311066
R1603 VSS.n693 VSS.n109 0.311066
R1604 VSS.n684 VSS.n110 0.311066
R1605 VSS.n674 VSS.n111 0.311066
R1606 VSS.n665 VSS.n112 0.311066
R1607 VSS.n654 VSS.n114 0.311066
R1608 VSS.n646 VSS.n115 0.311066
R1609 VSS.n635 VSS.n118 0.311066
R1610 VSS.n626 VSS.n119 0.311066
R1611 VSS.n615 VSS.n121 0.311066
R1612 VSS.n606 VSS.n122 0.311066
R1613 VSS.n597 VSS.n123 0.311066
R1614 VSS.n588 VSS.n125 0.311066
R1615 VSS.n579 VSS.n128 0.311066
R1616 VSS.n571 VSS.n129 0.311066
R1617 VSS.n559 VSS.n132 0.311066
R1618 VSS.n210 VSS.n208 0.284268
R1619 VSS.n220 VSS.n218 0.284268
R1620 VSS.n230 VSS.n228 0.284268
R1621 VSS.n240 VSS.n238 0.284268
R1622 VSS.n250 VSS.n248 0.284268
R1623 VSS.n259 VSS.n257 0.284268
R1624 VSS.n269 VSS.n266 0.284268
R1625 VSS.n280 VSS.n277 0.284268
R1626 VSS.n289 VSS.n287 0.284268
R1627 VSS.n300 VSS.n297 0.284268
R1628 VSS.n309 VSS.n307 0.284268
R1629 VSS.n318 VSS.n315 0.284268
R1630 VSS.n327 VSS.n324 0.284268
R1631 VSS.n338 VSS.n336 0.284268
R1632 VSS.n348 VSS.n345 0.284268
R1633 VSS.n356 VSS.n354 0.284268
R1634 VSS.n875 VSS.n874 0.279928
R1635 VSS.n432 VSS.n431 0.274268
R1636 VSS.n440 VSS.n439 0.274227
R1637 VSS.n452 VSS.n451 0.274227
R1638 VSS.n467 VSS.n466 0.274227
R1639 VSS.n482 VSS.n481 0.274227
R1640 VSS.n505 VSS.n504 0.274227
R1641 VSS.n520 VSS.n519 0.274227
R1642 VSS.n535 VSS.n534 0.274227
R1643 VSS.n900 VSS.n899 0.272997
R1644 VSS.n892 VSS.n891 0.272549
R1645 VSS.n865 VSS.n202 0.271299
R1646 VSS.n887 VSS.n204 0.267794
R1647 VSS.n887 VSS.n853 0.267794
R1648 VSS.n887 VSS.n848 0.267794
R1649 VSS.n887 VSS.n839 0.267794
R1650 VSS.n887 VSS.n838 0.267794
R1651 VSS.n887 VSS.n216 0.267794
R1652 VSS.n887 VSS.n225 0.267794
R1653 VSS.n887 VSS.n814 0.267794
R1654 VSS.n887 VSS.n802 0.267794
R1655 VSS.n887 VSS.n801 0.267794
R1656 VSS.n887 VSS.n236 0.267794
R1657 VSS.n887 VSS.n791 0.267794
R1658 VSS.n887 VSS.n246 0.267794
R1659 VSS.n887 VSS.n773 0.267794
R1660 VSS.n887 VSS.n747 0.267794
R1661 VSS.n887 VSS.n746 0.267794
R1662 VSS.n887 VSS.n265 0.267794
R1663 VSS.n887 VSS.n267 0.267794
R1664 VSS.n887 VSS.n727 0.267794
R1665 VSS.n887 VSS.n274 0.267794
R1666 VSS.n887 VSS.n278 0.267794
R1667 VSS.n887 VSS.n709 0.267794
R1668 VSS.n887 VSS.n699 0.267794
R1669 VSS.n887 VSS.n293 0.267794
R1670 VSS.n887 VSS.n690 0.267794
R1671 VSS.n887 VSS.n683 0.267794
R1672 VSS.n887 VSS.n298 0.267794
R1673 VSS.n887 VSS.n671 0.267794
R1674 VSS.n887 VSS.n664 0.267794
R1675 VSS.n887 VSS.n660 0.267794
R1676 VSS.n887 VSS.n645 0.267794
R1677 VSS.n887 VSS.n316 0.267794
R1678 VSS.n887 VSS.n632 0.267794
R1679 VSS.n887 VSS.n625 0.267794
R1680 VSS.n887 VSS.n325 0.267794
R1681 VSS.n887 VSS.n331 0.267794
R1682 VSS.n887 VSS.n612 0.267794
R1683 VSS.n887 VSS.n334 0.267794
R1684 VSS.n887 VSS.n594 0.267794
R1685 VSS.n887 VSS.n346 0.267794
R1686 VSS.n887 VSS.n570 0.267794
R1687 VSS.n887 VSS.n565 0.267794
R1688 VSS.n887 VSS.n80 0.267794
R1689 VSS.n887 VSS.n84 0.267794
R1690 VSS.n887 VSS.n86 0.267794
R1691 VSS.n887 VSS.n88 0.267794
R1692 VSS.n887 VSS.n92 0.267794
R1693 VSS.n887 VSS.n93 0.267794
R1694 VSS.n887 VSS.n96 0.267794
R1695 VSS.n887 VSS.n97 0.267794
R1696 VSS.n887 VSS.n98 0.267794
R1697 VSS.n887 VSS.n100 0.267794
R1698 VSS.n887 VSS.n104 0.267794
R1699 VSS.n887 VSS.n107 0.267794
R1700 VSS.n887 VSS.n108 0.267794
R1701 VSS.n887 VSS.n113 0.267794
R1702 VSS.n887 VSS.n116 0.267794
R1703 VSS.n887 VSS.n117 0.267794
R1704 VSS.n887 VSS.n120 0.267794
R1705 VSS.n887 VSS.n124 0.267794
R1706 VSS.n887 VSS.n126 0.267794
R1707 VSS.n887 VSS.n127 0.267794
R1708 VSS.n887 VSS.n130 0.267794
R1709 VSS.n887 VSS.n131 0.267794
R1710 VSS.n887 VSS.n136 0.267794
R1711 VSS.n854 VSS.n202 0.265518
R1712 VSS.n369 VSS.n134 0.259448
R1713 VSS.n367 VSS.n366 0.251101
R1714 VSS.n445 VSS.n444 0.245497
R1715 VSS.n845 VSS.n844 0.244247
R1716 VSS.n826 VSS.n825 0.244247
R1717 VSS.n808 VSS.n807 0.244247
R1718 VSS.n788 VSS.n787 0.244247
R1719 VSS.n770 VSS.n769 0.244247
R1720 VSS.n753 VSS.n752 0.244247
R1721 VSS.n733 VSS.n732 0.244247
R1722 VSS.n715 VSS.n714 0.244247
R1723 VSS.n696 VSS.n695 0.244247
R1724 VSS.n677 VSS.n676 0.244247
R1725 VSS.n657 VSS.n656 0.244247
R1726 VSS.n638 VSS.n637 0.244247
R1727 VSS.n618 VSS.n617 0.244247
R1728 VSS.n600 VSS.n599 0.244247
R1729 VSS.n582 VSS.n581 0.244247
R1730 VSS.n562 VSS.n561 0.244247
R1731 VSS.n851 VSS.n208 0.240049
R1732 VSS.n830 VSS.n218 0.240049
R1733 VSS.n812 VSS.n228 0.240049
R1734 VSS.n793 VSS.n238 0.240049
R1735 VSS.n775 VSS.n248 0.240049
R1736 VSS.n757 VSS.n257 0.240049
R1737 VSS.n738 VSS.n266 0.240049
R1738 VSS.n719 VSS.n277 0.240049
R1739 VSS.n701 VSS.n287 0.240049
R1740 VSS.n681 VSS.n297 0.240049
R1741 VSS.n662 VSS.n307 0.240049
R1742 VSS.n643 VSS.n315 0.240049
R1743 VSS.n623 VSS.n324 0.240049
R1744 VSS.n604 VSS.n336 0.240049
R1745 VSS.n586 VSS.n345 0.240049
R1746 VSS.n568 VSS.n354 0.240049
R1747 VSS.n453 VSS.n452 0.237997
R1748 VSS.n468 VSS.n467 0.237997
R1749 VSS.n483 VSS.n482 0.237997
R1750 VSS.n506 VSS.n505 0.237997
R1751 VSS.n521 VSS.n520 0.237997
R1752 VSS.n536 VSS.n535 0.237997
R1753 VSS.n436 VSS.n435 0.234227
R1754 VSS.n896 VSS.n895 0.232997
R1755 VSS.n897 VSS.n896 0.231727
R1756 VSS.n437 VSS.n436 0.230497
R1757 VSS.n845 VSS.n841 0.224227
R1758 VSS.n826 VSS.n822 0.224227
R1759 VSS.n808 VSS.n804 0.224227
R1760 VSS.n788 VSS.n784 0.224227
R1761 VSS.n770 VSS.n766 0.224227
R1762 VSS.n753 VSS.n749 0.224227
R1763 VSS.n733 VSS.n729 0.224227
R1764 VSS.n715 VSS.n711 0.224227
R1765 VSS.n696 VSS.n692 0.224227
R1766 VSS.n677 VSS.n673 0.224227
R1767 VSS.n657 VSS.n653 0.224227
R1768 VSS.n638 VSS.n634 0.224227
R1769 VSS.n618 VSS.n614 0.224227
R1770 VSS.n600 VSS.n596 0.224227
R1771 VSS.n582 VSS.n578 0.224227
R1772 VSS.n562 VSS.n558 0.224227
R1773 VSS.n444 VSS.n443 0.219227
R1774 VSS.n867 VSS.n866 0.21012
R1775 VSS.n863 VSS.n861 0.21012
R1776 VSS.n370 VSS.n369 0.206787
R1777 VSS.n891 VSS.n890 0.201058
R1778 VSS.n431 VSS.n430 0.200293
R1779 VSS.n901 VSS.n900 0.191727
R1780 VSS.n441 VSS.n440 0.190497
R1781 VSS.n852 VSS.n851 0.186138
R1782 VSS.n831 VSS.n830 0.186138
R1783 VSS.n813 VSS.n812 0.186138
R1784 VSS.n794 VSS.n793 0.186138
R1785 VSS.n776 VSS.n775 0.186138
R1786 VSS.n758 VSS.n757 0.186138
R1787 VSS.n739 VSS.n738 0.186138
R1788 VSS.n720 VSS.n719 0.186138
R1789 VSS.n702 VSS.n701 0.186138
R1790 VSS.n682 VSS.n681 0.186138
R1791 VSS.n663 VSS.n662 0.186138
R1792 VSS.n644 VSS.n643 0.186138
R1793 VSS.n624 VSS.n623 0.186138
R1794 VSS.n605 VSS.n604 0.186138
R1795 VSS.n587 VSS.n586 0.186138
R1796 VSS.n569 VSS.n568 0.186138
R1797 VSS.n449 VSS.n448 0.1833
R1798 VSS.n870 VSS.n869 0.179043
R1799 VSS.n365 VSS.n134 0.177116
R1800 VSS.n905 VSS.n904 0.167388
R1801 VSS.n138 VSS.n133 0.16705
R1802 VSS.n459 VSS.n458 0.166269
R1803 VSS.n474 VSS.n473 0.166269
R1804 VSS.n489 VSS.n488 0.166269
R1805 VSS.n512 VSS.n511 0.166269
R1806 VSS.n527 VSS.n526 0.166269
R1807 VSS.n542 VSS.n541 0.166269
R1808 VSS.n448 VSS.n447 0.164888
R1809 VSS.n854 VSS.n201 0.16205
R1810 VSS.n842 VSS.n199 0.16205
R1811 VSS.n832 VSS.n197 0.16205
R1812 VSS.n823 VSS.n195 0.16205
R1813 VSS.n815 VSS.n193 0.16205
R1814 VSS.n805 VSS.n191 0.16205
R1815 VSS.n795 VSS.n189 0.16205
R1816 VSS.n785 VSS.n187 0.16205
R1817 VSS.n777 VSS.n185 0.16205
R1818 VSS.n767 VSS.n183 0.16205
R1819 VSS.n759 VSS.n181 0.16205
R1820 VSS.n750 VSS.n179 0.16205
R1821 VSS.n740 VSS.n177 0.16205
R1822 VSS.n730 VSS.n175 0.16205
R1823 VSS.n721 VSS.n173 0.16205
R1824 VSS.n712 VSS.n171 0.16205
R1825 VSS.n703 VSS.n169 0.16205
R1826 VSS.n693 VSS.n167 0.16205
R1827 VSS.n684 VSS.n165 0.16205
R1828 VSS.n674 VSS.n163 0.16205
R1829 VSS.n665 VSS.n161 0.16205
R1830 VSS.n654 VSS.n159 0.16205
R1831 VSS.n646 VSS.n157 0.16205
R1832 VSS.n635 VSS.n155 0.16205
R1833 VSS.n626 VSS.n153 0.16205
R1834 VSS.n615 VSS.n151 0.16205
R1835 VSS.n606 VSS.n149 0.16205
R1836 VSS.n597 VSS.n147 0.16205
R1837 VSS.n588 VSS.n145 0.16205
R1838 VSS.n579 VSS.n143 0.16205
R1839 VSS.n571 VSS.n141 0.16205
R1840 VSS.n559 VSS.n139 0.16205
R1841 VSS.n887 VSS.n885 0.16137
R1842 VSS.n887 VSS.n74 0.16137
R1843 VSS.n887 VSS.n76 0.16137
R1844 VSS.n870 VSS.n859 0.161058
R1845 VSS.n430 VSS.n429 0.161058
R1846 VSS.n890 VSS.n889 0.160293
R1847 VSS.n841 VSS.n214 0.15705
R1848 VSS.n822 VSS.n224 0.15705
R1849 VSS.n804 VSS.n234 0.15705
R1850 VSS.n784 VSS.n244 0.15705
R1851 VSS.n766 VSS.n254 0.15705
R1852 VSS.n749 VSS.n263 0.15705
R1853 VSS.n729 VSS.n273 0.15705
R1854 VSS.n711 VSS.n284 0.15705
R1855 VSS.n692 VSS.n294 0.15705
R1856 VSS.n673 VSS.n304 0.15705
R1857 VSS.n653 VSS.n313 0.15705
R1858 VSS.n634 VSS.n322 0.15705
R1859 VSS.n614 VSS.n332 0.15705
R1860 VSS.n596 VSS.n342 0.15705
R1861 VSS.n578 VSS.n352 0.15705
R1862 VSS.n455 VSS.n422 0.155582
R1863 VSS.n420 VSS.n419 0.155582
R1864 VSS.n464 VSS.n417 0.155582
R1865 VSS.n470 VSS.n414 0.155582
R1866 VSS.n412 VSS.n411 0.155582
R1867 VSS.n479 VSS.n409 0.155582
R1868 VSS.n485 VSS.n406 0.155582
R1869 VSS.n404 VSS.n403 0.155582
R1870 VSS.n494 VSS.n401 0.155582
R1871 VSS.n508 VSS.n398 0.155582
R1872 VSS.n395 VSS.n394 0.155582
R1873 VSS.n517 VSS.n392 0.155582
R1874 VSS.n523 VSS.n389 0.155582
R1875 VSS.n387 VSS.n386 0.155582
R1876 VSS.n532 VSS.n384 0.155582
R1877 VSS.n538 VSS.n381 0.155582
R1878 VSS.n379 VSS.n378 0.155582
R1879 VSS.n375 VSS.n374 0.155582
R1880 VSS.n856 VSS.n852 0.1508
R1881 VSS.n834 VSS.n831 0.1508
R1882 VSS.n817 VSS.n813 0.1508
R1883 VSS.n797 VSS.n794 0.1508
R1884 VSS.n779 VSS.n776 0.1508
R1885 VSS.n761 VSS.n758 0.1508
R1886 VSS.n742 VSS.n739 0.1508
R1887 VSS.n723 VSS.n720 0.1508
R1888 VSS.n705 VSS.n702 0.1508
R1889 VSS.n686 VSS.n682 0.1508
R1890 VSS.n667 VSS.n663 0.1508
R1891 VSS.n648 VSS.n644 0.1508
R1892 VSS.n628 VSS.n624 0.1508
R1893 VSS.n608 VSS.n605 0.1508
R1894 VSS.n590 VSS.n587 0.1508
R1895 VSS.n573 VSS.n569 0.1508
R1896 VSS.n438 VSS.n437 0.149888
R1897 VSS.n898 VSS.n897 0.14955
R1898 VSS.n453 VSS.n427 0.149476
R1899 VSS.n457 VSS.n456 0.149476
R1900 VSS.n461 VSS.n418 0.149476
R1901 VSS.n468 VSS.n416 0.149476
R1902 VSS.n472 VSS.n471 0.149476
R1903 VSS.n476 VSS.n410 0.149476
R1904 VSS.n483 VSS.n408 0.149476
R1905 VSS.n487 VSS.n486 0.149476
R1906 VSS.n491 VSS.n402 0.149476
R1907 VSS.n506 VSS.n400 0.149476
R1908 VSS.n510 VSS.n509 0.149476
R1909 VSS.n514 VSS.n393 0.149476
R1910 VSS.n521 VSS.n391 0.149476
R1911 VSS.n525 VSS.n524 0.149476
R1912 VSS.n529 VSS.n385 0.149476
R1913 VSS.n536 VSS.n383 0.149476
R1914 VSS.n540 VSS.n539 0.149476
R1915 VSS.n544 VSS.n377 0.149476
R1916 VSS.n874 VSS.n873 0.148577
R1917 VSS.n895 VSS.n894 0.147388
R1918 VSS.n435 VSS.n434 0.14705
R1919 VSS.n902 VSS.n901 0.142118
R1920 VSS.n442 VSS.n441 0.142118
R1921 VSS.n370 VSS.n368 0.141022
R1922 VSS.n446 VSS.n445 0.134888
R1923 VSS.n501 VSS.n500 0.134888
R1924 VSS.n455 VSS.n454 0.129618
R1925 VSS.n470 VSS.n469 0.129618
R1926 VSS.n485 VSS.n484 0.129618
R1927 VSS.n508 VSS.n507 0.129618
R1928 VSS.n523 VSS.n522 0.129618
R1929 VSS.n538 VSS.n537 0.129618
R1930 VSS.n368 VSS.n367 0.127569
R1931 VSS.n458 VSS.n421 0.126138
R1932 VSS.n473 VSS.n413 0.126138
R1933 VSS.n488 VSS.n405 0.126138
R1934 VSS.n511 VSS.n397 0.126138
R1935 VSS.n526 VSS.n388 0.126138
R1936 VSS.n541 VSS.n380 0.126138
R1937 VSS.n859 VSS.n857 0.125868
R1938 VSS.n836 VSS.n835 0.125868
R1939 VSS.n819 VSS.n818 0.125868
R1940 VSS.n799 VSS.n798 0.125868
R1941 VSS.n781 VSS.n780 0.125868
R1942 VSS.n763 VSS.n762 0.125868
R1943 VSS.n744 VSS.n743 0.125868
R1944 VSS.n725 VSS.n724 0.125868
R1945 VSS.n707 VSS.n706 0.125868
R1946 VSS.n688 VSS.n687 0.125868
R1947 VSS.n669 VSS.n668 0.125868
R1948 VSS.n650 VSS.n649 0.125868
R1949 VSS.n630 VSS.n629 0.125868
R1950 VSS.n610 VSS.n609 0.125868
R1951 VSS.n592 VSS.n591 0.125868
R1952 VSS.n575 VSS.n574 0.125868
R1953 VSS.n49 VSS.n423 0.156005
R1954 VSS.n52 VSS.n415 0.156005
R1955 VSS.n55 VSS.n407 0.156005
R1956 VSS.n58 VSS.n399 0.156005
R1957 VSS.n61 VSS.n390 0.156005
R1958 VSS.n64 VSS.n382 0.156005
R1959 VSS.n553 VSS.n137 0.124618
R1960 VSS.n904 VSS.n903 0.12455
R1961 VSS.n548 VSS.n137 0.122118
R1962 VSS.n447 VSS.n446 0.12205
R1963 VSS.n464 VSS.n463 0.12205
R1964 VSS.n479 VSS.n478 0.12205
R1965 VSS.n494 VSS.n493 0.12205
R1966 VSS.n502 VSS.n501 0.12205
R1967 VSS.n517 VSS.n516 0.12205
R1968 VSS.n532 VSS.n531 0.12205
R1969 VSS.n376 VSS.n375 0.12205
R1970 VSS.n201 VSS.n200 0.119888
R1971 VSS.n199 VSS.n198 0.119888
R1972 VSS.n197 VSS.n196 0.119888
R1973 VSS.n195 VSS.n194 0.119888
R1974 VSS.n193 VSS.n192 0.119888
R1975 VSS.n191 VSS.n190 0.119888
R1976 VSS.n189 VSS.n188 0.119888
R1977 VSS.n187 VSS.n186 0.119888
R1978 VSS.n185 VSS.n184 0.119888
R1979 VSS.n183 VSS.n182 0.119888
R1980 VSS.n181 VSS.n180 0.119888
R1981 VSS.n179 VSS.n178 0.119888
R1982 VSS.n177 VSS.n176 0.119888
R1983 VSS.n175 VSS.n174 0.119888
R1984 VSS.n173 VSS.n172 0.119888
R1985 VSS.n171 VSS.n170 0.119888
R1986 VSS.n169 VSS.n168 0.119888
R1987 VSS.n167 VSS.n166 0.119888
R1988 VSS.n165 VSS.n164 0.119888
R1989 VSS.n163 VSS.n162 0.119888
R1990 VSS.n161 VSS.n160 0.119888
R1991 VSS.n159 VSS.n158 0.119888
R1992 VSS.n157 VSS.n156 0.119888
R1993 VSS.n155 VSS.n154 0.119888
R1994 VSS.n153 VSS.n152 0.119888
R1995 VSS.n151 VSS.n150 0.119888
R1996 VSS.n149 VSS.n148 0.119888
R1997 VSS.n147 VSS.n146 0.119888
R1998 VSS.n145 VSS.n144 0.119888
R1999 VSS.n143 VSS.n142 0.119888
R2000 VSS.n141 VSS.n140 0.119888
R2001 VSS.n139 VSS.n138 0.119888
R2002 VSS.n553 VSS.n133 0.114888
R2003 VSS.n903 VSS.n902 0.114618
R2004 VSS.n443 VSS.n442 0.114618
R2005 VSS.n835 VSS.n214 0.113638
R2006 VSS.n818 VSS.n224 0.113638
R2007 VSS.n798 VSS.n234 0.113638
R2008 VSS.n780 VSS.n244 0.113638
R2009 VSS.n762 VSS.n254 0.113638
R2010 VSS.n743 VSS.n263 0.113638
R2011 VSS.n724 VSS.n273 0.113638
R2012 VSS.n706 VSS.n284 0.113638
R2013 VSS.n687 VSS.n294 0.113638
R2014 VSS.n668 VSS.n304 0.113638
R2015 VSS.n649 VSS.n313 0.113638
R2016 VSS.n629 VSS.n322 0.113638
R2017 VSS.n609 VSS.n332 0.113638
R2018 VSS.n591 VSS.n342 0.113638
R2019 VSS.n574 VSS.n352 0.113638
R2020 VSS.n434 VSS.n433 0.109888
R2021 VSS.n894 VSS.n893 0.10955
R2022 VSS.n899 VSS.n898 0.107388
R2023 VSS.n439 VSS.n438 0.10705
R2024 VSS.n463 VSS.n462 0.106138
R2025 VSS.n478 VSS.n477 0.106138
R2026 VSS.n493 VSS.n492 0.106138
R2027 VSS.n516 VSS.n515 0.106138
R2028 VSS.n531 VSS.n530 0.106138
R2029 VSS.n545 VSS.n376 0.106138
R2030 VSS.n461 VSS.n460 0.105361
R2031 VSS.n476 VSS.n475 0.105361
R2032 VSS.n491 VSS.n490 0.105361
R2033 VSS.n514 VSS.n513 0.105361
R2034 VSS.n529 VSS.n528 0.105361
R2035 VSS.n544 VSS.n543 0.105361
R2036 VSS.n421 VSS.n420 0.10205
R2037 VSS.n413 VSS.n412 0.10205
R2038 VSS.n405 VSS.n404 0.10205
R2039 VSS.n397 VSS.n395 0.10205
R2040 VSS.n388 VSS.n387 0.10205
R2041 VSS.n380 VSS.n379 0.10205
R2042 VSS.n454 VSS.n423 0.0983676
R2043 VSS.n469 VSS.n415 0.0983676
R2044 VSS.n484 VSS.n407 0.0983676
R2045 VSS.n507 VSS.n399 0.0983676
R2046 VSS.n522 VSS.n390 0.0983676
R2047 VSS.n537 VSS.n382 0.0983676
R2048 VSS.n864 VSS.n863 0.094
R2049 VSS.n867 VSS.n864 0.094
R2050 VSS.n873 VSS.n203 0.08925
R2051 VSS.n857 VSS.n856 0.0883676
R2052 VSS.n836 VSS.n834 0.0883676
R2053 VSS.n819 VSS.n817 0.0883676
R2054 VSS.n799 VSS.n797 0.0883676
R2055 VSS.n781 VSS.n779 0.0883676
R2056 VSS.n763 VSS.n761 0.0883676
R2057 VSS.n744 VSS.n742 0.0883676
R2058 VSS.n725 VSS.n723 0.0883676
R2059 VSS.n707 VSS.n705 0.0883676
R2060 VSS.n688 VSS.n686 0.0883676
R2061 VSS.n669 VSS.n667 0.0883676
R2062 VSS.n650 VSS.n648 0.0883676
R2063 VSS.n630 VSS.n628 0.0883676
R2064 VSS.n610 VSS.n608 0.0883676
R2065 VSS.n592 VSS.n590 0.0883676
R2066 VSS.n575 VSS.n573 0.0883676
R2067 VSS.n556 VSS.n555 0.088
R2068 VSS.n51 VSS.n461 0.0435295
R2069 VSS.n54 VSS.n476 0.0435295
R2070 VSS.n492 VSS.n57 0.176279
R2071 VSS.n515 VSS.n60 0.176279
R2072 VSS.n63 VSS.n529 0.0435295
R2073 VSS.n545 VSS.n66 0.176279
R2074 VSS.n863 VSS.n862 0.0851154
R2075 VSS.n869 VSS.n867 0.0851154
R2076 VSS.n551 VSS.n547 0.0805
R2077 VSS.n889 VSS.n888 0.078
R2078 VSS.n429 VSS.n428 0.078
R2079 VSS.n365 VSS.n135 0.0771176
R2080 VSS.n862 VSS.n205 0.0746176
R2081 VSS.n860 VSS.n78 0.0746176
R2082 VSS.n550 VSS.n362 0.07425
R2083 VSS.n548 VSS.n135 0.0696176
R2084 VSS.n862 VSS.n206 0.06925
R2085 VSS.n860 VSS.n79 0.06925
R2086 VSS.n457 VSS.n50 0.103847
R2087 VSS.n472 VSS.n53 0.103847
R2088 VSS.n487 VSS.n56 0.103847
R2089 VSS.n510 VSS.n59 0.103847
R2090 VSS.n525 VSS.n62 0.103847
R2091 VSS.n540 VSS.n65 0.103847
R2092 VSS.n558 VSS.n361 0.06175
R2093 VSS.n865 VSS.n79 0.05925
R2094 VSS.n879 VSS.n877 0.05675
R2095 VSS.n876 VSS.n205 0.0546176
R2096 VSS.n873 VSS.n78 0.0546176
R2097 VSS.n542 VSS.n540 0.0543074
R2098 VSS.n527 VSS.n525 0.0543074
R2099 VSS.n512 VSS.n510 0.0543074
R2100 VSS.n489 VSS.n487 0.0543074
R2101 VSS.n474 VSS.n472 0.0543074
R2102 VSS.n459 VSS.n457 0.0543074
R2103 VSS.n50 VSS.n455 0.0180497
R2104 VSS.n53 VSS.n470 0.0180497
R2105 VSS.n56 VSS.n485 0.0180497
R2106 VSS.n59 VSS.n508 0.0180497
R2107 VSS.n552 VSS.n362 0.04925
R2108 VSS.n211 VSS.n210 0.048
R2109 VSS.n221 VSS.n220 0.048
R2110 VSS.n231 VSS.n230 0.048
R2111 VSS.n241 VSS.n240 0.048
R2112 VSS.n251 VSS.n250 0.048
R2113 VSS.n260 VSS.n259 0.048
R2114 VSS.n270 VSS.n269 0.048
R2115 VSS.n281 VSS.n280 0.048
R2116 VSS.n290 VSS.n289 0.048
R2117 VSS.n301 VSS.n300 0.048
R2118 VSS.n310 VSS.n309 0.048
R2119 VSS.n319 VSS.n318 0.048
R2120 VSS.n328 VSS.n327 0.048
R2121 VSS.n339 VSS.n338 0.048
R2122 VSS.n349 VSS.n348 0.048
R2123 VSS.n357 VSS.n356 0.048
R2124 VSS.n556 VSS.n552 0.04675
R2125 VSS.n844 VSS.n211 0.0405
R2126 VSS.n825 VSS.n221 0.0405
R2127 VSS.n807 VSS.n231 0.0405
R2128 VSS.n787 VSS.n241 0.0405
R2129 VSS.n769 VSS.n251 0.0405
R2130 VSS.n752 VSS.n260 0.0405
R2131 VSS.n732 VSS.n270 0.0405
R2132 VSS.n714 VSS.n281 0.0405
R2133 VSS.n695 VSS.n290 0.0405
R2134 VSS.n676 VSS.n301 0.0405
R2135 VSS.n656 VSS.n310 0.0405
R2136 VSS.n637 VSS.n319 0.0405
R2137 VSS.n617 VSS.n328 0.0405
R2138 VSS.n599 VSS.n339 0.0405
R2139 VSS.n581 VSS.n349 0.0405
R2140 VSS.n561 VSS.n357 0.0405
R2141 VSS.n888 VSS 0.038
R2142 VSS.n877 VSS.n876 0.033
R2143 VSS.n869 VSS.n868 0.033
R2144 VSS.n368 VSS.n364 0.02925
R2145 VSS.n868 VSS.n206 0.02675
R2146 VSS.n35 VSS.n32 0.00588067
R2147 VSS.n35 VSS.n33 0.00760728
R2148 VSS.t139 VSS.n30 116.468
R2149 VSS.t118 VSS.n29 116.469
R2150 VSS.t178 VSS.n31 116.468
R2151 VSS.n44 VSS.n8 0.00588066
R2152 VSS.t80 VSS.n20 116.469
R2153 VSS.t73 VSS.n46 212.157
R2154 VSS.n13 VSS.t175 116.469
R2155 VSS.n8 VSS.n3 0.023135
R2156 VSS.n28 VSS.t158 384.904
R2157 VSS.n551 VSS.n550 0.02175
R2158 VSS.n887 VSS.n886 0.0166972
R2159 VSS.n887 VSS.n71 0.0166972
R2160 VSS.n543 VSS.n379 0.0166107
R2161 VSS.n528 VSS.n387 0.0166107
R2162 VSS.n513 VSS.n395 0.0166107
R2163 VSS.n490 VSS.n404 0.0166107
R2164 VSS.n475 VSS.n412 0.0166107
R2165 VSS.n460 VSS.n420 0.0166107
R2166 VSS.n547 VSS.n364 0.0155
R2167 VSS.n878 VSS.n68 0.0112403
R2168 VSS.n905 VSS.n68 0.0095322
R2169 VSS.n887 VSS.n217 0.00938635
R2170 VSS.n887 VSS.n296 0.00938635
R2171 VSS.n887 VSS.n306 0.00938635
R2172 VSS.n887 VSS.n335 0.00938635
R2173 VSS.n887 VSS.n344 0.00938635
R2174 VSS.n887 VSS.n871 0.00937856
R2175 VSS.n887 VSS.n227 0.00937856
R2176 VSS.n887 VSS.n237 0.00937856
R2177 VSS.n887 VSS.n247 0.00937856
R2178 VSS.n887 VSS.n256 0.00937856
R2179 VSS.n887 VSS.n736 0.00937856
R2180 VSS.n887 VSS.n286 0.00937856
R2181 VSS.n887 VSS.n566 0.00937856
R2182 VSS.n887 VSS.n360 0.00937856
R2183 VSS.n887 VSS.n849 0.00937856
R2184 VSS.n887 VSS.n276 0.00937856
R2185 VSS.n887 VSS.n641 0.00937856
R2186 VSS.n887 VSS.n621 0.00937856
R2187 VSS.n555 VSS.n361 0.008
R2188 VSS.n879 VSS.n878 0.00675
R2189 VSS.n878 VSS.n203 0.00675
R2190 VSS.n40 VSS.n39 0.00179957
R2191 VSS.n40 VSS.n38 0.00179957
R2192 VSS.n41 VSS.t321 402.185
R2193 VSS.n40 VSS.n37 0.00179957
R2194 VSS.n15 VSS.t309 117.528
R2195 VSS.n8 VSS.n0 0.0025114
R2196 VSS.n40 VSS.n35 0.00351876
R2197 VSS.n0 VSS.t261 58.3217
R2198 VSS.n8 VSS.n1 0.0035486
R2199 VSS.n8 VSS.n22 0.00340352
R2200 VSS.n8 VSS.n21 0.00339401
R2201 VSS.n7 VSS.n15 0.002384
R2202 VSS.n17 VSS.t256 160.343
R2203 VSS.n8 VSS.n7 0.0042108
R2204 VSS.n16 VSS.t306 402.188
R2205 VSS.n8 VSS.n42 0.00452851
R2206 VSS.n40 VSS.n7 0.00349999
R2207 VSS.n14 VSS.t249 240.957
R2208 VSS.n9 VSS.n396 469.788
R2209 a_3747_311.n0 a_3747_311.t2 52.0388
R2210 a_3747_311.t1 a_3747_311.n0 35.4491
R2211 a_3747_311.n0 a_3747_311.t3 33.5891
R2212 a_3747_311.t0 a_3747_311.t1 5.61942
R2213 a_3171_311.n0 a_3171_311.t2 51.8377
R2214 a_3171_311.n0 a_3171_311.t3 33.3881
R2215 a_3171_311.t1 a_3171_311.n0 31.8923
R2216 a_3171_311.t0 a_3171_311.t1 5.61777
R2217 a_2595_311.n0 a_2595_311.t2 51.6367
R2218 a_2595_311.n0 a_2595_311.t3 33.187
R2219 a_2595_311.t1 a_2595_311.n0 27.993
R2220 a_2595_311.t0 a_2595_311.t1 5.73018
R2221 a_3747_1047.n0 a_3747_1047.t2 38.0081
R2222 a_3747_1047.n0 a_3747_1047.t3 33.3957
R2223 a_3747_1047.n1 a_3747_1047.t4 33.3957
R2224 a_3747_1047.n2 a_3747_1047.t5 33.3957
R2225 a_3747_1047.n3 a_3747_1047.t6 33.3957
R2226 a_3747_1047.n4 a_3747_1047.t7 33.3957
R2227 a_3747_1047.n5 a_3747_1047.t8 33.3957
R2228 a_3747_1047.n6 a_3747_1047.t9 33.3957
R2229 a_3747_1047.t1 a_3747_1047.n6 23.2419
R2230 a_3747_1047.t0 a_3747_1047.t1 5.61942
R2231 a_3747_1047.n6 a_3747_1047.n5 4.61291
R2232 a_3747_1047.n5 a_3747_1047.n4 4.61291
R2233 a_3747_1047.n4 a_3747_1047.n3 4.61291
R2234 a_3747_1047.n3 a_3747_1047.n2 4.61291
R2235 a_3747_1047.n2 a_3747_1047.n1 4.61291
R2236 a_3747_1047.n1 a_3747_1047.n0 4.61291
R2237 a_3171_1047.n0 a_3171_1047.t2 37.8054
R2238 a_3171_1047.n0 a_3171_1047.t3 33.193
R2239 a_3171_1047.n1 a_3171_1047.t4 33.193
R2240 a_3171_1047.n2 a_3171_1047.t5 33.193
R2241 a_3171_1047.n3 a_3171_1047.t6 33.193
R2242 a_3171_1047.n4 a_3171_1047.t7 33.193
R2243 a_3171_1047.n5 a_3171_1047.t8 33.193
R2244 a_3171_1047.n6 a_3171_1047.t9 33.193
R2245 a_3171_1047.t1 a_3171_1047.n6 23.0313
R2246 a_3171_1047.t0 a_3171_1047.t1 5.61777
R2247 a_3171_1047.n6 a_3171_1047.n5 4.61291
R2248 a_3171_1047.n5 a_3171_1047.n4 4.61291
R2249 a_3171_1047.n4 a_3171_1047.n3 4.61291
R2250 a_3171_1047.n3 a_3171_1047.n2 4.61291
R2251 a_3171_1047.n2 a_3171_1047.n1 4.61291
R2252 a_3171_1047.n1 a_3171_1047.n0 4.61291
R2253 a_2595_1047.n0 a_2595_1047.t2 37.7691
R2254 a_2595_1047.n0 a_2595_1047.t3 33.1567
R2255 a_2595_1047.n1 a_2595_1047.t4 33.1567
R2256 a_2595_1047.n2 a_2595_1047.t5 33.1567
R2257 a_2595_1047.n3 a_2595_1047.t6 33.1567
R2258 a_2595_1047.n4 a_2595_1047.t7 33.1567
R2259 a_2595_1047.n5 a_2595_1047.t8 33.1567
R2260 a_2595_1047.n6 a_2595_1047.t9 33.1567
R2261 a_2595_1047.t1 a_2595_1047.n6 22.7941
R2262 a_2595_1047.t0 a_2595_1047.t1 5.65522
R2263 a_2595_1047.n6 a_2595_1047.n5 4.61291
R2264 a_2595_1047.n5 a_2595_1047.n4 4.61291
R2265 a_2595_1047.n4 a_2595_1047.n3 4.61291
R2266 a_2595_1047.n3 a_2595_1047.n2 4.61291
R2267 a_2595_1047.n2 a_2595_1047.n1 4.61291
R2268 a_2595_1047.n1 a_2595_1047.n0 4.61291
R2269 a_2019_1047.n0 a_2019_1047.t2 37.9701
R2270 a_2019_1047.n0 a_2019_1047.t3 33.3577
R2271 a_2019_1047.n1 a_2019_1047.t4 33.3577
R2272 a_2019_1047.n2 a_2019_1047.t5 33.3577
R2273 a_2019_1047.n3 a_2019_1047.t6 33.3577
R2274 a_2019_1047.n4 a_2019_1047.t7 33.3577
R2275 a_2019_1047.n5 a_2019_1047.t8 33.3577
R2276 a_2019_1047.t1 a_2019_1047.t9 22.5945
R2277 a_2019_1047.t0 a_2019_1047.t1 5.62052
R2278 a_2019_1047.t9 a_2019_1047.n5 4.61291
R2279 a_2019_1047.n5 a_2019_1047.n4 4.61291
R2280 a_2019_1047.n4 a_2019_1047.n3 4.61291
R2281 a_2019_1047.n3 a_2019_1047.n2 4.61291
R2282 a_2019_1047.n2 a_2019_1047.n1 4.61291
R2283 a_2019_1047.n1 a_2019_1047.n0 4.61291
C1105 MUX_OUT VSS 3.24058f
C1106 MUX_SEL4 VSS 1.60778f
C1107 MUX_SEL3 VSS 0.90686f
C1108 MUX_SEL2 VSS 1.81137f
C1109 MUX_SEL1 VSS 0.95076f
C1110 MUX_SEL0 VSS 1.55166f
C1111 DELAY_VBIASN VSS 12.41106f
C1112 DELAY_OUT_LAST VSS 0.39284f
C1113 DELAY_VBIASP VSS 4.14121f
C1114 DELAY_IN VSS 1.91954f
C1115 VDD VSS 46.2831f
C1116 a_26985_519# VSS 0.17928f ; **FLOATING
C1117 a_23945_519# VSS 0.17928f ; **FLOATING
C1118 a_20905_519# VSS 0.17928f ; **FLOATING
C1119 a_17865_519# VSS 0.17593f ; **FLOATING
C1120 a_16851_309# VSS 0.38699f ; **FLOATING
C1121 a_16108_289# VSS 3.70428f ; **FLOATING
C1122 a_15964_289# VSS 0.17613f ; **FLOATING
C1123 a_15765_463# VSS 0.36132f ; **FLOATING
C1124 a_14825_519# VSS 0.17928f ; **FLOATING
C1125 a_11785_519# VSS 0.17928f ; **FLOATING
C1126 a_8745_519# VSS 0.17928f ; **FLOATING
C1127 a_5731_289# VSS 3.39133f ; **FLOATING
C1128 a_2019_311# VSS 1.61601f ; **FLOATING
C1129 a_5705_519# VSS 0.17638f ; **FLOATING
C1130 a_3449_331# VSS 0.18478f ; **FLOATING
C1131 a_2873_331# VSS 0.18321f ; **FLOATING
C1132 a_2297_331# VSS 0.18321f ; **FLOATING
C1133 a_1721_331# VSS 0.17001f ; **FLOATING
C1134 a_1544_289# VSS 0.30014f ; **FLOATING
C1135 a_1256_289# VSS 0.84266f ; **FLOATING
C1136 a_27991_1008# VSS 0.18706f ; **FLOATING
C1137 a_27915_1044# VSS 0.10926f ; **FLOATING
C1138 a_27124_1008# VSS 0.17878f ; **FLOATING
C1139 a_27048_1044# VSS 0.12122f ; **FLOATING
C1140 a_26471_1008# VSS 0.18175f ; **FLOATING
C1141 a_26395_1044# VSS 0.11073f ; **FLOATING
C1142 a_25604_1008# VSS 0.18087f ; **FLOATING
C1143 a_25630_1044# VSS 0.37805f ; **FLOATING
C1144 a_25528_1044# VSS 0.12433f ; **FLOATING
C1145 a_24951_1008# VSS 0.18335f ; **FLOATING
C1146 a_24875_1044# VSS 0.11016f ; **FLOATING
C1147 a_24084_1008# VSS 0.17878f ; **FLOATING
C1148 a_24008_1044# VSS 0.12122f ; **FLOATING
C1149 a_23431_1008# VSS 0.18175f ; **FLOATING
C1150 a_23355_1044# VSS 0.11073f ; **FLOATING
C1151 a_22564_1008# VSS 0.18087f ; **FLOATING
C1152 a_22590_1044# VSS 0.33314f ; **FLOATING
C1153 a_22488_1044# VSS 0.12433f ; **FLOATING
C1154 a_21911_1008# VSS 0.18335f ; **FLOATING
C1155 a_21835_1044# VSS 0.11016f ; **FLOATING
C1156 a_21044_1008# VSS 0.17878f ; **FLOATING
C1157 a_20968_1044# VSS 0.12122f ; **FLOATING
C1158 a_20391_1008# VSS 0.18175f ; **FLOATING
C1159 a_20315_1044# VSS 0.11073f ; **FLOATING
C1160 a_19524_1008# VSS 0.18087f ; **FLOATING
C1161 a_19550_1044# VSS 0.33563f ; **FLOATING
C1162 a_19448_1044# VSS 0.12433f ; **FLOATING
C1163 a_18871_1008# VSS 0.18335f ; **FLOATING
C1164 a_18795_1044# VSS 0.11016f ; **FLOATING
C1165 a_18004_1008# VSS 0.17878f ; **FLOATING
C1166 a_17928_1044# VSS 0.12122f ; **FLOATING
C1167 a_17351_1008# VSS 0.18022f ; **FLOATING
C1168 a_17275_1044# VSS 0.10926f ; **FLOATING
C1169 a_16484_1008# VSS 0.18023f ; **FLOATING
C1170 a_16510_1044# VSS 0.28935f ; **FLOATING
C1171 a_16408_1044# VSS 0.1229f ; **FLOATING
C1172 a_15831_1008# VSS 0.17846f ; **FLOATING
C1173 a_15755_1044# VSS 0.10926f ; **FLOATING
C1174 a_14964_1008# VSS 0.17878f ; **FLOATING
C1175 a_14888_1044# VSS 0.12122f ; **FLOATING
C1176 a_14311_1008# VSS 0.18175f ; **FLOATING
C1177 a_14235_1044# VSS 0.11073f ; **FLOATING
C1178 a_13444_1008# VSS 0.18087f ; **FLOATING
C1179 a_13470_1044# VSS 0.30333f ; **FLOATING
C1180 a_13368_1044# VSS 0.12433f ; **FLOATING
C1181 a_12791_1008# VSS 0.18335f ; **FLOATING
C1182 a_12715_1044# VSS 0.11016f ; **FLOATING
C1183 a_11924_1008# VSS 0.17878f ; **FLOATING
C1184 a_11848_1044# VSS 0.12122f ; **FLOATING
C1185 a_11271_1008# VSS 0.18175f ; **FLOATING
C1186 a_11195_1044# VSS 0.11073f ; **FLOATING
C1187 a_10404_1008# VSS 0.18087f ; **FLOATING
C1188 a_10430_1044# VSS 0.31665f ; **FLOATING
C1189 a_10328_1044# VSS 0.12433f ; **FLOATING
C1190 a_9751_1008# VSS 0.18335f ; **FLOATING
C1191 a_9675_1044# VSS 0.11016f ; **FLOATING
C1192 a_8884_1008# VSS 0.17878f ; **FLOATING
C1193 a_8808_1044# VSS 0.12122f ; **FLOATING
C1194 a_8231_1008# VSS 0.18175f ; **FLOATING
C1195 a_8155_1044# VSS 0.11073f ; **FLOATING
C1196 a_7364_1008# VSS 0.18087f ; **FLOATING
C1197 a_7390_1044# VSS 0.31357f ; **FLOATING
C1198 a_7288_1044# VSS 0.12433f ; **FLOATING
C1199 a_6711_1008# VSS 0.18335f ; **FLOATING
C1200 a_6635_1044# VSS 0.11016f ; **FLOATING
C1201 a_5844_1008# VSS 0.17878f ; **FLOATING
C1202 a_5768_1044# VSS 0.12122f ; **FLOATING
C1203 a_5191_1008# VSS 0.18022f ; **FLOATING
C1204 a_5115_1044# VSS 0.10926f ; **FLOATING
C1205 a_4324_1008# VSS 0.18023f ; **FLOATING
C1206 a_4350_1044# VSS 0.26655f ; **FLOATING
C1207 a_4248_1044# VSS 0.12443f ; **FLOATING
C1208 a_27705_1044# VSS 0.25296f ; **FLOATING
C1209 a_26185_1044# VSS 0.23475f ; **FLOATING
C1210 a_24665_1044# VSS 0.25432f ; **FLOATING
C1211 a_23145_1044# VSS 0.23475f ; **FLOATING
C1212 a_21625_1044# VSS 0.25432f ; **FLOATING
C1213 a_20105_1044# VSS 0.23475f ; **FLOATING
C1214 a_18585_1044# VSS 0.25432f ; **FLOATING
C1215 a_17065_1044# VSS 0.23385f ; **FLOATING
C1216 a_15545_1044# VSS 0.25296f ; **FLOATING
C1217 a_14025_1044# VSS 0.23475f ; **FLOATING
C1218 a_12505_1044# VSS 0.25432f ; **FLOATING
C1219 a_10985_1044# VSS 0.23475f ; **FLOATING
C1220 a_9465_1044# VSS 0.25432f ; **FLOATING
C1221 a_7945_1044# VSS 0.23475f ; **FLOATING
C1222 a_6425_1044# VSS 0.25432f ; **FLOATING
C1223 a_4905_1044# VSS 0.23549f ; **FLOATING
C1224 a_4157_1313# VSS 0.32875f ; **FLOATING
C1225 a_3449_1395# VSS 0.18629f ; **FLOATING
C1226 a_2873_1395# VSS 0.18349f ; **FLOATING
C1227 a_2297_1395# VSS 0.18349f ; **FLOATING
C1228 a_1721_1395# VSS 0.17029f ; **FLOATING
C1229 a_1544_1044# VSS 0.29829f ; **FLOATING
C1230 a_1256_1044# VSS 0.82978f ; **FLOATING
C1231 a_27671_1842# VSS 0.01336f ; **FLOATING
C1232 a_26911_1842# VSS 0.01336f ; **FLOATING
C1233 a_26151_1842# VSS 0.01336f ; **FLOATING
C1234 a_25391_1842# VSS 0.01336f ; **FLOATING
C1235 a_24631_1842# VSS 0.01336f ; **FLOATING
C1236 a_23871_1842# VSS 0.01336f ; **FLOATING
C1237 a_23111_1842# VSS 0.01336f ; **FLOATING
C1238 a_22351_1842# VSS 0.01336f ; **FLOATING
C1239 a_21591_1842# VSS 0.01336f ; **FLOATING
C1240 a_20831_1842# VSS 0.01336f ; **FLOATING
C1241 a_20071_1842# VSS 0.01336f ; **FLOATING
C1242 a_19311_1842# VSS 0.01336f ; **FLOATING
C1243 a_18551_1842# VSS 0.01336f ; **FLOATING
C1244 a_17791_1842# VSS 0.01336f ; **FLOATING
C1245 a_17031_1842# VSS 0.01336f ; **FLOATING
C1246 a_16271_1842# VSS 0.01336f ; **FLOATING
C1247 a_15511_1842# VSS 0.01336f ; **FLOATING
C1248 a_14751_1842# VSS 0.01336f ; **FLOATING
C1249 a_13991_1842# VSS 0.01336f ; **FLOATING
C1250 a_13231_1842# VSS 0.01336f ; **FLOATING
C1251 a_12471_1842# VSS 0.01336f ; **FLOATING
C1252 a_11711_1842# VSS 0.01336f ; **FLOATING
C1253 a_10951_1842# VSS 0.01336f ; **FLOATING
C1254 a_10191_1842# VSS 0.01336f ; **FLOATING
C1255 a_9431_1842# VSS 0.01336f ; **FLOATING
C1256 a_8671_1842# VSS 0.01336f ; **FLOATING
C1257 a_7911_1842# VSS 0.01336f ; **FLOATING
C1258 a_7151_1842# VSS 0.01336f ; **FLOATING
C1259 a_6391_1842# VSS 0.01336f ; **FLOATING
C1260 a_5631_1842# VSS 0.01336f ; **FLOATING
C1261 a_4871_1842# VSS 0.01336f ; **FLOATING
C1262 a_4111_1842# VSS 0.0139f ; **FLOATING
C1263 a_27563_1842# VSS 0.51284f ; **FLOATING
C1264 a_27997_1842# VSS 0.6533f ; **FLOATING
C1265 a_27433_1842# VSS 0.45843f ; **FLOATING
C1266 a_26803_1842# VSS 0.50902f ; **FLOATING
C1267 a_27237_1842# VSS 0.93747f ; **FLOATING
C1268 a_26673_1842# VSS 0.45994f ; **FLOATING
C1269 a_26043_1842# VSS 0.51137f ; **FLOATING
C1270 a_26477_1842# VSS 0.96549f ; **FLOATING
C1271 a_25913_1842# VSS 0.46292f ; **FLOATING
C1272 a_25283_1842# VSS 0.50906f ; **FLOATING
C1273 a_25717_1842# VSS 0.87619f ; **FLOATING
C1274 a_25153_1842# VSS 0.45997f ; **FLOATING
C1275 a_24523_1842# VSS 0.51043f ; **FLOATING
C1276 a_24957_1842# VSS 0.97121f ; **FLOATING
C1277 a_24393_1842# VSS 0.45843f ; **FLOATING
C1278 a_23763_1842# VSS 0.50902f ; **FLOATING
C1279 a_24197_1842# VSS 0.93322f ; **FLOATING
C1280 a_23633_1842# VSS 0.45994f ; **FLOATING
C1281 a_23003_1842# VSS 0.51137f ; **FLOATING
C1282 a_23437_1842# VSS 0.96549f ; **FLOATING
C1283 a_22873_1842# VSS 0.46292f ; **FLOATING
C1284 a_22243_1842# VSS 0.50906f ; **FLOATING
C1285 a_22677_1842# VSS 0.87619f ; **FLOATING
C1286 a_22113_1842# VSS 0.45997f ; **FLOATING
C1287 a_21483_1842# VSS 0.51043f ; **FLOATING
C1288 a_21917_1842# VSS 0.97121f ; **FLOATING
C1289 a_21353_1842# VSS 0.45843f ; **FLOATING
C1290 a_20723_1842# VSS 0.50902f ; **FLOATING
C1291 a_21157_1842# VSS 0.93322f ; **FLOATING
C1292 a_20593_1842# VSS 0.45994f ; **FLOATING
C1293 a_19963_1842# VSS 0.51137f ; **FLOATING
C1294 a_20397_1842# VSS 0.96549f ; **FLOATING
C1295 a_19833_1842# VSS 0.46292f ; **FLOATING
C1296 a_19203_1842# VSS 0.50906f ; **FLOATING
C1297 a_19637_1842# VSS 0.87619f ; **FLOATING
C1298 a_19073_1842# VSS 0.45997f ; **FLOATING
C1299 a_18443_1842# VSS 0.51043f ; **FLOATING
C1300 a_18877_1842# VSS 0.97121f ; **FLOATING
C1301 a_18313_1842# VSS 0.45843f ; **FLOATING
C1302 a_17683_1842# VSS 0.50902f ; **FLOATING
C1303 a_18117_1842# VSS 0.93322f ; **FLOATING
C1304 a_17553_1842# VSS 0.45994f ; **FLOATING
C1305 a_16923_1842# VSS 0.51133f ; **FLOATING
C1306 a_17357_1842# VSS 0.96549f ; **FLOATING
C1307 a_16793_1842# VSS 0.46262f ; **FLOATING
C1308 a_16163_1842# VSS 0.50902f ; **FLOATING
C1309 a_16597_1842# VSS 0.87137f ; **FLOATING
C1310 a_16033_1842# VSS 0.45859f ; **FLOATING
C1311 a_15403_1842# VSS 0.51041f ; **FLOATING
C1312 a_15837_1842# VSS 0.9618f ; **FLOATING
C1313 a_15273_1842# VSS 0.45843f ; **FLOATING
C1314 a_14643_1842# VSS 0.50902f ; **FLOATING
C1315 a_15077_1842# VSS 0.93209f ; **FLOATING
C1316 a_14513_1842# VSS 0.45994f ; **FLOATING
C1317 a_13883_1842# VSS 0.51137f ; **FLOATING
C1318 a_14317_1842# VSS 0.96549f ; **FLOATING
C1319 a_13753_1842# VSS 0.46292f ; **FLOATING
C1320 a_13123_1842# VSS 0.50904f ; **FLOATING
C1321 a_13557_1842# VSS 0.87619f ; **FLOATING
C1322 a_12993_1842# VSS 0.45997f ; **FLOATING
C1323 a_12363_1842# VSS 0.51043f ; **FLOATING
C1324 a_12797_1842# VSS 0.96954f ; **FLOATING
C1325 a_12233_1842# VSS 0.45843f ; **FLOATING
C1326 a_11603_1842# VSS 0.50902f ; **FLOATING
C1327 a_12037_1842# VSS 0.93322f ; **FLOATING
C1328 a_11473_1842# VSS 0.45994f ; **FLOATING
C1329 a_10843_1842# VSS 0.51137f ; **FLOATING
C1330 a_11277_1842# VSS 0.96549f ; **FLOATING
C1331 a_10713_1842# VSS 0.46292f ; **FLOATING
C1332 a_10083_1842# VSS 0.50904f ; **FLOATING
C1333 a_10517_1842# VSS 0.87619f ; **FLOATING
C1334 a_9953_1842# VSS 0.45997f ; **FLOATING
C1335 a_9323_1842# VSS 0.51043f ; **FLOATING
C1336 a_9757_1842# VSS 0.96954f ; **FLOATING
C1337 a_9193_1842# VSS 0.45843f ; **FLOATING
C1338 a_8563_1842# VSS 0.50902f ; **FLOATING
C1339 a_8997_1842# VSS 0.93322f ; **FLOATING
C1340 a_8433_1842# VSS 0.45994f ; **FLOATING
C1341 a_7803_1842# VSS 0.51137f ; **FLOATING
C1342 a_8237_1842# VSS 0.96549f ; **FLOATING
C1343 a_7673_1842# VSS 0.46292f ; **FLOATING
C1344 a_7043_1842# VSS 0.50904f ; **FLOATING
C1345 a_7477_1842# VSS 0.87619f ; **FLOATING
C1346 a_6913_1842# VSS 0.45997f ; **FLOATING
C1347 a_6283_1842# VSS 0.51043f ; **FLOATING
C1348 a_6717_1842# VSS 0.96895f ; **FLOATING
C1349 a_6153_1842# VSS 0.45843f ; **FLOATING
C1350 a_5523_1842# VSS 0.50902f ; **FLOATING
C1351 a_5957_1842# VSS 0.93322f ; **FLOATING
C1352 a_5393_1842# VSS 0.45994f ; **FLOATING
C1353 a_4763_1842# VSS 0.51133f ; **FLOATING
C1354 a_5197_1842# VSS 0.96549f ; **FLOATING
C1355 a_4633_1842# VSS 0.4629f ; **FLOATING
C1356 a_4003_1842# VSS 0.58899f ; **FLOATING
C1357 a_4437_1842# VSS 0.87666f ; **FLOATING
C1358 a_2019_1047.t2 VSS 0.93017f ; **FLOATING
C1359 a_2019_1047.t3 VSS 0.70616f ; **FLOATING
C1360 a_2019_1047.n0 VSS 5.0083f ; **FLOATING
C1361 a_2019_1047.t4 VSS 0.70616f ; **FLOATING
C1362 a_2019_1047.n1 VSS 3.38825f ; **FLOATING
C1363 a_2019_1047.t5 VSS 0.70616f ; **FLOATING
C1364 a_2019_1047.n2 VSS 3.38825f ; **FLOATING
C1365 a_2019_1047.t6 VSS 0.70616f ; **FLOATING
C1366 a_2019_1047.n3 VSS 3.38825f ; **FLOATING
C1367 a_2019_1047.t7 VSS 0.70616f ; **FLOATING
C1368 a_2019_1047.n4 VSS 3.38825f ; **FLOATING
C1369 a_2019_1047.t8 VSS 0.70616f ; **FLOATING
C1370 a_2019_1047.n5 VSS 3.38825f ; **FLOATING
C1371 a_2019_1047.t9 VSS 5.45426f ; **FLOATING
C1372 a_2019_1047.t1 VSS 1.07246f ; **FLOATING
C1373 a_2019_1047.t0 VSS 0.30482f ; **FLOATING
C1374 a_2595_1047.t2 VSS 1.36702f ; **FLOATING
C1375 a_2595_1047.t3 VSS 1.02094f ; **FLOATING
C1376 a_2595_1047.n0 VSS 7.7612f ; **FLOATING
C1377 a_2595_1047.t4 VSS 1.02094f ; **FLOATING
C1378 a_2595_1047.n1 VSS 5.27337f ; **FLOATING
C1379 a_2595_1047.t5 VSS 1.02094f ; **FLOATING
C1380 a_2595_1047.n2 VSS 5.27337f ; **FLOATING
C1381 a_2595_1047.t6 VSS 1.02094f ; **FLOATING
C1382 a_2595_1047.n3 VSS 5.27337f ; **FLOATING
C1383 a_2595_1047.t7 VSS 1.02094f ; **FLOATING
C1384 a_2595_1047.n4 VSS 5.27337f ; **FLOATING
C1385 a_2595_1047.t8 VSS 1.02094f ; **FLOATING
C1386 a_2595_1047.n5 VSS 5.27337f ; **FLOATING
C1387 a_2595_1047.t9 VSS 1.02094f ; **FLOATING
C1388 a_2595_1047.n6 VSS 7.58543f ; **FLOATING
C1389 a_2595_1047.t1 VSS 1.75118f ; **FLOATING
C1390 a_2595_1047.t0 VSS 0.48227f ; **FLOATING
C1391 a_3171_1047.t2 VSS 1.38441f ; **FLOATING
C1392 a_3171_1047.t3 VSS 1.03733f ; **FLOATING
C1393 a_3171_1047.n0 VSS 7.77853f ; **FLOATING
C1394 a_3171_1047.t4 VSS 1.03733f ; **FLOATING
C1395 a_3171_1047.n1 VSS 5.28081f ; **FLOATING
C1396 a_3171_1047.t5 VSS 1.03733f ; **FLOATING
C1397 a_3171_1047.n2 VSS 5.28081f ; **FLOATING
C1398 a_3171_1047.t6 VSS 1.03733f ; **FLOATING
C1399 a_3171_1047.n3 VSS 5.28081f ; **FLOATING
C1400 a_3171_1047.t7 VSS 1.03733f ; **FLOATING
C1401 a_3171_1047.n4 VSS 5.28081f ; **FLOATING
C1402 a_3171_1047.t8 VSS 1.03733f ; **FLOATING
C1403 a_3171_1047.n5 VSS 5.28081f ; **FLOATING
C1404 a_3171_1047.t9 VSS 1.03733f ; **FLOATING
C1405 a_3171_1047.n6 VSS 7.68344f ; **FLOATING
C1406 a_3171_1047.t1 VSS 1.77026f ; **FLOATING
C1407 a_3171_1047.t0 VSS 0.48084f ; **FLOATING
C1408 a_3747_1047.t2 VSS 0.96884f ; **FLOATING
C1409 a_3747_1047.t3 VSS 0.73759f ; **FLOATING
C1410 a_3747_1047.n0 VSS 5.16742f ; **FLOATING
C1411 a_3747_1047.t4 VSS 0.73759f ; **FLOATING
C1412 a_3747_1047.n1 VSS 3.49311f ; **FLOATING
C1413 a_3747_1047.t5 VSS 0.73759f ; **FLOATING
C1414 a_3747_1047.n2 VSS 3.49311f ; **FLOATING
C1415 a_3747_1047.t6 VSS 0.73759f ; **FLOATING
C1416 a_3747_1047.n3 VSS 3.49311f ; **FLOATING
C1417 a_3747_1047.t7 VSS 0.73759f ; **FLOATING
C1418 a_3747_1047.n4 VSS 3.49311f ; **FLOATING
C1419 a_3747_1047.t8 VSS 0.73759f ; **FLOATING
C1420 a_3747_1047.n5 VSS 3.49311f ; **FLOATING
C1421 a_3747_1047.t9 VSS 0.73759f ; **FLOATING
C1422 a_3747_1047.n6 VSS 5.18686f ; **FLOATING
C1423 a_3747_1047.t1 VSS 1.18534f ; **FLOATING
C1424 a_3747_1047.t0 VSS 0.31337f ; **FLOATING
C1425 a_2595_311.t1 VSS 3.27037f ; **FLOATING
C1426 a_2595_311.t2 VSS 5.04145f ; **FLOATING
C1427 a_2595_311.t3 VSS 1.20632f ; **FLOATING
C1428 a_2595_311.n0 VSS 26.8668f ; **FLOATING
C1429 a_2595_311.t0 VSS 0.49572f ; **FLOATING
C1430 a_3171_311.t2 VSS 5.05009f ; **FLOATING
C1431 a_3171_311.t3 VSS 1.21149f ; **FLOATING
C1432 a_3171_311.n0 VSS 29.8499f ; **FLOATING
C1433 a_3171_311.t1 VSS 4.61154f ; **FLOATING
C1434 a_3171_311.t0 VSS 0.4973f ; **FLOATING
C1435 a_3747_311.t2 VSS 3.08793f ; **FLOATING
C1436 a_3747_311.t3 VSS 0.74323f ; **FLOATING
C1437 a_3747_311.n0 VSS 19.8622f ; **FLOATING
C1438 a_3747_311.t1 VSS 3.68404f ; **FLOATING
C1439 a_3747_311.t0 VSS 0.30496f ; **FLOATING
C1440 DELAY_VBIASP.n0 VSS 0.14465f ; **FLOATING
C1441 DELAY_VBIASP.t31 VSS 0.3704f ; **FLOATING
C1442 DELAY_VBIASP.t30 VSS 0.36212f ; **FLOATING
C1443 DELAY_VBIASP.n1 VSS 0.64892f ; **FLOATING
C1444 DELAY_VBIASP.t29 VSS 0.36212f ; **FLOATING
C1445 DELAY_VBIASP.n2 VSS 0.44906f ; **FLOATING
C1446 DELAY_VBIASP.t28 VSS 0.36212f ; **FLOATING
C1447 DELAY_VBIASP.n3 VSS 0.44906f ; **FLOATING
C1448 DELAY_VBIASP.t27 VSS 0.36212f ; **FLOATING
C1449 DELAY_VBIASP.n4 VSS 0.44906f ; **FLOATING
C1450 DELAY_VBIASP.t26 VSS 0.36212f ; **FLOATING
C1451 DELAY_VBIASP.n5 VSS 0.44906f ; **FLOATING
C1452 DELAY_VBIASP.t25 VSS 0.36212f ; **FLOATING
C1453 DELAY_VBIASP.n6 VSS 0.44906f ; **FLOATING
C1454 DELAY_VBIASP.t24 VSS 0.36212f ; **FLOATING
C1455 DELAY_VBIASP.n7 VSS 0.44906f ; **FLOATING
C1456 DELAY_VBIASP.t23 VSS 0.36212f ; **FLOATING
C1457 DELAY_VBIASP.n8 VSS 0.44906f ; **FLOATING
C1458 DELAY_VBIASP.t22 VSS 0.36212f ; **FLOATING
C1459 DELAY_VBIASP.n9 VSS 0.44906f ; **FLOATING
C1460 DELAY_VBIASP.t21 VSS 0.36212f ; **FLOATING
C1461 DELAY_VBIASP.n10 VSS 0.44906f ; **FLOATING
C1462 DELAY_VBIASP.t20 VSS 0.36212f ; **FLOATING
C1463 DELAY_VBIASP.n11 VSS 0.44906f ; **FLOATING
C1464 DELAY_VBIASP.t19 VSS 0.36212f ; **FLOATING
C1465 DELAY_VBIASP.n12 VSS 0.44906f ; **FLOATING
C1466 DELAY_VBIASP.t18 VSS 0.36212f ; **FLOATING
C1467 DELAY_VBIASP.n13 VSS 0.44906f ; **FLOATING
C1468 DELAY_VBIASP.t17 VSS 0.36212f ; **FLOATING
C1469 DELAY_VBIASP.n14 VSS 0.44906f ; **FLOATING
C1470 DELAY_VBIASP.t16 VSS 0.36212f ; **FLOATING
C1471 DELAY_VBIASP.n15 VSS 0.44906f ; **FLOATING
C1472 DELAY_VBIASP.t15 VSS 0.36212f ; **FLOATING
C1473 DELAY_VBIASP.n16 VSS 0.44906f ; **FLOATING
C1474 DELAY_VBIASP.t14 VSS 0.36212f ; **FLOATING
C1475 DELAY_VBIASP.n17 VSS 0.44906f ; **FLOATING
C1476 DELAY_VBIASP.t13 VSS 0.36212f ; **FLOATING
C1477 DELAY_VBIASP.n18 VSS 0.44906f ; **FLOATING
C1478 DELAY_VBIASP.t12 VSS 0.36212f ; **FLOATING
C1479 DELAY_VBIASP.n19 VSS 0.44906f ; **FLOATING
C1480 DELAY_VBIASP.t11 VSS 0.36212f ; **FLOATING
C1481 DELAY_VBIASP.n20 VSS 0.44906f ; **FLOATING
C1482 DELAY_VBIASP.t10 VSS 0.36212f ; **FLOATING
C1483 DELAY_VBIASP.n21 VSS 0.44906f ; **FLOATING
C1484 DELAY_VBIASP.t9 VSS 0.36212f ; **FLOATING
C1485 DELAY_VBIASP.n22 VSS 0.44906f ; **FLOATING
C1486 DELAY_VBIASP.t8 VSS 0.36212f ; **FLOATING
C1487 DELAY_VBIASP.n23 VSS 0.44906f ; **FLOATING
C1488 DELAY_VBIASP.t7 VSS 0.36212f ; **FLOATING
C1489 DELAY_VBIASP.n24 VSS 0.44906f ; **FLOATING
C1490 DELAY_VBIASP.t6 VSS 0.36212f ; **FLOATING
C1491 DELAY_VBIASP.n25 VSS 0.44906f ; **FLOATING
C1492 DELAY_VBIASP.t5 VSS 0.36212f ; **FLOATING
C1493 DELAY_VBIASP.n26 VSS 0.44906f ; **FLOATING
C1494 DELAY_VBIASP.t4 VSS 0.36212f ; **FLOATING
C1495 DELAY_VBIASP.n27 VSS 0.44906f ; **FLOATING
C1496 DELAY_VBIASP.t3 VSS 0.36212f ; **FLOATING
C1497 DELAY_VBIASP.n28 VSS 0.44906f ; **FLOATING
C1498 DELAY_VBIASP.t2 VSS 0.36212f ; **FLOATING
C1499 DELAY_VBIASP.n29 VSS 0.44906f ; **FLOATING
C1500 DELAY_VBIASP.t1 VSS 0.36212f ; **FLOATING
C1501 DELAY_VBIASP.n30 VSS 0.44906f ; **FLOATING
C1502 DELAY_VBIASP.t0 VSS 0.36212f ; **FLOATING
C1503 DELAY_VBIASN.n0 VSS 0.37703f ; **FLOATING
C1504 DELAY_VBIASN.t31 VSS 0.22492f ; **FLOATING
C1505 DELAY_VBIASN.t30 VSS 0.21832f ; **FLOATING
C1506 DELAY_VBIASN.n1 VSS 0.51667f ; **FLOATING
C1507 DELAY_VBIASN.t29 VSS 0.21832f ; **FLOATING
C1508 DELAY_VBIASN.n2 VSS 0.35838f ; **FLOATING
C1509 DELAY_VBIASN.t28 VSS 0.21832f ; **FLOATING
C1510 DELAY_VBIASN.n3 VSS 0.35838f ; **FLOATING
C1511 DELAY_VBIASN.t27 VSS 0.21832f ; **FLOATING
C1512 DELAY_VBIASN.n4 VSS 0.35838f ; **FLOATING
C1513 DELAY_VBIASN.t26 VSS 0.21832f ; **FLOATING
C1514 DELAY_VBIASN.n5 VSS 0.35838f ; **FLOATING
C1515 DELAY_VBIASN.t25 VSS 0.21832f ; **FLOATING
C1516 DELAY_VBIASN.n6 VSS 0.35838f ; **FLOATING
C1517 DELAY_VBIASN.t24 VSS 0.21832f ; **FLOATING
C1518 DELAY_VBIASN.n7 VSS 0.35838f ; **FLOATING
C1519 DELAY_VBIASN.t23 VSS 0.21832f ; **FLOATING
C1520 DELAY_VBIASN.n8 VSS 0.35838f ; **FLOATING
C1521 DELAY_VBIASN.t22 VSS 0.21832f ; **FLOATING
C1522 DELAY_VBIASN.n9 VSS 0.35838f ; **FLOATING
C1523 DELAY_VBIASN.t21 VSS 0.21832f ; **FLOATING
C1524 DELAY_VBIASN.n10 VSS 0.35838f ; **FLOATING
C1525 DELAY_VBIASN.t20 VSS 0.21832f ; **FLOATING
C1526 DELAY_VBIASN.n11 VSS 0.35838f ; **FLOATING
C1527 DELAY_VBIASN.t19 VSS 0.21832f ; **FLOATING
C1528 DELAY_VBIASN.n12 VSS 0.35838f ; **FLOATING
C1529 DELAY_VBIASN.t18 VSS 0.21832f ; **FLOATING
C1530 DELAY_VBIASN.n13 VSS 0.35838f ; **FLOATING
C1531 DELAY_VBIASN.t17 VSS 0.21832f ; **FLOATING
C1532 DELAY_VBIASN.n14 VSS 0.35838f ; **FLOATING
C1533 DELAY_VBIASN.t16 VSS 0.21832f ; **FLOATING
C1534 DELAY_VBIASN.n15 VSS 0.35838f ; **FLOATING
C1535 DELAY_VBIASN.t15 VSS 0.21832f ; **FLOATING
C1536 DELAY_VBIASN.n16 VSS 0.35838f ; **FLOATING
C1537 DELAY_VBIASN.t14 VSS 0.21832f ; **FLOATING
C1538 DELAY_VBIASN.n17 VSS 0.35838f ; **FLOATING
C1539 DELAY_VBIASN.t13 VSS 0.21832f ; **FLOATING
C1540 DELAY_VBIASN.n18 VSS 0.35838f ; **FLOATING
C1541 DELAY_VBIASN.t12 VSS 0.21832f ; **FLOATING
C1542 DELAY_VBIASN.n19 VSS 0.35838f ; **FLOATING
C1543 DELAY_VBIASN.t11 VSS 0.21832f ; **FLOATING
C1544 DELAY_VBIASN.n20 VSS 0.35838f ; **FLOATING
C1545 DELAY_VBIASN.t10 VSS 0.21832f ; **FLOATING
C1546 DELAY_VBIASN.n21 VSS 0.35838f ; **FLOATING
C1547 DELAY_VBIASN.t9 VSS 0.21832f ; **FLOATING
C1548 DELAY_VBIASN.n22 VSS 0.35838f ; **FLOATING
C1549 DELAY_VBIASN.t8 VSS 0.21832f ; **FLOATING
C1550 DELAY_VBIASN.n23 VSS 0.35838f ; **FLOATING
C1551 DELAY_VBIASN.t7 VSS 0.21832f ; **FLOATING
C1552 DELAY_VBIASN.n24 VSS 0.35838f ; **FLOATING
C1553 DELAY_VBIASN.t6 VSS 0.21832f ; **FLOATING
C1554 DELAY_VBIASN.n25 VSS 0.35838f ; **FLOATING
C1555 DELAY_VBIASN.t5 VSS 0.21832f ; **FLOATING
C1556 DELAY_VBIASN.n26 VSS 0.35838f ; **FLOATING
C1557 DELAY_VBIASN.t4 VSS 0.21832f ; **FLOATING
C1558 DELAY_VBIASN.n27 VSS 0.35838f ; **FLOATING
C1559 DELAY_VBIASN.t3 VSS 0.21832f ; **FLOATING
C1560 DELAY_VBIASN.n28 VSS 0.35838f ; **FLOATING
C1561 DELAY_VBIASN.t2 VSS 0.21832f ; **FLOATING
C1562 DELAY_VBIASN.n29 VSS 0.35838f ; **FLOATING
C1563 DELAY_VBIASN.t1 VSS 0.21832f ; **FLOATING
C1564 DELAY_VBIASN.n30 VSS 0.35838f ; **FLOATING
C1565 DELAY_VBIASN.t0 VSS 0.21832f ; **FLOATING
.ends
