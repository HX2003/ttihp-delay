* NGSPICE file created from hx_delay_line_with_mux.ext - technology: ihp-sg13g2

.subckt hx_delay_line_with_mux VSS VDD DELAY_OUT_LAST DELAY_IN MUX_SEL0 MUX_SEL1 MUX_OUT
+ MUX_SEL4 MUX_SEL2 MUX_SEL3 DELAY_VBIASN DELAY_VBIASP
X0 VDD a_4003_1842# a_4437_1842# VDD sg13_lv_pmos ad=0.2128p pd=1.5u as=0.3808p ps=2.92u w=1.12u l=0.13u
X1 VSS.t243 a_15077_1842# a_15545_1044# VSS.t410 sg13_lv_nmos ad=0.1665p pd=1.19u as=0.2516p ps=2.16u w=0.74u l=0.13u
X2 a_27915_1044# a_27705_1044# VDD VDD sg13_lv_pmos ad=0.2128p pd=1.5u as=0.252p ps=1.57u w=1.12u l=0.13u
X3 VSS.t293 VDD VSS.t291 VSS.t292 sg13_lv_nmos ad=79.8f pd=0.8u as=0 ps=0 w=0.42u l=1u
X4 a_10951_2470# a_10713_1842# a_10843_1842# VDD sg13_lv_pmos ad=0.2128p pd=1.5u as=0.3808p ps=2.92u w=1.12u l=0.2u
X5 VSS.t261 a_3171_1047.t7 a_11924_1008# VSS.t260 sg13_lv_nmos ad=0.2516p pd=2.16u as=0.2516p ps=2.16u w=0.74u l=0.13u
X6 VDD VSS.t572 VDD VDD sg13_lv_pmos ad=0.34p pd=2.68u as=0.30484n ps=1.54979m w=1u l=1u
X7 VSS.t22 a_1256_1044# a_2967_1395# VSS.t21 sg13_lv_nmos ad=0.1331p pd=1.12u as=0.1216p ps=1.02u w=0.64u l=0.13u
X8 VSS.t296 VDD VSS.t295 VSS.t294 sg13_lv_nmos ad=0.1428p pd=1.52u as=0 ps=0 w=0.42u l=1u
X9 a_25153_1842# a_24957_1842# VSS.t128 VSS.t127 sg13_lv_nmos ad=0.2516p pd=2.16u as=0.1406p ps=1.12u w=0.74u l=0.13u
X10 VDD VSS.t586 VDD VDD sg13_lv_pmos ad=0.34p pd=2.68u as=0 ps=0 w=1u l=1u
X11 a_25630_1044# a_2019_1047.t2 a_25528_1044# VSS.t236 sg13_lv_nmos ad=0.2516p pd=2.16u as=0.1406p ps=1.12u w=0.74u l=0.13u
X12 VDD DELAY_VBIASP.t11 a_19311_2470# VDD sg13_lv_pmos ad=0.3808p pd=2.92u as=0.2128p ps=1.5u w=1.12u l=0.6u
X13 a_16108_289# a_2019_311# a_16510_1044# VSS.t176 sg13_lv_nmos ad=0.2516p pd=2.16u as=0.2516p ps=2.16u w=0.74u l=0.13u
X14 VDD DELAY_VBIASP.t24 a_9431_2470# VDD sg13_lv_pmos ad=0.3808p pd=2.92u as=0.2128p ps=1.5u w=1.12u l=0.6u
X15 VSS.t361 VDD VSS.t360 VSS.t359 sg13_lv_nmos ad=0.1428p pd=1.52u as=0 ps=0 w=0.42u l=1u
X16 VDD DELAY_VBIASP.t6 a_23111_2470# VDD sg13_lv_pmos ad=0.3808p pd=2.92u as=0.2128p ps=1.5u w=1.12u l=0.6u
X17 a_7390_1044# a_8231_1008# a_8155_1044# VDD sg13_lv_pmos ad=0.3808p pd=2.92u as=0.2128p ps=1.5u w=1.12u l=0.13u
X18 VSS.t221 a_2595_311.t3 a_8745_519# VSS.t220 sg13_lv_nmos ad=0.2516p pd=2.16u as=0.2516p ps=2.16u w=0.74u l=0.13u
X19 a_17791_1842# a_17553_1842# a_17683_1842# VSS.t107 sg13_lv_nmos ad=0.1406p pd=1.12u as=0.2516p ps=2.16u w=0.74u l=0.2u
X20 VDD a_12037_1842# a_12505_1044# VDD sg13_lv_pmos ad=0.252p pd=1.57u as=0.3808p ps=2.92u w=1.12u l=0.13u
X21 a_16510_1044# a_2019_1047.t5 a_16408_1044# VSS.t265 sg13_lv_nmos ad=0.2516p pd=2.16u as=0.1406p ps=1.12u w=0.74u l=0.13u
X22 a_21591_1842# a_21353_1842# a_21483_1842# VSS.t509 sg13_lv_nmos ad=0.1406p pd=1.12u as=0.2516p ps=2.16u w=0.74u l=0.2u
X23 a_6153_1842# a_5957_1842# VSS.t436 VSS.t435 sg13_lv_nmos ad=0.2516p pd=2.16u as=0.1406p ps=1.12u w=0.74u l=0.13u
X24 VSS.t279 a_16163_1842# a_16597_1842# VSS.t405 sg13_lv_nmos ad=0.1406p pd=1.12u as=0.2516p ps=2.16u w=0.74u l=0.13u
X25 VSS.t78 a_3171_1047.t2 a_27124_1008# VSS.t77 sg13_lv_nmos ad=0.2516p pd=2.16u as=0.2516p ps=2.16u w=0.74u l=0.13u
X26 VDD a_11603_1842# a_12037_1842# VDD sg13_lv_pmos ad=0.2128p pd=1.5u as=0.3808p ps=2.92u w=1.12u l=0.13u
X27 VDD a_3171_311.t3 a_11785_519# VDD sg13_lv_pmos ad=0.3808p pd=2.92u as=0.3808p ps=2.92u w=1.12u l=0.13u
X28 a_24393_1842# a_24197_1842# VDD VDD sg13_lv_pmos ad=0.3808p pd=2.92u as=0.2128p ps=1.5u w=1.12u l=0.13u
X29 a_5731_289# a_2595_311.t3 a_7390_1044# VSS.t219 sg13_lv_nmos ad=0.2516p pd=2.16u as=0.2516p ps=2.16u w=0.74u l=0.13u
X30 a_10430_1044# a_2595_1047.t7 a_11195_1044# VSS.t13 sg13_lv_nmos ad=0.2516p pd=2.16u as=0.1406p ps=1.12u w=0.74u l=0.13u
X31 a_23355_1044# a_23145_1044# VSS.t416 VSS.t531 sg13_lv_nmos ad=0.1406p pd=1.12u as=0.1665p ps=1.19u w=0.74u l=0.13u
X32 VDD DELAY_VBIASP.t17 a_14751_2470# VDD sg13_lv_pmos ad=0.3808p pd=2.92u as=0.2128p ps=1.5u w=1.12u l=0.6u
X33 VSS.t469 DELAY_VBIASN.t23 a_10191_1842# VSS.t468 sg13_lv_nmos ad=0.2516p pd=2.16u as=0.1406p ps=1.12u w=0.74u l=0.6u
X34 VSS.t102 a_3747_1047.t4 a_21911_1008# VSS.t101 sg13_lv_nmos ad=0.2516p pd=2.16u as=0.2516p ps=2.16u w=0.74u l=0.13u
X35 VSS.t274 a_19963_1842# a_20397_1842# VSS.t514 sg13_lv_nmos ad=0.1406p pd=1.12u as=0.2516p ps=2.16u w=0.74u l=0.13u
X36 VDD DELAY_VBIASP.t31 a_4111_2470# VDD sg13_lv_pmos ad=0.3808p pd=2.92u as=0.2128p ps=1.5u w=1.12u l=0.6u
X37 a_10328_1044# a_9757_1842# VDD VDD sg13_lv_pmos ad=0.2128p pd=1.5u as=0.3808p ps=2.92u w=1.12u l=0.13u
X38 a_20968_1044# a_20397_1842# VSS.t272 VSS.t271 sg13_lv_nmos ad=0.1406p pd=1.12u as=0.2516p ps=2.16u w=0.74u l=0.13u
X39 a_22590_1044# a_22564_1008# a_22488_1044# VDD sg13_lv_pmos ad=0.3808p pd=2.92u as=0.2128p ps=1.5u w=1.12u l=0.13u
X40 VDD VSS.t589 VDD VDD sg13_lv_pmos ad=0.19p pd=1.38u as=0 ps=0 w=1u l=1u
X41 a_8808_1044# a_8237_1842# VDD VDD sg13_lv_pmos ad=0.2128p pd=1.5u as=0.3808p ps=2.92u w=1.12u l=0.13u
X42 a_4157_1313# DELAY_IN VDD VDD sg13_lv_pmos ad=0.3808p pd=2.92u as=0.3808p ps=2.92u w=1.12u l=0.13u
X43 a_17031_2470# a_16793_1842# a_16923_1842# VDD sg13_lv_pmos ad=0.2128p pd=1.5u as=0.3808p ps=2.92u w=1.12u l=0.2u
X44 a_11473_1842# a_11277_1842# VSS.t9 VSS.t8 sg13_lv_nmos ad=0.2516p pd=2.16u as=0.1406p ps=1.12u w=0.74u l=0.13u
X45 VSS.t353 VDD VSS.t351 VSS.t352 sg13_lv_nmos ad=79.8f pd=0.8u as=0 ps=0 w=0.42u l=1u
X46 a_19448_1044# a_18877_1842# VSS.t165 VSS.t164 sg13_lv_nmos ad=0.1406p pd=1.12u as=0.2516p ps=2.16u w=0.74u l=0.13u
X47 a_10430_1044# a_3171_1047.t7 a_11848_1044# VSS.t259 sg13_lv_nmos ad=0.2516p pd=2.16u as=0.1406p ps=1.12u w=0.74u l=0.13u
X48 a_20831_2470# a_20593_1842# a_20723_1842# VDD sg13_lv_pmos ad=0.2128p pd=1.5u as=0.3808p ps=2.92u w=1.12u l=0.2u
X49 VSS.t318 VDD VSS.t316 VSS.t317 sg13_lv_nmos ad=79.8f pd=0.8u as=0 ps=0 w=0.42u l=1u
X50 VDD a_27237_1842# a_27705_1044# VDD sg13_lv_pmos ad=0.252p pd=1.57u as=0.3808p ps=2.92u w=1.12u l=0.13u
X51 a_5393_1842# a_5197_1842# VDD VDD sg13_lv_pmos ad=0.3808p pd=2.92u as=0.2128p ps=1.5u w=1.12u l=0.13u
X52 VDD DELAY_VBIASP.t14 a_17031_2470# VDD sg13_lv_pmos ad=0.3808p pd=2.92u as=0.2128p ps=1.5u w=1.12u l=0.6u
X53 VDD a_26803_1842# a_27237_1842# VDD sg13_lv_pmos ad=0.2128p pd=1.5u as=0.3808p ps=2.92u w=1.12u l=0.13u
X54 VDD MUX_SEL1 a_3449_1395# VDD sg13_lv_pmos ad=0.1918p pd=1.5u as=0.1596p ps=1.22u w=0.84u l=0.13u
X55 a_25630_1044# a_2595_1047.t2 a_26395_1044# VSS.t136 sg13_lv_nmos ad=0.2516p pd=2.16u as=0.1406p ps=1.12u w=0.74u l=0.13u
X56 VSS.t449 DELAY_VBIASN.t3 a_25391_1842# VSS.t448 sg13_lv_nmos ad=0.2516p pd=2.16u as=0.1406p ps=1.12u w=0.74u l=0.6u
X57 a_6635_1044# a_6425_1044# VDD VDD sg13_lv_pmos ad=0.2128p pd=1.5u as=0.252p ps=1.57u w=1.12u l=0.13u
X58 a_20315_1044# a_20105_1044# VDD VDD sg13_lv_pmos ad=0.2128p pd=1.5u as=0.252p ps=1.57u w=1.12u l=0.13u
X59 VDD a_2595_1047.t9 a_5191_1008# VDD sg13_lv_pmos ad=0.3808p pd=2.92u as=0.3808p ps=2.92u w=1.12u l=0.13u
X60 a_19311_2470# a_19073_1842# a_19203_1842# VDD sg13_lv_pmos ad=0.2128p pd=1.5u as=0.3808p ps=2.92u w=1.12u l=0.2u
X61 VSS.t19 a_1721_1395# a_2019_1047.t1 VSS.t18 sg13_lv_nmos ad=0.2812p pd=2.24u as=0.1406p ps=1.12u w=0.74u l=0.13u
X62 a_25528_1044# a_24957_1842# VDD VDD sg13_lv_pmos ad=0.2128p pd=1.5u as=0.3808p ps=2.92u w=1.12u l=0.13u
X63 VSS.t149 a_5957_1842# a_6425_1044# VSS.t434 sg13_lv_nmos ad=0.1665p pd=1.19u as=0.2516p ps=2.16u w=0.74u l=0.13u
X64 VSS.t547 a_2019_1047.t6 a_13444_1008# VSS.t546 sg13_lv_nmos ad=0.2516p pd=2.16u as=0.2516p ps=2.16u w=0.74u l=0.13u
X65 a_23111_2470# a_22873_1842# a_23003_1842# VDD sg13_lv_pmos ad=0.2128p pd=1.5u as=0.3808p ps=2.92u w=1.12u l=0.2u
X66 VSS.t291 VDD VSS.t290 VSS.t289 sg13_lv_nmos ad=0.1428p pd=1.52u as=0 ps=0 w=0.42u l=1u
X67 VSS.t32 a_15964_289# a_16851_309# VSS.t106 sg13_lv_nmos ad=0.1371p pd=1.12u as=0.2176p ps=1.96u w=0.64u l=0.13u
X68 a_10713_1842# a_10517_1842# VDD VDD sg13_lv_pmos ad=0.3808p pd=2.92u as=0.2128p ps=1.5u w=1.12u l=0.13u
X69 VDD a_17683_1842# a_18117_1842# VDD sg13_lv_pmos ad=0.2128p pd=1.5u as=0.3808p ps=2.92u w=1.12u l=0.13u
X70 a_16108_289# a_17865_519# a_16510_1044# VDD sg13_lv_pmos ad=0.3808p pd=2.92u as=0.3808p ps=2.92u w=1.12u l=0.13u
X71 a_26673_1842# a_26477_1842# VSS.t45 VSS.t73 sg13_lv_nmos ad=0.2516p pd=2.16u as=0.1406p ps=1.12u w=0.74u l=0.13u
X72 VDD a_7803_1842# a_8237_1842# VDD sg13_lv_pmos ad=0.2128p pd=1.5u as=0.3808p ps=2.92u w=1.12u l=0.13u
X73 a_4248_1044# a_4157_1313# VSS.t226 VSS.t225 sg13_lv_nmos ad=0.1406p pd=1.12u as=0.2516p ps=2.16u w=0.74u l=0.13u
X74 a_16108_289# a_3171_311.t2 a_22590_1044# VSS.t145 sg13_lv_nmos ad=0.2516p pd=2.16u as=0.2516p ps=2.16u w=0.74u l=0.13u
X75 VSS.t461 DELAY_VBIASN.t28 a_6391_1842# VSS.t460 sg13_lv_nmos ad=0.2516p pd=2.16u as=0.1406p ps=1.12u w=0.74u l=0.6u
X76 a_16408_1044# a_15837_1842# VDD VDD sg13_lv_pmos ad=0.2128p pd=1.5u as=0.3808p ps=2.92u w=1.12u l=0.13u
X77 a_19550_1044# a_3747_1047.t4 a_21835_1044# VSS.t100 sg13_lv_nmos ad=0.2516p pd=2.16u as=0.1406p ps=1.12u w=0.74u l=0.13u
X78 VSS.t475 DELAY_VBIASN.t9 a_20831_1842# VSS.t474 sg13_lv_nmos ad=0.2516p pd=2.16u as=0.1406p ps=1.12u w=0.74u l=0.6u
X79 a_3171_311.t0 a_2873_331# VDD VDD sg13_lv_pmos ad=0.2128p pd=1.5u as=0.1918p ps=1.5u w=1.12u l=0.13u
X80 a_3747_311.t0 a_3449_331# VDD VDD sg13_lv_pmos ad=0.2128p pd=1.5u as=0.1918p ps=1.5u w=1.12u l=0.13u
X81 a_7390_1044# a_9751_1008# a_9675_1044# VDD sg13_lv_pmos ad=0.3808p pd=2.92u as=0.2128p ps=1.5u w=1.12u l=0.13u
X82 a_10191_1842# a_9953_1842# a_10083_1842# VSS.t409 sg13_lv_nmos ad=0.1406p pd=1.12u as=0.2516p ps=2.16u w=0.74u l=0.2u
X83 VSS.t416 a_22677_1842# a_23145_1044# VSS.t415 sg13_lv_nmos ad=0.1665p pd=1.19u as=0.2516p ps=2.16u w=0.74u l=0.13u
X84 a_14751_2470# a_14513_1842# a_14643_1842# VDD sg13_lv_pmos ad=0.2128p pd=1.5u as=0.3808p ps=2.92u w=1.12u l=0.2u
X85 a_5731_289# a_8745_519# a_7390_1044# VDD sg13_lv_pmos ad=0.3808p pd=2.92u as=0.3808p ps=2.92u w=1.12u l=0.13u
X86 VDD VDD VDD VDD sg13_lv_pmos ad=0.2128p pd=1.5u as=0 ps=0 w=1.12u l=0.13u
X87 a_4111_2470# DELAY_IN a_4003_1842# VDD sg13_lv_pmos ad=0.2128p pd=1.5u as=0.3808p ps=2.92u w=1.12u l=0.2u
X88 a_7673_1842# a_7477_1842# VSS.t403 VSS.t522 sg13_lv_nmos ad=0.2516p pd=2.16u as=0.1406p ps=1.12u w=0.74u l=0.13u
X89 VDD a_3171_1047.t5 a_18004_1008# VDD sg13_lv_pmos ad=0.3808p pd=2.92u as=0.3808p ps=2.92u w=1.12u l=0.13u
X90 VDD a_13123_1842# a_13557_1842# VDD sg13_lv_pmos ad=0.2128p pd=1.5u as=0.3808p ps=2.92u w=1.12u l=0.13u
X91 VDD a_3747_311.t2 a_26985_519# VDD sg13_lv_pmos ad=0.3808p pd=2.92u as=0.3808p ps=2.92u w=1.12u l=0.13u
X92 a_25913_1842# a_25717_1842# VDD VDD sg13_lv_pmos ad=0.3808p pd=2.92u as=0.2128p ps=1.5u w=1.12u l=0.13u
X93 a_10430_1044# a_3747_1047.t7 a_12715_1044# VSS.t50 sg13_lv_nmos ad=0.2516p pd=2.16u as=0.1406p ps=1.12u w=0.74u l=0.13u
X94 a_14235_1044# a_14025_1044# VDD VDD sg13_lv_pmos ad=0.2128p pd=1.5u as=0.252p ps=1.57u w=1.12u l=0.13u
X95 a_24875_1044# a_24665_1044# VSS.t182 VSS.t232 sg13_lv_nmos ad=0.1406p pd=1.12u as=0.1665p ps=1.19u w=0.74u l=0.13u
X96 VSS.t473 DELAY_VBIASN.t21 a_11711_1842# VSS.t472 sg13_lv_nmos ad=0.2516p pd=2.16u as=0.1406p ps=1.12u w=0.74u l=0.6u
X97 VDD a_3747_1047.t7 a_12791_1008# VDD sg13_lv_pmos ad=0.3808p pd=2.92u as=0.3808p ps=2.92u w=1.12u l=0.13u
X98 VSS.t113 a_2595_1047.t3 a_23431_1008# VSS.t112 sg13_lv_nmos ad=0.2516p pd=2.16u as=0.2516p ps=2.16u w=0.74u l=0.13u
X99 VSS.t408 a_21483_1842# a_21917_1842# VSS.t407 sg13_lv_nmos ad=0.1406p pd=1.12u as=0.2516p ps=2.16u w=0.74u l=0.13u
X100 VSS.t68 a_13557_1842# a_14025_1044# VSS.t67 sg13_lv_nmos ad=0.1665p pd=1.19u as=0.2516p ps=2.16u w=0.74u l=0.13u
X101 a_11848_1044# a_11277_1842# VDD VDD sg13_lv_pmos ad=0.2128p pd=1.5u as=0.3808p ps=2.92u w=1.12u l=0.13u
X102 VDD VSS.t565 VDD VDD sg13_lv_pmos ad=0.19p pd=1.38u as=0 ps=0 w=1u l=1u
X103 a_25391_1842# a_25153_1842# a_25283_1842# VSS.t201 sg13_lv_nmos ad=0.1406p pd=1.12u as=0.2516p ps=2.16u w=0.74u l=0.2u
X104 a_12993_1842# a_12797_1842# VSS.t87 VSS.t86 sg13_lv_nmos ad=0.2516p pd=2.16u as=0.1406p ps=1.12u w=0.74u l=0.13u
X105 DELAY_OUT_LAST a_27997_1842# VDD VDD sg13_lv_pmos ad=0.3808p pd=2.92u as=0.2128p ps=1.5u w=1.12u l=0.13u
X106 VDD VSS.t564 VDD VDD sg13_lv_pmos ad=0.34p pd=2.68u as=0 ps=0 w=1u l=1u
X107 VDD a_19637_1842# a_20105_1044# VDD sg13_lv_pmos ad=0.252p pd=1.57u as=0.3808p ps=2.92u w=1.12u l=0.13u
X108 VSS.t489 DELAY_VBIASN.t18 a_13991_1842# VSS.t488 sg13_lv_nmos ad=0.2516p pd=2.16u as=0.1406p ps=1.12u w=0.74u l=0.6u
X109 VSS.t351 VDD VSS.t350 VSS.t349 sg13_lv_nmos ad=0.1428p pd=1.52u as=0 ps=0 w=0.42u l=1u
X110 a_22590_1044# a_3171_1047.t3 a_24008_1044# VSS.t213 sg13_lv_nmos ad=0.2516p pd=2.16u as=0.1406p ps=1.12u w=0.74u l=0.13u
X111 a_6913_1842# a_6717_1842# VDD VDD sg13_lv_pmos ad=0.3808p pd=2.92u as=0.2128p ps=1.5u w=1.12u l=0.13u
X112 VDD DELAY_VBIASP.t12 a_18551_2470# VDD sg13_lv_pmos ad=0.3808p pd=2.92u as=0.2128p ps=1.5u w=1.12u l=0.6u
X113 VSS.t180 a_23763_1842# a_24197_1842# VSS.t437 sg13_lv_nmos ad=0.1406p pd=1.12u as=0.2516p ps=2.16u w=0.74u l=0.13u
X114 VSS.t316 VDD VSS.t315 VSS.t314 sg13_lv_nmos ad=0.1428p pd=1.52u as=0 ps=0 w=0.42u l=1u
X115 VDD a_1256_1044# a_2873_1395# VDD sg13_lv_pmos ad=0.1918p pd=1.5u as=0.1596p ps=1.22u w=0.84u l=0.13u
X116 a_3171_311.t1 a_2873_331# VSS.t5 VSS.t28 sg13_lv_nmos ad=0.1406p pd=1.12u as=0.1331p ps=1.12u w=0.74u l=0.13u
X117 VDD a_2873_331# a_3171_311.t0 VDD sg13_lv_pmos ad=0.4256p pd=3u as=0.2128p ps=1.5u w=1.12u l=0.13u
X118 a_16510_1044# a_17351_1008# a_17275_1044# VDD sg13_lv_pmos ad=0.3808p pd=2.92u as=0.2128p ps=1.5u w=1.12u l=0.13u
X119 a_25630_1044# a_3747_1047.t2 a_27915_1044# VSS.t47 sg13_lv_nmos ad=0.2516p pd=2.16u as=0.1406p ps=1.12u w=0.74u l=0.13u
X120 VSS.t453 DELAY_VBIASN.t1 a_26911_1842# VSS.t452 sg13_lv_nmos ad=0.2516p pd=2.16u as=0.1406p ps=1.12u w=0.74u l=0.6u
X121 a_3747_311.t1 a_3449_331# VSS.t64 VSS.t63 sg13_lv_nmos ad=0.1406p pd=1.12u as=0.1331p ps=1.12u w=0.74u l=0.13u
X122 VDD a_3449_331# a_3747_311.t0 VDD sg13_lv_pmos ad=0.4256p pd=3u as=0.2128p ps=1.5u w=1.12u l=0.13u
X123 VDD DELAY_VBIASP.t7 a_22351_2470# VDD sg13_lv_pmos ad=0.3808p pd=2.92u as=0.2128p ps=1.5u w=1.12u l=0.6u
X124 VDD a_3747_1047.t2 a_27991_1008# VDD sg13_lv_pmos ad=0.3808p pd=2.92u as=0.3808p ps=2.92u w=1.12u l=0.13u
X125 VDD VSS.t597 VDD VDD sg13_lv_pmos ad=0.19p pd=1.38u as=0 ps=0 w=1u l=1u
X126 VDD a_3747_1047.t9 a_6711_1008# VDD sg13_lv_pmos ad=0.3808p pd=2.92u as=0.3808p ps=2.92u w=1.12u l=0.13u
X127 a_6391_1842# a_6153_1842# a_6283_1842# VSS.t508 sg13_lv_nmos ad=0.1406p pd=1.12u as=0.2516p ps=2.16u w=0.74u l=0.2u
X128 a_15273_1842# a_15077_1842# VSS.t400 VSS.t411 sg13_lv_nmos ad=0.2516p pd=2.16u as=0.1406p ps=1.12u w=0.74u l=0.13u
X129 a_19833_1842# a_19637_1842# VDD VDD sg13_lv_pmos ad=0.3808p pd=2.92u as=0.2128p ps=1.5u w=1.12u l=0.13u
X130 a_16108_289# a_23945_519# a_22590_1044# VDD sg13_lv_pmos ad=0.3808p pd=2.92u as=0.3808p ps=2.92u w=1.12u l=0.13u
X131 a_9193_1842# a_8997_1842# VDD VDD sg13_lv_pmos ad=0.3808p pd=2.92u as=0.2128p ps=1.5u w=1.12u l=0.13u
X132 a_24631_2470# a_24393_1842# a_24523_1842# VDD sg13_lv_pmos ad=0.2128p pd=1.5u as=0.3808p ps=2.92u w=1.12u l=0.2u
X133 VSS.t161 a_15403_1842# a_15837_1842# VSS.t207 sg13_lv_nmos ad=0.1406p pd=1.12u as=0.2516p ps=2.16u w=0.74u l=0.13u
X134 a_8155_1044# a_7945_1044# VSS.t62 VSS.t61 sg13_lv_nmos ad=0.1406p pd=1.12u as=0.1665p ps=1.19u w=0.74u l=0.13u
X135 a_23633_1842# a_23437_1842# VDD VDD sg13_lv_pmos ad=0.3808p pd=2.92u as=0.2128p ps=1.5u w=1.12u l=0.13u
X136 VSS.t194 a_4763_1842# a_5197_1842# VSS.t193 sg13_lv_nmos ad=0.1406p pd=1.12u as=0.2516p ps=2.16u w=0.74u l=0.13u
X137 a_27048_1044# a_26477_1842# VSS.t75 VSS.t74 sg13_lv_nmos ad=0.1406p pd=1.12u as=0.2516p ps=2.16u w=0.74u l=0.13u
X138 VDD a_9323_1842# a_9757_1842# VDD sg13_lv_pmos ad=0.2128p pd=1.5u as=0.3808p ps=2.92u w=1.12u l=0.13u
X139 a_5768_1044# a_5197_1842# VSS.t247 VSS.t246 sg13_lv_nmos ad=0.1406p pd=1.12u as=0.2516p ps=2.16u w=0.74u l=0.13u
X140 a_7390_1044# a_7364_1008# a_7288_1044# VDD sg13_lv_pmos ad=0.3808p pd=2.92u as=0.2128p ps=1.5u w=1.12u l=0.13u
X141 VSS.t441 DELAY_VBIASN.t26 a_7911_1842# VSS.t440 sg13_lv_nmos ad=0.2516p pd=2.16u as=0.1406p ps=1.12u w=0.74u l=0.6u
X142 VDD VSS.t581 VDD VDD sg13_lv_pmos ad=0.19p pd=1.38u as=0 ps=0 w=1u l=1u
X143 a_11711_1842# a_11473_1842# a_11603_1842# VSS.t533 sg13_lv_nmos ad=0.1406p pd=1.12u as=0.2516p ps=2.16u w=0.74u l=0.2u
X144 VSS.t182 a_24197_1842# a_24665_1044# VSS.t181 sg13_lv_nmos ad=0.1665p pd=1.19u as=0.2516p ps=2.16u w=0.74u l=0.13u
X145 a_16510_1044# a_3171_1047.t5 a_17928_1044# VSS.t139 sg13_lv_nmos ad=0.2516p pd=2.16u as=0.1406p ps=1.12u w=0.74u l=0.13u
X146 VSS.t308 VDD VSS.t306 VSS.t307 sg13_lv_nmos ad=79.8f pd=0.8u as=0 ps=0 w=0.42u l=1u
X147 a_5631_2470# a_5393_1842# a_5523_1842# VDD sg13_lv_pmos ad=0.2128p pd=1.5u as=0.3808p ps=2.92u w=1.12u l=0.2u
X148 a_14513_1842# a_14317_1842# VDD VDD sg13_lv_pmos ad=0.3808p pd=2.92u as=0.2128p ps=1.5u w=1.12u l=0.13u
X149 a_4633_1842# a_4437_1842# VDD VDD sg13_lv_pmos ad=0.3808p pd=2.92u as=0.2128p ps=1.5u w=1.12u l=0.13u
X150 VSS.t375 a_10083_1842# a_10517_1842# VSS.t374 sg13_lv_nmos ad=0.1406p pd=1.12u as=0.2516p ps=2.16u w=0.74u l=0.13u
X151 VDD a_2019_1047.t4 a_19524_1008# VDD sg13_lv_pmos ad=0.3808p pd=2.92u as=0.3808p ps=2.92u w=1.12u l=0.13u
X152 VSS.t255 a_3171_1047.t4 a_21044_1008# VSS.t254 sg13_lv_nmos ad=0.2516p pd=2.16u as=0.2516p ps=2.16u w=0.74u l=0.13u
X153 VSS.t30 a_2873_331# a_3171_311.t1 VSS.t29 sg13_lv_nmos ad=0.2812p pd=2.24u as=0.1406p ps=1.12u w=0.74u l=0.13u
X154 VSS.t66 a_3449_331# a_3747_311.t1 VSS.t65 sg13_lv_nmos ad=0.2812p pd=2.24u as=0.1406p ps=1.12u w=0.74u l=0.13u
X155 a_15755_1044# a_15545_1044# VDD VDD sg13_lv_pmos ad=0.2128p pd=1.5u as=0.252p ps=1.57u w=1.12u l=0.13u
X156 VDD a_2595_1047.t6 a_14311_1008# VDD sg13_lv_pmos ad=0.3808p pd=2.92u as=0.3808p ps=2.92u w=1.12u l=0.13u
X157 VSS.t501 DELAY_VBIASN.t4 a_24631_1842# VSS.t500 sg13_lv_nmos ad=0.2516p pd=2.16u as=0.1406p ps=1.12u w=0.74u l=0.6u
X158 a_5115_1044# a_4905_1044# VDD VDD sg13_lv_pmos ad=0.2128p pd=1.5u as=0.252p ps=1.57u w=1.12u l=0.13u
X159 a_18551_2470# a_18313_1842# a_18443_1842# VDD sg13_lv_pmos ad=0.2128p pd=1.5u as=0.3808p ps=2.92u w=1.12u l=0.2u
X160 VDD VSS.t573 VDD VDD sg13_lv_pmos ad=0.19p pd=1.38u as=0 ps=0 w=1u l=1u
X161 a_3171_1047.t1 a_2873_1395# VSS.t22 VSS.t227 sg13_lv_nmos ad=0.1406p pd=1.12u as=0.1331p ps=1.12u w=0.74u l=0.13u
X162 VSS.t56 a_2297_1395# a_2595_1047.t1 VSS.t55 sg13_lv_nmos ad=0.2812p pd=2.24u as=0.1406p ps=1.12u w=0.74u l=0.13u
X163 a_22351_2470# a_22113_1842# a_22243_1842# VDD sg13_lv_pmos ad=0.2128p pd=1.5u as=0.3808p ps=2.92u w=1.12u l=0.2u
X164 VSS.t380 VSS.t377 VSS.t379 VSS.t378 sg13_lv_nmos ad=0.2516p pd=2.16u as=0 ps=0 w=0.74u l=0.13u
X165 a_26911_1842# a_26673_1842# a_26803_1842# VSS.t192 sg13_lv_nmos ad=0.1406p pd=1.12u as=0.2516p ps=2.16u w=0.74u l=0.2u
X166 VSS.t218 a_3171_311.t3 a_11785_519# VSS.t217 sg13_lv_nmos ad=0.2516p pd=2.16u as=0.2516p ps=2.16u w=0.74u l=0.13u
X167 VDD a_1721_1395# a_2019_1047.t0 VDD sg13_lv_pmos ad=0.4256p pd=3u as=0.2128p ps=1.5u w=1.12u l=0.13u
X168 VDD a_16923_1842# a_17357_1842# VDD sg13_lv_pmos ad=0.2128p pd=1.5u as=0.3808p ps=2.92u w=1.12u l=0.13u
X169 a_2391_1395# MUX_SEL0 a_2297_1395# VSS.t512 sg13_lv_nmos ad=0.1216p pd=1.02u as=0.2176p ps=1.96u w=0.64u l=0.13u
X170 VSS.t17 a_1544_1044# a_1815_1395# VSS.t71 sg13_lv_nmos ad=0.1331p pd=1.12u as=0.1216p ps=1.02u w=0.64u l=0.13u
X171 a_13368_1044# a_12797_1842# VSS.t89 VSS.t88 sg13_lv_nmos ad=0.1406p pd=1.12u as=0.2516p ps=2.16u w=0.74u l=0.13u
X172 a_5731_289# a_3171_311.t3 a_10430_1044# VSS.t216 sg13_lv_nmos ad=0.2516p pd=2.16u as=0.2516p ps=2.16u w=0.74u l=0.13u
X173 VDD a_21157_1842# a_21625_1044# VDD sg13_lv_pmos ad=0.252p pd=1.57u as=0.3808p ps=2.92u w=1.12u l=0.13u
X174 VDD DELAY_VBIASP.t22 a_10951_2470# VDD sg13_lv_pmos ad=0.3808p pd=2.92u as=0.2128p ps=1.5u w=1.12u l=0.6u
X175 VSS.t491 DELAY_VBIASN.t16 a_15511_1842# VSS.t490 sg13_lv_nmos ad=0.2516p pd=2.16u as=0.1406p ps=1.12u w=0.74u l=0.6u
X176 VDD a_20723_1842# a_21157_1842# VDD sg13_lv_pmos ad=0.2128p pd=1.5u as=0.3808p ps=2.92u w=1.12u l=0.13u
X177 VSS.t168 a_25283_1842# a_25717_1842# VSS.t404 sg13_lv_nmos ad=0.1406p pd=1.12u as=0.2516p ps=2.16u w=0.74u l=0.13u
X178 a_4350_1044# a_3747_1047.t9 a_6635_1044# VSS.t0 sg13_lv_nmos ad=0.2516p pd=2.16u as=0.1406p ps=1.12u w=0.74u l=0.13u
X179 VSS.t443 DELAY_VBIASN.t29 a_5631_1842# VSS.t442 sg13_lv_nmos ad=0.2516p pd=2.16u as=0.1406p ps=1.12u w=0.74u l=0.6u
X180 VDD a_2019_1047.t9 a_4324_1008# VDD sg13_lv_pmos ad=0.3808p pd=2.92u as=0.3808p ps=2.92u w=1.12u l=0.13u
X181 a_16510_1044# a_18871_1008# a_18795_1044# VDD sg13_lv_pmos ad=0.3808p pd=2.92u as=0.2128p ps=1.5u w=1.12u l=0.13u
X182 a_19550_1044# a_2595_1047.t4 a_20315_1044# VSS.t79 sg13_lv_nmos ad=0.2516p pd=2.16u as=0.1406p ps=1.12u w=0.74u l=0.13u
X183 VDD DELAY_VBIASP.t5 a_23871_2470# VDD sg13_lv_pmos ad=0.3808p pd=2.92u as=0.2128p ps=1.5u w=1.12u l=0.6u
X184 VSS.t62 a_7477_1842# a_7945_1044# VSS.t521 sg13_lv_nmos ad=0.1665p pd=1.19u as=0.2516p ps=2.16u w=0.74u l=0.13u
X185 a_13231_2470# a_12993_1842# a_13123_1842# VDD sg13_lv_pmos ad=0.2128p pd=1.5u as=0.3808p ps=2.92u w=1.12u l=0.2u
X186 VDD VSS.t598 VDD VDD sg13_lv_pmos ad=0.34p pd=2.68u as=0 ps=0 w=1u l=1u
X187 a_12233_1842# a_12037_1842# VDD VDD sg13_lv_pmos ad=0.3808p pd=2.92u as=0.2128p ps=1.5u w=1.12u l=0.13u
X188 a_7911_1842# a_7673_1842# a_7803_1842# VSS.t554 sg13_lv_nmos ad=0.1406p pd=1.12u as=0.2516p ps=2.16u w=0.74u l=0.2u
X189 a_16793_1842# a_16597_1842# VSS.t279 VSS.t278 sg13_lv_nmos ad=0.2516p pd=2.16u as=0.1406p ps=1.12u w=0.74u l=0.13u
X190 VDD a_3747_311.t3 a_14825_519# VDD sg13_lv_pmos ad=0.3808p pd=2.92u as=0.3808p ps=2.92u w=1.12u l=0.13u
X191 VSS.t394 a_27563_1842# a_27997_1842# VSS.t393 sg13_lv_nmos ad=0.1406p pd=1.12u as=0.2516p ps=2.16u w=0.74u l=0.13u
X192 a_9675_1044# a_9465_1044# VSS.t135 VSS.t134 sg13_lv_nmos ad=0.1406p pd=1.12u as=0.1665p ps=1.19u w=0.74u l=0.13u
X193 a_20593_1842# a_20397_1842# VSS.t274 VSS.t273 sg13_lv_nmos ad=0.2516p pd=2.16u as=0.1406p ps=1.12u w=0.74u l=0.13u
X194 VSS.t12 a_2595_1047.t8 a_8231_1008# VSS.t11 sg13_lv_nmos ad=0.2516p pd=2.16u as=0.2516p ps=2.16u w=0.74u l=0.13u
X195 VSS.t191 a_6283_1842# a_6717_1842# VSS.t438 sg13_lv_nmos ad=0.1406p pd=1.12u as=0.2516p ps=2.16u w=0.74u l=0.13u
X196 a_10430_1044# a_10404_1008# a_10328_1044# VDD sg13_lv_pmos ad=0.3808p pd=2.92u as=0.2128p ps=1.5u w=1.12u l=0.13u
X197 VDD DELAY_VBIASP.t2 a_26151_2470# VDD sg13_lv_pmos ad=0.3808p pd=2.92u as=0.2128p ps=1.5u w=1.12u l=0.6u
X198 a_7390_1044# a_8884_1008# a_8808_1044# VDD sg13_lv_pmos ad=0.3808p pd=2.92u as=0.2128p ps=1.5u w=1.12u l=0.13u
X199 VDD DELAY_VBIASP.t30 a_4871_2470# VDD sg13_lv_pmos ad=0.3808p pd=2.92u as=0.2128p ps=1.5u w=1.12u l=0.6u
X200 a_3449_331# MUX_SEL2 VDD VDD sg13_lv_pmos ad=0.1596p pd=1.22u as=0.2856p ps=2.36u w=0.84u l=0.13u
X201 VDD VSS.t575 VDD VDD sg13_lv_pmos ad=0.19p pd=1.38u as=0 ps=0 w=1u l=1u
X202 a_19073_1842# a_18877_1842# VSS.t163 VSS.t162 sg13_lv_nmos ad=0.2516p pd=2.16u as=0.1406p ps=1.12u w=0.74u l=0.13u
X203 VDD a_15077_1842# a_15545_1044# VDD sg13_lv_pmos ad=0.252p pd=1.57u as=0.3808p ps=2.92u w=1.12u l=0.13u
X204 a_19550_1044# a_2019_1047.t4 a_19448_1044# VSS.t250 sg13_lv_nmos ad=0.2516p pd=2.16u as=0.1406p ps=1.12u w=0.74u l=0.13u
X205 VDD VDD VDD VDD sg13_lv_pmos ad=0.3808p pd=2.92u as=0 ps=0 w=1.12u l=0.6u
X206 VSS.t368 VDD VSS.t366 VSS.t367 sg13_lv_nmos ad=79.8f pd=0.8u as=0 ps=0 w=0.42u l=1u
X207 VSS.t422 a_19203_1842# a_19637_1842# VSS.t429 sg13_lv_nmos ad=0.1406p pd=1.12u as=0.2516p ps=2.16u w=0.74u l=0.13u
X208 VDD VSS.t577 VDD VDD sg13_lv_pmos ad=0.19p pd=1.38u as=0 ps=0 w=1u l=1u
X209 VDD VSS.t588 VDD VDD sg13_lv_pmos ad=0.34p pd=2.68u as=0 ps=0 w=1u l=1u
X210 a_27433_1842# a_27237_1842# VDD VDD sg13_lv_pmos ad=0.3808p pd=2.92u as=0.2128p ps=1.5u w=1.12u l=0.13u
X211 VDD a_1256_289# a_2873_331# VDD sg13_lv_pmos ad=0.1918p pd=1.5u as=0.1596p ps=1.22u w=0.84u l=0.13u
X212 a_13470_1044# a_2595_1047.t6 a_14235_1044# VSS.t108 sg13_lv_nmos ad=0.2516p pd=2.16u as=0.1406p ps=1.12u w=0.74u l=0.13u
X213 VSS.t520 a_8563_1842# a_8997_1842# VSS.t519 sg13_lv_nmos ad=0.1406p pd=1.12u as=0.2516p ps=2.16u w=0.74u l=0.13u
X214 VSS.t445 DELAY_VBIASN.t19 a_13231_1842# VSS.t444 sg13_lv_nmos ad=0.2516p pd=2.16u as=0.1406p ps=1.12u w=0.74u l=0.6u
X215 VDD a_3171_1047.t7 a_11924_1008# VDD sg13_lv_pmos ad=0.3808p pd=2.92u as=0.3808p ps=2.92u w=1.12u l=0.13u
X216 VSS.t550 a_2019_1047.t3 a_22564_1008# VSS.t549 sg13_lv_nmos ad=0.2516p pd=2.16u as=0.2516p ps=2.16u w=0.74u l=0.13u
X217 VSS.t392 a_23003_1842# a_23437_1842# VSS.t391 sg13_lv_nmos ad=0.1406p pd=1.12u as=0.2516p ps=2.16u w=0.74u l=0.13u
X218 VSS.t371 VDD VSS.t370 VSS.t369 sg13_lv_nmos ad=0.1428p pd=1.52u as=0 ps=0 w=0.42u l=1u
X219 VDD DELAY_VBIASP.t27 a_7151_2470# VDD sg13_lv_pmos ad=0.3808p pd=2.92u as=0.2128p ps=1.5u w=1.12u l=0.6u
X220 a_25630_1044# a_25604_1008# a_25528_1044# VDD sg13_lv_pmos ad=0.3808p pd=2.92u as=0.2128p ps=1.5u w=1.12u l=0.13u
X221 a_15511_1842# a_15273_1842# a_15403_1842# VSS.t525 sg13_lv_nmos ad=0.1406p pd=1.12u as=0.2516p ps=2.16u w=0.74u l=0.2u
X222 a_18313_1842# a_18117_1842# VDD VDD sg13_lv_pmos ad=0.3808p pd=2.92u as=0.2128p ps=1.5u w=1.12u l=0.13u
X223 a_5731_289# a_11785_519# a_10430_1044# VDD sg13_lv_pmos ad=0.3808p pd=2.92u as=0.3808p ps=2.92u w=1.12u l=0.13u
X224 VSS.t288 VDD VSS.t286 VSS.t287 sg13_lv_nmos ad=79.8f pd=0.8u as=0 ps=0 w=0.42u l=1u
X225 a_9431_2470# a_9193_1842# a_9323_1842# VDD sg13_lv_pmos ad=0.2128p pd=1.5u as=0.3808p ps=2.92u w=1.12u l=0.2u
X226 a_17275_1044# a_17065_1044# VSS.t245 VSS.t244 sg13_lv_nmos ad=0.1406p pd=1.12u as=0.1665p ps=1.19u w=0.74u l=0.13u
X227 VDD VSS.t574 VDD VDD sg13_lv_pmos ad=0.34p pd=2.68u as=0 ps=0 w=1u l=1u
X228 VSS.t96 a_3747_1047.t6 a_15831_1008# VSS.t95 sg13_lv_nmos ad=0.2516p pd=2.16u as=0.2516p ps=2.16u w=0.74u l=0.13u
X229 a_23871_2470# a_23633_1842# a_23763_1842# VDD sg13_lv_pmos ad=0.2128p pd=1.5u as=0.3808p ps=2.92u w=1.12u l=0.2u
X230 VSS.t433 a_13883_1842# a_14317_1842# VSS.t504 sg13_lv_nmos ad=0.1406p pd=1.12u as=0.2516p ps=2.16u w=0.74u l=0.13u
X231 VSS.t105 a_3747_311.t2 a_26985_519# VSS.t104 sg13_lv_nmos ad=0.2516p pd=2.16u as=0.2516p ps=2.16u w=0.74u l=0.13u
X232 a_8433_1842# a_8237_1842# VDD VDD sg13_lv_pmos ad=0.3808p pd=2.92u as=0.2128p ps=1.5u w=1.12u l=0.13u
X233 VDD a_18443_1842# a_18877_1842# VDD sg13_lv_pmos ad=0.2128p pd=1.5u as=0.3808p ps=2.92u w=1.12u l=0.13u
X234 a_22113_1842# a_21917_1842# VDD VDD sg13_lv_pmos ad=0.3808p pd=2.92u as=0.2128p ps=1.5u w=1.12u l=0.13u
X235 a_4350_1044# a_2019_1047.t9 a_4248_1044# VSS.t23 sg13_lv_nmos ad=0.2516p pd=2.16u as=0.1406p ps=1.12u w=0.74u l=0.13u
X236 a_14888_1044# a_14317_1842# VSS.t431 VSS.t430 sg13_lv_nmos ad=0.1406p pd=1.12u as=0.2516p ps=2.16u w=0.74u l=0.13u
X237 a_16108_289# a_3747_311.t2 a_25630_1044# VSS.t103 sg13_lv_nmos ad=0.2516p pd=2.16u as=0.2516p ps=2.16u w=0.74u l=0.13u
X238 VDD DELAY_VBIASP.t20 a_12471_2470# VDD sg13_lv_pmos ad=0.3808p pd=2.92u as=0.2128p ps=1.5u w=1.12u l=0.6u
X239 VSS.t186 a_4003_1842# a_4437_1842# VSS.t212 sg13_lv_nmos ad=0.1406p pd=1.12u as=0.2516p ps=2.16u w=0.74u l=0.13u
X240 a_16510_1044# a_16484_1008# a_16408_1044# VDD sg13_lv_pmos ad=0.3808p pd=2.92u as=0.2128p ps=1.5u w=1.12u l=0.13u
X241 VDD a_22243_1842# a_22677_1842# VDD sg13_lv_pmos ad=0.2128p pd=1.5u as=0.3808p ps=2.92u w=1.12u l=0.13u
X242 VDD a_3171_1047.t2 a_27124_1008# VDD sg13_lv_pmos ad=0.3808p pd=2.92u as=0.3808p ps=2.92u w=1.12u l=0.13u
X243 VDD MUX_SEL3 a_3449_331# VDD sg13_lv_pmos ad=0.1918p pd=1.5u as=0.1596p ps=1.22u w=0.84u l=0.13u
X244 a_2595_311.t0 a_2297_331# VDD VDD sg13_lv_pmos ad=0.2128p pd=1.5u as=0.1918p ps=1.5u w=1.12u l=0.13u
X245 a_10430_1044# a_11271_1008# a_11195_1044# VDD sg13_lv_pmos ad=0.3808p pd=2.92u as=0.2128p ps=1.5u w=1.12u l=0.13u
X246 a_23355_1044# a_23145_1044# VDD VDD sg13_lv_pmos ad=0.2128p pd=1.5u as=0.252p ps=1.57u w=1.12u l=0.13u
X247 VDD a_3747_1047.t4 a_21911_1008# VDD sg13_lv_pmos ad=0.3808p pd=2.92u as=0.3808p ps=2.92u w=1.12u l=0.13u
X248 VSS.t135 a_8997_1842# a_9465_1044# VSS.t524 sg13_lv_nmos ad=0.1665p pd=1.19u as=0.2516p ps=2.16u w=0.74u l=0.13u
X249 a_20968_1044# a_20397_1842# VDD VDD sg13_lv_pmos ad=0.2128p pd=1.5u as=0.3808p ps=2.92u w=1.12u l=0.13u
X250 a_10951_1842# a_10713_1842# a_10843_1842# VSS.t428 sg13_lv_nmos ad=0.1406p pd=1.12u as=0.2516p ps=2.16u w=0.74u l=0.2u
X251 VSS.t267 a_2019_1047.t5 a_16484_1008# VSS.t266 sg13_lv_nmos ad=0.2516p pd=2.16u as=0.2516p ps=2.16u w=0.74u l=0.13u
X252 a_26151_2470# a_25913_1842# a_26043_1842# VDD sg13_lv_pmos ad=0.2128p pd=1.5u as=0.3808p ps=2.92u w=1.12u l=0.2u
X253 a_13753_1842# a_13557_1842# VDD VDD sg13_lv_pmos ad=0.3808p pd=2.92u as=0.2128p ps=1.5u w=1.12u l=0.13u
X254 VDD a_1721_331# a_2019_311# VDD sg13_lv_pmos ad=0.4256p pd=3u as=0.2128p ps=1.5u w=1.12u l=0.13u
X255 a_4871_2470# a_4633_1842# a_4763_1842# VDD sg13_lv_pmos ad=0.2128p pd=1.5u as=0.3808p ps=2.92u w=1.12u l=0.2u
X256 VSS.t119 a_3171_1047.t9 a_5844_1008# VSS.t118 sg13_lv_nmos ad=0.2516p pd=2.16u as=0.2516p ps=2.16u w=0.74u l=0.13u
X257 VSS.t328 VDD VSS.t326 VSS.t327 sg13_lv_nmos ad=79.8f pd=0.8u as=0 ps=0 w=0.42u l=1u
X258 VDD a_2595_311.t2 a_20905_519# VDD sg13_lv_pmos ad=0.3808p pd=2.92u as=0.3808p ps=2.92u w=1.12u l=0.13u
X259 VDD a_2297_331# a_2595_311.t0 VDD sg13_lv_pmos ad=0.4256p pd=3u as=0.2128p ps=1.5u w=1.12u l=0.13u
X260 VSS.t15 a_2595_1047.t7 a_11271_1008# VSS.t14 sg13_lv_nmos ad=0.2516p pd=2.16u as=0.2516p ps=2.16u w=0.74u l=0.13u
X261 VSS.t481 DELAY_VBIASN.t11 a_19311_1842# VSS.t480 sg13_lv_nmos ad=0.2516p pd=2.16u as=0.1406p ps=1.12u w=0.74u l=0.6u
X262 VDD a_24523_1842# a_24957_1842# VDD sg13_lv_pmos ad=0.2128p pd=1.5u as=0.3808p ps=2.92u w=1.12u l=0.13u
X263 VSS.t224 a_3747_1047.t8 a_9751_1008# VSS.t223 sg13_lv_nmos ad=0.2516p pd=2.16u as=0.2516p ps=2.16u w=0.74u l=0.13u
X264 VSS.t471 DELAY_VBIASN.t24 a_9431_1842# VSS.t470 sg13_lv_nmos ad=0.2516p pd=2.16u as=0.1406p ps=1.12u w=0.74u l=0.6u
X265 a_19448_1044# a_18877_1842# VDD VDD sg13_lv_pmos ad=0.2128p pd=1.5u as=0.3808p ps=2.92u w=1.12u l=0.13u
X266 VSS.t499 DELAY_VBIASN.t6 a_23111_1842# VSS.t498 sg13_lv_nmos ad=0.2516p pd=2.16u as=0.1406p ps=1.12u w=0.74u l=0.6u
X267 a_10430_1044# a_11924_1008# a_11848_1044# VDD sg13_lv_pmos ad=0.3808p pd=2.92u as=0.2128p ps=1.5u w=1.12u l=0.13u
X268 VDD DELAY_VBIASP.t0 a_27671_2470# VDD sg13_lv_pmos ad=0.3808p pd=2.92u as=0.2128p ps=1.5u w=1.12u l=0.6u
X269 a_25630_1044# a_26471_1008# a_26395_1044# VDD sg13_lv_pmos ad=0.3808p pd=2.92u as=0.2128p ps=1.5u w=1.12u l=0.13u
X270 a_7151_2470# a_6913_1842# a_7043_1842# VDD sg13_lv_pmos ad=0.2128p pd=1.5u as=0.3808p ps=2.92u w=1.12u l=0.2u
X271 a_16033_1842# a_15837_1842# VDD VDD sg13_lv_pmos ad=0.3808p pd=2.92u as=0.2128p ps=1.5u w=1.12u l=0.13u
X272 VDD a_15964_289# a_16851_309# VDD sg13_lv_pmos ad=0.2086p pd=1.5u as=0.34p ps=2.68u w=1u l=0.13u
X273 VDD VSS.t576 VDD VDD sg13_lv_pmos ad=0.34p pd=2.68u as=0 ps=0 w=1u l=1u
X274 VSS.t210 a_11603_1842# a_12037_1842# VSS.t209 sg13_lv_nmos ad=0.1406p pd=1.12u as=0.2516p ps=2.16u w=0.74u l=0.13u
X275 VSS.t348 VDD VSS.t346 VSS.t347 sg13_lv_nmos ad=79.8f pd=0.8u as=0 ps=0 w=0.42u l=1u
X276 VDD VSS.t590 VDD VDD sg13_lv_pmos ad=0.34p pd=2.68u as=0 ps=0 w=1u l=1u
X277 VDD a_5957_1842# a_6425_1044# VDD sg13_lv_pmos ad=0.252p pd=1.57u as=0.3808p ps=2.92u w=1.12u l=0.13u
X278 a_24393_1842# a_24197_1842# VSS.t180 VSS.t179 sg13_lv_nmos ad=0.2516p pd=2.16u as=0.1406p ps=1.12u w=0.74u l=0.13u
X279 a_3747_1047.t1 a_3449_1395# VSS.t130 VSS.t129 sg13_lv_nmos ad=0.1406p pd=1.12u as=0.1331p ps=1.12u w=0.74u l=0.13u
X280 a_1544_1044# MUX_SEL1 VSS.t527 VSS.t526 sg13_lv_nmos ad=0.2516p pd=2.16u as=0.2516p ps=2.16u w=0.74u l=0.13u
X281 VDD VSS.t578 VDD VDD sg13_lv_pmos ad=0.34p pd=2.68u as=0 ps=0 w=1u l=1u
X282 a_3171_1047.t0 a_2873_1395# VDD VDD sg13_lv_pmos ad=0.2128p pd=1.5u as=0.1918p ps=1.5u w=1.12u l=0.13u
X283 a_13470_1044# a_3747_1047.t6 a_15755_1044# VSS.t94 sg13_lv_nmos ad=0.2516p pd=2.16u as=0.1406p ps=1.12u w=0.74u l=0.13u
X284 VDD a_5523_1842# a_5957_1842# VDD sg13_lv_pmos ad=0.2128p pd=1.5u as=0.3808p ps=2.92u w=1.12u l=0.13u
X285 VDD a_2297_1395# a_2595_1047.t0 VDD sg13_lv_pmos ad=0.4256p pd=3u as=0.2128p ps=1.5u w=1.12u l=0.13u
X286 VSS.t477 DELAY_VBIASN.t17 a_14751_1842# VSS.t476 sg13_lv_nmos ad=0.2516p pd=2.16u as=0.1406p ps=1.12u w=0.74u l=0.6u
X287 a_2967_1395# MUX_SEL1 a_2873_1395# VSS.t528 sg13_lv_nmos ad=0.1216p pd=1.02u as=0.2176p ps=1.96u w=0.64u l=0.13u
X288 a_4350_1044# a_2595_1047.t9 a_5115_1044# VSS.t262 sg13_lv_nmos ad=0.2516p pd=2.16u as=0.1406p ps=1.12u w=0.74u l=0.13u
X289 VDD a_2019_1047.t6 a_13444_1008# VDD sg13_lv_pmos ad=0.3808p pd=2.92u as=0.3808p ps=2.92u w=1.12u l=0.13u
X290 VSS.t138 a_2595_1047.t2 a_26471_1008# VSS.t137 sg13_lv_nmos ad=0.2516p pd=2.16u as=0.2516p ps=2.16u w=0.74u l=0.13u
X291 a_2595_311.t1 a_2297_331# VSS.t154 VSS.t153 sg13_lv_nmos ad=0.1406p pd=1.12u as=0.1331p ps=1.12u w=0.74u l=0.13u
X292 VSS.t457 DELAY_VBIASN.t31 a_4111_1842# VSS.t456 sg13_lv_nmos ad=0.2516p pd=2.16u as=0.1406p ps=1.12u w=0.74u l=0.6u
X293 a_2297_1395# MUX_SEL0 VDD VDD sg13_lv_pmos ad=0.1596p pd=1.22u as=0.2856p ps=2.36u w=0.84u l=0.13u
X294 VSS.t245 a_16597_1842# a_17065_1044# VSS.t280 sg13_lv_nmos ad=0.1665p pd=1.19u as=0.2516p ps=2.16u w=0.74u l=0.13u
X295 VDD DELAY_VBIASP.t25 a_8671_2470# VDD sg13_lv_pmos ad=0.3808p pd=2.92u as=0.2128p ps=1.5u w=1.12u l=0.6u
X296 VDD VSS.t591 VDD VDD sg13_lv_pmos ad=0.19p pd=1.38u as=0 ps=0 w=1u l=1u
X297 VDD a_1544_1044# a_1721_1395# VDD sg13_lv_pmos ad=0.1918p pd=1.5u as=0.1596p ps=1.22u w=0.84u l=0.13u
X298 a_4248_1044# a_4157_1313# VDD VDD sg13_lv_pmos ad=0.2128p pd=1.5u as=0.3808p ps=2.92u w=1.12u l=0.13u
X299 a_12471_2470# a_12233_1842# a_12363_1842# VDD sg13_lv_pmos ad=0.2128p pd=1.5u as=0.3808p ps=2.92u w=1.12u l=0.2u
X300 a_17031_1842# a_16793_1842# a_16923_1842# VSS.t39 sg13_lv_nmos ad=0.1406p pd=1.12u as=0.2516p ps=2.16u w=0.74u l=0.2u
X301 VSS.t123 a_1721_331# a_2019_311# VSS.t122 sg13_lv_nmos ad=0.2812p pd=2.24u as=0.1406p ps=1.12u w=0.74u l=0.13u
X302 a_19550_1044# a_21911_1008# a_21835_1044# VDD sg13_lv_pmos ad=0.3808p pd=2.92u as=0.2128p ps=1.5u w=1.12u l=0.13u
X303 a_16108_289# a_26985_519# a_25630_1044# VDD sg13_lv_pmos ad=0.3808p pd=2.92u as=0.3808p ps=2.92u w=1.12u l=0.13u
X304 VSS.t156 a_2297_331# a_2595_311.t1 VSS.t155 sg13_lv_nmos ad=0.2812p pd=2.24u as=0.1406p ps=1.12u w=0.74u l=0.13u
X305 a_18795_1044# a_18585_1044# VSS.t199 VSS.t551 sg13_lv_nmos ad=0.1406p pd=1.12u as=0.1665p ps=1.19u w=0.74u l=0.13u
X306 a_20831_1842# a_20593_1842# a_20723_1842# VSS.t532 sg13_lv_nmos ad=0.1406p pd=1.12u as=0.2516p ps=2.16u w=0.74u l=0.2u
X307 VSS.t286 VDD VSS.t285 VSS.t284 sg13_lv_nmos ad=0.1428p pd=1.52u as=0 ps=0 w=0.42u l=1u
X308 VDD a_22677_1842# a_23145_1044# VDD sg13_lv_pmos ad=0.252p pd=1.57u as=0.3808p ps=2.92u w=1.12u l=0.13u
X309 VSS.t144 a_2595_1047.t5 a_17351_1008# VSS.t143 sg13_lv_nmos ad=0.2516p pd=2.16u as=0.2516p ps=2.16u w=0.74u l=0.13u
X310 a_5393_1842# a_5197_1842# VSS.t194 VSS.t248 sg13_lv_nmos ad=0.2516p pd=2.16u as=0.1406p ps=1.12u w=0.74u l=0.13u
X311 VSS.t483 DELAY_VBIASN.t14 a_17031_1842# VSS.t482 sg13_lv_nmos ad=0.2516p pd=2.16u as=0.1406p ps=1.12u w=0.74u l=0.6u
X312 a_25630_1044# a_3171_1047.t2 a_27048_1044# VSS.t76 sg13_lv_nmos ad=0.2516p pd=2.16u as=0.1406p ps=1.12u w=0.74u l=0.13u
X313 a_9953_1842# a_9757_1842# VDD VDD sg13_lv_pmos ad=0.3808p pd=2.92u as=0.2128p ps=1.5u w=1.12u l=0.13u
X314 VDD a_10843_1842# a_11277_1842# VDD sg13_lv_pmos ad=0.2128p pd=1.5u as=0.3808p ps=2.92u w=1.12u l=0.13u
X315 VSS.t38 a_26803_1842# a_27237_1842# VSS.t37 sg13_lv_nmos ad=0.1406p pd=1.12u as=0.2516p ps=2.16u w=0.74u l=0.13u
X316 a_4350_1044# a_3171_1047.t9 a_5768_1044# VSS.t117 sg13_lv_nmos ad=0.2516p pd=2.16u as=0.1406p ps=1.12u w=0.74u l=0.13u
X317 a_10430_1044# a_12791_1008# a_12715_1044# VDD sg13_lv_pmos ad=0.3808p pd=2.92u as=0.2128p ps=1.5u w=1.12u l=0.13u
X318 a_19311_1842# a_19073_1842# a_19203_1842# VSS.t200 sg13_lv_nmos ad=0.1406p pd=1.12u as=0.2516p ps=2.16u w=0.74u l=0.2u
X319 a_24875_1044# a_24665_1044# VDD VDD sg13_lv_pmos ad=0.2128p pd=1.5u as=0.252p ps=1.57u w=1.12u l=0.13u
X320 VDD a_2595_1047.t3 a_23431_1008# VDD sg13_lv_pmos ad=0.3808p pd=2.92u as=0.3808p ps=2.92u w=1.12u l=0.13u
X321 VDD a_13557_1842# a_14025_1044# VDD sg13_lv_pmos ad=0.252p pd=1.57u as=0.3808p ps=2.92u w=1.12u l=0.13u
X322 a_23111_1842# a_22873_1842# a_23003_1842# VSS.t46 sg13_lv_nmos ad=0.1406p pd=1.12u as=0.2516p ps=2.16u w=0.74u l=0.2u
X323 a_27671_2470# a_27433_1842# a_27563_1842# VDD sg13_lv_pmos ad=0.2128p pd=1.5u as=0.3808p ps=2.92u w=1.12u l=0.2u
X324 VSS.t197 a_17683_1842# a_18117_1842# VSS.t211 sg13_lv_nmos ad=0.1406p pd=1.12u as=0.2516p ps=2.16u w=0.74u l=0.13u
X325 VSS.t343 VDD VSS.t341 VSS.t342 sg13_lv_nmos ad=79.8f pd=0.8u as=0 ps=0 w=0.42u l=1u
X326 a_10713_1842# a_10517_1842# VSS.t375 VSS.t517 sg13_lv_nmos ad=0.2516p pd=2.16u as=0.1406p ps=1.12u w=0.74u l=0.13u
X327 VSS.t235 a_2019_1047.t8 a_7364_1008# VSS.t234 sg13_lv_nmos ad=0.2516p pd=2.16u as=0.2516p ps=2.16u w=0.74u l=0.13u
X328 VSS.t269 a_7803_1842# a_8237_1842# VSS.t268 sg13_lv_nmos ad=0.1406p pd=1.12u as=0.2516p ps=2.16u w=0.74u l=0.13u
X329 VDD DELAY_VBIASP.t15 a_16271_2470# VDD sg13_lv_pmos ad=0.3808p pd=2.92u as=0.2128p ps=1.5u w=1.12u l=0.6u
X330 VSS.t338 VDD VSS.t336 VSS.t337 sg13_lv_nmos ad=79.8f pd=0.8u as=0 ps=0 w=0.42u l=1u
X331 VSS.t311 VDD VSS.t310 VSS.t309 sg13_lv_nmos ad=0.1428p pd=1.52u as=0 ps=0 w=0.42u l=1u
X332 VDD a_26043_1842# a_26477_1842# VDD sg13_lv_pmos ad=0.2128p pd=1.5u as=0.3808p ps=2.92u w=1.12u l=0.13u
X333 a_3543_331# MUX_SEL2 a_3449_331# VSS.t398 sg13_lv_nmos ad=0.1216p pd=1.02u as=0.2176p ps=1.96u w=0.64u l=0.13u
X334 a_22488_1044# a_21917_1842# VSS.t507 VSS.t506 sg13_lv_nmos ad=0.1406p pd=1.12u as=0.2516p ps=2.16u w=0.74u l=0.13u
X335 VDD VSS.t593 VDD VDD sg13_lv_pmos ad=0.19p pd=1.38u as=0 ps=0 w=1u l=1u
X336 a_22590_1044# a_24084_1008# a_24008_1044# VDD sg13_lv_pmos ad=0.3808p pd=2.92u as=0.2128p ps=1.5u w=1.12u l=0.13u
X337 VDD DELAY_VBIASP.t10 a_20071_2470# VDD sg13_lv_pmos ad=0.3808p pd=2.92u as=0.2128p ps=1.5u w=1.12u l=0.6u
X338 a_14751_1842# a_14513_1842# a_14643_1842# VSS.t270 sg13_lv_nmos ad=0.1406p pd=1.12u as=0.2516p ps=2.16u w=0.74u l=0.2u
X339 VSS.t229 a_2873_1395# a_3171_1047.t1 VSS.t228 sg13_lv_nmos ad=0.2812p pd=2.24u as=0.1406p ps=1.12u w=0.74u l=0.13u
X340 VDD VSS.t567 VDD VDD sg13_lv_pmos ad=0.19p pd=1.38u as=0 ps=0 w=1u l=1u
X341 a_25630_1044# a_27991_1008# a_27915_1044# VDD sg13_lv_pmos ad=0.3808p pd=2.92u as=0.2128p ps=1.5u w=1.12u l=0.13u
X342 VSS.t383 VSS.t381 VSS.t379 VSS.t382 sg13_lv_nmos ad=0.1406p pd=1.12u as=0 ps=0 w=0.74u l=0.13u
X343 a_4111_1842# DELAY_IN a_4003_1842# VSS.t275 sg13_lv_nmos ad=0.1406p pd=1.12u as=0.2516p ps=2.16u w=0.74u l=0.2u
X344 a_8671_2470# a_8433_1842# a_8563_1842# VDD sg13_lv_pmos ad=0.2128p pd=1.5u as=0.3808p ps=2.92u w=1.12u l=0.2u
X345 a_17553_1842# a_17357_1842# VDD VDD sg13_lv_pmos ad=0.3808p pd=2.92u as=0.2128p ps=1.5u w=1.12u l=0.13u
X346 VSS.t54 a_1544_1044# a_2391_1395# VSS.t72 sg13_lv_nmos ad=0.1331p pd=1.12u as=0.1216p ps=1.02u w=0.64u l=0.13u
X347 VSS.t241 a_3747_311.t3 a_14825_519# VSS.t240 sg13_lv_nmos ad=0.2516p pd=2.16u as=0.2516p ps=2.16u w=0.74u l=0.13u
X348 VSS.t5 a_1256_289# a_2967_331# VSS.t4 sg13_lv_nmos ad=0.1331p pd=1.12u as=0.1216p ps=1.02u w=0.64u l=0.13u
X349 a_2019_1047.t1 a_1721_1395# VSS.t17 VSS.t16 sg13_lv_nmos ad=0.1406p pd=1.12u as=0.1331p ps=1.12u w=0.74u l=0.13u
X350 a_15964_289# a_15765_463# a_5731_289# VSS.t552 sg13_lv_nmos ad=0.2183p pd=1.33u as=0.2516p ps=2.16u w=0.74u l=0.13u
X351 a_13470_1044# a_2019_1047.t6 a_13368_1044# VSS.t545 sg13_lv_nmos ad=0.2516p pd=2.16u as=0.1406p ps=1.12u w=0.74u l=0.13u
X352 VSS.t70 a_13123_1842# a_13557_1842# VSS.t157 sg13_lv_nmos ad=0.1406p pd=1.12u as=0.2516p ps=2.16u w=0.74u l=0.13u
X353 VDD VSS.t566 VDD VDD sg13_lv_pmos ad=0.34p pd=2.68u as=0 ps=0 w=1u l=1u
X354 VSS.t215 a_3171_1047.t3 a_24084_1008# VSS.t214 sg13_lv_nmos ad=0.2516p pd=2.16u as=0.2516p ps=2.16u w=0.74u l=0.13u
X355 a_25913_1842# a_25717_1842# VSS.t168 VSS.t167 sg13_lv_nmos ad=0.2516p pd=2.16u as=0.1406p ps=1.12u w=0.74u l=0.13u
X356 a_21353_1842# a_21157_1842# VDD VDD sg13_lv_pmos ad=0.3808p pd=2.92u as=0.2128p ps=1.5u w=1.12u l=0.13u
X357 VSS.t346 VDD VSS.t345 VSS.t344 sg13_lv_nmos ad=0.1428p pd=1.52u as=0 ps=0 w=0.42u l=1u
X358 a_2297_331# MUX_SEL2 VDD VDD sg13_lv_pmos ad=0.1596p pd=1.22u as=0.2856p ps=2.36u w=0.84u l=0.13u
X359 VDD a_7043_1842# a_7477_1842# VDD sg13_lv_pmos ad=0.2128p pd=1.5u as=0.3808p ps=2.92u w=1.12u l=0.13u
X360 a_2873_331# MUX_SEL3 VDD VDD sg13_lv_pmos ad=0.1596p pd=1.22u as=0.2856p ps=2.36u w=0.84u l=0.13u
X361 a_8155_1044# a_7945_1044# VDD VDD sg13_lv_pmos ad=0.2128p pd=1.5u as=0.252p ps=1.57u w=1.12u l=0.13u
X362 VSS.t199 a_18117_1842# a_18585_1044# VSS.t198 sg13_lv_nmos ad=0.1665p pd=1.19u as=0.2516p ps=2.16u w=0.74u l=0.13u
X363 a_27048_1044# a_26477_1842# VDD VDD sg13_lv_pmos ad=0.2128p pd=1.5u as=0.3808p ps=2.92u w=1.12u l=0.13u
X364 a_5768_1044# a_5197_1842# VDD VDD sg13_lv_pmos ad=0.2128p pd=1.5u as=0.3808p ps=2.92u w=1.12u l=0.13u
X365 a_13991_2470# a_13753_1842# a_13883_1842# VDD sg13_lv_pmos ad=0.2128p pd=1.5u as=0.3808p ps=2.92u w=1.12u l=0.2u
X366 VSS.t543 a_3171_1047.t6 a_14964_1008# VSS.t542 sg13_lv_nmos ad=0.2516p pd=2.16u as=0.2516p ps=2.16u w=0.74u l=0.13u
X367 VDD a_2019_311# a_17865_519# VDD sg13_lv_pmos ad=0.3808p pd=2.92u as=0.3808p ps=2.92u w=1.12u l=0.13u
X368 DELAY_OUT_LAST a_27997_1842# VSS.t394 VSS.t412 sg13_lv_nmos ad=0.2516p pd=2.16u as=0.1406p ps=1.12u w=0.74u l=0.13u
X369 a_11195_1044# a_10985_1044# VSS.t231 VSS.t230 sg13_lv_nmos ad=0.1406p pd=1.12u as=0.1665p ps=1.19u w=0.74u l=0.13u
X370 VDD a_24197_1842# a_24665_1044# VDD sg13_lv_pmos ad=0.252p pd=1.57u as=0.3808p ps=2.92u w=1.12u l=0.13u
X371 a_6913_1842# a_6717_1842# VSS.t191 VSS.t190 sg13_lv_nmos ad=0.2516p pd=2.16u as=0.1406p ps=1.12u w=0.74u l=0.13u
X372 VSS.t495 DELAY_VBIASN.t12 a_18551_1842# VSS.t494 sg13_lv_nmos ad=0.2516p pd=2.16u as=0.1406p ps=1.12u w=0.74u l=0.6u
X373 a_16510_1044# a_18004_1008# a_17928_1044# VDD sg13_lv_pmos ad=0.3808p pd=2.92u as=0.2128p ps=1.5u w=1.12u l=0.13u
X374 VDD a_12363_1842# a_12797_1842# VDD sg13_lv_pmos ad=0.2128p pd=1.5u as=0.3808p ps=2.92u w=1.12u l=0.13u
X375 VSS.t64 MUX_SEL3 a_3543_331# VSS.t205 sg13_lv_nmos ad=0.1331p pd=1.12u as=0.1216p ps=1.02u w=0.64u l=0.13u
X376 a_22590_1044# a_2595_1047.t3 a_23355_1044# VSS.t111 sg13_lv_nmos ad=0.2516p pd=2.16u as=0.1406p ps=1.12u w=0.74u l=0.13u
X377 VSS.t455 DELAY_VBIASN.t7 a_22351_1842# VSS.t454 sg13_lv_nmos ad=0.2516p pd=2.16u as=0.1406p ps=1.12u w=0.74u l=0.6u
X378 VDD a_3171_1047.t4 a_21044_1008# VDD sg13_lv_pmos ad=0.3808p pd=2.92u as=0.3808p ps=2.92u w=1.12u l=0.13u
X379 VDD VSS.t569 VDD VDD sg13_lv_pmos ad=0.19p pd=1.38u as=0 ps=0 w=1u l=1u
X380 a_16271_2470# a_16033_1842# a_16163_1842# VDD sg13_lv_pmos ad=0.2128p pd=1.5u as=0.3808p ps=2.92u w=1.12u l=0.2u
X381 VDD VSS.t583 VDD VDD sg13_lv_pmos ad=0.19p pd=1.38u as=0 ps=0 w=1u l=1u
X382 a_19833_1842# a_19637_1842# VSS.t422 VSS.t421 sg13_lv_nmos ad=0.2516p pd=2.16u as=0.1406p ps=1.12u w=0.74u l=0.13u
X383 VDD a_2019_311# a_5705_519# VDD sg13_lv_pmos ad=0.3808p pd=2.92u as=0.3808p ps=2.92u w=1.12u l=0.13u
X384 a_20071_2470# a_19833_1842# a_19963_1842# VDD sg13_lv_pmos ad=0.2128p pd=1.5u as=0.3808p ps=2.92u w=1.12u l=0.2u
X385 a_9193_1842# a_8997_1842# VSS.t520 VSS.t523 sg13_lv_nmos ad=0.2516p pd=2.16u as=0.1406p ps=1.12u w=0.74u l=0.13u
X386 a_24631_1842# a_24393_1842# a_24523_1842# VSS.t195 sg13_lv_nmos ad=0.1406p pd=1.12u as=0.2516p ps=2.16u w=0.74u l=0.2u
X387 VDD VSS.t582 VDD VDD sg13_lv_pmos ad=0.34p pd=2.68u as=0 ps=0 w=1u l=1u
X388 VSS.t116 a_2019_1047.t7 a_10404_1008# VSS.t115 sg13_lv_nmos ad=0.2516p pd=2.16u as=0.2516p ps=2.16u w=0.74u l=0.13u
X389 VDD a_14643_1842# a_15077_1842# VDD sg13_lv_pmos ad=0.2128p pd=1.5u as=0.3808p ps=2.92u w=1.12u l=0.13u
X390 VDD a_1544_289# a_2297_331# VDD sg13_lv_pmos ad=0.1918p pd=1.5u as=0.1596p ps=1.22u w=0.84u l=0.13u
X391 a_23633_1842# a_23437_1842# VSS.t392 VSS.t419 sg13_lv_nmos ad=0.2516p pd=2.16u as=0.1406p ps=1.12u w=0.74u l=0.13u
X392 VSS.t341 VDD VSS.t340 VSS.t339 sg13_lv_nmos ad=0.1428p pd=1.52u as=0 ps=0 w=0.42u l=1u
X393 a_2019_311# a_1721_331# VDD VDD sg13_lv_pmos ad=0.2128p pd=1.5u as=0.1918p ps=1.5u w=1.12u l=0.13u
X394 VSS.t172 a_9323_1842# a_9757_1842# VSS.t208 sg13_lv_nmos ad=0.1406p pd=1.12u as=0.2516p ps=2.16u w=0.74u l=0.13u
X395 a_26395_1044# a_26185_1044# VSS.t27 VSS.t26 sg13_lv_nmos ad=0.1406p pd=1.12u as=0.1665p ps=1.19u w=0.74u l=0.13u
X396 VDD DELAY_VBIASP.t13 a_17791_2470# VDD sg13_lv_pmos ad=0.3808p pd=2.92u as=0.2128p ps=1.5u w=1.12u l=0.6u
X397 VSS.t99 a_3747_1047.t3 a_24951_1008# VSS.t98 sg13_lv_nmos ad=0.2516p pd=2.16u as=0.2516p ps=2.16u w=0.74u l=0.13u
X398 VSS.t306 VDD VSS.t305 VSS.t304 sg13_lv_nmos ad=0.1428p pd=1.52u as=0 ps=0 w=0.42u l=1u
X399 VSS.t336 VDD VSS.t335 VSS.t334 sg13_lv_nmos ad=0.1428p pd=1.52u as=0 ps=0 w=0.42u l=1u
X400 a_3747_1047.t0 a_3449_1395# VDD VDD sg13_lv_pmos ad=0.2128p pd=1.5u as=0.1918p ps=1.5u w=1.12u l=0.13u
X401 a_13368_1044# a_12797_1842# VDD VDD sg13_lv_pmos ad=0.2128p pd=1.5u as=0.3808p ps=2.92u w=1.12u l=0.13u
X402 a_24008_1044# a_23437_1842# VSS.t418 VSS.t417 sg13_lv_nmos ad=0.1406p pd=1.12u as=0.2516p ps=2.16u w=0.74u l=0.13u
X403 VDD DELAY_VBIASP.t8 a_21591_2470# VDD sg13_lv_pmos ad=0.3808p pd=2.92u as=0.2128p ps=1.5u w=1.12u l=0.6u
X404 a_15964_289# MUX_SEL4 a_5731_289# VDD sg13_lv_pmos ad=0.3304p pd=1.71u as=0.3808p ps=2.92u w=1.12u l=0.13u
X405 a_4350_1044# a_6711_1008# a_6635_1044# VDD sg13_lv_pmos ad=0.3808p pd=2.92u as=0.2128p ps=1.5u w=1.12u l=0.13u
X406 a_2873_1395# MUX_SEL1 VDD VDD sg13_lv_pmos ad=0.1596p pd=1.22u as=0.2856p ps=2.36u w=0.84u l=0.13u
X407 a_1256_1044# MUX_SEL0 VSS.t511 VSS.t510 sg13_lv_nmos ad=0.2516p pd=2.16u as=0.2516p ps=2.16u w=0.74u l=0.13u
X408 VSS.t303 VDD VSS.t301 VSS.t302 sg13_lv_nmos ad=79.8f pd=0.8u as=0 ps=0 w=0.42u l=1u
X409 a_19550_1044# a_20391_1008# a_20315_1044# VDD sg13_lv_pmos ad=0.3808p pd=2.92u as=0.2128p ps=1.5u w=1.12u l=0.13u
X410 VDD VDD VDD VDD sg13_lv_pmos ad=0.2128p pd=1.5u as=0 ps=0 w=1.12u l=0.2u
X411 a_5631_1842# a_5393_1842# a_5523_1842# VSS.t534 sg13_lv_nmos ad=0.1406p pd=1.12u as=0.2516p ps=2.16u w=0.74u l=0.2u
X412 a_14513_1842# a_14317_1842# VSS.t433 VSS.t432 sg13_lv_nmos ad=0.2516p pd=2.16u as=0.1406p ps=1.12u w=0.74u l=0.13u
X413 VSS.t537 a_2595_311.t2 a_20905_519# VSS.t536 sg13_lv_nmos ad=0.2516p pd=2.16u as=0.2516p ps=2.16u w=0.74u l=0.13u
X414 VDD a_7477_1842# a_7945_1044# VDD sg13_lv_pmos ad=0.252p pd=1.57u as=0.3808p ps=2.92u w=1.12u l=0.13u
X415 a_13470_1044# a_3171_1047.t6 a_14888_1044# VSS.t541 sg13_lv_nmos ad=0.2516p pd=2.16u as=0.1406p ps=1.12u w=0.74u l=0.13u
X416 a_4633_1842# a_4437_1842# VSS.t186 VSS.t185 sg13_lv_nmos ad=0.2516p pd=2.16u as=0.1406p ps=1.12u w=0.74u l=0.13u
X417 a_1256_289# MUX_SEL2 VSS.t396 VSS.t395 sg13_lv_nmos ad=0.2516p pd=2.16u as=0.2516p ps=2.16u w=0.74u l=0.13u
X418 VSS.t238 a_2019_1047.t2 a_25604_1008# VSS.t237 sg13_lv_nmos ad=0.2516p pd=2.16u as=0.2516p ps=2.16u w=0.74u l=0.13u
X419 a_16108_289# MUX_SEL4 a_15964_289# VSS.t556 sg13_lv_nmos ad=0.2516p pd=2.16u as=0.2183p ps=1.33u w=0.74u l=0.13u
X420 a_22873_1842# a_22677_1842# VDD VDD sg13_lv_pmos ad=0.3808p pd=2.92u as=0.2128p ps=1.5u w=1.12u l=0.13u
X421 a_21835_1044# a_21625_1044# VSS.t83 VSS.t184 sg13_lv_nmos ad=0.1406p pd=1.12u as=0.1665p ps=1.19u w=0.74u l=0.13u
X422 VSS.t81 a_2595_1047.t4 a_20391_1008# VSS.t80 sg13_lv_nmos ad=0.2516p pd=2.16u as=0.2516p ps=2.16u w=0.74u l=0.13u
X423 a_9675_1044# a_9465_1044# VDD VDD sg13_lv_pmos ad=0.2128p pd=1.5u as=0.252p ps=1.57u w=1.12u l=0.13u
X424 VSS.t231 a_10517_1842# a_10985_1044# VSS.t516 sg13_lv_nmos ad=0.1665p pd=1.19u as=0.2516p ps=2.16u w=0.74u l=0.13u
X425 VDD a_2595_1047.t8 a_8231_1008# VDD sg13_lv_pmos ad=0.3808p pd=2.92u as=0.3808p ps=2.92u w=1.12u l=0.13u
X426 a_18551_1842# a_18313_1842# a_18443_1842# VSS.t530 sg13_lv_nmos ad=0.1406p pd=1.12u as=0.2516p ps=2.16u w=0.74u l=0.2u
X427 a_22351_1842# a_22113_1842# a_22243_1842# VSS.t59 sg13_lv_nmos ad=0.1406p pd=1.12u as=0.2516p ps=2.16u w=0.74u l=0.2u
X428 VSS.t540 a_3747_1047.t5 a_18871_1008# VSS.t539 sg13_lv_nmos ad=0.2516p pd=2.16u as=0.2516p ps=2.16u w=0.74u l=0.13u
X429 VSS.t91 a_16923_1842# a_17357_1842# VSS.t560 sg13_lv_nmos ad=0.1406p pd=1.12u as=0.2516p ps=2.16u w=0.74u l=0.13u
X430 VDD a_3171_311.t2 a_23945_519# VDD sg13_lv_pmos ad=0.3808p pd=2.92u as=0.3808p ps=2.92u w=1.12u l=0.13u
X431 a_2019_311# a_1721_331# VSS.t121 VSS.t120 sg13_lv_nmos ad=0.1406p pd=1.12u as=0.1331p ps=1.12u w=0.74u l=0.13u
X432 a_25153_1842# a_24957_1842# VDD VDD sg13_lv_pmos ad=0.3808p pd=2.92u as=0.2128p ps=1.5u w=1.12u l=0.13u
X433 a_17928_1044# a_17357_1842# VSS.t93 VSS.t92 sg13_lv_nmos ad=0.1406p pd=1.12u as=0.2516p ps=2.16u w=0.74u l=0.13u
X434 a_12715_1044# a_12505_1044# VSS.t283 VSS.t544 sg13_lv_nmos ad=0.1406p pd=1.12u as=0.1665p ps=1.19u w=0.74u l=0.13u
X435 VDD MUX_SEL4 a_15765_463# VDD sg13_lv_pmos ad=0.3808p pd=2.92u as=0.3808p ps=2.92u w=1.12u l=0.13u
X436 a_19550_1044# a_3171_1047.t4 a_20968_1044# VSS.t253 sg13_lv_nmos ad=0.2516p pd=2.16u as=0.1406p ps=1.12u w=0.74u l=0.13u
X437 VSS.t467 DELAY_VBIASN.t22 a_10951_1842# VSS.t466 sg13_lv_nmos ad=0.2516p pd=2.16u as=0.1406p ps=1.12u w=0.74u l=0.6u
X438 a_19550_1044# a_19524_1008# a_19448_1044# VDD sg13_lv_pmos ad=0.3808p pd=2.92u as=0.2128p ps=1.5u w=1.12u l=0.13u
X439 a_7288_1044# a_6717_1842# VSS.t189 VSS.t188 sg13_lv_nmos ad=0.1406p pd=1.12u as=0.2516p ps=2.16u w=0.74u l=0.13u
X440 VSS.t85 a_20723_1842# a_21157_1842# VSS.t206 sg13_lv_nmos ad=0.1406p pd=1.12u as=0.2516p ps=2.16u w=0.74u l=0.13u
X441 a_1544_289# MUX_SEL3 VSS.t203 VSS.t202 sg13_lv_nmos ad=0.2516p pd=2.16u as=0.2516p ps=2.16u w=0.74u l=0.13u
X442 a_13470_1044# a_14311_1008# a_14235_1044# VDD sg13_lv_pmos ad=0.3808p pd=2.92u as=0.2128p ps=1.5u w=1.12u l=0.13u
X443 a_22590_1044# a_3747_1047.t3 a_24875_1044# VSS.t97 sg13_lv_nmos ad=0.2516p pd=2.16u as=0.1406p ps=1.12u w=0.74u l=0.13u
X444 VSS.t451 DELAY_VBIASN.t5 a_23871_1842# VSS.t450 sg13_lv_nmos ad=0.2516p pd=2.16u as=0.1406p ps=1.12u w=0.74u l=0.6u
X445 VDD a_2019_1047.t3 a_22564_1008# VDD sg13_lv_pmos ad=0.3808p pd=2.92u as=0.3808p ps=2.92u w=1.12u l=0.13u
X446 VSS.t27 a_25717_1842# a_26185_1044# VSS.t166 sg13_lv_nmos ad=0.1665p pd=1.19u as=0.2516p ps=2.16u w=0.74u l=0.13u
X447 a_13231_1842# a_12993_1842# a_13123_1842# VSS.t406 sg13_lv_nmos ad=0.1406p pd=1.12u as=0.2516p ps=2.16u w=0.74u l=0.2u
X448 VSS.t298 VDD VSS.t296 VSS.t297 sg13_lv_nmos ad=79.8f pd=0.8u as=0 ps=0 w=0.42u l=1u
X449 a_17791_2470# a_17553_1842# a_17683_1842# VDD sg13_lv_pmos ad=0.2128p pd=1.5u as=0.3808p ps=2.92u w=1.12u l=0.2u
X450 VSS.t58 a_4437_1842# a_4905_1044# VSS.t187 sg13_lv_nmos ad=0.1665p pd=1.19u as=0.2516p ps=2.16u w=0.74u l=0.13u
X451 VDD VSS.t570 VDD VDD sg13_lv_pmos ad=0.34p pd=2.68u as=0 ps=0 w=1u l=1u
X452 a_12233_1842# a_12037_1842# VSS.t210 VSS.t281 sg13_lv_nmos ad=0.2516p pd=2.16u as=0.1406p ps=1.12u w=0.74u l=0.13u
X453 VSS.t132 a_3449_1395# a_3747_1047.t1 VSS.t131 sg13_lv_nmos ad=0.2812p pd=2.24u as=0.1406p ps=1.12u w=0.74u l=0.13u
X454 VDD VSS.t584 VDD VDD sg13_lv_pmos ad=0.34p pd=2.68u as=0 ps=0 w=1u l=1u
X455 VDD VSS.t579 VDD VDD sg13_lv_pmos ad=0.19p pd=1.38u as=0 ps=0 w=1u l=1u
X456 VSS.t363 VDD VSS.t361 VSS.t362 sg13_lv_nmos ad=79.8f pd=0.8u as=0 ps=0 w=0.42u l=1u
X457 VSS.t258 a_3171_1047.t8 a_8884_1008# VSS.t257 sg13_lv_nmos ad=0.2516p pd=2.16u as=0.2516p ps=2.16u w=0.74u l=0.13u
X458 a_21591_2470# a_21353_1842# a_21483_1842# VDD sg13_lv_pmos ad=0.2128p pd=1.5u as=0.3808p ps=2.92u w=1.12u l=0.2u
X459 VDD a_2873_1395# a_3171_1047.t0 VDD sg13_lv_pmos ad=0.4256p pd=3u as=0.2128p ps=1.5u w=1.12u l=0.13u
X460 a_6153_1842# a_5957_1842# VDD VDD sg13_lv_pmos ad=0.3808p pd=2.92u as=0.2128p ps=1.5u w=1.12u l=0.13u
X461 VDD a_16163_1842# a_16597_1842# VDD sg13_lv_pmos ad=0.2128p pd=1.5u as=0.3808p ps=2.92u w=1.12u l=0.13u
X462 a_3543_1395# MUX_SEL0 a_3449_1395# VSS.t513 sg13_lv_nmos ad=0.1216p pd=1.02u as=0.2176p ps=1.96u w=0.64u l=0.13u
X463 VDD a_1544_1044# a_2297_1395# VDD sg13_lv_pmos ad=0.1918p pd=1.5u as=0.1596p ps=1.22u w=0.84u l=0.13u
X464 VDD DELAY_VBIASP.t23 a_10191_2470# VDD sg13_lv_pmos ad=0.3808p pd=2.92u as=0.2128p ps=1.5u w=1.12u l=0.6u
X465 a_17275_1044# a_17065_1044# VDD VDD sg13_lv_pmos ad=0.2128p pd=1.5u as=0.252p ps=1.57u w=1.12u l=0.13u
X466 a_2019_1047.t0 a_1721_1395# VDD VDD sg13_lv_pmos ad=0.2128p pd=1.5u as=0.1918p ps=1.5u w=1.12u l=0.13u
X467 a_27915_1044# a_27705_1044# VSS.t42 VSS.t150 sg13_lv_nmos ad=0.1406p pd=1.12u as=0.1665p ps=1.19u w=0.74u l=0.13u
X468 VSS.t485 DELAY_VBIASN.t2 a_26151_1842# VSS.t484 sg13_lv_nmos ad=0.2516p pd=2.16u as=0.1406p ps=1.12u w=0.74u l=0.6u
X469 VDD a_3747_1047.t6 a_15831_1008# VDD sg13_lv_pmos ad=0.3808p pd=2.92u as=0.3808p ps=2.92u w=1.12u l=0.13u
X470 VDD a_19963_1842# a_20397_1842# VDD sg13_lv_pmos ad=0.2128p pd=1.5u as=0.3808p ps=2.92u w=1.12u l=0.13u
X471 VSS.t366 VDD VSS.t365 VSS.t364 sg13_lv_nmos ad=0.1428p pd=1.52u as=0 ps=0 w=0.42u l=1u
X472 VSS.t459 DELAY_VBIASN.t30 a_4871_1842# VSS.t458 sg13_lv_nmos ad=0.2516p pd=2.16u as=0.1406p ps=1.12u w=0.74u l=0.6u
X473 a_14888_1044# a_14317_1842# VDD VDD sg13_lv_pmos ad=0.2128p pd=1.5u as=0.3808p ps=2.92u w=1.12u l=0.13u
X474 a_4350_1044# a_4324_1008# a_4248_1044# VDD sg13_lv_pmos ad=0.3808p pd=2.92u as=0.2128p ps=1.5u w=1.12u l=0.13u
X475 a_1256_289# MUX_SEL2 VDD VDD sg13_lv_pmos ad=0.3808p pd=2.92u as=0.3808p ps=2.92u w=1.12u l=0.13u
X476 VSS.t387 VSS.t384 VSS.t386 VSS.t385 sg13_lv_nmos ad=0.2516p pd=2.16u as=0 ps=0 w=0.74u l=0.6u
X477 a_16108_289# a_15765_463# a_15964_289# VDD sg13_lv_pmos ad=0.3808p pd=2.92u as=0.3304p ps=1.71u w=1.12u l=0.13u
X478 a_11473_1842# a_11277_1842# VDD VDD sg13_lv_pmos ad=0.3808p pd=2.92u as=0.2128p ps=1.5u w=1.12u l=0.13u
X479 VDD a_8997_1842# a_9465_1044# VDD sg13_lv_pmos ad=0.252p pd=1.57u as=0.3808p ps=2.92u w=1.12u l=0.13u
X480 a_27433_1842# a_27237_1842# VSS.t38 VSS.t43 sg13_lv_nmos ad=0.2516p pd=2.16u as=0.1406p ps=1.12u w=0.74u l=0.13u
X481 a_2391_331# MUX_SEL2 a_2297_331# VSS.t397 sg13_lv_nmos ad=0.1216p pd=1.02u as=0.2176p ps=1.96u w=0.64u l=0.13u
X482 a_2967_331# MUX_SEL3 a_2873_331# VSS.t204 sg13_lv_nmos ad=0.1216p pd=1.02u as=0.2176p ps=1.96u w=0.64u l=0.13u
X483 VDD a_2019_1047.t5 a_16484_1008# VDD sg13_lv_pmos ad=0.3808p pd=2.92u as=0.3808p ps=2.92u w=1.12u l=0.13u
X484 a_7390_1044# a_2595_1047.t8 a_8155_1044# VSS.t10 sg13_lv_nmos ad=0.2516p pd=2.16u as=0.1406p ps=1.12u w=0.74u l=0.13u
X485 VSS.t463 DELAY_VBIASN.t27 a_7151_1842# VSS.t462 sg13_lv_nmos ad=0.2516p pd=2.16u as=0.1406p ps=1.12u w=0.74u l=0.6u
X486 VDD a_3171_1047.t9 a_5844_1008# VDD sg13_lv_pmos ad=0.3808p pd=2.92u as=0.3808p ps=2.92u w=1.12u l=0.13u
X487 VDD DELAY_VBIASP.t3 a_25391_2470# VDD sg13_lv_pmos ad=0.3808p pd=2.92u as=0.2128p ps=1.5u w=1.12u l=0.6u
X488 VDD a_2595_1047.t7 a_11271_1008# VDD sg13_lv_pmos ad=0.3808p pd=2.92u as=0.3808p ps=2.92u w=1.12u l=0.13u
X489 VDD VSS.t587 VDD VDD sg13_lv_pmos ad=0.19p pd=1.38u as=0 ps=0 w=1u l=1u
X490 VSS.t283 a_12037_1842# a_12505_1044# VSS.t282 sg13_lv_nmos ad=0.1665p pd=1.19u as=0.2516p ps=2.16u w=0.74u l=0.13u
X491 VDD a_3747_1047.t8 a_9751_1008# VDD sg13_lv_pmos ad=0.3808p pd=2.92u as=0.3808p ps=2.92u w=1.12u l=0.13u
X492 a_9431_1842# a_9193_1842# a_9323_1842# VSS.t35 sg13_lv_nmos ad=0.1406p pd=1.12u as=0.2516p ps=2.16u w=0.74u l=0.2u
X493 a_18313_1842# a_18117_1842# VSS.t197 VSS.t196 sg13_lv_nmos ad=0.2516p pd=2.16u as=0.1406p ps=1.12u w=0.74u l=0.13u
X494 MUX_OUT a_16851_309# VSS.t32 VSS.t31 sg13_lv_nmos ad=0.1406p pd=1.12u as=0.1371p ps=1.12u w=0.74u l=0.13u
X495 VSS.t358 VDD VSS.t356 VSS.t357 sg13_lv_nmos ad=79.8f pd=0.8u as=0 ps=0 w=0.42u l=1u
X496 a_23871_1842# a_23633_1842# a_23763_1842# VSS.t124 sg13_lv_nmos ad=0.1406p pd=1.12u as=0.2516p ps=2.16u w=0.74u l=0.2u
X497 a_8433_1842# a_8237_1842# VSS.t269 VSS.t424 sg13_lv_nmos ad=0.2516p pd=2.16u as=0.1406p ps=1.12u w=0.74u l=0.13u
X498 VSS.t163 a_18443_1842# a_18877_1842# VSS.t518 sg13_lv_nmos ad=0.1406p pd=1.12u as=0.2516p ps=2.16u w=0.74u l=0.13u
X499 VSS.t323 VDD VSS.t321 VSS.t322 sg13_lv_nmos ad=79.8f pd=0.8u as=0 ps=0 w=0.42u l=1u
X500 a_22113_1842# a_21917_1842# VSS.t408 VSS.t505 sg13_lv_nmos ad=0.2516p pd=2.16u as=0.1406p ps=1.12u w=0.74u l=0.13u
X501 a_1544_289# MUX_SEL3 VDD VDD sg13_lv_pmos ad=0.3808p pd=2.92u as=0.3808p ps=2.92u w=1.12u l=0.13u
X502 a_26673_1842# a_26477_1842# VDD VDD sg13_lv_pmos ad=0.3808p pd=2.92u as=0.2128p ps=1.5u w=1.12u l=0.13u
X503 a_10328_1044# a_9757_1842# VSS.t170 VSS.t169 sg13_lv_nmos ad=0.1406p pd=1.12u as=0.2516p ps=2.16u w=0.74u l=0.13u
X504 VSS.t326 VDD VSS.t325 VSS.t324 sg13_lv_nmos ad=0.1428p pd=1.52u as=0 ps=0 w=0.42u l=1u
X505 a_22590_1044# a_2019_1047.t3 a_22488_1044# VSS.t548 sg13_lv_nmos ad=0.2516p pd=2.16u as=0.1406p ps=1.12u w=0.74u l=0.13u
X506 VSS.t447 DELAY_VBIASN.t20 a_12471_1842# VSS.t446 sg13_lv_nmos ad=0.2516p pd=2.16u as=0.1406p ps=1.12u w=0.74u l=0.6u
X507 a_8808_1044# a_8237_1842# VSS.t426 VSS.t425 sg13_lv_nmos ad=0.1406p pd=1.12u as=0.2516p ps=2.16u w=0.74u l=0.13u
X508 VSS.t414 a_22243_1842# a_22677_1842# VSS.t427 sg13_lv_nmos ad=0.1406p pd=1.12u as=0.2516p ps=2.16u w=0.74u l=0.13u
X509 VDD DELAY_VBIASP.t28 a_6391_2470# VDD sg13_lv_pmos ad=0.3808p pd=2.92u as=0.2128p ps=1.5u w=1.12u l=0.6u
X510 a_13470_1044# a_15831_1008# a_15755_1044# VDD sg13_lv_pmos ad=0.3808p pd=2.92u as=0.2128p ps=1.5u w=1.12u l=0.13u
X511 a_1544_1044# MUX_SEL1 VDD VDD sg13_lv_pmos ad=0.3808p pd=2.92u as=0.3808p ps=2.92u w=1.12u l=0.13u
X512 VDD DELAY_VBIASP.t9 a_20831_2470# VDD sg13_lv_pmos ad=0.3808p pd=2.92u as=0.2128p ps=1.5u w=1.12u l=0.6u
X513 VDD a_2595_1047.t2 a_26471_1008# VDD sg13_lv_pmos ad=0.3808p pd=2.92u as=0.3808p ps=2.92u w=1.12u l=0.13u
X514 a_4350_1044# a_5191_1008# a_5115_1044# VDD sg13_lv_pmos ad=0.3808p pd=2.92u as=0.2128p ps=1.5u w=1.12u l=0.13u
X515 VDD a_16597_1842# a_17065_1044# VDD sg13_lv_pmos ad=0.252p pd=1.57u as=0.3808p ps=2.92u w=1.12u l=0.13u
X516 VSS.t42 a_27237_1842# a_27705_1044# VSS.t41 sg13_lv_nmos ad=0.1665p pd=1.19u as=0.2516p ps=2.16u w=0.74u l=0.13u
X517 a_10191_2470# a_9953_1842# a_10083_1842# VDD sg13_lv_pmos ad=0.2128p pd=1.5u as=0.3808p ps=2.92u w=1.12u l=0.2u
X518 a_2595_1047.t1 a_2297_1395# VSS.t54 VSS.t53 sg13_lv_nmos ad=0.1406p pd=1.12u as=0.1331p ps=1.12u w=0.74u l=0.13u
X519 a_26151_1842# a_25913_1842# a_26043_1842# VSS.t40 sg13_lv_nmos ad=0.1406p pd=1.12u as=0.2516p ps=2.16u w=0.74u l=0.2u
X520 VSS.t178 a_2019_311# a_17865_519# VSS.t177 sg13_lv_nmos ad=0.2516p pd=2.16u as=0.2516p ps=2.16u w=0.74u l=0.13u
X521 VSS.t154 a_1544_289# a_2391_331# VSS.t561 sg13_lv_nmos ad=0.1331p pd=1.12u as=0.1216p ps=1.02u w=0.64u l=0.13u
X522 a_4871_1842# a_4633_1842# a_4763_1842# VSS.t36 sg13_lv_nmos ad=0.1406p pd=1.12u as=0.2516p ps=2.16u w=0.74u l=0.2u
X523 a_13753_1842# a_13557_1842# VSS.t70 VSS.t69 sg13_lv_nmos ad=0.2516p pd=2.16u as=0.1406p ps=1.12u w=0.74u l=0.13u
X524 a_1815_1395# a_1256_1044# a_1721_1395# VSS.t20 sg13_lv_nmos ad=0.1216p pd=1.02u as=0.2176p ps=1.96u w=0.64u l=0.13u
X525 a_7673_1842# a_7477_1842# VDD VDD sg13_lv_pmos ad=0.3808p pd=2.92u as=0.2128p ps=1.5u w=1.12u l=0.13u
X526 VDD VSS.t580 VDD VDD sg13_lv_pmos ad=0.34p pd=2.68u as=0 ps=0 w=1u l=1u
X527 a_1721_331# a_1256_289# VDD VDD sg13_lv_pmos ad=0.1596p pd=1.22u as=0.2856p ps=2.36u w=0.84u l=0.13u
X528 VSS.t128 a_24523_1842# a_24957_1842# VSS.t439 sg13_lv_nmos ad=0.1406p pd=1.12u as=0.2516p ps=2.16u w=0.74u l=0.13u
X529 a_6635_1044# a_6425_1044# VSS.t149 VSS.t148 sg13_lv_nmos ad=0.1406p pd=1.12u as=0.1665p ps=1.19u w=0.74u l=0.13u
X530 VSS.t264 a_2595_1047.t9 a_5191_1008# VSS.t263 sg13_lv_nmos ad=0.2516p pd=2.16u as=0.2516p ps=2.16u w=0.74u l=0.13u
X531 a_20315_1044# a_20105_1044# VSS.t152 VSS.t151 sg13_lv_nmos ad=0.1406p pd=1.12u as=0.1665p ps=1.19u w=0.74u l=0.13u
X532 VDD DELAY_VBIASP.t21 a_11711_2470# VDD sg13_lv_pmos ad=0.3808p pd=2.92u as=0.2128p ps=1.5u w=1.12u l=0.6u
X533 a_18795_1044# a_18585_1044# VDD VDD sg13_lv_pmos ad=0.2128p pd=1.5u as=0.252p ps=1.57u w=1.12u l=0.13u
X534 a_25528_1044# a_24957_1842# VSS.t126 VSS.t125 sg13_lv_nmos ad=0.1406p pd=1.12u as=0.2516p ps=2.16u w=0.74u l=0.13u
X535 VSS.t503 DELAY_VBIASN.t0 a_27671_1842# VSS.t502 sg13_lv_nmos ad=0.2516p pd=2.16u as=0.1406p ps=1.12u w=0.74u l=0.6u
X536 a_5731_289# a_3747_311.t3 a_13470_1044# VSS.t239 sg13_lv_nmos ad=0.2516p pd=2.16u as=0.2516p ps=2.16u w=0.74u l=0.13u
X537 a_25630_1044# a_27124_1008# a_27048_1044# VDD sg13_lv_pmos ad=0.3808p pd=2.92u as=0.2128p ps=1.5u w=1.12u l=0.13u
X538 VDD a_2595_1047.t5 a_17351_1008# VDD sg13_lv_pmos ad=0.3808p pd=2.92u as=0.3808p ps=2.92u w=1.12u l=0.13u
X539 VDD a_21483_1842# a_21917_1842# VDD sg13_lv_pmos ad=0.2128p pd=1.5u as=0.3808p ps=2.92u w=1.12u l=0.13u
X540 a_4350_1044# a_5844_1008# a_5768_1044# VDD sg13_lv_pmos ad=0.3808p pd=2.92u as=0.2128p ps=1.5u w=1.12u l=0.13u
X541 VSS.t34 a_16851_309# MUX_OUT VSS.t33 sg13_lv_nmos ad=0.2516p pd=2.16u as=0.1406p ps=1.12u w=0.74u l=0.13u
X542 VSS.t175 a_2019_311# a_5705_519# VSS.t174 sg13_lv_nmos ad=0.2516p pd=2.16u as=0.2516p ps=2.16u w=0.74u l=0.13u
X543 VDD a_1544_289# a_1721_331# VDD sg13_lv_pmos ad=0.1918p pd=1.5u as=0.1596p ps=1.22u w=0.84u l=0.13u
X544 a_7151_1842# a_6913_1842# a_7043_1842# VSS.t555 sg13_lv_nmos ad=0.1406p pd=1.12u as=0.2516p ps=2.16u w=0.74u l=0.2u
X545 a_16033_1842# a_15837_1842# VSS.t161 VSS.t160 sg13_lv_nmos ad=0.2516p pd=2.16u as=0.1406p ps=1.12u w=0.74u l=0.13u
X546 MUX_OUT a_16851_309# VDD VDD sg13_lv_pmos ad=0.2128p pd=1.5u as=0.2086p ps=1.5u w=1.12u l=0.13u
X547 a_25391_2470# a_25153_1842# a_25283_1842# VDD sg13_lv_pmos ad=0.2128p pd=1.5u as=0.3808p ps=2.92u w=1.12u l=0.2u
X548 VDD VSS.t592 VDD VDD sg13_lv_pmos ad=0.34p pd=2.68u as=0 ps=0 w=1u l=1u
X549 a_12993_1842# a_12797_1842# VDD VDD sg13_lv_pmos ad=0.3808p pd=2.92u as=0.2128p ps=1.5u w=1.12u l=0.13u
X550 a_16408_1044# a_15837_1842# VSS.t159 VSS.t158 sg13_lv_nmos ad=0.1406p pd=1.12u as=0.2516p ps=2.16u w=0.74u l=0.13u
X551 VSS.t436 a_5523_1842# a_5957_1842# VSS.t559 sg13_lv_nmos ad=0.1406p pd=1.12u as=0.2516p ps=2.16u w=0.74u l=0.13u
X552 VDD DELAY_VBIASP.t18 a_13991_2470# VDD sg13_lv_pmos ad=0.3808p pd=2.92u as=0.2128p ps=1.5u w=1.12u l=0.6u
X553 a_5731_289# a_2019_311# a_4350_1044# VSS.t173 sg13_lv_nmos ad=0.2516p pd=2.16u as=0.2516p ps=2.16u w=0.74u l=0.13u
X554 a_7390_1044# a_3747_1047.t8 a_9675_1044# VSS.t222 sg13_lv_nmos ad=0.2516p pd=2.16u as=0.1406p ps=1.12u w=0.74u l=0.13u
X555 VDD a_23763_1842# a_24197_1842# VDD sg13_lv_pmos ad=0.2128p pd=1.5u as=0.3808p ps=2.92u w=1.12u l=0.13u
X556 VSS.t465 DELAY_VBIASN.t25 a_8671_1842# VSS.t464 sg13_lv_nmos ad=0.2516p pd=2.16u as=0.1406p ps=1.12u w=0.74u l=0.6u
X557 VDD a_2019_1047.t8 a_7364_1008# VDD sg13_lv_pmos ad=0.3808p pd=2.92u as=0.3808p ps=2.92u w=1.12u l=0.13u
X558 VDD DELAY_VBIASP.t1 a_26911_2470# VDD sg13_lv_pmos ad=0.3808p pd=2.92u as=0.2128p ps=1.5u w=1.12u l=0.6u
X559 VDD VSS.t563 VDD VDD sg13_lv_pmos ad=0.19p pd=1.38u as=0 ps=0 w=1u l=1u
X560 a_12471_1842# a_12233_1842# a_12363_1842# VSS.t376 sg13_lv_nmos ad=0.1406p pd=1.12u as=0.2516p ps=2.16u w=0.74u l=0.2u
X561 a_22488_1044# a_21917_1842# VDD VDD sg13_lv_pmos ad=0.2128p pd=1.5u as=0.3808p ps=2.92u w=1.12u l=0.13u
X562 VDD a_2595_311.t3 a_8745_519# VDD sg13_lv_pmos ad=0.3808p pd=2.92u as=0.3808p ps=2.92u w=1.12u l=0.13u
X563 VSS.t141 a_3171_1047.t5 a_18004_1008# VSS.t140 sg13_lv_nmos ad=0.2516p pd=2.16u as=0.2516p ps=2.16u w=0.74u l=0.13u
X564 a_6391_2470# a_6153_1842# a_6283_1842# VDD sg13_lv_pmos ad=0.2128p pd=1.5u as=0.3808p ps=2.92u w=1.12u l=0.2u
X565 a_15273_1842# a_15077_1842# VDD VDD sg13_lv_pmos ad=0.3808p pd=2.92u as=0.2128p ps=1.5u w=1.12u l=0.13u
X566 a_14235_1044# a_14025_1044# VSS.t68 VSS.t133 sg13_lv_nmos ad=0.1406p pd=1.12u as=0.1665p ps=1.19u w=0.74u l=0.13u
X567 VSS.t52 a_3747_1047.t7 a_12791_1008# VSS.t51 sg13_lv_nmos ad=0.2516p pd=2.16u as=0.2516p ps=2.16u w=0.74u l=0.13u
X568 a_9953_1842# a_9757_1842# VSS.t172 VSS.t171 sg13_lv_nmos ad=0.2516p pd=2.16u as=0.1406p ps=1.12u w=0.74u l=0.13u
X569 VSS.t9 a_10843_1842# a_11277_1842# VSS.t60 sg13_lv_nmos ad=0.1406p pd=1.12u as=0.2516p ps=2.16u w=0.74u l=0.13u
X570 VSS.t356 VDD VSS.t355 VSS.t354 sg13_lv_nmos ad=0.1428p pd=1.52u as=0 ps=0 w=0.42u l=1u
X571 VDD a_15403_1842# a_15837_1842# VDD sg13_lv_pmos ad=0.2128p pd=1.5u as=0.3808p ps=2.92u w=1.12u l=0.13u
X572 VSS.t321 VDD VSS.t320 VSS.t319 sg13_lv_nmos ad=0.1428p pd=1.52u as=0 ps=0 w=0.42u l=1u
X573 a_11848_1044# a_11277_1842# VSS.t7 VSS.t6 sg13_lv_nmos ad=0.1406p pd=1.12u as=0.2516p ps=2.16u w=0.74u l=0.13u
X574 VDD a_4763_1842# a_5197_1842# VDD sg13_lv_pmos ad=0.2128p pd=1.5u as=0.3808p ps=2.92u w=1.12u l=0.13u
X575 VSS.t333 VDD VSS.t331 VSS.t332 sg13_lv_nmos ad=79.8f pd=0.8u as=0 ps=0 w=0.42u l=1u
X576 a_13470_1044# a_13444_1008# a_13368_1044# VDD sg13_lv_pmos ad=0.3808p pd=2.92u as=0.2128p ps=1.5u w=1.12u l=0.13u
X577 VDD a_3449_1395# a_3747_1047.t0 VDD sg13_lv_pmos ad=0.4256p pd=3u as=0.2128p ps=1.5u w=1.12u l=0.13u
X578 VDD a_3171_1047.t3 a_24084_1008# VDD sg13_lv_pmos ad=0.3808p pd=2.92u as=0.3808p ps=2.92u w=1.12u l=0.13u
X579 a_3449_1395# MUX_SEL0 VDD VDD sg13_lv_pmos ad=0.1596p pd=1.22u as=0.2856p ps=2.36u w=0.84u l=0.13u
X580 VDD DELAY_VBIASP.t26 a_7911_2470# VDD sg13_lv_pmos ad=0.3808p pd=2.92u as=0.2128p ps=1.5u w=1.12u l=0.6u
X581 VDD VSS.t595 VDD VDD sg13_lv_pmos ad=0.19p pd=1.38u as=0 ps=0 w=1u l=1u
X582 VDD VSS.t594 VDD VDD sg13_lv_pmos ad=0.34p pd=2.68u as=0 ps=0 w=1u l=1u
X583 VDD a_16851_309# MUX_OUT VDD sg13_lv_pmos ad=0.7336p pd=3.55u as=0.2128p ps=1.5u w=1.12u l=0.13u
X584 VSS.t147 a_3171_311.t2 a_23945_519# VSS.t146 sg13_lv_nmos ad=0.2516p pd=2.16u as=0.2516p ps=2.16u w=0.74u l=0.13u
X585 VDD a_18117_1842# a_18585_1044# VDD sg13_lv_pmos ad=0.252p pd=1.57u as=0.3808p ps=2.92u w=1.12u l=0.13u
X586 VSS.t152 a_19637_1842# a_20105_1044# VSS.t420 sg13_lv_nmos ad=0.1665p pd=1.19u as=0.2516p ps=2.16u w=0.74u l=0.13u
X587 a_11711_2470# a_11473_1842# a_11603_1842# VDD sg13_lv_pmos ad=0.2128p pd=1.5u as=0.3808p ps=2.92u w=1.12u l=0.2u
X588 a_27671_1842# a_27433_1842# a_27563_1842# VSS.t401 sg13_lv_nmos ad=0.1406p pd=1.12u as=0.2516p ps=2.16u w=0.74u l=0.2u
X589 VSS.t558 MUX_SEL4 a_15765_463# VSS.t557 sg13_lv_nmos ad=0.2516p pd=2.16u as=0.2516p ps=2.16u w=0.74u l=0.13u
X590 a_5731_289# a_14825_519# a_13470_1044# VDD sg13_lv_pmos ad=0.3808p pd=2.92u as=0.3808p ps=2.92u w=1.12u l=0.13u
X591 a_16510_1044# a_2595_1047.t5 a_17275_1044# VSS.t142 sg13_lv_nmos ad=0.2516p pd=2.16u as=0.1406p ps=1.12u w=0.74u l=0.13u
X592 VSS.t493 DELAY_VBIASN.t15 a_16271_1842# VSS.t492 sg13_lv_nmos ad=0.2516p pd=2.16u as=0.1406p ps=1.12u w=0.74u l=0.6u
X593 VDD VSS.t568 VDD VDD sg13_lv_pmos ad=0.34p pd=2.68u as=0 ps=0 w=1u l=1u
X594 VDD a_3171_1047.t6 a_14964_1008# VDD sg13_lv_pmos ad=0.3808p pd=2.92u as=0.3808p ps=2.92u w=1.12u l=0.13u
X595 VDD a_10083_1842# a_10517_1842# VDD sg13_lv_pmos ad=0.2128p pd=1.5u as=0.3808p ps=2.92u w=1.12u l=0.13u
X596 VSS.t49 a_3747_1047.t2 a_27991_1008# VSS.t48 sg13_lv_nmos ad=0.2516p pd=2.16u as=0.2516p ps=2.16u w=0.74u l=0.13u
X597 VSS.t45 a_26043_1842# a_26477_1842# VSS.t44 sg13_lv_nmos ad=0.1406p pd=1.12u as=0.2516p ps=2.16u w=0.74u l=0.13u
X598 a_11195_1044# a_10985_1044# VDD VDD sg13_lv_pmos ad=0.2128p pd=1.5u as=0.252p ps=1.57u w=1.12u l=0.13u
X599 VSS.t2 a_3747_1047.t9 a_6711_1008# VSS.t1 sg13_lv_nmos ad=0.2516p pd=2.16u as=0.2516p ps=2.16u w=0.74u l=0.13u
X600 a_16108_289# a_2595_311.t2 a_19550_1044# VSS.t535 sg13_lv_nmos ad=0.2516p pd=2.16u as=0.2516p ps=2.16u w=0.74u l=0.13u
X601 VSS.t497 DELAY_VBIASN.t10 a_20071_1842# VSS.t496 sg13_lv_nmos ad=0.2516p pd=2.16u as=0.1406p ps=1.12u w=0.74u l=0.6u
X602 VDD DELAY_VBIASP.t4 a_24631_2470# VDD sg13_lv_pmos ad=0.3808p pd=2.92u as=0.2128p ps=1.5u w=1.12u l=0.6u
X603 a_22590_1044# a_23431_1008# a_23355_1044# VDD sg13_lv_pmos ad=0.3808p pd=2.92u as=0.2128p ps=1.5u w=1.12u l=0.13u
X604 VSS.t313 VDD VSS.t311 VSS.t312 sg13_lv_nmos ad=79.8f pd=0.8u as=0 ps=0 w=0.42u l=1u
X605 a_8671_1842# a_8433_1842# a_8563_1842# VSS.t183 sg13_lv_nmos ad=0.1406p pd=1.12u as=0.2516p ps=2.16u w=0.74u l=0.2u
X606 a_17553_1842# a_17357_1842# VSS.t91 VSS.t90 sg13_lv_nmos ad=0.2516p pd=2.16u as=0.1406p ps=1.12u w=0.74u l=0.13u
X607 a_5731_289# a_5705_519# a_4350_1044# VDD sg13_lv_pmos ad=0.3808p pd=2.92u as=0.3808p ps=2.92u w=1.12u l=0.13u
X608 VDD VDD VDD VDD sg13_lv_pmos ad=0.3808p pd=2.92u as=0 ps=0 w=1.12u l=0.13u
X609 a_26911_2470# a_26673_1842# a_26803_1842# VDD sg13_lv_pmos ad=0.2128p pd=1.5u as=0.3808p ps=2.92u w=1.12u l=0.2u
X610 a_7390_1044# a_2019_1047.t8 a_7288_1044# VSS.t233 sg13_lv_nmos ad=0.2516p pd=2.16u as=0.1406p ps=1.12u w=0.74u l=0.13u
X611 a_21353_1842# a_21157_1842# VSS.t85 VSS.t84 sg13_lv_nmos ad=0.2516p pd=2.16u as=0.1406p ps=1.12u w=0.74u l=0.13u
X612 VSS.t403 a_7043_1842# a_7477_1842# VSS.t402 sg13_lv_nmos ad=0.1406p pd=1.12u as=0.2516p ps=2.16u w=0.74u l=0.13u
X613 VDD DELAY_VBIASP.t16 a_15511_2470# VDD sg13_lv_pmos ad=0.3808p pd=2.92u as=0.2128p ps=1.5u w=1.12u l=0.6u
X614 VDD a_2019_1047.t7 a_10404_1008# VDD sg13_lv_pmos ad=0.3808p pd=2.92u as=0.3808p ps=2.92u w=1.12u l=0.13u
X615 VDD a_25283_1842# a_25717_1842# VDD sg13_lv_pmos ad=0.2128p pd=1.5u as=0.3808p ps=2.92u w=1.12u l=0.13u
X616 VDD DELAY_VBIASP.t29 a_5631_2470# VDD sg13_lv_pmos ad=0.3808p pd=2.92u as=0.2128p ps=1.5u w=1.12u l=0.6u
X617 a_26395_1044# a_26185_1044# VDD VDD sg13_lv_pmos ad=0.2128p pd=1.5u as=0.252p ps=1.57u w=1.12u l=0.13u
X618 VDD a_3747_1047.t3 a_24951_1008# VDD sg13_lv_pmos ad=0.3808p pd=2.92u as=0.3808p ps=2.92u w=1.12u l=0.13u
X619 VDD VSS.t571 VDD VDD sg13_lv_pmos ad=0.19p pd=1.38u as=0 ps=0 w=1u l=1u
X620 a_13991_1842# a_13753_1842# a_13883_1842# VSS.t515 sg13_lv_nmos ad=0.1406p pd=1.12u as=0.2516p ps=2.16u w=0.74u l=0.2u
X621 a_24008_1044# a_23437_1842# VDD VDD sg13_lv_pmos ad=0.2128p pd=1.5u as=0.3808p ps=2.92u w=1.12u l=0.13u
X622 VDD VSS.t585 VDD VDD sg13_lv_pmos ad=0.19p pd=1.38u as=0 ps=0 w=1u l=1u
X623 VSS.t252 a_2019_1047.t4 a_19524_1008# VSS.t251 sg13_lv_nmos ad=0.2516p pd=2.16u as=0.2516p ps=2.16u w=0.74u l=0.13u
X624 a_7911_2470# a_7673_1842# a_7803_1842# VDD sg13_lv_pmos ad=0.2128p pd=1.5u as=0.3808p ps=2.92u w=1.12u l=0.2u
X625 a_16793_1842# a_16597_1842# VDD VDD sg13_lv_pmos ad=0.3808p pd=2.92u as=0.2128p ps=1.5u w=1.12u l=0.13u
X626 VSS.t130 MUX_SEL1 a_3543_1395# VSS.t529 sg13_lv_nmos ad=0.1331p pd=1.12u as=0.1216p ps=1.02u w=0.64u l=0.13u
X627 a_15755_1044# a_15545_1044# VSS.t243 VSS.t242 sg13_lv_nmos ad=0.1406p pd=1.12u as=0.1665p ps=1.19u w=0.74u l=0.13u
X628 a_2595_1047.t0 a_2297_1395# VDD VDD sg13_lv_pmos ad=0.2128p pd=1.5u as=0.1918p ps=1.5u w=1.12u l=0.13u
X629 VSS.t110 a_2595_1047.t6 a_14311_1008# VSS.t109 sg13_lv_nmos ad=0.2516p pd=2.16u as=0.2516p ps=2.16u w=0.74u l=0.13u
X630 VSS.t87 a_12363_1842# a_12797_1842# VSS.t423 sg13_lv_nmos ad=0.1406p pd=1.12u as=0.2516p ps=2.16u w=0.74u l=0.13u
X631 a_5115_1044# a_4905_1044# VSS.t58 VSS.t57 sg13_lv_nmos ad=0.1406p pd=1.12u as=0.1665p ps=1.19u w=0.74u l=0.13u
X632 a_1256_1044# MUX_SEL0 VDD VDD sg13_lv_pmos ad=0.3808p pd=2.92u as=0.3808p ps=2.92u w=1.12u l=0.13u
X633 VDD a_27563_1842# a_27997_1842# VDD sg13_lv_pmos ad=0.2128p pd=1.5u as=0.3808p ps=2.92u w=1.12u l=0.13u
X634 a_20593_1842# a_20397_1842# VDD VDD sg13_lv_pmos ad=0.3808p pd=2.92u as=0.2128p ps=1.5u w=1.12u l=0.13u
X635 a_1721_1395# a_1256_1044# VDD VDD sg13_lv_pmos ad=0.1596p pd=1.22u as=0.2856p ps=2.36u w=0.84u l=0.13u
X636 VDD a_6283_1842# a_6717_1842# VDD sg13_lv_pmos ad=0.2128p pd=1.5u as=0.3808p ps=2.92u w=1.12u l=0.13u
X637 a_13470_1044# a_14964_1008# a_14888_1044# VDD sg13_lv_pmos ad=0.3808p pd=2.92u as=0.2128p ps=1.5u w=1.12u l=0.13u
X638 VSS.t331 VDD VSS.t330 VSS.t329 sg13_lv_nmos ad=0.1428p pd=1.52u as=0 ps=0 w=0.42u l=1u
X639 VDD a_2019_1047.t2 a_25604_1008# VDD sg13_lv_pmos ad=0.3808p pd=2.92u as=0.3808p ps=2.92u w=1.12u l=0.13u
X640 a_16271_1842# a_16033_1842# a_16163_1842# VSS.t249 sg13_lv_nmos ad=0.1406p pd=1.12u as=0.2516p ps=2.16u w=0.74u l=0.2u
X641 a_21835_1044# a_21625_1044# VDD VDD sg13_lv_pmos ad=0.2128p pd=1.5u as=0.252p ps=1.57u w=1.12u l=0.13u
X642 VDD VSS.t596 VDD VDD sg13_lv_pmos ad=0.34p pd=2.68u as=0 ps=0 w=1u l=1u
X643 VDD a_2595_1047.t4 a_20391_1008# VDD sg13_lv_pmos ad=0.3808p pd=2.92u as=0.3808p ps=2.92u w=1.12u l=0.13u
X644 a_19073_1842# a_18877_1842# VDD VDD sg13_lv_pmos ad=0.3808p pd=2.92u as=0.2128p ps=1.5u w=1.12u l=0.13u
X645 VDD a_10517_1842# a_10985_1044# VDD sg13_lv_pmos ad=0.252p pd=1.57u as=0.3808p ps=2.92u w=1.12u l=0.13u
X646 VSS.t83 a_21157_1842# a_21625_1044# VSS.t82 sg13_lv_nmos ad=0.1665p pd=1.19u as=0.2516p ps=2.16u w=0.74u l=0.13u
X647 a_20071_1842# a_19833_1842# a_19963_1842# VSS.t553 sg13_lv_nmos ad=0.1406p pd=1.12u as=0.2516p ps=2.16u w=0.74u l=0.2u
X648 VSS.t400 a_14643_1842# a_15077_1842# VSS.t399 sg13_lv_nmos ad=0.1406p pd=1.12u as=0.2516p ps=2.16u w=0.74u l=0.13u
X649 a_1815_331# a_1256_289# a_1721_331# VSS.t3 sg13_lv_nmos ad=0.1216p pd=1.02u as=0.2176p ps=1.96u w=0.64u l=0.13u
X650 VDD a_19203_1842# a_19637_1842# VDD sg13_lv_pmos ad=0.2128p pd=1.5u as=0.3808p ps=2.92u w=1.12u l=0.13u
X651 VSS.t25 a_2019_1047.t9 a_4324_1008# VSS.t24 sg13_lv_nmos ad=0.2516p pd=2.16u as=0.2516p ps=2.16u w=0.74u l=0.13u
X652 a_16108_289# a_20905_519# a_19550_1044# VDD sg13_lv_pmos ad=0.3808p pd=2.92u as=0.3808p ps=2.92u w=1.12u l=0.13u
X653 a_16510_1044# a_3747_1047.t5 a_18795_1044# VSS.t538 sg13_lv_nmos ad=0.2516p pd=2.16u as=0.1406p ps=1.12u w=0.74u l=0.13u
X654 VDD a_8563_1842# a_8997_1842# VDD sg13_lv_pmos ad=0.2128p pd=1.5u as=0.3808p ps=2.92u w=1.12u l=0.13u
X655 VDD DELAY_VBIASP.t19 a_13231_2470# VDD sg13_lv_pmos ad=0.3808p pd=2.92u as=0.2128p ps=1.5u w=1.12u l=0.6u
X656 VSS.t479 DELAY_VBIASN.t13 a_17791_1842# VSS.t478 sg13_lv_nmos ad=0.2516p pd=2.16u as=0.1406p ps=1.12u w=0.74u l=0.6u
X657 VSS.t301 VDD VSS.t300 VSS.t299 sg13_lv_nmos ad=0.1428p pd=1.52u as=0 ps=0 w=0.42u l=1u
X658 VDD a_3747_1047.t5 a_18871_1008# VDD sg13_lv_pmos ad=0.3808p pd=2.92u as=0.3808p ps=2.92u w=1.12u l=0.13u
X659 VDD a_23003_1842# a_23437_1842# VDD sg13_lv_pmos ad=0.2128p pd=1.5u as=0.3808p ps=2.92u w=1.12u l=0.13u
X660 a_12715_1044# a_12505_1044# VDD VDD sg13_lv_pmos ad=0.2128p pd=1.5u as=0.252p ps=1.57u w=1.12u l=0.13u
X661 a_19550_1044# a_21044_1008# a_20968_1044# VDD sg13_lv_pmos ad=0.3808p pd=2.92u as=0.2128p ps=1.5u w=1.12u l=0.13u
X662 a_17928_1044# a_17357_1842# VDD VDD sg13_lv_pmos ad=0.2128p pd=1.5u as=0.3808p ps=2.92u w=1.12u l=0.13u
X663 VSS.t487 DELAY_VBIASN.t8 a_21591_1842# VSS.t486 sg13_lv_nmos ad=0.2516p pd=2.16u as=0.1406p ps=1.12u w=0.74u l=0.6u
X664 VSS.t121 a_1544_289# a_1815_331# VSS.t562 sg13_lv_nmos ad=0.1331p pd=1.12u as=0.1216p ps=1.02u w=0.64u l=0.13u
X665 a_7288_1044# a_6717_1842# VDD VDD sg13_lv_pmos ad=0.2128p pd=1.5u as=0.3808p ps=2.92u w=1.12u l=0.13u
X666 a_15511_2470# a_15273_1842# a_15403_1842# VDD sg13_lv_pmos ad=0.2128p pd=1.5u as=0.3808p ps=2.92u w=1.12u l=0.2u
X667 VSS.t386 VSS.t388 VSS.t390 VSS.t389 sg13_lv_nmos ad=0.1406p pd=1.12u as=0 ps=0 w=0.74u l=0.2u
X668 a_22590_1044# a_24951_1008# a_24875_1044# VDD sg13_lv_pmos ad=0.3808p pd=2.92u as=0.2128p ps=1.5u w=1.12u l=0.13u
X669 VSS.t373 VDD VSS.t371 VSS.t372 sg13_lv_nmos ad=79.8f pd=0.8u as=0 ps=0 w=0.42u l=1u
X670 a_10430_1044# a_2019_1047.t7 a_10328_1044# VSS.t114 sg13_lv_nmos ad=0.2516p pd=2.16u as=0.1406p ps=1.12u w=0.74u l=0.13u
X671 VDD a_25717_1842# a_26185_1044# VDD sg13_lv_pmos ad=0.252p pd=1.57u as=0.3808p ps=2.92u w=1.12u l=0.13u
X672 VDD a_13883_1842# a_14317_1842# VDD sg13_lv_pmos ad=0.2128p pd=1.5u as=0.3808p ps=2.92u w=1.12u l=0.13u
X673 VDD a_4437_1842# a_4905_1044# VDD sg13_lv_pmos ad=0.252p pd=1.57u as=0.3808p ps=2.92u w=1.12u l=0.13u
X674 a_4157_1313# DELAY_IN VSS.t277 VSS.t276 sg13_lv_nmos ad=0.2516p pd=2.16u as=0.2553p ps=2.17u w=0.74u l=0.13u
X675 a_7390_1044# a_3171_1047.t8 a_8808_1044# VSS.t256 sg13_lv_nmos ad=0.2516p pd=2.16u as=0.1406p ps=1.12u w=0.74u l=0.13u
X676 a_22873_1842# a_22677_1842# VSS.t414 VSS.t413 sg13_lv_nmos ad=0.2516p pd=2.16u as=0.1406p ps=1.12u w=0.74u l=0.13u
X677 VDD a_3171_1047.t8 a_8884_1008# VDD sg13_lv_pmos ad=0.3808p pd=2.92u as=0.3808p ps=2.92u w=1.12u l=0.13u
C0 VDD DELAY_OUT_LAST 0.46312f
C1 a_25604_1008# VDD 0.28633f
C2 a_21044_1008# a_21157_1842# 0.02055f
C3 a_21625_1044# a_21157_1842# 0.2079f
C4 a_14025_1044# a_13470_1044# 0.03209f
C5 a_7288_1044# VDD 0.17274f
C6 a_19311_2470# a_19203_1842# 0.01697f
C7 a_1256_289# a_2297_331# 0.04261f
C8 a_4157_1313# a_4248_1044# 0.11672f
C9 a_15765_463# a_2019_311# 0.05969f
C10 a_11603_1842# a_11711_1842# 0.01163f
C11 a_16033_1842# a_15837_1842# 0.76914f
C12 DELAY_VBIASN a_20723_1842# 0.07254f
C13 DELAY_VBIASP a_21917_1842# 0.0414f
C14 a_7390_1044# a_8155_1044# 0.39037f
C15 a_27433_1842# a_27997_1842# 0.0114f
C16 a_15077_1842# a_15837_1842# 0.02912f
C17 a_24523_1842# a_24631_2470# 0.01697f
C18 a_17791_1842# a_17683_1842# 0.01163f
C19 a_17553_1842# VDD 0.49417f
C20 a_18877_1842# a_19637_1842# 0.06198f
C21 a_11277_1842# a_10517_1842# 0.01669f
C22 a_7477_1842# a_8237_1842# 0.01669f
C23 a_4905_1044# a_4350_1044# 0.03209f
C24 VDD a_7911_2470# 0.01806f
C25 a_22113_1842# a_22243_1842# 0.70845f
C26 a_23145_1044# a_22590_1044# 0.03209f
C27 VDD a_14311_1008# 0.28336f
C28 MUX_OUT VDD 0.35871f
C29 a_4633_1842# VDD 0.49285f
C30 a_6153_1842# VDD 0.49285f
C31 a_6635_1044# VDD 0.15406f
C32 DELAY_VBIASN a_19833_1842# 0.0961f
C33 a_8433_1842# DELAY_VBIASN 0.0961f
C34 a_14317_1842# a_13883_1842# 0.6972f
C35 a_16510_1044# a_17065_1044# 0.03209f
C36 a_23003_1842# a_23111_1842# 0.01163f
C37 DELAY_OUT_LAST a_27997_1842# 0.70955f
C38 DELAY_VBIASP a_27563_1842# 0.06629f
C39 DELAY_VBIASN a_27433_1842# 0.0961f
C40 a_15837_1842# DELAY_VBIASP 0.0414f
C41 a_14643_1842# DELAY_VBIASN 0.07254f
C42 a_7390_1044# a_9323_1842# 0.01012f
C43 a_16510_1044# a_18004_1008# 0.28279f
C44 a_10083_1842# VDD 0.49727f
C45 a_8808_1044# VDD 0.17499f
C46 a_22677_1842# a_22564_1008# 0.05157f
C47 MUX_SEL4 a_2297_331# 0.04338f
C48 MUX_SEL3 a_2873_331# 0.12606f
C49 MUX_SEL2 a_3449_331# 0.10741f
C50 DELAY_VBIASP a_18313_1842# 0.11222f
C51 a_6913_1842# DELAY_VBIASP 0.11222f
C52 a_12505_1044# a_10430_1044# 0.03208f
C53 a_15964_289# a_16108_289# 0.42202f
C54 a_27671_2470# a_27563_1842# 0.01697f
C55 a_24197_1842# DELAY_VBIASN 0.09156f
C56 a_23355_1044# a_23431_1008# 0.01194f
C57 a_20105_1044# a_19550_1044# 0.03209f
C58 a_13753_1842# DELAY_VBIASN 0.0961f
C59 a_25153_1842# a_25283_1842# 0.70845f
C60 a_18585_1044# VDD 0.29722f
C61 a_7477_1842# a_7945_1044# 0.19203f
C62 DELAY_OUT_LAST DELAY_VBIASN 0.04786f
C63 a_14825_519# a_5731_289# 0.28056f
C64 a_22873_1842# a_23437_1842# 0.0114f
C65 a_6425_1044# a_5957_1842# 0.2079f
C66 a_18795_1044# VDD 0.15406f
C67 a_9757_1842# a_10328_1044# 0.10864f
C68 a_9193_1842# a_9323_1842# 0.70845f
C69 a_12797_1842# a_13557_1842# 0.06198f
C70 a_22590_1044# a_23945_519# 0.02165f
C71 a_25717_1842# a_26477_1842# 0.01669f
C72 a_26151_2470# a_26043_1842# 0.01697f
C73 a_22677_1842# DELAY_VBIASP 0.0414f
C74 a_11195_1044# VDD 0.15389f
C75 a_10517_1842# VDD 0.86707f
C76 a_15755_1044# VDD 0.15389f
C77 a_20397_1842# a_21157_1842# 0.03319f
C78 a_12233_1842# DELAY_VBIASP 0.11222f
C79 a_6283_1842# a_4350_1044# 0.01012f
C80 a_25153_1842# VDD 0.49426f
C81 a_24957_1842# a_25528_1044# 0.10864f
C82 a_17553_1842# DELAY_VBIASN 0.0961f
C83 a_6283_1842# a_6391_1842# 0.01163f
C84 a_16510_1044# a_2019_311# 0.03139f
C85 a_14317_1842# a_13470_1044# 0.08038f
C86 a_16108_289# a_26985_519# 0.2906f
C87 MUX_SEL4 a_14825_519# 0.03307f
C88 a_22590_1044# a_23355_1044# 0.39037f
C89 a_23763_1842# a_24197_1842# 0.6972f
C90 a_4633_1842# DELAY_VBIASN 0.0961f
C91 a_6153_1842# DELAY_VBIASN 0.0961f
C92 a_6283_1842# DELAY_VBIASP 0.06627f
C93 a_6717_1842# a_7288_1044# 0.10864f
C94 a_17553_1842# a_18117_1842# 0.0114f
C95 a_4763_1842# a_4871_1842# 0.01163f
C96 a_19550_1044# a_19637_1842# 0.1088f
C97 a_12797_1842# a_13444_1008# 0.02011f
C98 VDD a_24008_1044# 0.17499f
C99 a_17357_1842# a_17928_1044# 0.10863f
C100 a_10083_1842# DELAY_VBIASN 0.07254f
C101 a_11277_1842# DELAY_VBIASP 0.0414f
C102 a_17031_1842# a_16923_1842# 0.01163f
C103 VDD a_21157_1842# 0.85848f
C104 a_16597_1842# a_17357_1842# 0.01669f
C105 a_14964_1008# a_13470_1044# 0.28279f
C106 a_22113_1842# a_21917_1842# 0.76914f
C107 a_21157_1842# a_21353_1842# 0.77122f
C108 a_4633_1842# a_5197_1842# 0.0114f
C109 a_6635_1044# a_6711_1008# 0.01194f
C110 a_1544_1044# VDD 0.45079f
C111 a_6153_1842# a_6717_1842# 0.0114f
C112 a_16851_309# a_16510_1044# 0.02131f
C113 a_8237_1842# a_8563_1842# 0.01427f
C114 a_9323_1842# a_9431_1842# 0.01163f
C115 a_21591_2470# a_21483_1842# 0.01697f
C116 a_2297_331# a_2019_311# 0.04011f
C117 DELAY_VBIASP a_20397_1842# 0.0414f
C118 VDD a_19203_1842# 0.49737f
C119 a_13368_1044# a_13470_1044# 0.37183f
C120 a_7803_1842# VDD 0.4973f
C121 a_11473_1842# a_12037_1842# 0.0114f
C122 a_22590_1044# a_24951_1008# 0.26208f
C123 a_22564_1008# VDD 0.28633f
C124 a_16033_1842# VDD 0.49413f
C125 a_17031_2470# VDD 0.01806f
C126 VDD a_26803_1842# 0.49671f
C127 a_15077_1842# VDD 0.85963f
C128 a_25630_1044# a_26043_1842# 0.01012f
C129 a_18117_1842# a_18585_1044# 0.2079f
C130 a_10517_1842# DELAY_VBIASN 0.08375f
C131 a_12363_1842# a_12471_1842# 0.01163f
C132 a_25153_1842# DELAY_VBIASN 0.0961f
C133 a_5115_1044# a_5191_1008# 0.01194f
C134 a_4437_1842# a_4324_1008# 0.05157f
C135 a_25717_1842# a_25604_1008# 0.05157f
C136 a_25283_1842# DELAY_VBIASP 0.06627f
C137 VDD a_12715_1044# 0.15406f
C138 a_27124_1008# a_25630_1044# 0.28279f
C139 a_1256_289# VDD 0.40292f
C140 a_20071_2470# a_19963_1842# 0.01697f
C141 MUX_SEL0 MUX_SEL2 0.01204f
C142 a_4350_1044# VDD 0.87635f
C143 a_17865_519# VDD 0.29444f
C144 a_12797_1842# a_10430_1044# 0.02479f
C145 a_24197_1842# a_24084_1008# 0.02055f
C146 a_23633_1842# VDD 0.49417f
C147 a_17357_1842# a_16510_1044# 0.08038f
C148 a_8808_1044# a_8884_1008# 0.01176f
C149 a_13123_1842# VDD 0.49727f
C150 a_8997_1842# DELAY_VBIASP 0.04141f
C151 VDD a_5731_289# 0.6143f
C152 VDD DELAY_VBIASP 13.3418f
C153 a_12037_1842# a_12505_1044# 0.2079f
C154 a_1256_289# a_1721_331# 0.13421f
C155 DELAY_VBIASP a_21353_1842# 0.11222f
C156 DELAY_VBIASN a_21157_1842# 0.09156f
C157 a_7390_1044# a_7364_1008# 0.277f
C158 a_15077_1842# a_15273_1842# 0.77122f
C159 VDD a_27671_2470# 0.01806f
C160 a_18877_1842# a_19073_1842# 0.76914f
C161 a_16923_1842# VDD 0.4973f
C162 a_26985_519# a_25630_1044# 0.02165f
C163 a_10430_1044# a_12791_1008# 0.26208f
C164 a_10843_1842# a_10430_1044# 0.01012f
C165 a_7803_1842# a_7911_1842# 0.01163f
C166 a_7477_1842# a_7673_1842# 0.73897f
C167 a_10713_1842# a_10517_1842# 0.73897f
C168 a_4157_1313# a_4350_1044# 0.04624f
C169 VDD a_7151_2470# 0.01806f
C170 a_22113_1842# a_22677_1842# 0.0114f
C171 VDD a_14235_1044# 0.15389f
C172 MUX_SEL4 VDD 2.63176f
C173 a_18585_1044# a_18871_1008# 0.01885f
C174 a_4003_1842# VDD 0.61559f
C175 DELAY_VBIASN a_19203_1842# 0.07254f
C176 a_5523_1842# VDD 0.49671f
C177 a_5844_1008# VDD 0.28225f
C178 a_7803_1842# DELAY_VBIASN 0.07254f
C179 a_16510_1044# a_17351_1008# 0.28268f
C180 a_16033_1842# DELAY_VBIASN 0.0961f
C181 a_16108_289# a_18877_1842# 0.0157f
C182 a_4003_1842# a_4111_1842# 0.01163f
C183 a_18795_1044# a_18871_1008# 0.01194f
C184 DELAY_VBIASP a_27997_1842# 0.04001f
C185 a_15077_1842# DELAY_VBIASN 0.09156f
C186 DELAY_VBIASN a_26803_1842# 0.07254f
C187 a_15273_1842# DELAY_VBIASP 0.11222f
C188 a_7390_1044# a_9757_1842# 0.02479f
C189 a_22677_1842# a_22590_1044# 0.1088f
C190 a_22243_1842# a_22351_2470# 0.01697f
C191 MUX_SEL3 a_2297_331# 0.01595f
C192 MUX_SEL4 a_1721_331# 0.05813f
C193 MUX_SEL2 a_2873_331# 0.01422f
C194 a_8231_1008# VDD 0.28336f
C195 MUX_OUT a_1544_289# 0.69943f
C196 a_4350_1044# DELAY_VBIASN 0.02115f
C197 a_10430_1044# a_11924_1008# 0.28279f
C198 a_11195_1044# a_11271_1008# 0.01194f
C199 a_10985_1044# a_10430_1044# 0.03209f
C200 a_15755_1044# a_15831_1008# 0.01194f
C201 a_15765_463# a_16108_289# 0.42004f
C202 a_23633_1842# DELAY_VBIASN 0.0961f
C203 a_17065_1044# VDD 0.30218f
C204 a_13123_1842# DELAY_VBIASN 0.07254f
C205 a_20391_1008# a_19550_1044# 0.28268f
C206 a_25153_1842# a_25717_1842# 0.0114f
C207 MUX_SEL4 a_4157_1313# 0.08229f
C208 a_18551_1842# a_18443_1842# 0.01163f
C209 DELAY_VBIASP DELAY_VBIASN 3.50557f
C210 a_15403_1842# a_13470_1044# 0.01012f
C211 a_11785_519# a_5731_289# 0.28056f
C212 a_4437_1842# a_4905_1044# 0.19203f
C213 a_18004_1008# VDD 0.28225f
C214 a_14964_1008# a_14317_1842# 0.02312f
C215 a_9193_1842# a_9757_1842# 0.0114f
C216 a_12797_1842# a_12993_1842# 0.76914f
C217 a_10404_1008# VDD 0.28633f
C218 a_20397_1842# a_20593_1842# 0.76914f
C219 a_9953_1842# VDD 0.49426f
C220 a_5197_1842# a_4350_1044# 0.08038f
C221 VDD a_15511_2470# 0.01806f
C222 a_4350_1044# a_6711_1008# 0.26208f
C223 a_19550_1044# a_19963_1842# 0.01012f
C224 a_6717_1842# a_4350_1044# 0.02479f
C225 a_24957_1842# a_24951_1008# 0.02354f
C226 a_24523_1842# VDD 0.4973f
C227 a_16923_1842# DELAY_VBIASN 0.07254f
C228 a_18117_1842# DELAY_VBIASP 0.04141f
C229 a_25528_1044# a_25630_1044# 0.37183f
C230 a_16108_289# a_23945_519# 0.2906f
C231 VDD a_17683_1842# 0.49671f
C232 a_20105_1044# VDD 0.30409f
C233 a_23763_1842# a_23633_1842# 0.70845f
C234 MUX_SEL4 a_11785_519# 0.03255f
C235 a_5197_1842# DELAY_VBIASP 0.0414f
C236 a_4003_1842# DELAY_VBIASN 0.06486f
C237 a_6717_1842# DELAY_VBIASP 0.0414f
C238 a_5523_1842# DELAY_VBIASN 0.07254f
C239 a_20397_1842# a_19637_1842# 0.01669f
C240 a_7477_1842# a_7364_1008# 0.05157f
C241 a_23763_1842# DELAY_VBIASP 0.06627f
C242 a_24008_1044# a_24084_1008# 0.01176f
C243 VDD a_23431_1008# 0.28336f
C244 a_12037_1842# a_12797_1842# 0.02912f
C245 a_14643_1842# a_14751_1842# 0.01163f
C246 a_25283_1842# a_25391_1842# 0.01163f
C247 VDD a_2019_311# 1.43004f
C248 a_10713_1842# DELAY_VBIASP 0.11222f
C249 VDD a_20593_1842# 0.49417f
C250 a_22113_1842# VDD 0.49426f
C251 a_16597_1842# a_16793_1842# 0.73897f
C252 a_6283_1842# a_6391_2470# 0.01697f
C253 a_16108_289# a_19550_1044# 0.58202f
C254 MUX_SEL4 a_6717_1842# 0.0195f
C255 a_21157_1842# a_20723_1842# 0.6972f
C256 a_5197_1842# a_5844_1008# 0.02312f
C257 a_5197_1842# a_5523_1842# 0.01427f
C258 a_16108_289# a_16510_1044# 0.56108f
C259 a_8237_1842# a_8997_1842# 0.03319f
C260 a_1721_331# a_2019_311# 0.18452f
C261 a_26477_1842# a_26803_1842# 0.01427f
C262 VDD a_19637_1842# 0.86707f
C263 a_8237_1842# VDD 0.86909f
C264 a_11277_1842# a_11603_1842# 0.01427f
C265 a_27705_1044# VDD 0.29918f
C266 a_22590_1044# VDD 0.89557f
C267 a_22590_1044# a_24875_1044# 0.39036f
C268 a_4763_1842# a_4871_2470# 0.01697f
C269 VDD a_27237_1842# 0.85969f
C270 a_14513_1842# VDD 0.49417f
C271 a_9953_1842# DELAY_VBIASN 0.0961f
C272 a_4157_1313# a_2019_311# 0.01018f
C273 a_25717_1842# DELAY_VBIASP 0.0414f
C274 a_24523_1842# DELAY_VBIASN 0.07254f
C275 a_27048_1044# a_25630_1044# 0.38994f
C276 a_22488_1044# a_21917_1842# 0.10864f
C277 a_27991_1008# VDD 0.28201f
C278 a_1544_1044# a_1721_1395# 0.38063f
C279 MUX_SEL0 MUX_SEL1 3.14917f
C280 a_18117_1842# a_18004_1008# 0.02055f
C281 DELAY_VBIASN a_17683_1842# 0.07254f
C282 a_16851_309# VDD 0.51536f
C283 DELAY_VBIASP a_26477_1842# 0.04144f
C284 a_23003_1842# VDD 0.4973f
C285 a_13557_1842# VDD 0.86707f
C286 a_16108_289# a_21917_1842# 0.0157f
C287 a_9323_1842# a_9431_2470# 0.01697f
C288 a_26803_1842# a_26911_1842# 0.01163f
C289 VDD DELAY_IN 1.33375f
C290 a_12037_1842# a_11924_1008# 0.02055f
C291 a_1256_1044# MUX_SEL1 1.44243f
C292 a_18117_1842# a_17683_1842# 0.6972f
C293 a_1256_289# a_1544_289# 1.25711f
C294 a_16271_2470# a_16163_1842# 0.01697f
C295 DELAY_VBIASN a_20593_1842# 0.0961f
C296 a_22113_1842# DELAY_VBIASN 0.0961f
C297 DELAY_VBIASP a_20723_1842# 0.06627f
C298 a_7945_1044# VDD 0.30409f
C299 a_15077_1842# a_14643_1842# 0.6972f
C300 VDD a_26911_2470# 0.01806f
C301 a_18877_1842# a_18443_1842# 0.6972f
C302 a_17357_1842# VDD 0.86909f
C303 a_19550_1044# a_20315_1044# 0.39037f
C304 a_11277_1842# a_10430_1044# 0.08038f
C305 a_10083_1842# a_10517_1842# 0.69698f
C306 a_7477_1842# a_7043_1842# 0.69698f
C307 a_4350_1044# a_4248_1044# 0.37183f
C308 a_1256_1044# MUX_SEL0 0.3314f
C309 a_20831_1842# a_20723_1842# 0.01163f
C310 VDD a_6391_2470# 0.01806f
C311 a_11603_1842# a_11711_2470# 0.01697f
C312 MUX_SEL3 VDD 0.4053f
C313 a_21835_1044# a_21911_1008# 0.01194f
C314 VDD a_13444_1008# 0.28633f
C315 a_11603_1842# VDD 0.49671f
C316 a_18585_1044# a_18795_1044# 0.09424f
C317 a_4437_1842# VDD 0.86998f
C318 a_5768_1044# VDD 0.17499f
C319 DELAY_VBIASP a_19833_1842# 0.11222f
C320 DELAY_VBIASN a_19637_1842# 0.08375f
C321 a_5957_1842# VDD 0.85848f
C322 a_8237_1842# DELAY_VBIASN 0.09974f
C323 a_8433_1842# DELAY_VBIASP 0.11222f
C324 a_26471_1008# a_26185_1044# 0.01885f
C325 a_16510_1044# a_17275_1044# 0.39037f
C326 a_22590_1044# DELAY_VBIASN 0.02115f
C327 a_4157_1313# DELAY_IN 0.50642f
C328 DELAY_VBIASP a_27433_1842# 0.11222f
C329 DELAY_VBIASN a_27237_1842# 0.09456f
C330 a_14513_1842# DELAY_VBIASN 0.0961f
C331 a_14643_1842# DELAY_VBIASP 0.06627f
C332 a_27048_1044# a_27124_1008# 0.01176f
C333 a_8155_1044# VDD 0.15389f
C334 MUX_SEL4 a_1544_289# 0.47529f
C335 a_1544_1044# MUX_OUT 0.04258f
C336 MUX_SEL2 a_2297_331# 0.10655f
C337 a_2297_1395# MUX_SEL1 0.01995f
C338 a_10430_1044# a_11848_1044# 0.38994f
C339 a_23633_1842# a_24197_1842# 0.0114f
C340 a_15765_463# a_15964_289# 0.061f
C341 a_7803_1842# a_7911_2470# 0.01697f
C342 a_20391_1008# a_20397_1842# 0.02349f
C343 a_23003_1842# DELAY_VBIASN 0.07254f
C344 a_24197_1842# DELAY_VBIASP 0.04141f
C345 a_17351_1008# VDD 0.28565f
C346 a_13557_1842# DELAY_VBIASN 0.08375f
C347 a_15545_1044# VDD 0.29918f
C348 a_13753_1842# DELAY_VBIASP 0.11222f
C349 a_24957_1842# a_25283_1842# 0.01427f
C350 a_5731_289# a_8745_519# 0.28635f
C351 DELAY_VBIASP DELAY_OUT_LAST 0.21225f
C352 a_15837_1842# a_13470_1044# 0.02479f
C353 DELAY_IN DELAY_VBIASN 0.07156f
C354 a_2297_1395# MUX_SEL0 0.10655f
C355 a_4437_1842# a_4157_1313# 0.01771f
C356 a_4905_1044# a_5191_1008# 0.01885f
C357 a_22677_1842# a_23437_1842# 0.01669f
C358 MUX_OUT a_1256_289# 0.1134f
C359 a_4003_1842# a_4111_2470# 0.01697f
C360 a_12797_1842# a_12363_1842# 0.6972f
C361 a_10430_1044# VDD 0.88416f
C362 a_9323_1842# VDD 0.4973f
C363 a_20397_1842# a_19963_1842# 0.6972f
C364 a_4350_1044# a_6635_1044# 0.39036f
C365 VDD a_14751_2470# 0.01806f
C366 a_8237_1842# a_8884_1008# 0.02312f
C367 a_17553_1842# DELAY_VBIASP 0.11222f
C368 a_24957_1842# VDD 0.87825f
C369 a_17357_1842# DELAY_VBIASN 0.09974f
C370 a_1256_1044# a_2297_1395# 0.04619f
C371 MUX_SEL4 a_8745_519# 0.04472f
C372 MUX_OUT a_5731_289# 1.04829f
C373 a_11603_1842# DELAY_VBIASN 0.07254f
C374 a_20391_1008# VDD 0.28336f
C375 a_23003_1842# a_23111_2470# 0.01697f
C376 a_4437_1842# DELAY_VBIASN 0.08375f
C377 a_4633_1842# DELAY_VBIASP 0.11222f
C378 a_14825_519# a_13470_1044# 0.02058f
C379 a_6153_1842# DELAY_VBIASP 0.11222f
C380 a_5957_1842# DELAY_VBIASN 0.09156f
C381 a_17357_1842# a_18117_1842# 0.03319f
C382 a_7477_1842# a_7390_1044# 0.1088f
C383 a_19524_1008# a_18877_1842# 0.02011f
C384 a_12797_1842# a_13368_1044# 0.10864f
C385 a_21911_1008# a_19550_1044# 0.26208f
C386 a_12037_1842# a_12233_1842# 0.77122f
C387 VDD a_5705_519# 0.29556f
C388 a_10083_1842# DELAY_VBIASP 0.06627f
C389 a_16510_1044# a_18443_1842# 0.01012f
C390 VDD a_19963_1842# 0.4973f
C391 MUX_SEL4 MUX_OUT 0.91933f
C392 a_14235_1044# a_14311_1008# 0.01194f
C393 a_16597_1842# a_16163_1842# 0.69698f
C394 a_21591_2470# VDD 0.01806f
C395 a_25913_1842# a_26043_1842# 0.70845f
C396 a_25630_1044# a_27563_1842# 0.01024f
C397 a_17791_2470# a_17683_1842# 0.01697f
C398 a_20593_1842# a_20723_1842# 0.70845f
C399 a_4437_1842# a_5197_1842# 0.01669f
C400 a_5197_1842# a_5768_1044# 0.10863f
C401 a_5197_1842# a_5957_1842# 0.03319f
C402 a_5957_1842# a_6717_1842# 0.02912f
C403 a_15964_289# a_16510_1044# 0.05416f
C404 a_10083_1842# a_10191_1842# 0.01163f
C405 a_1544_289# a_2019_311# 0.01747f
C406 a_26477_1842# a_27237_1842# 0.03319f
C407 VDD a_19073_1842# 0.49426f
C408 a_7673_1842# VDD 0.49294f
C409 a_11277_1842# a_12037_1842# 0.03319f
C410 VDD a_22351_2470# 0.01806f
C411 a_26185_1044# VDD 0.30409f
C412 a_24665_1044# a_24951_1008# 0.01885f
C413 a_22488_1044# VDD 0.17274f
C414 a_22590_1044# a_24084_1008# 0.28279f
C415 VDD a_26673_1842# 0.49417f
C416 a_10430_1044# DELAY_VBIASN 0.02115f
C417 a_10517_1842# DELAY_VBIASP 0.0414f
C418 a_9323_1842# DELAY_VBIASN 0.07254f
C419 a_13883_1842# VDD 0.4973f
C420 a_11785_519# a_10430_1044# 0.02058f
C421 a_25153_1842# DELAY_VBIASP 0.11222f
C422 a_24957_1842# DELAY_VBIASN 0.09992f
C423 a_26471_1008# a_25630_1044# 0.28268f
C424 a_27915_1044# VDD 0.15389f
C425 a_21911_1008# a_21917_1842# 0.02354f
C426 a_16108_289# VDD 1.25759f
C427 a_12363_1842# a_12471_2470# 0.01697f
C428 a_16597_1842# a_16484_1008# 0.05157f
C429 a_23437_1842# VDD 0.86909f
C430 a_12993_1842# VDD 0.49426f
C431 a_19637_1842# a_19833_1842# 0.73897f
C432 a_8237_1842# a_8433_1842# 0.76914f
C433 a_12505_1044# a_12791_1008# 0.01885f
C434 a_17553_1842# a_17683_1842# 0.70845f
C435 DELAY_VBIASN a_19963_1842# 0.07254f
C436 DELAY_VBIASP a_21157_1842# 0.04141f
C437 a_27237_1842# a_27433_1842# 0.77122f
C438 a_14513_1842# a_14643_1842# 0.70845f
C439 MUX_SEL1 a_2873_1395# 0.13092f
C440 VDD a_26151_2470# 0.01806f
C441 a_16793_1842# VDD 0.49277f
C442 a_18313_1842# a_18443_1842# 0.70845f
C443 a_19550_1044# a_19524_1008# 0.277f
C444 a_6913_1842# a_7043_1842# 0.70845f
C445 a_10083_1842# a_9953_1842# 0.70845f
C446 VDD a_5631_2470# 0.01806f
C447 a_15964_289# a_15837_1842# 0.02f
C448 MUX_SEL2 VDD 0.50938f
C449 a_21625_1044# a_21911_1008# 0.01885f
C450 VDD a_13470_1044# 0.87936f
C451 a_12037_1842# VDD 0.85848f
C452 a_24197_1842# a_22590_1044# 0.05231f
C453 MUX_OUT a_2019_311# 8.45486f
C454 a_5393_1842# VDD 0.49417f
C455 a_5191_1008# VDD 0.28565f
C456 DELAY_VBIASN a_19073_1842# 0.0961f
C457 DELAY_VBIASP a_19203_1842# 0.06627f
C458 a_7803_1842# DELAY_VBIASP 0.06627f
C459 a_7673_1842# DELAY_VBIASN 0.0961f
C460 MUX_SEL0 a_2873_1395# 0.01504f
C461 a_16510_1044# a_16484_1008# 0.277f
C462 a_15831_1008# a_15545_1044# 0.01885f
C463 VDD a_10191_2470# 0.01806f
C464 a_26395_1044# a_26185_1044# 0.09424f
C465 a_16033_1842# DELAY_VBIASP 0.11222f
C466 a_3449_1395# DELAY_IN 0.01058f
C467 DELAY_VBIASN a_26673_1842# 0.0961f
C468 DELAY_VBIASP a_26803_1842# 0.06627f
C469 a_13883_1842# DELAY_VBIASN 0.07254f
C470 a_15077_1842# DELAY_VBIASP 0.04141f
C471 a_4350_1044# a_5731_289# 0.41099f
C472 a_7364_1008# VDD 0.28633f
C473 MUX_SEL2 a_1721_331# 0.01315f
C474 a_1544_1044# MUX_SEL4 0.03407f
C475 MUX_SEL3 a_1544_289# 0.15976f
C476 a_10430_1044# a_11271_1008# 0.28268f
C477 a_20315_1044# VDD 0.15389f
C478 a_10517_1842# a_10404_1008# 0.05157f
C479 a_1256_1044# a_2873_1395# 0.28892f
C480 a_9953_1842# a_10517_1842# 0.0114f
C481 a_17031_2470# a_16923_1842# 0.01697f
C482 a_13557_1842# a_13753_1842# 0.73897f
C483 a_16163_1842# a_15837_1842# 0.01427f
C484 a_23437_1842# DELAY_VBIASN 0.09974f
C485 a_23633_1842# DELAY_VBIASP 0.11222f
C486 a_17275_1044# VDD 0.15389f
C487 a_13123_1842# DELAY_VBIASP 0.06627f
C488 a_14025_1044# VDD 0.30409f
C489 a_12993_1842# DELAY_VBIASN 0.0961f
C490 a_24957_1842# a_25717_1842# 0.06198f
C491 a_19550_1044# a_21483_1842# 0.01012f
C492 a_4905_1044# a_5115_1044# 0.09424f
C493 a_22677_1842# a_22873_1842# 0.73897f
C494 a_8997_1842# a_9757_1842# 0.02912f
C495 MUX_SEL4 a_1256_289# 0.65005f
C496 a_12233_1842# a_12363_1842# 0.70845f
C497 MUX_SEL4 a_4350_1044# 0.31434f
C498 MUX_OUT a_16851_309# 0.45865f
C499 a_10328_1044# VDD 0.17274f
C500 a_9757_1842# VDD 0.87771f
C501 a_4350_1044# a_5844_1008# 0.28279f
C502 a_24393_1842# VDD 0.49285f
C503 VDD a_13991_2470# 0.01806f
C504 a_8237_1842# a_8808_1044# 0.10863f
C505 a_16923_1842# DELAY_VBIASP 0.06627f
C506 a_16793_1842# DELAY_VBIASN 0.0961f
C507 VDD a_25630_1044# 0.89531f
C508 MUX_SEL4 a_5731_289# 4.60702f
C509 DELAY_VBIASN a_13470_1044# 0.02115f
C510 a_12037_1842# DELAY_VBIASN 0.09156f
C511 a_23145_1044# a_23355_1044# 0.09424f
C512 a_23763_1842# a_23437_1842# 0.01427f
C513 a_4003_1842# DELAY_VBIASP 0.05992f
C514 a_5523_1842# DELAY_VBIASP 0.06627f
C515 a_5393_1842# DELAY_VBIASN 0.0961f
C516 a_16484_1008# a_15837_1842# 0.02011f
C517 a_17357_1842# a_17553_1842# 0.76914f
C518 a_12797_1842# a_12791_1008# 0.02354f
C519 a_21917_1842# a_21483_1842# 0.6972f
C520 a_21835_1044# a_19550_1044# 0.39036f
C521 VDD a_3449_331# 0.46596f
C522 a_16510_1044# a_18877_1842# 0.02479f
C523 MUX_SEL3 MUX_OUT 0.79533f
C524 a_25717_1842# a_26185_1044# 0.19203f
C525 a_13470_1044# a_14888_1044# 0.38994f
C526 a_14643_1842# a_14751_2470# 0.01697f
C527 a_20831_2470# VDD 0.01806f
C528 a_20593_1842# a_21157_1842# 0.0114f
C529 a_5197_1842# a_5393_1842# 0.76914f
C530 a_5197_1842# a_5191_1008# 0.02349f
C531 a_4437_1842# a_4633_1842# 0.73897f
C532 a_5957_1842# a_6153_1842# 0.77122f
C533 a_26477_1842# a_26673_1842# 0.76914f
C534 VDD a_18443_1842# 0.4973f
C535 a_11277_1842# a_11473_1842# 0.76914f
C536 a_7043_1842# VDD 0.49723f
C537 a_24665_1044# VDD 0.29722f
C538 a_24665_1044# a_24875_1044# 0.09424f
C539 a_24957_1842# a_24197_1842# 0.02912f
C540 a_22590_1044# a_24008_1044# 0.38994f
C541 a_21911_1008# VDD 0.2822f
C542 a_9953_1842# DELAY_VBIASP 0.11222f
C543 a_14317_1842# VDD 0.86909f
C544 VDD a_26043_1842# 0.4973f
C545 a_9757_1842# DELAY_VBIASN 0.09992f
C546 a_6717_1842# a_7364_1008# 0.02011f
C547 a_19963_1842# a_19833_1842# 0.70845f
C548 a_24957_1842# a_25604_1008# 0.02011f
C549 a_24523_1842# DELAY_VBIASP 0.06627f
C550 a_24393_1842# DELAY_VBIASN 0.0961f
C551 a_27124_1008# VDD 0.28225f
C552 a_16510_1044# a_17928_1044# 0.38994f
C553 a_26395_1044# a_25630_1044# 0.39037f
C554 DELAY_VBIASN a_25630_1044# 0.02756f
C555 a_1256_289# a_2019_311# 0.02904f
C556 a_15964_289# VDD 0.31312f
C557 DELAY_VBIASP a_17683_1842# 0.06627f
C558 a_17865_519# a_2019_311# 0.13959f
C559 a_4350_1044# a_2019_311# 0.02042f
C560 a_7390_1044# a_9675_1044# 0.39036f
C561 a_22873_1842# VDD 0.49294f
C562 a_16597_1842# a_16510_1044# 0.1088f
C563 a_23437_1842# a_24084_1008# 0.02312f
C564 a_12363_1842# VDD 0.4973f
C565 a_25283_1842# a_25391_2470# 0.01697f
C566 a_15837_1842# a_15403_1842# 0.6972f
C567 a_19637_1842# a_19203_1842# 0.69698f
C568 a_15831_1008# a_13470_1044# 0.26208f
C569 a_8237_1842# a_7803_1842# 0.6972f
C570 a_2019_311# a_5731_289# 1.15781f
C571 a_22243_1842# a_21917_1842# 0.01427f
C572 a_18551_2470# a_18443_1842# 0.01697f
C573 a_9757_1842# a_9751_1008# 0.02354f
C574 a_22590_1044# a_22564_1008# 0.277f
C575 a_10843_1842# a_10951_1842# 0.01163f
C576 a_22113_1842# DELAY_VBIASP 0.11222f
C577 DELAY_VBIASP a_20593_1842# 0.11222f
C578 a_27237_1842# a_26803_1842# 0.6972f
C579 a_14964_1008# VDD 0.28225f
C580 a_14513_1842# a_15077_1842# 0.0114f
C581 VDD a_25391_2470# 0.01806f
C582 a_18313_1842# a_18877_1842# 0.0114f
C583 a_19448_1044# a_19524_1008# 0.01176f
C584 a_16163_1842# VDD 0.4973f
C585 a_26985_519# VDD 0.29292f
C586 a_6913_1842# a_7477_1842# 0.0114f
C587 VDD a_4871_2470# 0.01806f
C588 a_7390_1044# a_9465_1044# 0.03208f
C589 MUX_SEL1 VDD 0.50267f
C590 a_21625_1044# a_21835_1044# 0.09424f
C591 VDD a_13368_1044# 0.17274f
C592 a_11473_1842# VDD 0.49417f
C593 MUX_SEL4 a_2019_311# 0.90276f
C594 a_5115_1044# VDD 0.15389f
C595 DELAY_VBIASN a_18443_1842# 0.07254f
C596 a_4763_1842# VDD 0.4973f
C597 DELAY_VBIASP a_19637_1842# 0.0414f
C598 a_8237_1842# DELAY_VBIASP 0.0414f
C599 a_13883_1842# a_13753_1842# 0.70845f
C600 a_7043_1842# DELAY_VBIASN 0.07254f
C601 a_16108_289# a_20905_519# 0.2906f
C602 a_16408_1044# a_16484_1008# 0.01176f
C603 a_15755_1044# a_15545_1044# 0.09424f
C604 DELAY_VBIASP a_27237_1842# 0.06189f
C605 DELAY_VBIASN a_26043_1842# 0.07254f
C606 a_14317_1842# DELAY_VBIASN 0.09974f
C607 a_14513_1842# DELAY_VBIASP 0.11222f
C608 a_7390_1044# a_8997_1842# 0.05231f
C609 MUX_SEL0 VDD 0.56365f
C610 a_22677_1842# a_23145_1044# 0.19203f
C611 a_7390_1044# VDD 0.8686f
C612 MUX_SEL2 a_1544_289# 0.07405f
C613 a_10430_1044# a_11195_1044# 0.39037f
C614 a_23437_1842# a_24197_1842# 0.03319f
C615 a_10517_1842# a_10430_1044# 0.1088f
C616 a_19524_1008# VDD 0.28633f
C617 a_13557_1842# a_13123_1842# 0.69698f
C618 a_26911_2470# a_26803_1842# 0.01697f
C619 a_16597_1842# a_15837_1842# 0.06198f
C620 a_22873_1842# DELAY_VBIASN 0.0961f
C621 a_23003_1842# DELAY_VBIASP 0.06627f
C622 a_12505_1044# VDD 0.29722f
C623 a_12363_1842# DELAY_VBIASN 0.07254f
C624 a_16484_1008# VDD 0.28597f
C625 a_13557_1842# DELAY_VBIASP 0.0414f
C626 a_23763_1842# a_23871_1842# 0.01163f
C627 a_24957_1842# a_25153_1842# 0.76914f
C628 a_19550_1044# a_21917_1842# 0.02479f
C629 a_1256_1044# VDD 0.475f
C630 a_25717_1842# a_25630_1044# 0.1088f
C631 DELAY_IN DELAY_VBIASP 0.07719f
C632 a_14317_1842# a_14888_1044# 0.10863f
C633 a_7043_1842# a_6717_1842# 0.01427f
C634 a_22677_1842# a_22243_1842# 0.69698f
C635 MUX_SEL3 a_1256_289# 1.41161f
C636 a_8997_1842# a_9193_1842# 0.77122f
C637 a_12233_1842# a_12797_1842# 0.0114f
C638 a_16271_2470# VDD 0.01806f
C639 MUX_OUT a_16108_289# 0.24265f
C640 a_25630_1044# a_26477_1842# 0.08038f
C641 a_9193_1842# VDD 0.49285f
C642 a_4437_1842# a_4350_1044# 0.1088f
C643 a_5957_1842# a_4350_1044# 0.05231f
C644 VDD a_13231_2470# 0.01806f
C645 a_8237_1842# a_8231_1008# 0.02349f
C646 a_4350_1044# a_5768_1044# 0.38994f
C647 a_17357_1842# DELAY_VBIASP 0.0414f
C648 a_16163_1842# DELAY_VBIASN 0.07254f
C649 a_5523_1842# a_5631_1842# 0.01163f
C650 VDD a_25528_1044# 0.17274f
C651 MUX_SEL4 DELAY_IN 0.0663f
C652 a_11473_1842# DELAY_VBIASN 0.0961f
C653 a_11603_1842# DELAY_VBIASP 0.06627f
C654 VDD a_21483_1842# 0.4973f
C655 a_4437_1842# DELAY_VBIASP 0.0414f
C656 a_4003_1842# DELAY_IN 0.54998f
C657 a_5957_1842# DELAY_VBIASP 0.04141f
C658 a_4763_1842# DELAY_VBIASN 0.07254f
C659 a_15545_1044# a_15077_1842# 0.2079f
C660 a_17357_1842# a_16923_1842# 0.6972f
C661 a_19448_1044# a_18877_1842# 0.10864f
C662 a_14964_1008# a_14888_1044# 0.01176f
C663 a_21625_1044# a_19550_1044# 0.03208f
C664 a_21353_1842# a_21483_1842# 0.70845f
C665 a_21044_1008# a_19550_1044# 0.28279f
C666 a_2297_1395# VDD 0.46536f
C667 VDD a_2873_331# 0.46491f
C668 a_7390_1044# DELAY_VBIASN 0.02115f
C669 MUX_SEL2 MUX_OUT 0.08497f
C670 MUX_SEL3 MUX_SEL4 0.75489f
C671 a_7288_1044# a_7364_1008# 0.01176f
C672 a_13470_1044# a_14311_1008# 0.28268f
C673 a_24523_1842# a_22590_1044# 0.01012f
C674 a_20071_2470# VDD 0.01806f
C675 a_10430_1044# a_12715_1044# 0.39036f
C676 a_6425_1044# VDD 0.29722f
C677 a_20105_1044# a_19637_1842# 0.19203f
C678 a_15403_1842# VDD 0.4973f
C679 a_4437_1842# a_4003_1842# 0.69698f
C680 a_13123_1842# a_13231_1842# 0.01163f
C681 a_8231_1008# a_7945_1044# 0.01885f
C682 a_5197_1842# a_4763_1842# 0.6972f
C683 a_5957_1842# a_5844_1008# 0.02055f
C684 a_5768_1044# a_5844_1008# 0.01176f
C685 a_5957_1842# a_5523_1842# 0.6972f
C686 a_8563_1842# a_8671_1842# 0.01163f
C687 a_20831_2470# a_20723_1842# 0.01697f
C688 a_26477_1842# a_26043_1842# 0.6972f
C689 VDD a_18877_1842# 0.87825f
C690 a_7477_1842# VDD 0.86707f
C691 a_11277_1842# a_10843_1842# 0.6972f
C692 a_23145_1044# VDD 0.30409f
C693 a_10430_1044# a_5731_289# 0.41176f
C694 a_24393_1842# a_24197_1842# 0.77122f
C695 a_22590_1044# a_23431_1008# 0.28268f
C696 a_21835_1044# VDD 0.15406f
C697 a_9193_1842# DELAY_VBIASN 0.0961f
C698 a_27124_1008# a_26477_1842# 0.02312f
C699 a_9323_1842# DELAY_VBIASP 0.06627f
C700 a_7390_1044# a_9751_1008# 0.26208f
C701 a_10083_1842# a_10191_2470# 0.01697f
C702 a_24957_1842# DELAY_VBIASP 0.0414f
C703 a_27048_1044# VDD 0.17499f
C704 a_25604_1008# a_25630_1044# 0.277f
C705 a_14025_1044# a_14311_1008# 0.01885f
C706 a_17357_1842# a_18004_1008# 0.02312f
C707 a_15765_463# VDD 0.35368f
C708 a_16851_309# a_2019_311# 0.01299f
C709 a_4350_1044# a_5705_519# 0.02005f
C710 DELAY_VBIASN a_21483_1842# 0.07254f
C711 a_8155_1044# a_8231_1008# 0.01194f
C712 a_7390_1044# a_8884_1008# 0.28279f
C713 a_22243_1842# VDD 0.49737f
C714 a_23437_1842# a_24008_1044# 0.10863f
C715 a_15273_1842# a_15403_1842# 0.70845f
C716 a_12797_1842# VDD 0.87771f
C717 MUX_SEL4 a_10430_1044# 0.24983f
C718 a_19073_1842# a_19203_1842# 0.70845f
C719 a_11277_1842# a_11924_1008# 0.02312f
C720 a_15755_1044# a_13470_1044# 0.39036f
C721 a_7673_1842# a_7803_1842# 0.70845f
C722 a_5705_519# a_5731_289# 0.28954f
C723 a_22677_1842# a_21917_1842# 0.06198f
C724 a_17357_1842# a_17683_1842# 0.01427f
C725 a_17928_1044# VDD 0.17499f
C726 a_22488_1044# a_22564_1008# 0.01176f
C727 a_27705_1044# a_27237_1842# 0.2079f
C728 DELAY_VBIASP a_19963_1842# 0.06627f
C729 a_26673_1842# a_26803_1842# 0.70845f
C730 a_14317_1842# a_14643_1842# 0.01427f
C731 a_17351_1008# a_17065_1044# 0.01885f
C732 a_27991_1008# a_27705_1044# 0.01885f
C733 VDD a_24631_2470# 0.01806f
C734 a_19550_1044# a_20397_1842# 0.08038f
C735 a_19448_1044# a_19550_1044# 0.37183f
C736 a_16597_1842# VDD 0.86876f
C737 a_23945_519# VDD 0.29292f
C738 a_15403_1842# DELAY_VBIASN 0.07254f
C739 a_7043_1842# a_7151_1842# 0.01163f
C740 a_10083_1842# a_9757_1842# 0.01427f
C741 VDD a_12791_1008# 0.2822f
C742 a_10843_1842# VDD 0.4973f
C743 a_24197_1842# a_24665_1044# 0.2079f
C744 a_23003_1842# a_22590_1044# 0.01012f
C745 MUX_SEL4 a_5705_519# 0.03556f
C746 a_11848_1044# a_11924_1008# 0.01176f
C747 MUX_SEL3 a_2019_311# 0.06209f
C748 a_4324_1008# VDD 0.28597f
C749 DELAY_VBIASP a_19073_1842# 0.11222f
C750 DELAY_VBIASN a_18877_1842# 0.09992f
C751 a_7673_1842# DELAY_VBIASP 0.11222f
C752 a_14317_1842# a_13753_1842# 0.0114f
C753 a_7477_1842# DELAY_VBIASN 0.08375f
C754 a_16108_289# a_17865_519# 0.29564f
C755 a_16408_1044# a_16510_1044# 0.37183f
C756 VDD a_23355_1044# 0.15389f
C757 DELAY_VBIASP a_26673_1842# 0.11222f
C758 a_13883_1842# DELAY_VBIASP 0.06627f
C759 a_19311_1842# a_19203_1842# 0.01163f
C760 a_16108_289# a_5731_289# 0.01334f
C761 a_6425_1044# a_6711_1008# 0.01885f
C762 a_18117_1842# a_18877_1842# 0.02912f
C763 a_10430_1044# a_10404_1008# 0.277f
C764 a_23437_1842# a_23633_1842# 0.76914f
C765 a_19550_1044# VDD 0.89766f
C766 a_9757_1842# a_10517_1842# 0.06198f
C767 a_12993_1842# a_13123_1842# 0.70845f
C768 a_11924_1008# VDD 0.28225f
C769 a_23437_1842# DELAY_VBIASP 0.0414f
C770 a_22243_1842# DELAY_VBIASN 0.07254f
C771 a_10985_1044# VDD 0.30409f
C772 a_12993_1842# DELAY_VBIASP 0.11222f
C773 a_12797_1842# DELAY_VBIASN 0.09992f
C774 a_16510_1044# VDD 0.8795f
C775 a_24957_1842# a_24523_1842# 0.6972f
C776 a_25913_1842# VDD 0.49294f
C777 MUX_SEL1 a_3449_1395# 0.29404f
C778 a_14317_1842# a_14311_1008# 0.02349f
C779 a_7477_1842# a_6717_1842# 0.06198f
C780 a_15077_1842# a_13470_1044# 0.05231f
C781 a_1721_1395# MUX_SEL0 0.01315f
C782 a_4157_1313# a_4324_1008# 0.02463f
C783 MUX_SEL2 a_1256_289# 0.33134f
C784 a_8997_1842# a_8563_1842# 0.6972f
C785 MUX_OUT a_15964_289# 0.01307f
C786 a_2873_1395# VDD 0.46517f
C787 MUX_SEL4 a_16108_289# 0.1283f
C788 a_8563_1842# VDD 0.49671f
C789 MUX_SEL0 a_3449_1395# 0.10753f
C790 a_20105_1044# a_20391_1008# 0.01885f
C791 VDD a_12471_2470# 0.01806f
C792 a_4350_1044# a_5191_1008# 0.28268f
C793 a_16597_1842# DELAY_VBIASN 0.08375f
C794 a_16793_1842# DELAY_VBIASP 0.11222f
C795 VDD a_24951_1008# 0.2822f
C796 a_24875_1044# a_24951_1008# 0.01194f
C797 a_13557_1842# a_13444_1008# 0.05157f
C798 a_1256_1044# a_1721_1395# 0.13421f
C799 a_15403_1842# a_15511_1842# 0.01163f
C800 a_13470_1044# a_5731_289# 0.41365f
C801 a_12037_1842# DELAY_VBIASP 0.04141f
C802 a_10843_1842# DELAY_VBIASN 0.07254f
C803 VDD a_21917_1842# 0.87825f
C804 a_4437_1842# DELAY_IN 0.05007f
C805 a_5393_1842# DELAY_VBIASP 0.11222f
C806 a_16408_1044# a_15837_1842# 0.10864f
C807 a_16793_1842# a_16923_1842# 0.70845f
C808 a_18871_1008# a_18877_1842# 0.02354f
C809 a_21044_1008# a_20397_1842# 0.02312f
C810 a_21353_1842# a_21917_1842# 0.0114f
C811 a_20968_1044# a_19550_1044# 0.38994f
C812 a_24523_1842# a_24631_1842# 0.01163f
C813 a_13883_1842# a_13991_1842# 0.01163f
C814 VDD a_2297_331# 0.46496f
C815 a_7390_1044# a_8745_519# 0.01756f
C816 a_5705_519# a_2019_311# 0.13872f
C817 a_7288_1044# a_7390_1044# 0.37183f
C818 MUX_SEL1 MUX_OUT 0.09357f
C819 MUX_SEL2 MUX_SEL4 0.01978f
C820 MUX_SEL4 a_13470_1044# 0.256f
C821 a_13470_1044# a_14235_1044# 0.39037f
C822 a_19550_1044# DELAY_VBIASN 0.02115f
C823 a_24957_1842# a_22590_1044# 0.02479f
C824 a_5523_1842# a_5631_2470# 0.01697f
C825 a_19311_2470# VDD 0.01806f
C826 a_4905_1044# VDD 0.30126f
C827 VDD a_27563_1842# 0.49811f
C828 a_15837_1842# VDD 0.87963f
C829 a_16510_1044# DELAY_VBIASN 0.02115f
C830 a_8155_1044# a_7945_1044# 0.09424f
C831 a_25913_1842# DELAY_VBIASN 0.0961f
C832 a_4633_1842# a_4763_1842# 0.70845f
C833 a_5393_1842# a_5523_1842# 0.70845f
C834 VDD a_18313_1842# 0.49285f
C835 a_6913_1842# VDD 0.49426f
C836 a_10713_1842# a_10843_1842# 0.70845f
C837 a_21625_1044# VDD 0.29722f
C838 a_21044_1008# VDD 0.28225f
C839 a_27048_1044# a_26477_1842# 0.10863f
C840 a_8563_1842# DELAY_VBIASN 0.07254f
C841 a_18117_1842# a_16510_1044# 0.05231f
C842 a_9757_1842# DELAY_VBIASP 0.0414f
C843 a_17357_1842# a_17351_1008# 0.02349f
C844 a_24393_1842# DELAY_VBIASP 0.11222f
C845 a_27563_1842# a_27671_1842# 0.01163f
C846 DELAY_VBIASP a_25630_1044# 0.01522f
C847 a_26471_1008# VDD 0.28336f
C848 a_25604_1008# a_25528_1044# 0.01176f
C849 a_14025_1044# a_14235_1044# 0.09424f
C850 a_1256_1044# MUX_OUT 0.02466f
C851 a_14825_519# VDD 0.29292f
C852 a_16108_289# a_2019_311# 0.33889f
C853 DELAY_VBIASN a_21917_1842# 0.09992f
C854 a_22677_1842# VDD 0.86707f
C855 a_7390_1044# a_8808_1044# 0.38994f
C856 a_23437_1842# a_23431_1008# 0.02349f
C857 a_27997_1842# a_27563_1842# 0.69646f
C858 a_12233_1842# VDD 0.49285f
C859 a_15273_1842# a_15837_1842# 0.0114f
C860 a_8563_1842# a_8671_2470# 0.01697f
C861 a_26043_1842# a_26151_1842# 0.01163f
C862 a_19073_1842# a_19637_1842# 0.0114f
C863 MUX_SEL4 a_9757_1842# 0.01829f
C864 a_11277_1842# a_11848_1044# 0.10863f
C865 a_7673_1842# a_8237_1842# 0.0114f
C866 a_21591_1842# a_21483_1842# 0.01163f
C867 VDD a_9431_2470# 0.01806f
C868 a_9675_1044# a_9465_1044# 0.09424f
C869 a_22488_1044# a_22590_1044# 0.37183f
C870 a_6283_1842# VDD 0.4973f
C871 a_26673_1842# a_27237_1842# 0.0114f
C872 a_14317_1842# a_15077_1842# 0.03319f
C873 a_27915_1044# a_27705_1044# 0.09424f
C874 VDD a_23871_2470# 0.01806f
C875 a_17275_1044# a_17065_1044# 0.09424f
C876 a_15837_1842# DELAY_VBIASN 0.09992f
C877 DELAY_VBIASN a_27563_1842# 0.07259f
C878 a_20071_1842# a_19963_1842# 0.01163f
C879 a_16108_289# a_22590_1044# 0.58202f
C880 a_10843_1842# a_10951_2470# 0.01697f
C881 a_11277_1842# VDD 0.86909f
C882 a_20968_1044# a_21044_1008# 0.01176f
C883 a_16510_1044# a_18871_1008# 0.26208f
C884 a_27915_1044# a_27991_1008# 0.01194f
C885 a_9675_1044# VDD 0.15406f
C886 a_23437_1842# a_22590_1044# 0.08038f
C887 MUX_SEL4 a_3449_331# 0.05166f
C888 DELAY_VBIASN a_18313_1842# 0.0961f
C889 DELAY_VBIASP a_18443_1842# 0.06627f
C890 a_10985_1044# a_11271_1008# 0.01885f
C891 a_7043_1842# DELAY_VBIASP 0.06627f
C892 a_6913_1842# DELAY_VBIASN 0.0961f
C893 a_16108_289# a_16851_309# 0.06181f
C894 a_20105_1044# a_20315_1044# 0.09424f
C895 a_14317_1842# DELAY_VBIASP 0.0414f
C896 DELAY_VBIASP a_26043_1842# 0.06627f
C897 a_25717_1842# a_25913_1842# 0.73897f
C898 a_26395_1044# a_26471_1008# 0.01194f
C899 a_1544_1044# MUX_SEL1 0.1672f
C900 a_15964_289# a_5731_289# 0.2778f
C901 VDD a_20397_1842# 0.86909f
C902 a_6425_1044# a_6635_1044# 0.09424f
C903 a_18117_1842# a_18313_1842# 0.77122f
C904 a_10328_1044# a_10404_1008# 0.01176f
C905 a_19448_1044# VDD 0.17274f
C906 a_9757_1842# a_10404_1008# 0.02011f
C907 a_23437_1842# a_23003_1842# 0.6972f
C908 a_9757_1842# a_9953_1842# 0.76914f
C909 a_14964_1008# a_15077_1842# 0.02055f
C910 a_9465_1044# a_8997_1842# 0.2079f
C911 a_16033_1842# a_16163_1842# 0.70845f
C912 a_25913_1842# a_26477_1842# 0.0114f
C913 a_12993_1842# a_13557_1842# 0.0114f
C914 a_7043_1842# a_7151_2470# 0.01697f
C915 a_11848_1044# VDD 0.17499f
C916 a_22873_1842# DELAY_VBIASP 0.11222f
C917 a_22677_1842# DELAY_VBIASN 0.08375f
C918 a_12233_1842# DELAY_VBIASN 0.0961f
C919 a_16408_1044# VDD 0.17274f
C920 a_12363_1842# DELAY_VBIASP 0.06627f
C921 a_9465_1044# VDD 0.29722f
C922 a_24393_1842# a_24523_1842# 0.70845f
C923 a_25283_1842# VDD 0.49737f
C924 a_6913_1842# a_6717_1842# 0.76914f
C925 a_4324_1008# a_4248_1044# 0.01176f
C926 a_1544_1044# MUX_SEL0 0.07603f
C927 MUX_SEL4 a_15964_289# 0.5544f
C928 a_6283_1842# DELAY_VBIASN 0.07254f
C929 a_8997_1842# VDD 0.85848f
C930 VDD a_11711_2470# 0.01806f
C931 a_7803_1842# a_7390_1044# 0.01012f
C932 a_4763_1842# a_4350_1044# 0.01012f
C933 a_4350_1044# a_5115_1044# 0.39037f
C934 a_16163_1842# DELAY_VBIASP 0.06627f
C935 VDD a_24875_1044# 0.15406f
C936 a_13557_1842# a_13470_1044# 0.1088f
C937 a_1256_1044# a_1544_1044# 1.26509f
C938 a_11277_1842# DELAY_VBIASN 0.09974f
C939 a_11473_1842# DELAY_VBIASP 0.11222f
C940 VDD a_21353_1842# 0.49285f
C941 a_4763_1842# DELAY_VBIASP 0.06627f
C942 a_15831_1008# a_15837_1842# 0.02354f
C943 a_16793_1842# a_17357_1842# 0.0114f
C944 a_20905_519# a_19550_1044# 0.02165f
C945 a_12505_1044# a_12715_1044# 0.09424f
C946 a_20968_1044# a_20397_1842# 0.10863f
C947 VDD a_1721_331# 0.45259f
C948 a_6717_1842# a_6283_1842# 0.6972f
C949 a_7390_1044# a_5731_289# 0.41331f
C950 a_8433_1842# a_8563_1842# 0.70845f
C951 DELAY_VBIASN a_20397_1842# 0.09974f
C952 a_3449_331# a_2019_311# 0.01176f
C953 MUX_SEL2 MUX_SEL3 3.21891f
C954 MUX_SEL1 MUX_SEL4 0.03574f
C955 a_13470_1044# a_13444_1008# 0.277f
C956 a_23763_1842# a_23871_2470# 0.01697f
C957 a_12037_1842# a_11603_1842# 0.6972f
C958 a_27705_1044# a_25630_1044# 0.03208f
C959 a_14025_1044# a_13557_1842# 0.19203f
C960 a_18551_2470# VDD 0.01806f
C961 a_4157_1313# VDD 0.48935f
C962 a_15273_1842# VDD 0.49285f
C963 a_9675_1044# a_9751_1008# 0.01194f
C964 VDD a_27997_1842# 0.76025f
C965 a_25630_1044# a_27237_1842# 0.05253f
C966 a_25283_1842# DELAY_VBIASN 0.07254f
C967 a_5393_1842# a_5957_1842# 0.0114f
C968 a_27991_1008# a_25630_1044# 0.26208f
C969 a_1544_1044# a_2297_1395# 0.28651f
C970 a_24957_1842# a_16108_289# 0.0157f
C971 a_1544_289# a_2297_331# 0.27303f
C972 a_10713_1842# a_11277_1842# 0.0114f
C973 MUX_SEL4 a_7390_1044# 0.34655f
C974 a_20968_1044# VDD 0.17499f
C975 a_22243_1842# a_22351_1842# 0.01163f
C976 a_13123_1842# a_13231_2470# 0.01697f
C977 a_26471_1008# a_26477_1842# 0.02349f
C978 a_9193_1842# DELAY_VBIASP 0.11222f
C979 a_8997_1842# DELAY_VBIASN 0.09156f
C980 a_26395_1044# VDD 0.15389f
C981 VDD DELAY_VBIASN 0.9333f
C982 a_15545_1044# a_13470_1044# 0.03208f
C983 a_1256_1044# MUX_SEL4 0.04908f
C984 a_11785_519# VDD 0.29292f
C985 a_9465_1044# a_9751_1008# 0.01885f
C986 a_1256_289# a_2873_331# 0.27926f
C987 a_15964_289# a_2019_311# 0.02413f
C988 DELAY_VBIASP a_21483_1842# 0.06627f
C989 DELAY_VBIASN a_21353_1842# 0.0961f
C990 a_7390_1044# a_8231_1008# 0.28268f
C991 a_27433_1842# a_27563_1842# 0.70845f
C992 a_12037_1842# a_10430_1044# 0.05231f
C993 a_11277_1842# a_11271_1008# 0.02349f
C994 a_18117_1842# VDD 0.85848f
C995 a_18877_1842# a_19203_1842# 0.01427f
C996 VDD a_8671_2470# 0.01806f
C997 a_6425_1044# a_4350_1044# 0.03208f
C998 a_24665_1044# a_22590_1044# 0.03208f
C999 DELAY_IN a_3449_331# 0.01017f
C1000 VDD a_14888_1044# 0.17499f
C1001 a_9751_1008# VDD 0.2822f
C1002 a_5197_1842# VDD 0.86909f
C1003 a_6711_1008# VDD 0.2822f
C1004 a_6717_1842# VDD 0.87726f
C1005 a_14317_1842# a_14513_1842# 0.76914f
C1006 VDD a_23111_2470# 0.01806f
C1007 a_23763_1842# VDD 0.49671f
C1008 a_17275_1044# a_17351_1008# 0.01194f
C1009 a_16510_1044# a_18585_1044# 0.03208f
C1010 a_4157_1313# DELAY_VBIASN 0.01202f
C1011 a_27124_1008# a_27237_1842# 0.02055f
C1012 a_15403_1842# DELAY_VBIASP 0.06627f
C1013 a_15273_1842# DELAY_VBIASN 0.0961f
C1014 DELAY_VBIASN a_27997_1842# 0.04176f
C1015 a_8884_1008# a_8997_1842# 0.02055f
C1016 a_10713_1842# VDD 0.49294f
C1017 a_16510_1044# a_18795_1044# 0.39036f
C1018 a_8884_1008# VDD 0.28225f
C1019 MUX_SEL3 a_3449_331# 0.28429f
C1020 MUX_SEL4 a_2873_331# 0.04916f
C1021 MUX_OUT a_2297_331# 0.01179f
C1022 DELAY_VBIASP a_18877_1842# 0.0414f
C1023 a_7477_1842# DELAY_VBIASP 0.0414f
C1024 a_10985_1044# a_11195_1044# 0.09424f
C1025 a_10985_1044# a_10517_1842# 0.19203f
C1026 a_14317_1842# a_13557_1842# 0.01669f
C1027 a_15964_289# a_16851_309# 0.16757f
C1028 a_25717_1842# a_25283_1842# 0.69698f
C1029 a_20391_1008# a_20315_1044# 0.01194f
C1030 a_16271_1842# a_16163_1842# 0.01163f
C1031 a_15765_463# a_5731_289# 0.23301f
C1032 a_10328_1044# a_10430_1044# 0.37183f
C1033 a_18871_1008# VDD 0.2822f
C1034 a_22873_1842# a_23003_1842# 0.70845f
C1035 a_9757_1842# a_9323_1842# 0.6972f
C1036 a_12797_1842# a_13123_1842# 0.01427f
C1037 a_16033_1842# a_16597_1842# 0.0114f
C1038 a_11271_1008# VDD 0.28336f
C1039 a_22243_1842# DELAY_VBIASP 0.06627f
C1040 a_20397_1842# a_20723_1842# 0.01427f
C1041 a_24393_1842# a_24957_1842# 0.0114f
C1042 a_15831_1008# VDD 0.2816f
C1043 a_12797_1842# DELAY_VBIASP 0.0414f
C1044 a_25717_1842# VDD 0.86707f
C1045 a_19550_1044# a_21157_1842# 0.05231f
C1046 a_18117_1842# DELAY_VBIASN 0.09156f
C1047 a_13883_1842# a_13470_1044# 0.01012f
C1048 a_12715_1044# a_12791_1008# 0.01194f
C1049 MUX_SEL4 a_15765_463# 0.65508f
C1050 a_6717_1842# DELAY_VBIASN 0.09992f
C1051 VDD a_26477_1842# 0.86909f
C1052 a_5197_1842# DELAY_VBIASN 0.09974f
C1053 a_20397_1842# a_19833_1842# 0.0114f
C1054 a_8237_1842# a_7390_1044# 0.08038f
C1055 VDD a_10951_2470# 0.01806f
C1056 a_23763_1842# DELAY_VBIASN 0.07254f
C1057 a_4350_1044# a_4324_1008# 0.277f
C1058 a_16597_1842# DELAY_VBIASP 0.0414f
C1059 a_19524_1008# a_19637_1842# 0.05157f
C1060 MUX_SEL4 a_12797_1842# 0.01829f
C1061 VDD a_24084_1008# 0.28225f
C1062 MUX_SEL1 DELAY_IN 0.01858f
C1063 a_10713_1842# DELAY_VBIASN 0.0961f
C1064 a_10843_1842# DELAY_VBIASP 0.06627f
C1065 VDD a_20723_1842# 0.49671f
C1066 a_15403_1842# a_15511_2470# 0.01697f
C1067 a_21157_1842# a_21917_1842# 0.02912f
C1068 VDD a_1544_289# 0.39113f
C1069 a_1721_1395# VDD 0.4533f
C1070 a_6717_1842# a_6711_1008# 0.02354f
C1071 MUX_SEL0 DELAY_IN 0.14089f
C1072 a_6153_1842# a_6283_1842# 0.70845f
C1073 a_17865_519# a_16510_1044# 0.02165f
C1074 a_8433_1842# a_8997_1842# 0.0114f
C1075 a_13368_1044# a_13444_1008# 0.01176f
C1076 VDD a_19833_1842# 0.49294f
C1077 a_8433_1842# VDD 0.49417f
C1078 a_11473_1842# a_11603_1842# 0.70845f
C1079 a_4248_1044# VDD 0.17587f
C1080 a_26185_1044# a_25630_1044# 0.03209f
C1081 a_17791_2470# VDD 0.01806f
C1082 a_13883_1842# a_13991_2470# 0.01697f
C1083 a_3449_1395# VDD 0.46731f
C1084 VDD a_27433_1842# 0.49285f
C1085 a_14643_1842# VDD 0.49671f
C1086 a_7390_1044# a_7945_1044# 0.03209f
C1087 VDD a_4111_2470# 0.01866f
C1088 a_25913_1842# DELAY_VBIASP 0.11222f
C1089 a_25717_1842# DELAY_VBIASN 0.08411f
C1090 a_22564_1008# a_21917_1842# 0.02011f
C1091 a_27915_1044# a_25630_1044# 0.39036f
C1092 a_1544_289# a_1721_331# 0.36963f
C1093 a_20905_519# VDD 0.29292f
C1094 a_16108_289# a_25630_1044# 0.55833f
C1095 a_12363_1842# a_10430_1044# 0.01012f
C1096 a_23145_1044# a_23431_1008# 0.01885f
C1097 a_17928_1044# a_18004_1008# 0.01176f
C1098 a_16923_1842# a_16510_1044# 0.01012f
C1099 a_24197_1842# VDD 0.85848f
C1100 DELAY_VBIASN a_26477_1842# 0.10224f
C1101 a_13753_1842# VDD 0.49294f
C1102 a_8563_1842# DELAY_VBIASP 0.06627f
C1103 a_16597_1842# a_17065_1044# 0.19203f
C1104 VDD a_8745_519# 0.29292f
R0 DELAY_VBIASN.n1 DELAY_VBIASN.t31 34.3755
R1 DELAY_VBIASN.n1 DELAY_VBIASN.t30 33.0005
R2 DELAY_VBIASN.n2 DELAY_VBIASN.t29 33.0005
R3 DELAY_VBIASN.n3 DELAY_VBIASN.t28 33.0005
R4 DELAY_VBIASN.n4 DELAY_VBIASN.t27 33.0005
R5 DELAY_VBIASN.n5 DELAY_VBIASN.t26 33.0005
R6 DELAY_VBIASN.n6 DELAY_VBIASN.t25 33.0005
R7 DELAY_VBIASN.n7 DELAY_VBIASN.t24 33.0005
R8 DELAY_VBIASN.n8 DELAY_VBIASN.t23 33.0005
R9 DELAY_VBIASN.n9 DELAY_VBIASN.t22 33.0005
R10 DELAY_VBIASN.n10 DELAY_VBIASN.t21 33.0005
R11 DELAY_VBIASN.n11 DELAY_VBIASN.t20 33.0005
R12 DELAY_VBIASN.n12 DELAY_VBIASN.t19 33.0005
R13 DELAY_VBIASN.n13 DELAY_VBIASN.t18 33.0005
R14 DELAY_VBIASN.n14 DELAY_VBIASN.t17 33.0005
R15 DELAY_VBIASN.n15 DELAY_VBIASN.t16 33.0005
R16 DELAY_VBIASN.n16 DELAY_VBIASN.t15 33.0005
R17 DELAY_VBIASN.n17 DELAY_VBIASN.t14 33.0005
R18 DELAY_VBIASN.n18 DELAY_VBIASN.t13 33.0005
R19 DELAY_VBIASN.n19 DELAY_VBIASN.t12 33.0005
R20 DELAY_VBIASN.n20 DELAY_VBIASN.t11 33.0005
R21 DELAY_VBIASN.n21 DELAY_VBIASN.t10 33.0005
R22 DELAY_VBIASN.n22 DELAY_VBIASN.t9 33.0005
R23 DELAY_VBIASN.n23 DELAY_VBIASN.t8 33.0005
R24 DELAY_VBIASN.n24 DELAY_VBIASN.t7 33.0005
R25 DELAY_VBIASN.n25 DELAY_VBIASN.t6 33.0005
R26 DELAY_VBIASN.n26 DELAY_VBIASN.t5 33.0005
R27 DELAY_VBIASN.n27 DELAY_VBIASN.t4 33.0005
R28 DELAY_VBIASN.n28 DELAY_VBIASN.t3 33.0005
R29 DELAY_VBIASN.n29 DELAY_VBIASN.t2 33.0005
R30 DELAY_VBIASN.n30 DELAY_VBIASN.t1 33.0005
R31 DELAY_VBIASN.n0 DELAY_VBIASN.t0 33.0005
R32 DELAY_VBIASN DELAY_VBIASN.n0 1.55517
R33 DELAY_VBIASN.n0 DELAY_VBIASN.n30 1.3755
R34 DELAY_VBIASN.n30 DELAY_VBIASN.n29 1.3755
R35 DELAY_VBIASN.n29 DELAY_VBIASN.n28 1.3755
R36 DELAY_VBIASN.n28 DELAY_VBIASN.n27 1.3755
R37 DELAY_VBIASN.n27 DELAY_VBIASN.n26 1.3755
R38 DELAY_VBIASN.n26 DELAY_VBIASN.n25 1.3755
R39 DELAY_VBIASN.n25 DELAY_VBIASN.n24 1.3755
R40 DELAY_VBIASN.n24 DELAY_VBIASN.n23 1.3755
R41 DELAY_VBIASN.n23 DELAY_VBIASN.n22 1.3755
R42 DELAY_VBIASN.n22 DELAY_VBIASN.n21 1.3755
R43 DELAY_VBIASN.n21 DELAY_VBIASN.n20 1.3755
R44 DELAY_VBIASN.n20 DELAY_VBIASN.n19 1.3755
R45 DELAY_VBIASN.n19 DELAY_VBIASN.n18 1.3755
R46 DELAY_VBIASN.n18 DELAY_VBIASN.n17 1.3755
R47 DELAY_VBIASN.n17 DELAY_VBIASN.n16 1.3755
R48 DELAY_VBIASN.n16 DELAY_VBIASN.n15 1.3755
R49 DELAY_VBIASN.n15 DELAY_VBIASN.n14 1.3755
R50 DELAY_VBIASN.n14 DELAY_VBIASN.n13 1.3755
R51 DELAY_VBIASN.n13 DELAY_VBIASN.n12 1.3755
R52 DELAY_VBIASN.n12 DELAY_VBIASN.n11 1.3755
R53 DELAY_VBIASN.n11 DELAY_VBIASN.n10 1.3755
R54 DELAY_VBIASN.n10 DELAY_VBIASN.n9 1.3755
R55 DELAY_VBIASN.n9 DELAY_VBIASN.n8 1.3755
R56 DELAY_VBIASN.n8 DELAY_VBIASN.n7 1.3755
R57 DELAY_VBIASN.n7 DELAY_VBIASN.n6 1.3755
R58 DELAY_VBIASN.n6 DELAY_VBIASN.n5 1.3755
R59 DELAY_VBIASN.n5 DELAY_VBIASN.n4 1.3755
R60 DELAY_VBIASN.n4 DELAY_VBIASN.n3 1.3755
R61 DELAY_VBIASN.n3 DELAY_VBIASN.n2 1.3755
R62 DELAY_VBIASN.n2 DELAY_VBIASN.n1 1.3755
R63 DELAY_VBIASP.n1 DELAY_VBIASP.t31 34.3685
R64 DELAY_VBIASP.n1 DELAY_VBIASP.t30 33.0005
R65 DELAY_VBIASP.n2 DELAY_VBIASP.t29 33.0005
R66 DELAY_VBIASP.n3 DELAY_VBIASP.t28 33.0005
R67 DELAY_VBIASP.n4 DELAY_VBIASP.t27 33.0005
R68 DELAY_VBIASP.n5 DELAY_VBIASP.t26 33.0005
R69 DELAY_VBIASP.n6 DELAY_VBIASP.t25 33.0005
R70 DELAY_VBIASP.n7 DELAY_VBIASP.t24 33.0005
R71 DELAY_VBIASP.n8 DELAY_VBIASP.t23 33.0005
R72 DELAY_VBIASP.n9 DELAY_VBIASP.t22 33.0005
R73 DELAY_VBIASP.n10 DELAY_VBIASP.t21 33.0005
R74 DELAY_VBIASP.n11 DELAY_VBIASP.t20 33.0005
R75 DELAY_VBIASP.n12 DELAY_VBIASP.t19 33.0005
R76 DELAY_VBIASP.n13 DELAY_VBIASP.t18 33.0005
R77 DELAY_VBIASP.n14 DELAY_VBIASP.t17 33.0005
R78 DELAY_VBIASP.n15 DELAY_VBIASP.t16 33.0005
R79 DELAY_VBIASP.n16 DELAY_VBIASP.t15 33.0005
R80 DELAY_VBIASP.n17 DELAY_VBIASP.t14 33.0005
R81 DELAY_VBIASP.n18 DELAY_VBIASP.t13 33.0005
R82 DELAY_VBIASP.n19 DELAY_VBIASP.t12 33.0005
R83 DELAY_VBIASP.n20 DELAY_VBIASP.t11 33.0005
R84 DELAY_VBIASP.n21 DELAY_VBIASP.t10 33.0005
R85 DELAY_VBIASP.n22 DELAY_VBIASP.t9 33.0005
R86 DELAY_VBIASP.n23 DELAY_VBIASP.t8 33.0005
R87 DELAY_VBIASP.n24 DELAY_VBIASP.t7 33.0005
R88 DELAY_VBIASP.n25 DELAY_VBIASP.t6 33.0005
R89 DELAY_VBIASP.n26 DELAY_VBIASP.t5 33.0005
R90 DELAY_VBIASP.n27 DELAY_VBIASP.t4 33.0005
R91 DELAY_VBIASP.n28 DELAY_VBIASP.t3 33.0005
R92 DELAY_VBIASP.n29 DELAY_VBIASP.t2 33.0005
R93 DELAY_VBIASP.n30 DELAY_VBIASP.t1 33.0005
R94 DELAY_VBIASP.n0 DELAY_VBIASP.t0 33.0005
R95 DELAY_VBIASP DELAY_VBIASP.n0 1.70586
R96 DELAY_VBIASP.n0 DELAY_VBIASP.n30 1.36852
R97 DELAY_VBIASP.n30 DELAY_VBIASP.n29 1.36852
R98 DELAY_VBIASP.n29 DELAY_VBIASP.n28 1.36852
R99 DELAY_VBIASP.n28 DELAY_VBIASP.n27 1.36852
R100 DELAY_VBIASP.n27 DELAY_VBIASP.n26 1.36852
R101 DELAY_VBIASP.n26 DELAY_VBIASP.n25 1.36852
R102 DELAY_VBIASP.n25 DELAY_VBIASP.n24 1.36852
R103 DELAY_VBIASP.n24 DELAY_VBIASP.n23 1.36852
R104 DELAY_VBIASP.n23 DELAY_VBIASP.n22 1.36852
R105 DELAY_VBIASP.n22 DELAY_VBIASP.n21 1.36852
R106 DELAY_VBIASP.n21 DELAY_VBIASP.n20 1.36852
R107 DELAY_VBIASP.n20 DELAY_VBIASP.n19 1.36852
R108 DELAY_VBIASP.n19 DELAY_VBIASP.n18 1.36852
R109 DELAY_VBIASP.n18 DELAY_VBIASP.n17 1.36852
R110 DELAY_VBIASP.n17 DELAY_VBIASP.n16 1.36852
R111 DELAY_VBIASP.n16 DELAY_VBIASP.n15 1.36852
R112 DELAY_VBIASP.n15 DELAY_VBIASP.n14 1.36852
R113 DELAY_VBIASP.n14 DELAY_VBIASP.n13 1.36852
R114 DELAY_VBIASP.n13 DELAY_VBIASP.n12 1.36852
R115 DELAY_VBIASP.n12 DELAY_VBIASP.n11 1.36852
R116 DELAY_VBIASP.n11 DELAY_VBIASP.n10 1.36852
R117 DELAY_VBIASP.n10 DELAY_VBIASP.n9 1.36852
R118 DELAY_VBIASP.n9 DELAY_VBIASP.n8 1.36852
R119 DELAY_VBIASP.n8 DELAY_VBIASP.n7 1.36852
R120 DELAY_VBIASP.n7 DELAY_VBIASP.n6 1.36852
R121 DELAY_VBIASP.n6 DELAY_VBIASP.n5 1.36852
R122 DELAY_VBIASP.n5 DELAY_VBIASP.n4 1.36852
R123 DELAY_VBIASP.n4 DELAY_VBIASP.n3 1.36852
R124 DELAY_VBIASP.n3 DELAY_VBIASP.n2 1.36852
R125 DELAY_VBIASP.n2 DELAY_VBIASP.n1 1.36852
R126 VSS.n5 VSS.n107 7963.82
R127 VSS.t287 VSS.n5 101.74
R128 VSS.n5 VSS.t349 58.3218
R129 VSS.t362 VSS.n5 101.74
R130 VSS.n8 VSS.n5 0.577899
R131 VSS.t552 VSS.n5 21.009
R132 VSS.n5 VSS.n108 0.547872
R133 VSS.n5 VSS.t369 49.8619
R134 VSS.n5 VSS.t357 97.2306
R135 VSS.t339 VSS.n5 49.8619
R136 VSS.n5 VSS.t327 97.2306
R137 VSS.t309 VSS.n5 49.8619
R138 VSS.n5 VSS.t297 97.2306
R139 VSS.n7 VSS.t205 409.723
R140 VSS.n5 VSS.t556 49.7663
R141 VSS.n9 VSS.t122 59.6836
R142 VSS.t562 VSS.n422 357.007
R143 VSS.t561 VSS.n10 343.118
R144 VSS.n5 VSS.t202 97.2225
R145 VSS.n5 VSS.t312 97.2306
R146 VSS.n5 VSS.t342 97.2306
R147 VSS.n5 VSS.t372 97.2306
R148 VSS.t31 VSS.n15 332.017
R149 VSS.n5 VSS.t332 101.74
R150 VSS.n423 VSS.t28 299.425
R151 VSS.t299 VSS.n5 105.689
R152 VSS.n5 VSS.t103 110.546
R153 VSS.t145 VSS.n5 110.547
R154 VSS.t535 VSS.n5 110.547
R155 VSS.t176 VSS.n5 110.547
R156 VSS.t216 VSS.n5 110.547
R157 VSS.t219 VSS.n5 110.547
R158 VSS.t173 VSS.n5 110.547
R159 VSS.n423 VSS.t4 287.909
R160 VSS.n5 VSS.t276 114.148
R161 VSS.n7 VSS.n5 9.73657
R162 VSS.n14 VSS.t63 332.017
R163 VSS.n15 VSS.t33 106.362
R164 VSS.n5 VSS.t174 116.469
R165 VSS.t220 VSS.n5 116.469
R166 VSS.t217 VSS.n5 116.469
R167 VSS.t536 VSS.n5 116.469
R168 VSS.t155 VSS.n12 107.335
R169 VSS.n84 VSS.t275 252.375
R170 VSS.t525 VSS.n69 252.375
R171 VSS.t40 VSS.n53 252.375
R172 VSS.n18 VSS.t36 252.375
R173 VSS.t508 VSS.n78 252.375
R174 VSS.t554 VSS.n76 252.375
R175 VSS.t35 VSS.n73 252.375
R176 VSS.n24 VSS.t428 252.375
R177 VSS.n27 VSS.t376 252.375
R178 VSS.n30 VSS.t515 252.375
R179 VSS.n34 VSS.t39 252.375
R180 VSS.t530 VSS.n66 252.375
R181 VSS.t553 VSS.n63 252.375
R182 VSS.n40 VSS.t509 252.375
R183 VSS.n43 VSS.t46 252.375
R184 VSS.n46 VSS.t195 252.375
R185 VSS.t401 VSS.n51 252.375
R186 VSS.t534 VSS.n81 252.117
R187 VSS.n75 VSS.t183 252.117
R188 VSS.t107 VSS.n67 252.117
R189 VSS.t59 VSS.n60 252.117
R190 VSS.n58 VSS.t124 252.117
R191 VSS.t201 VSS.n56 252.117
R192 VSS.n20 VSS.t555 252.115
R193 VSS.t409 VSS.n97 252.115
R194 VSS.t533 VSS.n96 252.115
R195 VSS.n28 VSS.t406 252.115
R196 VSS.t270 VSS.n92 252.115
R197 VSS.n32 VSS.t249 252.115
R198 VSS.n38 VSS.t200 252.115
R199 VSS.n39 VSS.t532 252.115
R200 VSS.n48 VSS.t192 252.115
R201 VSS.t456 VSS.n237 250.837
R202 VSS.t458 VSS.n239 250.837
R203 VSS.t442 VSS.n245 250.837
R204 VSS.t460 VSS.n247 250.837
R205 VSS.t462 VSS.n253 250.837
R206 VSS.t440 VSS.n255 250.837
R207 VSS.t464 VSS.n261 250.837
R208 VSS.t470 VSS.n263 250.837
R209 VSS.t468 VSS.n269 250.837
R210 VSS.t466 VSS.n271 250.837
R211 VSS.t472 VSS.n277 250.837
R212 VSS.t446 VSS.n279 250.837
R213 VSS.t444 VSS.n285 250.837
R214 VSS.t488 VSS.n287 250.837
R215 VSS.t476 VSS.n293 250.837
R216 VSS.t490 VSS.n295 250.837
R217 VSS.t492 VSS.n301 250.837
R218 VSS.t482 VSS.n303 250.837
R219 VSS.t478 VSS.n309 250.837
R220 VSS.t494 VSS.n311 250.837
R221 VSS.t480 VSS.n317 250.837
R222 VSS.t496 VSS.n319 250.837
R223 VSS.t474 VSS.n325 250.837
R224 VSS.t486 VSS.n327 250.837
R225 VSS.t454 VSS.n333 250.837
R226 VSS.t498 VSS.n335 250.837
R227 VSS.t450 VSS.n341 250.837
R228 VSS.t500 VSS.n343 250.837
R229 VSS.t448 VSS.n349 250.837
R230 VSS.t484 VSS.n351 250.837
R231 VSS.t452 VSS.n357 250.837
R232 VSS.t502 VSS.n359 250.837
R233 VSS.n5 VSS.t395 117.216
R234 VSS.n5 VSS.t292 117.531
R235 VSS.n803 VSS.t248 234.114
R236 VSS.n786 VSS.t190 234.114
R237 VSS.n769 VSS.t424 234.114
R238 VSS.n752 VSS.t171 234.114
R239 VSS.n735 VSS.t8 234.114
R240 VSS.n718 VSS.t86 234.114
R241 VSS.n701 VSS.t432 234.114
R242 VSS.n684 VSS.t160 234.114
R243 VSS.n667 VSS.t90 234.114
R244 VSS.n650 VSS.t162 234.114
R245 VSS.n633 VSS.t273 234.114
R246 VSS.n616 VSS.t505 234.114
R247 VSS.n599 VSS.t419 234.114
R248 VSS.n582 VSS.t127 234.114
R249 VSS.n565 VSS.t73 234.114
R250 VSS.n548 VSS.t412 234.114
R251 VSS.t120 VSS.n422 230.327
R252 VSS.t322 VSS.n5 117.529
R253 VSS.t337 VSS.n5 117.528
R254 VSS.t367 VSS.n5 117.526
R255 VSS.n5 VSS.n11 4666.38
R256 VSS.t246 VSS.n80 225.361
R257 VSS.t430 VSS.n70 225.361
R258 VSS.t164 VSS.n64 225.361
R259 VSS.t506 VSS.n59 225.361
R260 VSS.t125 VSS.n55 225.361
R261 VSS.t74 VSS.n52 225.361
R262 VSS.t225 VSS.n100 225.359
R263 VSS.t188 VSS.n99 225.359
R264 VSS.t425 VSS.n98 225.359
R265 VSS.n22 VSS.t169 225.359
R266 VSS.t6 VSS.n95 225.359
R267 VSS.t88 VSS.n94 225.359
R268 VSS.t158 VSS.n91 225.359
R269 VSS.n36 VSS.t92 225.359
R270 VSS.t271 VSS.n89 225.359
R271 VSS.t417 VSS.n88 225.359
R272 VSS.n5 VSS.t240 116.469
R273 VSS.n5 VSS.t104 116.469
R274 VSS.t250 VSS.n90 211.982
R275 VSS.t76 VSS.n87 211.982
R276 VSS.n23 VSS.t114 211.982
R277 VSS.n26 VSS.t259 211.982
R278 VSS.n29 VSS.t545 211.982
R279 VSS.n31 VSS.t541 211.982
R280 VSS.n33 VSS.t265 211.982
R281 VSS.n37 VSS.t139 211.982
R282 VSS.n42 VSS.t548 211.982
R283 VSS.n45 VSS.t213 211.982
R284 VSS.n83 VSS.t23 211.982
R285 VSS.n79 VSS.t117 211.982
R286 VSS.n77 VSS.t233 211.982
R287 VSS.n74 VSS.t256 211.982
R288 VSS.n61 VSS.t253 211.982
R289 VSS.n54 VSS.t236 211.982
R290 VSS.n9 VSS.t120 221.012
R291 VSS.n10 VSS.t397 107.931
R292 VSS.t153 VSS.n12 398.622
R293 VSS.t187 VSS.n82 195.26
R294 VSS.t524 VSS.n72 195.26
R295 VSS.t282 VSS.n71 195.26
R296 VSS.t410 VSS.n68 195.26
R297 VSS.t198 VSS.n65 195.26
R298 VSS.t420 VSS.n62 195.26
R299 VSS.t181 VSS.n57 195.26
R300 VSS.t41 VSS.n50 195.26
R301 VSS.n19 VSS.t434 195.26
R302 VSS.n21 VSS.t521 195.26
R303 VSS.n25 VSS.t516 195.26
R304 VSS.t67 VSS.n93 195.26
R305 VSS.n35 VSS.t280 195.26
R306 VSS.n41 VSS.t82 195.26
R307 VSS.n44 VSS.t415 195.26
R308 VSS.n47 VSS.t166 195.26
R309 VSS.n15 VSS.n5 6.82739
R310 VSS.n14 VSS.t65 106.362
R311 VSS.n809 VSS.t57 187.292
R312 VSS.n792 VSS.t148 187.292
R313 VSS.n775 VSS.t61 187.292
R314 VSS.n758 VSS.t134 187.292
R315 VSS.n741 VSS.t230 187.292
R316 VSS.n724 VSS.t544 187.292
R317 VSS.n707 VSS.t133 187.292
R318 VSS.n690 VSS.t242 187.292
R319 VSS.n673 VSS.t244 187.292
R320 VSS.n656 VSS.t551 187.292
R321 VSS.n639 VSS.t151 187.292
R322 VSS.n622 VSS.t184 187.292
R323 VSS.n605 VSS.t531 187.292
R324 VSS.n588 VSS.t232 187.292
R325 VSS.n571 VSS.t26 187.292
R326 VSS.n554 VSS.t150 187.292
R327 VSS.n7 VSS.t398 105.523
R328 VSS.n5 VSS.t239 110.546
R329 VSS.t263 VSS.n243 173.913
R330 VSS.t1 VSS.n251 173.913
R331 VSS.t11 VSS.n259 173.913
R332 VSS.n267 VSS.t223 173.913
R333 VSS.n275 VSS.t14 173.913
R334 VSS.t51 VSS.n283 173.913
R335 VSS.n291 VSS.t109 173.913
R336 VSS.t95 VSS.n299 173.913
R337 VSS.t143 VSS.n307 173.913
R338 VSS.t539 VSS.n315 173.913
R339 VSS.t80 VSS.n323 173.913
R340 VSS.t101 VSS.n331 173.913
R341 VSS.t112 VSS.n339 173.913
R342 VSS.t98 VSS.n347 173.913
R343 VSS.t137 VSS.n355 173.913
R344 VSS.t48 VSS.n363 173.913
R345 VSS.t24 VSS.t185 163.881
R346 VSS.t118 VSS.t435 163.881
R347 VSS.t234 VSS.t522 163.881
R348 VSS.t257 VSS.t523 163.881
R349 VSS.t115 VSS.t517 163.881
R350 VSS.t260 VSS.t281 163.881
R351 VSS.t546 VSS.t69 163.881
R352 VSS.t542 VSS.t411 163.881
R353 VSS.t266 VSS.t278 163.881
R354 VSS.t140 VSS.t196 163.881
R355 VSS.t251 VSS.t421 163.881
R356 VSS.t254 VSS.t84 163.881
R357 VSS.t549 VSS.t413 163.881
R358 VSS.t214 VSS.t179 163.881
R359 VSS.t237 VSS.t167 163.881
R360 VSS.t77 VSS.t43 163.881
R361 VSS.n5 VSS.t284 105.689
R362 VSS.t302 VSS.n5 101.74
R363 VSS.n5 VSS.t314 105.688
R364 VSS.n5 VSS.t329 105.688
R365 VSS.n5 VSS.t344 105.689
R366 VSS.n5 VSS.t359 105.689
R367 VSS.t528 VSS.n103 157.062
R368 VSS.t513 VSS.n102 156.429
R369 VSS.t212 VSS.n83 155.126
R370 VSS.t559 VSS.n79 155.126
R371 VSS.t402 VSS.n77 155.126
R372 VSS.t519 VSS.n74 155.126
R373 VSS.t206 VSS.n61 155.126
R374 VSS.t404 VSS.n54 155.126
R375 VSS.n23 VSS.t374 155.125
R376 VSS.n26 VSS.t209 155.125
R377 VSS.n29 VSS.t157 155.125
R378 VSS.n31 VSS.t399 155.125
R379 VSS.n33 VSS.t405 155.125
R380 VSS.n37 VSS.t211 155.125
R381 VSS.t429 VSS.n90 155.125
R382 VSS.n42 VSS.t427 155.125
R383 VSS.n45 VSS.t437 155.125
R384 VSS.t37 VSS.n87 155.125
R385 VSS.n831 VSS.t131 153.846
R386 VSS.n809 VSS.t262 153.846
R387 VSS.n792 VSS.t0 153.846
R388 VSS.n775 VSS.t10 153.846
R389 VSS.n758 VSS.t222 153.846
R390 VSS.n741 VSS.t13 153.846
R391 VSS.n724 VSS.t50 153.846
R392 VSS.n707 VSS.t108 153.846
R393 VSS.n690 VSS.t94 153.846
R394 VSS.n673 VSS.t142 153.846
R395 VSS.n656 VSS.t538 153.846
R396 VSS.n639 VSS.t79 153.846
R397 VSS.n622 VSS.t100 153.846
R398 VSS.n605 VSS.t111 153.846
R399 VSS.n588 VSS.t97 153.846
R400 VSS.n571 VSS.t136 153.846
R401 VSS.n554 VSS.t47 153.846
R402 VSS.t228 VSS.n102 153.327
R403 VSS.t529 VSS.n101 153.236
R404 VSS.t4 VSS.n13 165.508
R405 VSS.t193 VSS.n242 147.157
R406 VSS.t438 VSS.n250 147.157
R407 VSS.t268 VSS.n258 147.157
R408 VSS.t208 VSS.n266 147.157
R409 VSS.t60 VSS.n274 147.157
R410 VSS.t423 VSS.n282 147.157
R411 VSS.t504 VSS.n290 147.157
R412 VSS.t207 VSS.n298 147.157
R413 VSS.t560 VSS.n306 147.157
R414 VSS.t518 VSS.n314 147.157
R415 VSS.t514 VSS.n322 147.157
R416 VSS.t407 VSS.n330 147.157
R417 VSS.t391 VSS.n338 147.157
R418 VSS.t439 VSS.n346 147.157
R419 VSS.t44 VSS.n354 147.157
R420 VSS.t393 VSS.n362 147.157
R421 VSS.t389 VSS.n86 145.093
R422 VSS.t385 VSS.n86 138.404
R423 VSS.n17 VSS.t20 134.661
R424 VSS.n49 VSS.t385 131.974
R425 VSS.n4 VSS.t63 130.939
R426 VSS.n108 VSS.t31 131.005
R427 VSS.n841 VSS.t53 126.945
R428 VSS.n842 VSS.t18 123.212
R429 VSS.n101 VSS.t513 120.691
R430 VSS.n3 VSS.t561 119.422
R431 VSS.t526 VSS.n17 117.858
R432 VSS.t71 VSS.n129 115.745
R433 VSS.t72 VSS.n130 108.276
R434 VSS.n811 VSS.t212 107.023
R435 VSS.n803 VSS.t193 107.023
R436 VSS.n794 VSS.t559 107.023
R437 VSS.n786 VSS.t438 107.023
R438 VSS.n777 VSS.t402 107.023
R439 VSS.n769 VSS.t268 107.023
R440 VSS.n760 VSS.t519 107.023
R441 VSS.n752 VSS.t208 107.023
R442 VSS.t374 VSS.n743 107.023
R443 VSS.n735 VSS.t60 107.023
R444 VSS.t209 VSS.n726 107.023
R445 VSS.n718 VSS.t423 107.023
R446 VSS.t157 VSS.n709 107.023
R447 VSS.n701 VSS.t504 107.023
R448 VSS.t399 VSS.n692 107.023
R449 VSS.n684 VSS.t207 107.023
R450 VSS.t405 VSS.n675 107.023
R451 VSS.n667 VSS.t560 107.023
R452 VSS.t211 VSS.n658 107.023
R453 VSS.n650 VSS.t518 107.023
R454 VSS.n641 VSS.t429 107.023
R455 VSS.n633 VSS.t514 107.023
R456 VSS.n624 VSS.t206 107.023
R457 VSS.n616 VSS.t407 107.023
R458 VSS.t427 VSS.n607 107.023
R459 VSS.n599 VSS.t391 107.023
R460 VSS.t437 VSS.n590 107.023
R461 VSS.n582 VSS.t439 107.023
R462 VSS.n573 VSS.t404 107.023
R463 VSS.n565 VSS.t44 107.023
R464 VSS.n556 VSS.t37 107.023
R465 VSS.n548 VSS.t393 107.023
R466 VSS.n831 VSS.t378 100.335
R467 VSS.t262 VSS.n242 100.335
R468 VSS.t0 VSS.n250 100.335
R469 VSS.t10 VSS.n258 100.335
R470 VSS.t222 VSS.n266 100.335
R471 VSS.t13 VSS.n274 100.335
R472 VSS.t50 VSS.n282 100.335
R473 VSS.t108 VSS.n290 100.335
R474 VSS.t94 VSS.n298 100.335
R475 VSS.t142 VSS.n306 100.335
R476 VSS.t538 VSS.n314 100.335
R477 VSS.t79 VSS.n322 100.335
R478 VSS.t100 VSS.n330 100.335
R479 VSS.t111 VSS.n338 100.335
R480 VSS.t97 VSS.n346 100.335
R481 VSS.t136 VSS.n354 100.335
R482 VSS.t47 VSS.n362 100.335
R483 VSS.n840 VSS.t227 97.0758
R484 VSS.n2 VSS.t562 96.5008
R485 VSS.t55 VSS.n103 93.5889
R486 VSS.n840 VSS.t21 93.3421
R487 VSS.n49 VSS.t48 88.4945
R488 VSS.t223 VSS.n97 88.2366
R489 VSS.t14 VSS.n96 88.2366
R490 VSS.t109 VSS.n92 88.2366
R491 VSS.n20 VSS.t1 88.2366
R492 VSS.n28 VSS.t51 88.2366
R493 VSS.n32 VSS.t95 88.2366
R494 VSS.n38 VSS.t539 88.2366
R495 VSS.n39 VSS.t80 88.2366
R496 VSS.n48 VSS.t137 88.2366
R497 VSS.n81 VSS.t263 88.2359
R498 VSS.n75 VSS.t11 88.2359
R499 VSS.n67 VSS.t143 88.2359
R500 VSS.n60 VSS.t101 88.2359
R501 VSS.n58 VSS.t112 88.2359
R502 VSS.n56 VSS.t98 88.2359
R503 VSS.n16 VSS.t510 88.133
R504 VSS.n107 VSS.n105 2.77711
R505 VSS.t378 VSS.t129 86.957
R506 VSS.t131 VSS.t382 86.957
R507 VSS.t3 VSS.n2 69.4495
R508 VSS.t510 VSS.n11 82.7875
R509 VSS.n130 VSS.t512 82.1411
R510 VSS.t512 VSS.n104 75.0671
R511 VSS.t129 VSS.n85 74.8587
R512 VSS.t16 VSS.n129 74.6738
R513 VSS.n9 VSS.n5 2.67074
R514 VSS.n811 VSS.t24 70.2346
R515 VSS.n794 VSS.t118 70.2346
R516 VSS.n777 VSS.t234 70.2346
R517 VSS.n760 VSS.t257 70.2346
R518 VSS.n743 VSS.t115 70.2346
R519 VSS.n726 VSS.t260 70.2346
R520 VSS.n709 VSS.t546 70.2346
R521 VSS.n692 VSS.t542 70.2346
R522 VSS.n675 VSS.t266 70.2346
R523 VSS.n658 VSS.t140 70.2346
R524 VSS.n641 VSS.t251 70.2346
R525 VSS.n624 VSS.t254 70.2346
R526 VSS.n607 VSS.t549 70.2346
R527 VSS.n590 VSS.t214 70.2346
R528 VSS.n573 VSS.t237 70.2346
R529 VSS.n556 VSS.t77 70.2346
R530 VSS.t304 VSS.n5 58.3211
R531 VSS.t319 VSS.n5 58.3216
R532 VSS.t334 VSS.n5 58.3225
R533 VSS.n5 VSS.t352 117.529
R534 VSS.t364 VSS.n5 58.3294
R535 VSS.n842 VSS.t16 67.2065
R536 VSS.n810 VSS.t187 66.8901
R537 VSS.t57 VSS.n239 66.8901
R538 VSS.t434 VSS.n793 66.8901
R539 VSS.t148 VSS.n247 66.8901
R540 VSS.t521 VSS.n776 66.8901
R541 VSS.t61 VSS.n255 66.8901
R542 VSS.n759 VSS.t524 66.8901
R543 VSS.t134 VSS.n263 66.8901
R544 VSS.t516 VSS.n742 66.8901
R545 VSS.t230 VSS.n271 66.8901
R546 VSS.n725 VSS.t282 66.8901
R547 VSS.t544 VSS.n279 66.8901
R548 VSS.n708 VSS.t67 66.8901
R549 VSS.t133 VSS.n287 66.8901
R550 VSS.n691 VSS.t410 66.8901
R551 VSS.t242 VSS.n295 66.8901
R552 VSS.t280 VSS.n674 66.8901
R553 VSS.t244 VSS.n303 66.8901
R554 VSS.n657 VSS.t198 66.8901
R555 VSS.t551 VSS.n311 66.8901
R556 VSS.n640 VSS.t420 66.8901
R557 VSS.t151 VSS.n319 66.8901
R558 VSS.t82 VSS.n623 66.8901
R559 VSS.t184 VSS.n327 66.8901
R560 VSS.t415 VSS.n606 66.8901
R561 VSS.t531 VSS.n335 66.8901
R562 VSS.n589 VSS.t181 66.8901
R563 VSS.t232 VSS.n343 66.8901
R564 VSS.t166 VSS.n572 66.8901
R565 VSS.t26 VSS.n351 66.8901
R566 VSS.n555 VSS.t41 66.8901
R567 VSS.t150 VSS.n359 66.8901
R568 VSS.n841 VSS.t55 63.4728
R569 VSS.t21 VSS.n132 62.2523
R570 VSS.t153 VSS.n3 61.8407
R571 VSS.t227 VSS.n839 58.5186
R572 VSS.n5 VSS.t294 49.8619
R573 VSS.n5 VSS.t324 49.8619
R574 VSS.n5 VSS.t354 49.8619
R575 VSS.n16 VSS.t526 54.532
R576 VSS.t205 VSS.n4 50.3244
R577 VSS.t106 VSS.n108 44.8755
R578 VSS.t23 VSS.n237 50.1677
R579 VSS.t117 VSS.n245 50.1677
R580 VSS.t233 VSS.n253 50.1677
R581 VSS.t256 VSS.n261 50.1677
R582 VSS.t114 VSS.n269 50.1677
R583 VSS.t259 VSS.n277 50.1677
R584 VSS.t545 VSS.n285 50.1677
R585 VSS.t541 VSS.n293 50.1677
R586 VSS.t265 VSS.n301 50.1677
R587 VSS.t139 VSS.n309 50.1677
R588 VSS.n317 VSS.t250 50.1677
R589 VSS.t253 VSS.n325 50.1677
R590 VSS.t548 VSS.n333 50.1677
R591 VSS.t213 VSS.n341 50.1677
R592 VSS.t236 VSS.n349 50.1677
R593 VSS.n357 VSS.t76 50.1677
R594 VSS.n131 VSS.t72 47.3176
R595 VSS.n843 VSS.t71 39.8503
R596 VSS.n818 VSS.t225 36.7898
R597 VSS.n802 VSS.t246 36.7898
R598 VSS.n785 VSS.t188 36.7898
R599 VSS.n768 VSS.t425 36.7898
R600 VSS.t169 VSS.n751 36.7898
R601 VSS.n734 VSS.t6 36.7898
R602 VSS.n717 VSS.t88 36.7898
R603 VSS.n700 VSS.t430 36.7898
R604 VSS.n683 VSS.t158 36.7898
R605 VSS.t92 VSS.n666 36.7898
R606 VSS.n649 VSS.t164 36.7898
R607 VSS.n632 VSS.t271 36.7898
R608 VSS.n615 VSS.t506 36.7898
R609 VSS.n598 VSS.t417 36.7898
R610 VSS.n581 VSS.t125 36.7898
R611 VSS.n564 VSS.t74 36.7898
R612 VSS.t20 VSS.n843 36.1166
R613 VSS.t18 VSS.n104 33.9948
R614 VSS.t53 VSS.n131 28.6493
R615 VSS.t185 VSS.n18 28.2938
R616 VSS.t435 VSS.n78 28.2938
R617 VSS.t522 VSS.n76 28.2938
R618 VSS.t523 VSS.n73 28.2938
R619 VSS.t517 VSS.n24 28.2938
R620 VSS.t281 VSS.n27 28.2938
R621 VSS.t69 VSS.n30 28.2938
R622 VSS.t278 VSS.n34 28.2938
R623 VSS.t196 VSS.n66 28.2938
R624 VSS.t421 VSS.n63 28.2938
R625 VSS.t84 VSS.n40 28.2938
R626 VSS.t413 VSS.n43 28.2938
R627 VSS.t179 VSS.n46 28.2938
R628 VSS.t43 VSS.n51 28.2938
R629 VSS.t411 VSS.n69 28.2928
R630 VSS.t167 VSS.n53 28.2928
R631 VSS.n85 VSS.t529 28.0352
R632 VSS.n8 VSS.t29 25.6732
R633 VSS.t557 VSS.n5 21.1052
R634 VSS.t382 VSS.n84 21.6039
R635 VSS.t248 VSS.n243 20.0674
R636 VSS.t190 VSS.n251 20.0674
R637 VSS.t424 VSS.n259 20.0674
R638 VSS.t171 VSS.n267 20.0674
R639 VSS.t8 VSS.n275 20.0674
R640 VSS.t86 VSS.n283 20.0674
R641 VSS.t432 VSS.n291 20.0674
R642 VSS.t160 VSS.n299 20.0674
R643 VSS.t90 VSS.n307 20.0674
R644 VSS.t162 VSS.n315 20.0674
R645 VSS.t273 VSS.n323 20.0674
R646 VSS.t505 VSS.n331 20.0674
R647 VSS.t419 VSS.n339 20.0674
R648 VSS.t127 VSS.n347 20.0674
R649 VSS.t73 VSS.n355 20.0674
R650 VSS.t412 VSS.n363 20.0674
R651 VSS.t275 VSS.n100 18.0025
R652 VSS.t555 VSS.n99 18.0025
R653 VSS.t183 VSS.n98 18.0025
R654 VSS.n95 VSS.t533 18.0025
R655 VSS.t406 VSS.n94 18.0025
R656 VSS.t515 VSS.n93 18.0025
R657 VSS.t249 VSS.n91 18.0025
R658 VSS.t532 VSS.n89 18.0025
R659 VSS.t124 VSS.n88 18.0025
R660 VSS.n19 VSS.t508 18.0025
R661 VSS.n21 VSS.t554 18.0025
R662 VSS.n22 VSS.t409 18.0025
R663 VSS.t428 VSS.n25 18.0025
R664 VSS.t39 VSS.n35 18.0025
R665 VSS.n36 VSS.t107 18.0025
R666 VSS.t509 VSS.n41 18.0025
R667 VSS.t46 VSS.n44 18.0025
R668 VSS.n47 VSS.t40 18.0025
R669 VSS.t36 VSS.n82 18.0017
R670 VSS.n80 VSS.t534 18.0017
R671 VSS.n72 VSS.t35 18.0017
R672 VSS.t376 VSS.n71 18.0017
R673 VSS.n70 VSS.t270 18.0017
R674 VSS.n68 VSS.t525 18.0017
R675 VSS.n65 VSS.t530 18.0017
R676 VSS.t200 VSS.n64 18.0017
R677 VSS.n62 VSS.t553 18.0017
R678 VSS.n59 VSS.t59 18.0017
R679 VSS.t195 VSS.n57 18.0017
R680 VSS.n55 VSS.t201 18.0017
R681 VSS.t192 VSS.n52 18.0017
R682 VSS.n50 VSS.t401 18.0017
R683 VSS.n839 VSS.t228 17.4483
R684 VSS.n857 VSS.t22 17.3368
R685 VSS.n853 VSS.t54 17.3368
R686 VSS.n849 VSS.t17 17.3368
R687 VSS.n430 VSS.t121 17.3368
R688 VSS.n434 VSS.t154 17.3368
R689 VSS.n438 VSS.t5 17.3368
R690 VSS.n442 VSS.t64 17.3368
R691 VSS.n836 VSS.t130 17.3368
R692 VSS.n491 VSS.t32 17.2607
R693 VSS.n421 VSS.t286 17.2313
R694 VSS.n449 VSS.t291 17.2313
R695 VSS.n453 VSS.t296 17.2313
R696 VSS.n413 VSS.t301 17.2313
R697 VSS.n464 VSS.t306 17.2313
R698 VSS.n468 VSS.t311 17.2313
R699 VSS.n405 VSS.t316 17.2313
R700 VSS.n479 VSS.t321 17.2313
R701 VSS.n483 VSS.t326 17.2313
R702 VSS.n397 VSS.t331 17.2313
R703 VSS.n502 VSS.t336 17.2313
R704 VSS.n506 VSS.t341 17.2313
R705 VSS.n389 VSS.t346 17.2313
R706 VSS.n517 VSS.t351 17.2313
R707 VSS.n521 VSS.t356 17.2313
R708 VSS.n381 VSS.t361 17.2313
R709 VSS.n532 VSS.t366 17.2313
R710 VSS.n536 VSS.t371 17.2313
R711 VSS.n844 VSS.n105 17.0005
R712 VSS.n105 VSS.n129 17.0005
R713 VSS.n105 VSS.n842 17.0005
R714 VSS.n105 VSS.n130 17.0005
R715 VSS.n105 VSS.n841 17.0005
R716 VSS.n105 VSS.n840 17.0005
R717 VSS.n105 VSS.n838 17.0005
R718 VSS.n105 VSS.n236 17.0005
R719 VSS.n105 VSS.n241 17.0005
R720 VSS.n105 VSS.n249 17.0005
R721 VSS.n105 VSS.n257 17.0005
R722 VSS.n105 VSS.n265 17.0005
R723 VSS.n105 VSS.n273 17.0005
R724 VSS.n105 VSS.n281 17.0005
R725 VSS.n105 VSS.n289 17.0005
R726 VSS.n105 VSS.n297 17.0005
R727 VSS.n105 VSS.n305 17.0005
R728 VSS.n105 VSS.n313 17.0005
R729 VSS.n105 VSS.n321 17.0005
R730 VSS.n105 VSS.n329 17.0005
R731 VSS.n105 VSS.n337 17.0005
R732 VSS.n105 VSS.n345 17.0005
R733 VSS.n105 VSS.n353 17.0005
R734 VSS.n105 VSS.n361 17.0005
R735 VSS.n105 VSS.n364 17.0005
R736 VSS.n105 VSS.n547 17.0005
R737 VSS.n105 VSS.n365 17.0005
R738 VSS.n105 VSS.n542 17.0005
R739 VSS.n105 VSS.n366 17.0005
R740 VSS.n105 VSS.n234 17.0005
R741 VSS.n105 VSS.n134 17.0005
R742 VSS.n5 VSS.n123 5.65652
R743 VSS.n5 VSS.n114 5.65652
R744 VSS.n5 VSS.n14 6.82737
R745 VSS.n5 VSS.n423 17.0005
R746 VSS.n5 VSS.n13 0.592458
R747 VSS.n5 VSS.n12 9.32125
R748 VSS.n5 VSS.n10 7.24297
R749 VSS.n5 VSS.n422 17.0005
R750 VSS.n425 VSS.n5 17.0005
R751 VSS.n424 VSS.t285 17.0005
R752 VSS.n420 VSS.t288 17.0005
R753 VSS.n447 VSS.t290 17.0005
R754 VSS.n417 VSS.t293 17.0005
R755 VSS.n416 VSS.t295 17.0005
R756 VSS.n415 VSS.t298 17.0005
R757 VSS.n414 VSS.t300 17.0005
R758 VSS.n412 VSS.t303 17.0005
R759 VSS.n462 VSS.t305 17.0005
R760 VSS.n409 VSS.t308 17.0005
R761 VSS.n408 VSS.t310 17.0005
R762 VSS.n407 VSS.t313 17.0005
R763 VSS.n406 VSS.t315 17.0005
R764 VSS.n404 VSS.t318 17.0005
R765 VSS.n477 VSS.t320 17.0005
R766 VSS.n401 VSS.t323 17.0005
R767 VSS.n400 VSS.t325 17.0005
R768 VSS.n399 VSS.t328 17.0005
R769 VSS.n398 VSS.t330 17.0005
R770 VSS.n396 VSS.t333 17.0005
R771 VSS.n500 VSS.t335 17.0005
R772 VSS.n393 VSS.t338 17.0005
R773 VSS.n392 VSS.t340 17.0005
R774 VSS.n391 VSS.t343 17.0005
R775 VSS.n390 VSS.t345 17.0005
R776 VSS.n388 VSS.t348 17.0005
R777 VSS.n515 VSS.t350 17.0005
R778 VSS.n385 VSS.t353 17.0005
R779 VSS.n384 VSS.t355 17.0005
R780 VSS.n383 VSS.t358 17.0005
R781 VSS.n382 VSS.t360 17.0005
R782 VSS.n380 VSS.t363 17.0005
R783 VSS.n530 VSS.t365 17.0005
R784 VSS.n377 VSS.t368 17.0005
R785 VSS.n376 VSS.t370 17.0005
R786 VSS.n373 VSS.t373 17.0005
R787 VSS.n13 VSS.t204 15.2265
R788 VSS.n420 VSS.t597 15.3099
R789 VSS.n417 VSS.t595 15.3099
R790 VSS.n415 VSS.t593 15.3099
R791 VSS.n412 VSS.t591 15.3099
R792 VSS.n409 VSS.t589 15.3099
R793 VSS.n407 VSS.t587 15.3099
R794 VSS.n404 VSS.t585 15.3099
R795 VSS.n401 VSS.t583 15.3099
R796 VSS.n399 VSS.t581 15.3099
R797 VSS.n396 VSS.t579 15.3099
R798 VSS.n393 VSS.t577 15.3099
R799 VSS.n391 VSS.t575 15.3099
R800 VSS.n388 VSS.t573 15.3099
R801 VSS.n385 VSS.t571 15.3099
R802 VSS.n383 VSS.t569 15.3099
R803 VSS.n380 VSS.t567 15.3099
R804 VSS.n377 VSS.t565 15.3099
R805 VSS.n373 VSS.t563 15.3099
R806 VSS.n424 VSS.t598 15.2696
R807 VSS.n447 VSS.t596 15.2696
R808 VSS.n416 VSS.t594 15.2696
R809 VSS.n414 VSS.t592 15.2696
R810 VSS.n462 VSS.t590 15.2696
R811 VSS.n408 VSS.t588 15.2696
R812 VSS.n406 VSS.t586 15.2696
R813 VSS.n477 VSS.t584 15.2696
R814 VSS.n400 VSS.t582 15.2696
R815 VSS.n398 VSS.t580 15.2696
R816 VSS.n500 VSS.t578 15.2696
R817 VSS.n392 VSS.t576 15.2696
R818 VSS.n390 VSS.t574 15.2696
R819 VSS.n515 VSS.t572 15.2696
R820 VSS.n384 VSS.t570 15.2696
R821 VSS.n382 VSS.t568 15.2696
R822 VSS.n530 VSS.t566 15.2696
R823 VSS.n376 VSS.t564 15.2696
R824 VSS.n543 VSS.t384 15.1276
R825 VSS.n369 VSS.t388 15.0005
R826 VSS.n824 VSS.t381 15.0005
R827 VSS.n833 VSS.t377 15.0005
R828 VSS.n132 VSS.t528 13.7147
R829 VSS.n169 VSS.t394 8.85039
R830 VSS.n171 VSS.t38 8.85039
R831 VSS.n173 VSS.t45 8.85039
R832 VSS.n175 VSS.t168 8.85039
R833 VSS.n177 VSS.t128 8.85039
R834 VSS.n179 VSS.t180 8.85039
R835 VSS.n181 VSS.t392 8.85039
R836 VSS.n183 VSS.t414 8.85039
R837 VSS.n185 VSS.t408 8.85039
R838 VSS.n187 VSS.t85 8.85039
R839 VSS.n189 VSS.t274 8.85039
R840 VSS.n191 VSS.t422 8.85039
R841 VSS.n193 VSS.t163 8.85039
R842 VSS.n195 VSS.t197 8.85039
R843 VSS.n197 VSS.t91 8.85039
R844 VSS.n199 VSS.t279 8.85039
R845 VSS.n201 VSS.t161 8.85039
R846 VSS.n203 VSS.t400 8.85039
R847 VSS.n205 VSS.t433 8.85039
R848 VSS.n207 VSS.t70 8.85039
R849 VSS.n209 VSS.t87 8.85039
R850 VSS.n211 VSS.t210 8.85039
R851 VSS.n213 VSS.t9 8.85039
R852 VSS.n215 VSS.t375 8.85039
R853 VSS.n217 VSS.t172 8.85039
R854 VSS.n219 VSS.t520 8.85039
R855 VSS.n221 VSS.t269 8.85039
R856 VSS.n223 VSS.t403 8.85039
R857 VSS.n225 VSS.t191 8.85039
R858 VSS.n227 VSS.t436 8.85039
R859 VSS.n229 VSS.t194 8.85039
R860 VSS.n231 VSS.t186 8.85039
R861 VSS.n859 VSS.t229 8.80385
R862 VSS.n855 VSS.t56 8.80385
R863 VSS.n851 VSS.t19 8.80385
R864 VSS.n828 VSS.t132 8.80385
R865 VSS.n432 VSS.t123 8.80285
R866 VSS.n436 VSS.t156 8.80285
R867 VSS.n440 VSS.t30 8.80285
R868 VSS.n0 VSS.t66 8.80285
R869 VSS.n549 VSS.t49 8.77423
R870 VSS.n360 VSS.t42 8.77423
R871 VSS.n557 VSS.t78 8.77423
R872 VSS.n562 VSS.t75 8.77423
R873 VSS.n566 VSS.t138 8.77423
R874 VSS.n352 VSS.t27 8.77423
R875 VSS.n574 VSS.t238 8.77423
R876 VSS.n579 VSS.t126 8.77423
R877 VSS.n583 VSS.t99 8.77423
R878 VSS.n344 VSS.t182 8.77423
R879 VSS.n591 VSS.t215 8.77423
R880 VSS.n596 VSS.t418 8.77423
R881 VSS.n600 VSS.t113 8.77423
R882 VSS.n336 VSS.t416 8.77423
R883 VSS.n608 VSS.t550 8.77423
R884 VSS.n613 VSS.t507 8.77423
R885 VSS.n617 VSS.t102 8.77423
R886 VSS.n328 VSS.t83 8.77423
R887 VSS.n625 VSS.t255 8.77423
R888 VSS.n630 VSS.t272 8.77423
R889 VSS.n634 VSS.t81 8.77423
R890 VSS.n320 VSS.t152 8.77423
R891 VSS.n642 VSS.t252 8.77423
R892 VSS.n647 VSS.t165 8.77423
R893 VSS.n651 VSS.t540 8.77423
R894 VSS.n312 VSS.t199 8.77423
R895 VSS.n659 VSS.t141 8.77423
R896 VSS.n664 VSS.t93 8.77423
R897 VSS.n668 VSS.t144 8.77423
R898 VSS.n304 VSS.t245 8.77423
R899 VSS.n676 VSS.t267 8.77423
R900 VSS.n681 VSS.t159 8.77423
R901 VSS.n685 VSS.t96 8.77423
R902 VSS.n296 VSS.t243 8.77423
R903 VSS.n693 VSS.t543 8.77423
R904 VSS.n698 VSS.t431 8.77423
R905 VSS.n702 VSS.t110 8.77423
R906 VSS.n288 VSS.t68 8.77423
R907 VSS.n710 VSS.t547 8.77423
R908 VSS.n715 VSS.t89 8.77423
R909 VSS.n719 VSS.t52 8.77423
R910 VSS.n280 VSS.t283 8.77423
R911 VSS.n727 VSS.t261 8.77423
R912 VSS.n732 VSS.t7 8.77423
R913 VSS.n736 VSS.t15 8.77423
R914 VSS.n272 VSS.t231 8.77423
R915 VSS.n744 VSS.t116 8.77423
R916 VSS.n749 VSS.t170 8.77423
R917 VSS.n753 VSS.t224 8.77423
R918 VSS.n264 VSS.t135 8.77423
R919 VSS.n761 VSS.t258 8.77423
R920 VSS.n766 VSS.t426 8.77423
R921 VSS.n770 VSS.t12 8.77423
R922 VSS.n256 VSS.t62 8.77423
R923 VSS.n778 VSS.t235 8.77423
R924 VSS.n783 VSS.t189 8.77423
R925 VSS.n787 VSS.t2 8.77423
R926 VSS.n248 VSS.t149 8.77423
R927 VSS.n795 VSS.t119 8.77423
R928 VSS.n800 VSS.t247 8.77423
R929 VSS.n804 VSS.t264 8.77423
R930 VSS.n240 VSS.t58 8.77423
R931 VSS.n812 VSS.t25 8.77423
R932 VSS.n819 VSS.t226 8.77423
R933 VSS.n6 VSS.t175 8.82841
R934 VSS.n457 VSS.t221 8.77323
R935 VSS.n472 VSS.t218 8.77323
R936 VSS.n487 VSS.t241 8.77323
R937 VSS.n489 VSS.t558 8.77323
R938 VSS.n495 VSS.t178 8.77323
R939 VSS.n510 VSS.t537 8.77323
R940 VSS.n525 VSS.t147 8.77323
R941 VSS.n371 VSS.t105 8.77323
R942 VSS.n1 VSS.t277 8.79211
R943 VSS.n493 VSS.t34 8.76678
R944 VSS.n847 VSS.t527 8.75731
R945 VSS.n845 VSS.t511 8.75731
R946 VSS.n426 VSS.t396 8.75631
R947 VSS.n428 VSS.t203 8.75631
R948 VSS.n535 VSS.n127 0.0435295
R949 VSS.n126 VSS.n5 5.65652
R950 VSS.n125 VSS.n527 0.0633111
R951 VSS.n520 VSS.n124 0.0435295
R952 VSS.n514 VSS.n123 0.0180497
R953 VSS.n122 VSS.n512 0.0633111
R954 VSS.n121 VSS.n5 4.22409
R955 VSS.n120 VSS.n5 5.65652
R956 VSS.n119 VSS.n497 0.0633111
R957 VSS.n482 VSS.n118 0.0435295
R958 VSS.n117 VSS.n5 5.65652
R959 VSS.n116 VSS.n474 0.0633111
R960 VSS.n467 VSS.n115 0.0435295
R961 VSS.n461 VSS.n114 0.0180497
R962 VSS.n113 VSS.n459 0.0633111
R963 VSS.n112 VSS.n5 4.22409
R964 VSS.n111 VSS.n5 5.65652
R965 VSS.n110 VSS.n444 0.0633111
R966 VSS.n105 VSS.n831 8.5005
R967 VSS.n105 VSS.n818 8.5005
R968 VSS.n105 VSS.n237 8.5005
R969 VSS.n105 VSS.n811 8.5005
R970 VSS.n105 VSS.n810 8.5005
R971 VSS.n105 VSS.n239 8.5005
R972 VSS.n105 VSS.n809 8.5005
R973 VSS.n105 VSS.n242 8.5005
R974 VSS.n105 VSS.n803 8.5005
R975 VSS.n105 VSS.n243 8.5005
R976 VSS.n105 VSS.n802 8.5005
R977 VSS.n105 VSS.n245 8.5005
R978 VSS.n105 VSS.n794 8.5005
R979 VSS.n105 VSS.n793 8.5005
R980 VSS.n105 VSS.n247 8.5005
R981 VSS.n105 VSS.n792 8.5005
R982 VSS.n105 VSS.n250 8.5005
R983 VSS.n105 VSS.n786 8.5005
R984 VSS.n105 VSS.n251 8.5005
R985 VSS.n105 VSS.n785 8.5005
R986 VSS.n105 VSS.n253 8.5005
R987 VSS.n105 VSS.n777 8.5005
R988 VSS.n105 VSS.n776 8.5005
R989 VSS.n105 VSS.n255 8.5005
R990 VSS.n105 VSS.n775 8.5005
R991 VSS.n105 VSS.n258 8.5005
R992 VSS.n105 VSS.n769 8.5005
R993 VSS.n105 VSS.n259 8.5005
R994 VSS.n105 VSS.n768 8.5005
R995 VSS.n105 VSS.n261 8.5005
R996 VSS.n105 VSS.n760 8.5005
R997 VSS.n105 VSS.n759 8.5005
R998 VSS.n105 VSS.n263 8.5005
R999 VSS.n105 VSS.n758 8.5005
R1000 VSS.n105 VSS.n266 8.5005
R1001 VSS.n105 VSS.n752 8.5005
R1002 VSS.n105 VSS.n267 8.5005
R1003 VSS.n105 VSS.n751 8.5005
R1004 VSS.n105 VSS.n269 8.5005
R1005 VSS.n105 VSS.n743 8.5005
R1006 VSS.n105 VSS.n742 8.5005
R1007 VSS.n105 VSS.n271 8.5005
R1008 VSS.n105 VSS.n741 8.5005
R1009 VSS.n105 VSS.n274 8.5005
R1010 VSS.n105 VSS.n735 8.5005
R1011 VSS.n105 VSS.n275 8.5005
R1012 VSS.n105 VSS.n734 8.5005
R1013 VSS.n105 VSS.n277 8.5005
R1014 VSS.n105 VSS.n726 8.5005
R1015 VSS.n105 VSS.n725 8.5005
R1016 VSS.n105 VSS.n279 8.5005
R1017 VSS.n105 VSS.n724 8.5005
R1018 VSS.n105 VSS.n282 8.5005
R1019 VSS.n105 VSS.n718 8.5005
R1020 VSS.n105 VSS.n283 8.5005
R1021 VSS.n105 VSS.n717 8.5005
R1022 VSS.n105 VSS.n285 8.5005
R1023 VSS.n105 VSS.n709 8.5005
R1024 VSS.n105 VSS.n708 8.5005
R1025 VSS.n105 VSS.n287 8.5005
R1026 VSS.n105 VSS.n707 8.5005
R1027 VSS.n105 VSS.n290 8.5005
R1028 VSS.n105 VSS.n701 8.5005
R1029 VSS.n105 VSS.n291 8.5005
R1030 VSS.n105 VSS.n700 8.5005
R1031 VSS.n105 VSS.n293 8.5005
R1032 VSS.n105 VSS.n692 8.5005
R1033 VSS.n105 VSS.n691 8.5005
R1034 VSS.n105 VSS.n295 8.5005
R1035 VSS.n105 VSS.n690 8.5005
R1036 VSS.n105 VSS.n298 8.5005
R1037 VSS.n105 VSS.n684 8.5005
R1038 VSS.n105 VSS.n299 8.5005
R1039 VSS.n105 VSS.n683 8.5005
R1040 VSS.n105 VSS.n301 8.5005
R1041 VSS.n105 VSS.n675 8.5005
R1042 VSS.n105 VSS.n674 8.5005
R1043 VSS.n105 VSS.n303 8.5005
R1044 VSS.n105 VSS.n673 8.5005
R1045 VSS.n105 VSS.n306 8.5005
R1046 VSS.n105 VSS.n667 8.5005
R1047 VSS.n105 VSS.n307 8.5005
R1048 VSS.n105 VSS.n666 8.5005
R1049 VSS.n105 VSS.n309 8.5005
R1050 VSS.n105 VSS.n658 8.5005
R1051 VSS.n105 VSS.n657 8.5005
R1052 VSS.n105 VSS.n311 8.5005
R1053 VSS.n105 VSS.n656 8.5005
R1054 VSS.n105 VSS.n314 8.5005
R1055 VSS.n105 VSS.n650 8.5005
R1056 VSS.n105 VSS.n315 8.5005
R1057 VSS.n105 VSS.n649 8.5005
R1058 VSS.n105 VSS.n317 8.5005
R1059 VSS.n105 VSS.n641 8.5005
R1060 VSS.n105 VSS.n640 8.5005
R1061 VSS.n105 VSS.n319 8.5005
R1062 VSS.n105 VSS.n639 8.5005
R1063 VSS.n105 VSS.n322 8.5005
R1064 VSS.n105 VSS.n633 8.5005
R1065 VSS.n105 VSS.n323 8.5005
R1066 VSS.n105 VSS.n632 8.5005
R1067 VSS.n105 VSS.n325 8.5005
R1068 VSS.n105 VSS.n624 8.5005
R1069 VSS.n105 VSS.n623 8.5005
R1070 VSS.n105 VSS.n327 8.5005
R1071 VSS.n105 VSS.n622 8.5005
R1072 VSS.n105 VSS.n330 8.5005
R1073 VSS.n105 VSS.n616 8.5005
R1074 VSS.n105 VSS.n331 8.5005
R1075 VSS.n105 VSS.n615 8.5005
R1076 VSS.n105 VSS.n333 8.5005
R1077 VSS.n105 VSS.n607 8.5005
R1078 VSS.n105 VSS.n606 8.5005
R1079 VSS.n105 VSS.n335 8.5005
R1080 VSS.n105 VSS.n605 8.5005
R1081 VSS.n105 VSS.n338 8.5005
R1082 VSS.n105 VSS.n599 8.5005
R1083 VSS.n105 VSS.n339 8.5005
R1084 VSS.n105 VSS.n598 8.5005
R1085 VSS.n105 VSS.n341 8.5005
R1086 VSS.n105 VSS.n590 8.5005
R1087 VSS.n105 VSS.n589 8.5005
R1088 VSS.n105 VSS.n343 8.5005
R1089 VSS.n105 VSS.n588 8.5005
R1090 VSS.n105 VSS.n346 8.5005
R1091 VSS.n105 VSS.n582 8.5005
R1092 VSS.n105 VSS.n347 8.5005
R1093 VSS.n105 VSS.n581 8.5005
R1094 VSS.n105 VSS.n349 8.5005
R1095 VSS.n105 VSS.n573 8.5005
R1096 VSS.n105 VSS.n572 8.5005
R1097 VSS.n105 VSS.n351 8.5005
R1098 VSS.n105 VSS.n571 8.5005
R1099 VSS.n105 VSS.n354 8.5005
R1100 VSS.n105 VSS.n565 8.5005
R1101 VSS.n105 VSS.n355 8.5005
R1102 VSS.n105 VSS.n564 8.5005
R1103 VSS.n105 VSS.n357 8.5005
R1104 VSS.n105 VSS.n556 8.5005
R1105 VSS.n105 VSS.n555 8.5005
R1106 VSS.n105 VSS.n359 8.5005
R1107 VSS.n105 VSS.n554 8.5005
R1108 VSS.n105 VSS.n362 8.5005
R1109 VSS.n105 VSS.n548 8.5005
R1110 VSS.n105 VSS.n363 8.5005
R1111 VSS.n107 VSS.t389 122.516
R1112 VSS.n534 VSS.n5 8.49319
R1113 VSS.n519 VSS.n5 8.49319
R1114 VSS.n504 VSS.n5 8.49319
R1115 VSS.n481 VSS.n5 8.49319
R1116 VSS.n466 VSS.n5 8.49319
R1117 VSS.n451 VSS.n5 8.49319
R1118 VSS.n858 VSS.n105 8.47732
R1119 VSS.n105 VSS.n235 8.47732
R1120 VSS.n105 VSS.n817 8.47732
R1121 VSS.n105 VSS.n801 8.47732
R1122 VSS.n105 VSS.n784 8.47732
R1123 VSS.n105 VSS.n767 8.47732
R1124 VSS.n105 VSS.n750 8.47732
R1125 VSS.n105 VSS.n733 8.47732
R1126 VSS.n105 VSS.n716 8.47732
R1127 VSS.n105 VSS.n699 8.47732
R1128 VSS.n105 VSS.n682 8.47732
R1129 VSS.n105 VSS.n665 8.47732
R1130 VSS.n105 VSS.n648 8.47732
R1131 VSS.n105 VSS.n631 8.47732
R1132 VSS.n105 VSS.n614 8.47732
R1133 VSS.n105 VSS.n597 8.47732
R1134 VSS.n105 VSS.n580 8.47732
R1135 VSS.n105 VSS.n563 8.47732
R1136 VSS.n105 VSS.n133 8.47732
R1137 VSS.n105 VSS.n168 8.47732
R1138 VSS.n105 VSS.n167 8.47732
R1139 VSS.n5 VSS.n127 4.22409
R1140 VSS.n528 VSS.n5 8.47732
R1141 VSS.n5 VSS.n125 4.21421
R1142 VSS.n124 VSS.n5 4.22409
R1143 VSS.n513 VSS.n5 8.47732
R1144 VSS.n5 VSS.n122 4.21421
R1145 VSS.n506 VSS.n121 0.176279
R1146 VSS.n498 VSS.n5 8.47732
R1147 VSS.n5 VSS.n119 4.21421
R1148 VSS.n118 VSS.n5 4.22409
R1149 VSS.n475 VSS.n5 8.47732
R1150 VSS.n5 VSS.n116 4.21421
R1151 VSS.n115 VSS.n5 4.22409
R1152 VSS.n460 VSS.n5 8.47732
R1153 VSS.n5 VSS.n113 4.21421
R1154 VSS.n453 VSS.n112 0.176279
R1155 VSS.n445 VSS.n5 8.47732
R1156 VSS.n5 VSS.n110 4.21421
R1157 VSS.n439 VSS.n5 8.47732
R1158 VSS.n368 VSS.t390 8.46888
R1159 VSS.n540 VSS.t386 8.46888
R1160 VSS.n545 VSS.t387 8.46631
R1161 VSS.n551 VSS.t503 8.46631
R1162 VSS.n560 VSS.t453 8.46631
R1163 VSS.n568 VSS.t485 8.46631
R1164 VSS.n577 VSS.t449 8.46631
R1165 VSS.n585 VSS.t501 8.46631
R1166 VSS.n594 VSS.t451 8.46631
R1167 VSS.n602 VSS.t499 8.46631
R1168 VSS.n611 VSS.t455 8.46631
R1169 VSS.n619 VSS.t487 8.46631
R1170 VSS.n628 VSS.t475 8.46631
R1171 VSS.n636 VSS.t497 8.46631
R1172 VSS.n645 VSS.t481 8.46631
R1173 VSS.n653 VSS.t495 8.46631
R1174 VSS.n662 VSS.t479 8.46631
R1175 VSS.n670 VSS.t483 8.46631
R1176 VSS.n679 VSS.t493 8.46631
R1177 VSS.n687 VSS.t491 8.46631
R1178 VSS.n696 VSS.t477 8.46631
R1179 VSS.n704 VSS.t489 8.46631
R1180 VSS.n713 VSS.t445 8.46631
R1181 VSS.n721 VSS.t447 8.46631
R1182 VSS.n730 VSS.t473 8.46631
R1183 VSS.n738 VSS.t467 8.46631
R1184 VSS.n747 VSS.t469 8.46631
R1185 VSS.n755 VSS.t471 8.46631
R1186 VSS.n764 VSS.t465 8.46631
R1187 VSS.n772 VSS.t441 8.46631
R1188 VSS.n781 VSS.t463 8.46631
R1189 VSS.n789 VSS.t461 8.46631
R1190 VSS.n798 VSS.t443 8.46631
R1191 VSS.n806 VSS.t459 8.46631
R1192 VSS.n815 VSS.t457 8.46631
R1193 VSS.n826 VSS.t383 8.46519
R1194 VSS.n821 VSS.t379 8.46519
R1195 VSS.n834 VSS.t380 8.46519
R1196 VSS.n861 VSS.n128 6.99673
R1197 VSS.n106 VSS.n370 0.383491
R1198 VSS.n850 VSS.n105 5.62581
R1199 VSS.n854 VSS.n105 5.62581
R1200 VSS.n860 VSS.n105 5.62581
R1201 VSS.n105 VSS.n813 5.62581
R1202 VSS.n105 VSS.n244 5.62581
R1203 VSS.n105 VSS.n796 5.62581
R1204 VSS.n105 VSS.n252 5.62581
R1205 VSS.n105 VSS.n779 5.62581
R1206 VSS.n105 VSS.n260 5.62581
R1207 VSS.n105 VSS.n762 5.62581
R1208 VSS.n105 VSS.n268 5.62581
R1209 VSS.n105 VSS.n745 5.62581
R1210 VSS.n105 VSS.n276 5.62581
R1211 VSS.n105 VSS.n728 5.62581
R1212 VSS.n105 VSS.n284 5.62581
R1213 VSS.n105 VSS.n711 5.62581
R1214 VSS.n105 VSS.n292 5.62581
R1215 VSS.n105 VSS.n694 5.62581
R1216 VSS.n105 VSS.n300 5.62581
R1217 VSS.n105 VSS.n677 5.62581
R1218 VSS.n105 VSS.n308 5.62581
R1219 VSS.n105 VSS.n660 5.62581
R1220 VSS.n105 VSS.n316 5.62581
R1221 VSS.n105 VSS.n643 5.62581
R1222 VSS.n105 VSS.n324 5.62581
R1223 VSS.n105 VSS.n626 5.62581
R1224 VSS.n105 VSS.n332 5.62581
R1225 VSS.n105 VSS.n609 5.62581
R1226 VSS.n105 VSS.n340 5.62581
R1227 VSS.n105 VSS.n592 5.62581
R1228 VSS.n105 VSS.n348 5.62581
R1229 VSS.n105 VSS.n575 5.62581
R1230 VSS.n105 VSS.n356 5.62581
R1231 VSS.n105 VSS.n558 5.62581
R1232 VSS.n105 VSS.n232 5.62581
R1233 VSS.n105 VSS.n230 5.62581
R1234 VSS.n105 VSS.n228 5.62581
R1235 VSS.n105 VSS.n226 5.62581
R1236 VSS.n105 VSS.n224 5.62581
R1237 VSS.n105 VSS.n222 5.62581
R1238 VSS.n105 VSS.n220 5.62581
R1239 VSS.n105 VSS.n218 5.62581
R1240 VSS.n105 VSS.n216 5.62581
R1241 VSS.n105 VSS.n214 5.62581
R1242 VSS.n105 VSS.n212 5.62581
R1243 VSS.n105 VSS.n210 5.62581
R1244 VSS.n105 VSS.n208 5.62581
R1245 VSS.n105 VSS.n206 5.62581
R1246 VSS.n105 VSS.n204 5.62581
R1247 VSS.n105 VSS.n202 5.62581
R1248 VSS.n105 VSS.n200 5.62581
R1249 VSS.n105 VSS.n198 5.62581
R1250 VSS.n105 VSS.n196 5.62581
R1251 VSS.n105 VSS.n194 5.62581
R1252 VSS.n105 VSS.n192 5.62581
R1253 VSS.n105 VSS.n190 5.62581
R1254 VSS.n105 VSS.n188 5.62581
R1255 VSS.n105 VSS.n186 5.62581
R1256 VSS.n105 VSS.n184 5.62581
R1257 VSS.n105 VSS.n182 5.62581
R1258 VSS.n105 VSS.n180 5.62581
R1259 VSS.n105 VSS.n178 5.62581
R1260 VSS.n105 VSS.n176 5.62581
R1261 VSS.n105 VSS.n174 5.62581
R1262 VSS.n105 VSS.n172 5.62581
R1263 VSS.n105 VSS.n170 5.62581
R1264 VSS.n105 VSS.n166 5.62581
R1265 VSS.n5 VSS.n375 5.62581
R1266 VSS.n5 VSS.n379 5.62581
R1267 VSS.n522 VSS.n5 5.62581
R1268 VSS.n5 VSS.n387 5.62581
R1269 VSS.n507 VSS.n5 5.62581
R1270 VSS.n5 VSS.n395 5.62581
R1271 VSS.n492 VSS.n5 5.62581
R1272 VSS.n484 VSS.n5 5.62581
R1273 VSS.n5 VSS.n403 5.62581
R1274 VSS.n469 VSS.n5 5.62581
R1275 VSS.n5 VSS.n411 5.62581
R1276 VSS.n454 VSS.n5 5.62581
R1277 VSS.n5 VSS.n419 5.62581
R1278 VSS.n443 VSS.n5 5.62581
R1279 VSS.n435 VSS.n5 5.62581
R1280 VSS.n431 VSS.n5 5.62581
R1281 VSS.n425 VSS.n128 4.28471
R1282 VSS.n5 VSS.n533 4.21914
R1283 VSS.n5 VSS.n518 4.21914
R1284 VSS.n5 VSS.n503 4.21914
R1285 VSS.n5 VSS.n480 4.21914
R1286 VSS.n5 VSS.n465 4.21914
R1287 VSS.n5 VSS.n450 4.21914
R1288 VSS.n105 VSS.n106 1.77247
R1289 VSS.n846 VSS.n105 4.19244
R1290 VSS.n105 VSS.n830 4.19244
R1291 VSS.n427 VSS.n5 4.19244
R1292 VSS VSS.n128 3.80469
R1293 VSS.n818 VSS.t456 3.34498
R1294 VSS.n810 VSS.t458 3.34498
R1295 VSS.n802 VSS.t442 3.34498
R1296 VSS.n793 VSS.t460 3.34498
R1297 VSS.n785 VSS.t462 3.34498
R1298 VSS.n776 VSS.t440 3.34498
R1299 VSS.n768 VSS.t464 3.34498
R1300 VSS.n759 VSS.t470 3.34498
R1301 VSS.n751 VSS.t468 3.34498
R1302 VSS.n742 VSS.t466 3.34498
R1303 VSS.n734 VSS.t472 3.34498
R1304 VSS.n725 VSS.t446 3.34498
R1305 VSS.n717 VSS.t444 3.34498
R1306 VSS.n708 VSS.t488 3.34498
R1307 VSS.n700 VSS.t476 3.34498
R1308 VSS.n691 VSS.t490 3.34498
R1309 VSS.n683 VSS.t492 3.34498
R1310 VSS.n674 VSS.t482 3.34498
R1311 VSS.n666 VSS.t478 3.34498
R1312 VSS.n657 VSS.t494 3.34498
R1313 VSS.n649 VSS.t480 3.34498
R1314 VSS.n640 VSS.t496 3.34498
R1315 VSS.n632 VSS.t474 3.34498
R1316 VSS.n623 VSS.t486 3.34498
R1317 VSS.n615 VSS.t454 3.34498
R1318 VSS.n606 VSS.t498 3.34498
R1319 VSS.n598 VSS.t450 3.34498
R1320 VSS.n589 VSS.t500 3.34498
R1321 VSS.n581 VSS.t448 3.34498
R1322 VSS.n572 VSS.t484 3.34498
R1323 VSS.n564 VSS.t452 3.34498
R1324 VSS.n555 VSS.t502 3.34498
R1325 VSS.n852 VSS.n105 3.3265
R1326 VSS.n856 VSS.n105 3.3265
R1327 VSS.n105 VSS.n808 3.3265
R1328 VSS.n105 VSS.n791 3.3265
R1329 VSS.n105 VSS.n774 3.3265
R1330 VSS.n105 VSS.n757 3.3265
R1331 VSS.n105 VSS.n740 3.3265
R1332 VSS.n105 VSS.n723 3.3265
R1333 VSS.n105 VSS.n706 3.3265
R1334 VSS.n105 VSS.n689 3.3265
R1335 VSS.n105 VSS.n672 3.3265
R1336 VSS.n105 VSS.n655 3.3265
R1337 VSS.n105 VSS.n638 3.3265
R1338 VSS.n105 VSS.n621 3.3265
R1339 VSS.n105 VSS.n604 3.3265
R1340 VSS.n105 VSS.n587 3.3265
R1341 VSS.n105 VSS.n570 3.3265
R1342 VSS.n105 VSS.n553 3.3265
R1343 VSS.n526 VSS.n5 3.3265
R1344 VSS.n511 VSS.n5 3.3265
R1345 VSS.n496 VSS.n5 3.3265
R1346 VSS.n473 VSS.n5 3.3265
R1347 VSS.n458 VSS.n5 3.3265
R1348 VSS.n444 VSS.n6 0.440892
R1349 VSS.n441 VSS.n5 3.3265
R1350 VSS.n437 VSS.n5 3.3265
R1351 VSS.n433 VSS.n5 3.3265
R1352 VSS.n837 VSS 3.16675
R1353 VSS.n538 VSS.n537 3.01826
R1354 VSS.n105 VSS.n109 2.83376
R1355 VSS.n848 VSS.n105 2.74446
R1356 VSS.n105 VSS.n238 2.74446
R1357 VSS.n105 VSS.n246 2.74446
R1358 VSS.n105 VSS.n254 2.74446
R1359 VSS.n105 VSS.n262 2.74446
R1360 VSS.n105 VSS.n270 2.74446
R1361 VSS.n105 VSS.n278 2.74446
R1362 VSS.n105 VSS.n286 2.74446
R1363 VSS.n105 VSS.n294 2.74446
R1364 VSS.n105 VSS.n302 2.74446
R1365 VSS.n105 VSS.n310 2.74446
R1366 VSS.n105 VSS.n318 2.74446
R1367 VSS.n105 VSS.n326 2.74446
R1368 VSS.n105 VSS.n334 2.74446
R1369 VSS.n105 VSS.n342 2.74446
R1370 VSS.n105 VSS.n350 2.74446
R1371 VSS.n105 VSS.n358 2.74446
R1372 VSS.n105 VSS.n233 2.74446
R1373 VSS.n429 VSS.n5 2.74446
R1374 VSS.n105 VSS.n135 2.32483
R1375 VSS.n105 VSS.n136 2.32483
R1376 VSS.n105 VSS.n137 2.32483
R1377 VSS.n105 VSS.n138 2.32483
R1378 VSS.n105 VSS.n139 2.32483
R1379 VSS.n105 VSS.n140 2.32483
R1380 VSS.n105 VSS.n141 2.32483
R1381 VSS.n105 VSS.n142 2.32483
R1382 VSS.n105 VSS.n143 2.32483
R1383 VSS.n105 VSS.n144 2.32483
R1384 VSS.n105 VSS.n145 2.32483
R1385 VSS.n105 VSS.n146 2.32483
R1386 VSS.n105 VSS.n147 2.32483
R1387 VSS.n105 VSS.n148 2.32483
R1388 VSS.n105 VSS.n149 2.32483
R1389 VSS.n105 VSS.n150 2.32483
R1390 VSS.n105 VSS.n151 2.32483
R1391 VSS.n105 VSS.n152 2.32483
R1392 VSS.n105 VSS.n153 2.32483
R1393 VSS.n105 VSS.n154 2.32483
R1394 VSS.n105 VSS.n155 2.32483
R1395 VSS.n105 VSS.n156 2.32483
R1396 VSS.n105 VSS.n157 2.32483
R1397 VSS.n105 VSS.n158 2.32483
R1398 VSS.n105 VSS.n159 2.32483
R1399 VSS.n105 VSS.n160 2.32483
R1400 VSS.n105 VSS.n161 2.32483
R1401 VSS.n105 VSS.n162 2.32483
R1402 VSS.n105 VSS.n163 2.32483
R1403 VSS.n105 VSS.n164 2.32483
R1404 VSS.n105 VSS.n165 2.32483
R1405 VSS.n490 VSS.n5 2.00687
R1406 VSS.n105 VSS.n11 1.64417
R1407 VSS.n105 VSS.n843 1.64417
R1408 VSS.n105 VSS.n131 1.64417
R1409 VSS.n105 VSS.n132 1.64417
R1410 VSS.n105 VSS.n839 1.64417
R1411 VSS.n5 VSS.n372 1.56144
R1412 VSS.n524 VSS.n5 1.56144
R1413 VSS.n509 VSS.n5 1.56144
R1414 VSS.n486 VSS.n5 1.56144
R1415 VSS.n471 VSS.n5 1.56144
R1416 VSS.n456 VSS.n5 1.56144
R1417 VSS.n494 VSS.n5 1.12565
R1418 VSS.n537 VSS.n5 0.92982
R1419 VSS.n5 VSS.n1 0.761893
R1420 VSS.n6 VSS.n5 0.665344
R1421 VSS.n488 VSS.n5 0.849178
R1422 VSS.n488 VSS.n487 0.728316
R1423 VSS.n489 VSS.n488 0.69965
R1424 VSS.n537 VSS.n371 0.69304
R1425 VSS.n5 VSS.n4 0.613782
R1426 VSS.n8 VSS.t28 154.007
R1427 VSS.n5 VSS.n3 0.613782
R1428 VSS.n494 VSS.n493 0.603496
R1429 VSS.n105 VSS.n101 0.556705
R1430 VSS.n495 VSS.n494 0.540438
R1431 VSS VSS.n861 0.48296
R1432 VSS.n546 VSS.n545 0.419816
R1433 VSS.n552 VSS.n551 0.419816
R1434 VSS.n561 VSS.n560 0.419816
R1435 VSS.n569 VSS.n568 0.419816
R1436 VSS.n578 VSS.n577 0.419816
R1437 VSS.n586 VSS.n585 0.419816
R1438 VSS.n595 VSS.n594 0.419816
R1439 VSS.n603 VSS.n602 0.419816
R1440 VSS.n612 VSS.n611 0.419816
R1441 VSS.n620 VSS.n619 0.419816
R1442 VSS.n629 VSS.n628 0.419816
R1443 VSS.n637 VSS.n636 0.419816
R1444 VSS.n646 VSS.n645 0.419816
R1445 VSS.n654 VSS.n653 0.419816
R1446 VSS.n663 VSS.n662 0.419816
R1447 VSS.n671 VSS.n670 0.419816
R1448 VSS.n680 VSS.n679 0.419816
R1449 VSS.n688 VSS.n687 0.419816
R1450 VSS.n697 VSS.n696 0.419816
R1451 VSS.n705 VSS.n704 0.419816
R1452 VSS.n714 VSS.n713 0.419816
R1453 VSS.n722 VSS.n721 0.419816
R1454 VSS.n731 VSS.n730 0.419816
R1455 VSS.n739 VSS.n738 0.419816
R1456 VSS.n748 VSS.n747 0.419816
R1457 VSS.n756 VSS.n755 0.419816
R1458 VSS.n765 VSS.n764 0.419816
R1459 VSS.n773 VSS.n772 0.419816
R1460 VSS.n782 VSS.n781 0.419816
R1461 VSS.n790 VSS.n789 0.419816
R1462 VSS.n799 VSS.n798 0.419816
R1463 VSS.n807 VSS.n806 0.419816
R1464 VSS.n816 VSS.n815 0.419816
R1465 VSS.n457 VSS.n456 0.413418
R1466 VSS.n472 VSS.n471 0.413418
R1467 VSS.n487 VSS.n486 0.413418
R1468 VSS.n510 VSS.n509 0.413418
R1469 VSS.n525 VSS.n524 0.413418
R1470 VSS.n372 VSS.n371 0.413418
R1471 VSS.n826 VSS.n825 0.385697
R1472 VSS.n821 VSS.n820 0.385697
R1473 VSS.n545 VSS.n544 0.383459
R1474 VSS.n551 VSS.n550 0.383459
R1475 VSS.n560 VSS.n559 0.383459
R1476 VSS.n568 VSS.n567 0.383459
R1477 VSS.n577 VSS.n576 0.383459
R1478 VSS.n585 VSS.n584 0.383459
R1479 VSS.n594 VSS.n593 0.383459
R1480 VSS.n602 VSS.n601 0.383459
R1481 VSS.n611 VSS.n610 0.383459
R1482 VSS.n619 VSS.n618 0.383459
R1483 VSS.n628 VSS.n627 0.383459
R1484 VSS.n636 VSS.n635 0.383459
R1485 VSS.n645 VSS.n644 0.383459
R1486 VSS.n653 VSS.n652 0.383459
R1487 VSS.n662 VSS.n661 0.383459
R1488 VSS.n670 VSS.n669 0.383459
R1489 VSS.n679 VSS.n678 0.383459
R1490 VSS.n687 VSS.n686 0.383459
R1491 VSS.n696 VSS.n695 0.383459
R1492 VSS.n704 VSS.n703 0.383459
R1493 VSS.n713 VSS.n712 0.383459
R1494 VSS.n721 VSS.n720 0.383459
R1495 VSS.n730 VSS.n729 0.383459
R1496 VSS.n738 VSS.n737 0.383459
R1497 VSS.n747 VSS.n746 0.383459
R1498 VSS.n755 VSS.n754 0.383459
R1499 VSS.n764 VSS.n763 0.383459
R1500 VSS.n772 VSS.n771 0.383459
R1501 VSS.n781 VSS.n780 0.383459
R1502 VSS.n789 VSS.n788 0.383459
R1503 VSS.n798 VSS.n797 0.383459
R1504 VSS.n806 VSS.n805 0.383459
R1505 VSS.n815 VSS.n814 0.383459
R1506 VSS.n491 VSS.n490 0.380519
R1507 VSS.n835 VSS.n834 0.379351
R1508 VSS.n541 VSS.n540 0.37817
R1509 VSS.n490 VSS.n489 0.359515
R1510 VSS.n231 VSS.n135 0.351341
R1511 VSS.n229 VSS.n136 0.351341
R1512 VSS.n227 VSS.n137 0.351341
R1513 VSS.n225 VSS.n138 0.351341
R1514 VSS.n223 VSS.n139 0.351341
R1515 VSS.n221 VSS.n140 0.351341
R1516 VSS.n219 VSS.n141 0.351341
R1517 VSS.n217 VSS.n142 0.351341
R1518 VSS.n215 VSS.n143 0.351341
R1519 VSS.n213 VSS.n144 0.351341
R1520 VSS.n211 VSS.n145 0.351341
R1521 VSS.n209 VSS.n146 0.351341
R1522 VSS.n207 VSS.n147 0.351341
R1523 VSS.n205 VSS.n148 0.351341
R1524 VSS.n203 VSS.n149 0.351341
R1525 VSS.n201 VSS.n150 0.351341
R1526 VSS.n199 VSS.n151 0.351341
R1527 VSS.n197 VSS.n152 0.351341
R1528 VSS.n195 VSS.n153 0.351341
R1529 VSS.n193 VSS.n154 0.351341
R1530 VSS.n191 VSS.n155 0.351341
R1531 VSS.n189 VSS.n156 0.351341
R1532 VSS.n187 VSS.n157 0.351341
R1533 VSS.n185 VSS.n158 0.351341
R1534 VSS.n183 VSS.n159 0.351341
R1535 VSS.n181 VSS.n160 0.351341
R1536 VSS.n179 VSS.n161 0.351341
R1537 VSS.n177 VSS.n162 0.351341
R1538 VSS.n175 VSS.n163 0.351341
R1539 VSS.n173 VSS.n164 0.351341
R1540 VSS.n171 VSS.n165 0.351341
R1541 VSS.n368 VSS.n367 0.345929
R1542 VSS.n540 VSS.n539 0.345929
R1543 VSS.n374 VSS.n372 0.340858
R1544 VSS.n524 VSS.n523 0.340858
R1545 VSS.n509 VSS.n508 0.340858
R1546 VSS.n486 VSS.n485 0.340858
R1547 VSS.n471 VSS.n470 0.340858
R1548 VSS.n456 VSS.n455 0.340858
R1549 VSS.n849 VSS.n848 0.318018
R1550 VSS.n430 VSS.n429 0.316299
R1551 VSS.n805 VSS.n135 0.311066
R1552 VSS.n797 VSS.n136 0.311066
R1553 VSS.n788 VSS.n137 0.311066
R1554 VSS.n780 VSS.n138 0.311066
R1555 VSS.n771 VSS.n139 0.311066
R1556 VSS.n763 VSS.n140 0.311066
R1557 VSS.n754 VSS.n141 0.311066
R1558 VSS.n746 VSS.n142 0.311066
R1559 VSS.n737 VSS.n143 0.311066
R1560 VSS.n729 VSS.n144 0.311066
R1561 VSS.n720 VSS.n145 0.311066
R1562 VSS.n712 VSS.n146 0.311066
R1563 VSS.n703 VSS.n147 0.311066
R1564 VSS.n695 VSS.n148 0.311066
R1565 VSS.n686 VSS.n149 0.311066
R1566 VSS.n678 VSS.n150 0.311066
R1567 VSS.n669 VSS.n151 0.311066
R1568 VSS.n661 VSS.n152 0.311066
R1569 VSS.n652 VSS.n153 0.311066
R1570 VSS.n644 VSS.n154 0.311066
R1571 VSS.n635 VSS.n155 0.311066
R1572 VSS.n627 VSS.n156 0.311066
R1573 VSS.n618 VSS.n157 0.311066
R1574 VSS.n610 VSS.n158 0.311066
R1575 VSS.n601 VSS.n159 0.311066
R1576 VSS.n593 VSS.n160 0.311066
R1577 VSS.n584 VSS.n161 0.311066
R1578 VSS.n576 VSS.n162 0.311066
R1579 VSS.n567 VSS.n163 0.311066
R1580 VSS.n559 VSS.n164 0.311066
R1581 VSS.n550 VSS.n165 0.311066
R1582 VSS.n240 VSS.n238 0.284268
R1583 VSS.n248 VSS.n246 0.284268
R1584 VSS.n256 VSS.n254 0.284268
R1585 VSS.n264 VSS.n262 0.284268
R1586 VSS.n272 VSS.n270 0.284268
R1587 VSS.n280 VSS.n278 0.284268
R1588 VSS.n288 VSS.n286 0.284268
R1589 VSS.n296 VSS.n294 0.284268
R1590 VSS.n304 VSS.n302 0.284268
R1591 VSS.n312 VSS.n310 0.284268
R1592 VSS.n320 VSS.n318 0.284268
R1593 VSS.n328 VSS.n326 0.284268
R1594 VSS.n336 VSS.n334 0.284268
R1595 VSS.n344 VSS.n342 0.284268
R1596 VSS.n352 VSS.n350 0.284268
R1597 VSS.n360 VSS.n358 0.284268
R1598 VSS.n834 VSS.n833 0.279928
R1599 VSS.n429 VSS.n428 0.274268
R1600 VSS.n437 VSS.n436 0.274227
R1601 VSS.n458 VSS.n457 0.274227
R1602 VSS.n473 VSS.n472 0.274227
R1603 VSS.n496 VSS.n495 0.274227
R1604 VSS.n511 VSS.n510 0.274227
R1605 VSS.n526 VSS.n525 0.274227
R1606 VSS.n856 VSS.n855 0.272997
R1607 VSS.n848 VSS.n847 0.272549
R1608 VSS.n825 VSS.n233 0.271299
R1609 VSS.n105 VSS.n85 0.267794
R1610 VSS.n105 VSS.n83 0.267794
R1611 VSS.n105 VSS.n82 0.267794
R1612 VSS.n105 VSS.n81 0.267794
R1613 VSS.n105 VSS.n80 0.267794
R1614 VSS.n105 VSS.n79 0.267794
R1615 VSS.n105 VSS.n19 0.267794
R1616 VSS.n105 VSS.n20 0.267794
R1617 VSS.n105 VSS.n77 0.267794
R1618 VSS.n105 VSS.n21 0.267794
R1619 VSS.n105 VSS.n75 0.267794
R1620 VSS.n105 VSS.n74 0.267794
R1621 VSS.n105 VSS.n72 0.267794
R1622 VSS.n105 VSS.n22 0.267794
R1623 VSS.n105 VSS.n23 0.267794
R1624 VSS.n105 VSS.n25 0.267794
R1625 VSS.n105 VSS.n26 0.267794
R1626 VSS.n105 VSS.n71 0.267794
R1627 VSS.n105 VSS.n28 0.267794
R1628 VSS.n105 VSS.n29 0.267794
R1629 VSS.n105 VSS.n70 0.267794
R1630 VSS.n105 VSS.n31 0.267794
R1631 VSS.n105 VSS.n68 0.267794
R1632 VSS.n105 VSS.n32 0.267794
R1633 VSS.n105 VSS.n33 0.267794
R1634 VSS.n105 VSS.n35 0.267794
R1635 VSS.n105 VSS.n67 0.267794
R1636 VSS.n105 VSS.n36 0.267794
R1637 VSS.n105 VSS.n37 0.267794
R1638 VSS.n105 VSS.n65 0.267794
R1639 VSS.n105 VSS.n38 0.267794
R1640 VSS.n105 VSS.n64 0.267794
R1641 VSS.n105 VSS.n62 0.267794
R1642 VSS.n105 VSS.n39 0.267794
R1643 VSS.n105 VSS.n61 0.267794
R1644 VSS.n105 VSS.n41 0.267794
R1645 VSS.n105 VSS.n60 0.267794
R1646 VSS.n105 VSS.n59 0.267794
R1647 VSS.n105 VSS.n42 0.267794
R1648 VSS.n105 VSS.n44 0.267794
R1649 VSS.n105 VSS.n58 0.267794
R1650 VSS.n105 VSS.n45 0.267794
R1651 VSS.n105 VSS.n57 0.267794
R1652 VSS.n105 VSS.n56 0.267794
R1653 VSS.n105 VSS.n55 0.267794
R1654 VSS.n105 VSS.n54 0.267794
R1655 VSS.n105 VSS.n47 0.267794
R1656 VSS.n105 VSS.n48 0.267794
R1657 VSS.n105 VSS.n52 0.267794
R1658 VSS.n105 VSS.n50 0.267794
R1659 VSS.n105 VSS.n100 0.267794
R1660 VSS.n105 VSS.n99 0.267794
R1661 VSS.n105 VSS.n98 0.267794
R1662 VSS.n105 VSS.n97 0.267794
R1663 VSS.n105 VSS.n96 0.267794
R1664 VSS.n105 VSS.n95 0.267794
R1665 VSS.n105 VSS.n94 0.267794
R1666 VSS.n105 VSS.n93 0.267794
R1667 VSS.n105 VSS.n92 0.267794
R1668 VSS.n105 VSS.n91 0.267794
R1669 VSS.n105 VSS.n90 0.267794
R1670 VSS.n105 VSS.n89 0.267794
R1671 VSS.n105 VSS.n88 0.267794
R1672 VSS.n105 VSS.n87 0.267794
R1673 VSS.n105 VSS.n86 0.267794
R1674 VSS.n814 VSS.n233 0.265518
R1675 VSS.n106 VSS.n367 0.380544
R1676 VSS.n369 VSS.n368 0.251101
R1677 VSS.n442 VSS.n441 0.245497
R1678 VSS.n808 VSS.n807 0.244247
R1679 VSS.n791 VSS.n790 0.244247
R1680 VSS.n774 VSS.n773 0.244247
R1681 VSS.n757 VSS.n756 0.244247
R1682 VSS.n740 VSS.n739 0.244247
R1683 VSS.n723 VSS.n722 0.244247
R1684 VSS.n706 VSS.n705 0.244247
R1685 VSS.n689 VSS.n688 0.244247
R1686 VSS.n672 VSS.n671 0.244247
R1687 VSS.n655 VSS.n654 0.244247
R1688 VSS.n638 VSS.n637 0.244247
R1689 VSS.n621 VSS.n620 0.244247
R1690 VSS.n604 VSS.n603 0.244247
R1691 VSS.n587 VSS.n586 0.244247
R1692 VSS.n570 VSS.n569 0.244247
R1693 VSS.n553 VSS.n552 0.244247
R1694 VSS.n812 VSS.n238 0.240049
R1695 VSS.n795 VSS.n246 0.240049
R1696 VSS.n778 VSS.n254 0.240049
R1697 VSS.n761 VSS.n262 0.240049
R1698 VSS.n744 VSS.n270 0.240049
R1699 VSS.n727 VSS.n278 0.240049
R1700 VSS.n710 VSS.n286 0.240049
R1701 VSS.n693 VSS.n294 0.240049
R1702 VSS.n676 VSS.n302 0.240049
R1703 VSS.n659 VSS.n310 0.240049
R1704 VSS.n642 VSS.n318 0.240049
R1705 VSS.n625 VSS.n326 0.240049
R1706 VSS.n608 VSS.n334 0.240049
R1707 VSS.n591 VSS.n342 0.240049
R1708 VSS.n574 VSS.n350 0.240049
R1709 VSS.n557 VSS.n358 0.240049
R1710 VSS.n459 VSS.n458 0.237997
R1711 VSS.n474 VSS.n473 0.237997
R1712 VSS.n497 VSS.n496 0.237997
R1713 VSS.n512 VSS.n511 0.237997
R1714 VSS.n527 VSS.n526 0.237997
R1715 VSS.n433 VSS.n432 0.234227
R1716 VSS.n852 VSS.n851 0.232997
R1717 VSS.n853 VSS.n852 0.231727
R1718 VSS.n434 VSS.n433 0.230497
R1719 VSS.n808 VSS.n804 0.224227
R1720 VSS.n791 VSS.n787 0.224227
R1721 VSS.n774 VSS.n770 0.224227
R1722 VSS.n757 VSS.n753 0.224227
R1723 VSS.n740 VSS.n736 0.224227
R1724 VSS.n723 VSS.n719 0.224227
R1725 VSS.n706 VSS.n702 0.224227
R1726 VSS.n689 VSS.n685 0.224227
R1727 VSS.n672 VSS.n668 0.224227
R1728 VSS.n655 VSS.n651 0.224227
R1729 VSS.n638 VSS.n634 0.224227
R1730 VSS.n621 VSS.n617 0.224227
R1731 VSS.n604 VSS.n600 0.224227
R1732 VSS.n587 VSS.n583 0.224227
R1733 VSS.n570 VSS.n566 0.224227
R1734 VSS.n553 VSS.n549 0.224227
R1735 VSS.n441 VSS.n440 0.219227
R1736 VSS.n827 VSS.n826 0.21012
R1737 VSS.n823 VSS.n821 0.21012
R1738 VSS.n847 VSS.n846 0.201058
R1739 VSS.n428 VSS.n427 0.200293
R1740 VSS.n857 VSS.n856 0.191727
R1741 VSS.n438 VSS.n437 0.190497
R1742 VSS.n813 VSS.n812 0.186138
R1743 VSS.n796 VSS.n795 0.186138
R1744 VSS.n779 VSS.n778 0.186138
R1745 VSS.n762 VSS.n761 0.186138
R1746 VSS.n745 VSS.n744 0.186138
R1747 VSS.n728 VSS.n727 0.186138
R1748 VSS.n711 VSS.n710 0.186138
R1749 VSS.n694 VSS.n693 0.186138
R1750 VSS.n677 VSS.n676 0.186138
R1751 VSS.n660 VSS.n659 0.186138
R1752 VSS.n643 VSS.n642 0.186138
R1753 VSS.n626 VSS.n625 0.186138
R1754 VSS.n609 VSS.n608 0.186138
R1755 VSS.n592 VSS.n591 0.186138
R1756 VSS.n575 VSS.n574 0.186138
R1757 VSS.n558 VSS.n557 0.186138
R1758 VSS.n830 VSS.n829 0.179043
R1759 VSS.n861 VSS.n860 0.167388
R1760 VSS.n169 VSS.n166 0.16705
R1761 VSS.n450 VSS.n449 0.166269
R1762 VSS.n465 VSS.n464 0.166269
R1763 VSS.n480 VSS.n479 0.166269
R1764 VSS.n503 VSS.n502 0.166269
R1765 VSS.n518 VSS.n517 0.166269
R1766 VSS.n533 VSS.n532 0.166269
R1767 VSS.n1 VSS.n0 0.318488
R1768 VSS.n814 VSS.n232 0.16205
R1769 VSS.n805 VSS.n230 0.16205
R1770 VSS.n797 VSS.n228 0.16205
R1771 VSS.n788 VSS.n226 0.16205
R1772 VSS.n780 VSS.n224 0.16205
R1773 VSS.n771 VSS.n222 0.16205
R1774 VSS.n763 VSS.n220 0.16205
R1775 VSS.n754 VSS.n218 0.16205
R1776 VSS.n746 VSS.n216 0.16205
R1777 VSS.n737 VSS.n214 0.16205
R1778 VSS.n729 VSS.n212 0.16205
R1779 VSS.n720 VSS.n210 0.16205
R1780 VSS.n712 VSS.n208 0.16205
R1781 VSS.n703 VSS.n206 0.16205
R1782 VSS.n695 VSS.n204 0.16205
R1783 VSS.n686 VSS.n202 0.16205
R1784 VSS.n678 VSS.n200 0.16205
R1785 VSS.n669 VSS.n198 0.16205
R1786 VSS.n661 VSS.n196 0.16205
R1787 VSS.n652 VSS.n194 0.16205
R1788 VSS.n644 VSS.n192 0.16205
R1789 VSS.n635 VSS.n190 0.16205
R1790 VSS.n627 VSS.n188 0.16205
R1791 VSS.n618 VSS.n186 0.16205
R1792 VSS.n610 VSS.n184 0.16205
R1793 VSS.n601 VSS.n182 0.16205
R1794 VSS.n593 VSS.n180 0.16205
R1795 VSS.n584 VSS.n178 0.16205
R1796 VSS.n576 VSS.n176 0.16205
R1797 VSS.n567 VSS.n174 0.16205
R1798 VSS.n559 VSS.n172 0.16205
R1799 VSS.n550 VSS.n170 0.16205
R1800 VSS.n105 VSS.n17 0.16137
R1801 VSS.n105 VSS.n103 0.16137
R1802 VSS.n105 VSS.n102 0.16137
R1803 VSS.n830 VSS.n819 0.161058
R1804 VSS.n427 VSS.n426 0.161058
R1805 VSS.n846 VSS.n845 0.160293
R1806 VSS.n804 VSS.n244 0.15705
R1807 VSS.n787 VSS.n252 0.15705
R1808 VSS.n770 VSS.n260 0.15705
R1809 VSS.n753 VSS.n268 0.15705
R1810 VSS.n736 VSS.n276 0.15705
R1811 VSS.n719 VSS.n284 0.15705
R1812 VSS.n702 VSS.n292 0.15705
R1813 VSS.n685 VSS.n300 0.15705
R1814 VSS.n668 VSS.n308 0.15705
R1815 VSS.n651 VSS.n316 0.15705
R1816 VSS.n634 VSS.n324 0.15705
R1817 VSS.n617 VSS.n332 0.15705
R1818 VSS.n600 VSS.n340 0.15705
R1819 VSS.n583 VSS.n348 0.15705
R1820 VSS.n566 VSS.n356 0.15705
R1821 VSS.n446 VSS.n420 0.155582
R1822 VSS.n418 VSS.n417 0.155582
R1823 VSS.n455 VSS.n415 0.155582
R1824 VSS.n461 VSS.n412 0.155582
R1825 VSS.n410 VSS.n409 0.155582
R1826 VSS.n470 VSS.n407 0.155582
R1827 VSS.n476 VSS.n404 0.155582
R1828 VSS.n402 VSS.n401 0.155582
R1829 VSS.n485 VSS.n399 0.155582
R1830 VSS.n499 VSS.n396 0.155582
R1831 VSS.n394 VSS.n393 0.155582
R1832 VSS.n508 VSS.n391 0.155582
R1833 VSS.n514 VSS.n388 0.155582
R1834 VSS.n386 VSS.n385 0.155582
R1835 VSS.n523 VSS.n383 0.155582
R1836 VSS.n529 VSS.n380 0.155582
R1837 VSS.n378 VSS.n377 0.155582
R1838 VSS.n374 VSS.n373 0.155582
R1839 VSS.n816 VSS.n813 0.1508
R1840 VSS.n799 VSS.n796 0.1508
R1841 VSS.n782 VSS.n779 0.1508
R1842 VSS.n765 VSS.n762 0.1508
R1843 VSS.n748 VSS.n745 0.1508
R1844 VSS.n731 VSS.n728 0.1508
R1845 VSS.n714 VSS.n711 0.1508
R1846 VSS.n697 VSS.n694 0.1508
R1847 VSS.n680 VSS.n677 0.1508
R1848 VSS.n663 VSS.n660 0.1508
R1849 VSS.n646 VSS.n643 0.1508
R1850 VSS.n629 VSS.n626 0.1508
R1851 VSS.n612 VSS.n609 0.1508
R1852 VSS.n595 VSS.n592 0.1508
R1853 VSS.n578 VSS.n575 0.1508
R1854 VSS.n561 VSS.n558 0.1508
R1855 VSS.n435 VSS.n434 0.149888
R1856 VSS.n854 VSS.n853 0.14955
R1857 VSS.n444 VSS.n424 0.149476
R1858 VSS.n448 VSS.n447 0.149476
R1859 VSS.n452 VSS.n416 0.149476
R1860 VSS.n459 VSS.n414 0.149476
R1861 VSS.n463 VSS.n462 0.149476
R1862 VSS.n467 VSS.n408 0.149476
R1863 VSS.n474 VSS.n406 0.149476
R1864 VSS.n478 VSS.n477 0.149476
R1865 VSS.n482 VSS.n400 0.149476
R1866 VSS.n497 VSS.n398 0.149476
R1867 VSS.n501 VSS.n500 0.149476
R1868 VSS.n505 VSS.n392 0.149476
R1869 VSS.n512 VSS.n390 0.149476
R1870 VSS.n516 VSS.n515 0.149476
R1871 VSS.n520 VSS.n384 0.149476
R1872 VSS.n527 VSS.n382 0.149476
R1873 VSS.n531 VSS.n530 0.149476
R1874 VSS.n535 VSS.n376 0.149476
R1875 VSS.n833 VSS.n832 0.148577
R1876 VSS.n851 VSS.n850 0.147388
R1877 VSS.n432 VSS.n431 0.14705
R1878 VSS.n858 VSS.n857 0.142118
R1879 VSS.n439 VSS.n438 0.142118
R1880 VSS.n443 VSS.n442 0.134888
R1881 VSS.n492 VSS.n491 0.134888
R1882 VSS.n446 VSS.n445 0.129618
R1883 VSS.n461 VSS.n460 0.129618
R1884 VSS.n476 VSS.n475 0.129618
R1885 VSS.n499 VSS.n498 0.129618
R1886 VSS.n514 VSS.n513 0.129618
R1887 VSS.n529 VSS.n528 0.129618
R1888 VSS.n370 VSS.n369 0.127569
R1889 VSS.n449 VSS.n419 0.126138
R1890 VSS.n464 VSS.n411 0.126138
R1891 VSS.n479 VSS.n403 0.126138
R1892 VSS.n502 VSS.n395 0.126138
R1893 VSS.n517 VSS.n387 0.126138
R1894 VSS.n532 VSS.n379 0.126138
R1895 VSS.n819 VSS.n817 0.125868
R1896 VSS.n801 VSS.n800 0.125868
R1897 VSS.n784 VSS.n783 0.125868
R1898 VSS.n767 VSS.n766 0.125868
R1899 VSS.n750 VSS.n749 0.125868
R1900 VSS.n733 VSS.n732 0.125868
R1901 VSS.n716 VSS.n715 0.125868
R1902 VSS.n699 VSS.n698 0.125868
R1903 VSS.n682 VSS.n681 0.125868
R1904 VSS.n665 VSS.n664 0.125868
R1905 VSS.n648 VSS.n647 0.125868
R1906 VSS.n631 VSS.n630 0.125868
R1907 VSS.n614 VSS.n613 0.125868
R1908 VSS.n597 VSS.n596 0.125868
R1909 VSS.n580 VSS.n579 0.125868
R1910 VSS.n563 VSS.n562 0.125868
R1911 VSS.n110 VSS.n421 0.156005
R1912 VSS.n113 VSS.n413 0.156005
R1913 VSS.n116 VSS.n405 0.156005
R1914 VSS.n119 VSS.n397 0.156005
R1915 VSS.n122 VSS.n389 0.156005
R1916 VSS.n125 VSS.n381 0.156005
R1917 VSS.n544 VSS.n168 0.124618
R1918 VSS.n860 VSS.n859 0.12455
R1919 VSS.n539 VSS.n168 0.122118
R1920 VSS.n0 VSS.n443 0.12205
R1921 VSS.n455 VSS.n454 0.12205
R1922 VSS.n470 VSS.n469 0.12205
R1923 VSS.n485 VSS.n484 0.12205
R1924 VSS.n493 VSS.n492 0.12205
R1925 VSS.n508 VSS.n507 0.12205
R1926 VSS.n523 VSS.n522 0.12205
R1927 VSS.n375 VSS.n374 0.12205
R1928 VSS.n232 VSS.n231 0.119888
R1929 VSS.n230 VSS.n229 0.119888
R1930 VSS.n228 VSS.n227 0.119888
R1931 VSS.n226 VSS.n225 0.119888
R1932 VSS.n224 VSS.n223 0.119888
R1933 VSS.n222 VSS.n221 0.119888
R1934 VSS.n220 VSS.n219 0.119888
R1935 VSS.n218 VSS.n217 0.119888
R1936 VSS.n216 VSS.n215 0.119888
R1937 VSS.n214 VSS.n213 0.119888
R1938 VSS.n212 VSS.n211 0.119888
R1939 VSS.n210 VSS.n209 0.119888
R1940 VSS.n208 VSS.n207 0.119888
R1941 VSS.n206 VSS.n205 0.119888
R1942 VSS.n204 VSS.n203 0.119888
R1943 VSS.n202 VSS.n201 0.119888
R1944 VSS.n200 VSS.n199 0.119888
R1945 VSS.n198 VSS.n197 0.119888
R1946 VSS.n196 VSS.n195 0.119888
R1947 VSS.n194 VSS.n193 0.119888
R1948 VSS.n192 VSS.n191 0.119888
R1949 VSS.n190 VSS.n189 0.119888
R1950 VSS.n188 VSS.n187 0.119888
R1951 VSS.n186 VSS.n185 0.119888
R1952 VSS.n184 VSS.n183 0.119888
R1953 VSS.n182 VSS.n181 0.119888
R1954 VSS.n180 VSS.n179 0.119888
R1955 VSS.n178 VSS.n177 0.119888
R1956 VSS.n176 VSS.n175 0.119888
R1957 VSS.n174 VSS.n173 0.119888
R1958 VSS.n172 VSS.n171 0.119888
R1959 VSS.n170 VSS.n169 0.119888
R1960 VSS.n544 VSS.n166 0.114888
R1961 VSS.n859 VSS.n858 0.114618
R1962 VSS.n440 VSS.n439 0.114618
R1963 VSS.n800 VSS.n244 0.113638
R1964 VSS.n783 VSS.n252 0.113638
R1965 VSS.n766 VSS.n260 0.113638
R1966 VSS.n749 VSS.n268 0.113638
R1967 VSS.n732 VSS.n276 0.113638
R1968 VSS.n715 VSS.n284 0.113638
R1969 VSS.n698 VSS.n292 0.113638
R1970 VSS.n681 VSS.n300 0.113638
R1971 VSS.n664 VSS.n308 0.113638
R1972 VSS.n647 VSS.n316 0.113638
R1973 VSS.n630 VSS.n324 0.113638
R1974 VSS.n613 VSS.n332 0.113638
R1975 VSS.n596 VSS.n340 0.113638
R1976 VSS.n579 VSS.n348 0.113638
R1977 VSS.n562 VSS.n356 0.113638
R1978 VSS.n431 VSS.n430 0.109888
R1979 VSS.n850 VSS.n849 0.10955
R1980 VSS.n855 VSS.n854 0.107388
R1981 VSS.n436 VSS.n435 0.10705
R1982 VSS.n454 VSS.n453 0.106138
R1983 VSS.n469 VSS.n468 0.106138
R1984 VSS.n484 VSS.n483 0.106138
R1985 VSS.n507 VSS.n506 0.106138
R1986 VSS.n522 VSS.n521 0.106138
R1987 VSS.n536 VSS.n375 0.106138
R1988 VSS.n452 VSS.n451 0.105361
R1989 VSS.n467 VSS.n466 0.105361
R1990 VSS.n482 VSS.n481 0.105361
R1991 VSS.n505 VSS.n504 0.105361
R1992 VSS.n520 VSS.n519 0.105361
R1993 VSS.n535 VSS.n534 0.105361
R1994 VSS.n419 VSS.n418 0.10205
R1995 VSS.n411 VSS.n410 0.10205
R1996 VSS.n403 VSS.n402 0.10205
R1997 VSS.n395 VSS.n394 0.10205
R1998 VSS.n387 VSS.n386 0.10205
R1999 VSS.n379 VSS.n378 0.10205
R2000 VSS.n445 VSS.n421 0.0983676
R2001 VSS.n460 VSS.n413 0.0983676
R2002 VSS.n475 VSS.n405 0.0983676
R2003 VSS.n498 VSS.n397 0.0983676
R2004 VSS.n513 VSS.n389 0.0983676
R2005 VSS.n528 VSS.n381 0.0983676
R2006 VSS.n824 VSS.n823 0.094
R2007 VSS.n827 VSS.n824 0.094
R2008 VSS.n832 VSS.n234 0.08925
R2009 VSS.n817 VSS.n816 0.0883676
R2010 VSS.n801 VSS.n799 0.0883676
R2011 VSS.n784 VSS.n782 0.0883676
R2012 VSS.n767 VSS.n765 0.0883676
R2013 VSS.n750 VSS.n748 0.0883676
R2014 VSS.n733 VSS.n731 0.0883676
R2015 VSS.n716 VSS.n714 0.0883676
R2016 VSS.n699 VSS.n697 0.0883676
R2017 VSS.n682 VSS.n680 0.0883676
R2018 VSS.n665 VSS.n663 0.0883676
R2019 VSS.n648 VSS.n646 0.0883676
R2020 VSS.n631 VSS.n629 0.0883676
R2021 VSS.n614 VSS.n612 0.0883676
R2022 VSS.n597 VSS.n595 0.0883676
R2023 VSS.n580 VSS.n578 0.0883676
R2024 VSS.n563 VSS.n561 0.0883676
R2025 VSS.n547 VSS.n546 0.088
R2026 VSS.n112 VSS.n452 0.0435295
R2027 VSS.n468 VSS.n115 0.176279
R2028 VSS.n483 VSS.n118 0.176279
R2029 VSS.n121 VSS.n505 0.0435295
R2030 VSS.n521 VSS.n124 0.176279
R2031 VSS.n536 VSS.n127 0.176279
R2032 VSS.n823 VSS.n822 0.0851154
R2033 VSS.n829 VSS.n827 0.0851154
R2034 VSS.n542 VSS.n538 0.0805
R2035 VSS.n845 VSS.n844 0.078
R2036 VSS.n426 VSS.n425 0.078
R2037 VSS.n367 VSS.n167 0.0771176
R2038 VSS.n822 VSS.n235 0.0746176
R2039 VSS.n820 VSS.n133 0.0746176
R2040 VSS.n541 VSS.n365 0.07425
R2041 VSS.n539 VSS.n167 0.0696176
R2042 VSS.n822 VSS.n236 0.06925
R2043 VSS.n820 VSS.n134 0.06925
R2044 VSS.n448 VSS.n111 0.103847
R2045 VSS.n463 VSS.n114 0.103847
R2046 VSS.n478 VSS.n117 0.103847
R2047 VSS.n501 VSS.n120 0.103847
R2048 VSS.n516 VSS.n123 0.103847
R2049 VSS.n531 VSS.n126 0.103847
R2050 VSS.n549 VSS.n364 0.06175
R2051 VSS.n825 VSS.n134 0.05925
R2052 VSS.n838 VSS.n836 0.05675
R2053 VSS.n835 VSS.n235 0.0546176
R2054 VSS.n832 VSS.n133 0.0546176
R2055 VSS.n533 VSS.n531 0.0543074
R2056 VSS.n518 VSS.n516 0.0543074
R2057 VSS.n503 VSS.n501 0.0543074
R2058 VSS.n480 VSS.n478 0.0543074
R2059 VSS.n465 VSS.n463 0.0543074
R2060 VSS.n450 VSS.n448 0.0543074
R2061 VSS.n111 VSS.n446 0.0180497
R2062 VSS.n117 VSS.n476 0.0180497
R2063 VSS.n120 VSS.n499 0.0180497
R2064 VSS.n126 VSS.n529 0.0180497
R2065 VSS.n543 VSS.n365 0.04925
R2066 VSS.n241 VSS.n240 0.048
R2067 VSS.n249 VSS.n248 0.048
R2068 VSS.n257 VSS.n256 0.048
R2069 VSS.n265 VSS.n264 0.048
R2070 VSS.n273 VSS.n272 0.048
R2071 VSS.n281 VSS.n280 0.048
R2072 VSS.n289 VSS.n288 0.048
R2073 VSS.n297 VSS.n296 0.048
R2074 VSS.n305 VSS.n304 0.048
R2075 VSS.n313 VSS.n312 0.048
R2076 VSS.n321 VSS.n320 0.048
R2077 VSS.n329 VSS.n328 0.048
R2078 VSS.n337 VSS.n336 0.048
R2079 VSS.n345 VSS.n344 0.048
R2080 VSS.n353 VSS.n352 0.048
R2081 VSS.n361 VSS.n360 0.048
R2082 VSS.n547 VSS.n543 0.04675
R2083 VSS.n807 VSS.n241 0.0405
R2084 VSS.n790 VSS.n249 0.0405
R2085 VSS.n773 VSS.n257 0.0405
R2086 VSS.n756 VSS.n265 0.0405
R2087 VSS.n739 VSS.n273 0.0405
R2088 VSS.n722 VSS.n281 0.0405
R2089 VSS.n705 VSS.n289 0.0405
R2090 VSS.n688 VSS.n297 0.0405
R2091 VSS.n671 VSS.n305 0.0405
R2092 VSS.n654 VSS.n313 0.0405
R2093 VSS.n637 VSS.n321 0.0405
R2094 VSS.n620 VSS.n329 0.0405
R2095 VSS.n603 VSS.n337 0.0405
R2096 VSS.n586 VSS.n345 0.0405
R2097 VSS.n569 VSS.n353 0.0405
R2098 VSS.n552 VSS.n361 0.0405
R2099 VSS.n844 VSS 0.038
R2100 VSS.n836 VSS.n835 0.033
R2101 VSS.n829 VSS.n828 0.033
R2102 VSS.n370 VSS.n366 0.02925
R2103 VSS.n828 VSS.n236 0.02675
R2104 VSS.t146 VSS.n5 116.468
R2105 VSS.t177 VSS.n5 116.468
R2106 VSS.n542 VSS.n541 0.02175
R2107 VSS.n105 VSS.n16 0.0166972
R2108 VSS.n105 VSS.n104 0.0166972
R2109 VSS.n534 VSS.n378 0.0166107
R2110 VSS.n519 VSS.n386 0.0166107
R2111 VSS.n504 VSS.n394 0.0166107
R2112 VSS.n481 VSS.n402 0.0166107
R2113 VSS.n466 VSS.n410 0.0166107
R2114 VSS.n451 VSS.n418 0.0166107
R2115 VSS.n538 VSS.n366 0.0155
R2116 VSS.n837 VSS.n109 0.0112403
R2117 VSS.n861 VSS.n109 0.0095322
R2118 VSS.n105 VSS.n84 0.00938635
R2119 VSS.n105 VSS.n69 0.00938635
R2120 VSS.n105 VSS.n53 0.00938635
R2121 VSS.n105 VSS.n18 0.00937856
R2122 VSS.n105 VSS.n76 0.00937856
R2123 VSS.n105 VSS.n27 0.00937856
R2124 VSS.n105 VSS.n30 0.00937856
R2125 VSS.n105 VSS.n34 0.00937856
R2126 VSS.n105 VSS.n66 0.00937856
R2127 VSS.n105 VSS.n63 0.00937856
R2128 VSS.n105 VSS.n40 0.00937856
R2129 VSS.n105 VSS.n43 0.00937856
R2130 VSS.n105 VSS.n46 0.00937856
R2131 VSS.n105 VSS.n51 0.00937856
R2132 VSS.n105 VSS.n49 0.00937856
R2133 VSS.n105 VSS.n78 0.00937856
R2134 VSS.n105 VSS.n73 0.00937856
R2135 VSS.n546 VSS.n364 0.008
R2136 VSS.n838 VSS.n837 0.00675
R2137 VSS.n837 VSS.n234 0.00675
R2138 VSS.n5 VSS.t347 101.74
R2139 VSS.n5 VSS.t307 117.531
R2140 VSS.n5 VSS.t289 58.3211
R2141 VSS.n105 VSS.n24 0.00989368
R2142 VSS.n5 VSS.t317 101.74
R2143 VSS.n5 VSS.n2 1.43869
R2144 a_3747_311.n0 a_3747_311.t2 52.0388
R2145 a_3747_311.t1 a_3747_311.n0 35.4491
R2146 a_3747_311.n0 a_3747_311.t3 33.5891
R2147 a_3747_311.t0 a_3747_311.t1 5.61942
R2148 a_3171_311.n0 a_3171_311.t2 51.8377
R2149 a_3171_311.n0 a_3171_311.t3 33.3881
R2150 a_3171_311.t1 a_3171_311.n0 31.8923
R2151 a_3171_311.t0 a_3171_311.t1 5.61777
R2152 a_2595_311.n0 a_2595_311.t2 51.6367
R2153 a_2595_311.n0 a_2595_311.t3 33.187
R2154 a_2595_311.t1 a_2595_311.n0 27.993
R2155 a_2595_311.t0 a_2595_311.t1 5.73018
R2156 a_3747_1047.n0 a_3747_1047.t2 38.0081
R2157 a_3747_1047.n0 a_3747_1047.t3 33.3957
R2158 a_3747_1047.n1 a_3747_1047.t4 33.3957
R2159 a_3747_1047.n2 a_3747_1047.t5 33.3957
R2160 a_3747_1047.n3 a_3747_1047.t6 33.3957
R2161 a_3747_1047.n4 a_3747_1047.t7 33.3957
R2162 a_3747_1047.n5 a_3747_1047.t8 33.3957
R2163 a_3747_1047.n6 a_3747_1047.t9 33.3957
R2164 a_3747_1047.t1 a_3747_1047.n6 23.2419
R2165 a_3747_1047.t0 a_3747_1047.t1 5.61942
R2166 a_3747_1047.n6 a_3747_1047.n5 4.61291
R2167 a_3747_1047.n5 a_3747_1047.n4 4.61291
R2168 a_3747_1047.n4 a_3747_1047.n3 4.61291
R2169 a_3747_1047.n3 a_3747_1047.n2 4.61291
R2170 a_3747_1047.n2 a_3747_1047.n1 4.61291
R2171 a_3747_1047.n1 a_3747_1047.n0 4.61291
R2172 a_3171_1047.n0 a_3171_1047.t2 37.8054
R2173 a_3171_1047.n0 a_3171_1047.t3 33.193
R2174 a_3171_1047.n1 a_3171_1047.t4 33.193
R2175 a_3171_1047.n2 a_3171_1047.t5 33.193
R2176 a_3171_1047.n3 a_3171_1047.t6 33.193
R2177 a_3171_1047.n4 a_3171_1047.t7 33.193
R2178 a_3171_1047.n5 a_3171_1047.t8 33.193
R2179 a_3171_1047.n6 a_3171_1047.t9 33.193
R2180 a_3171_1047.t1 a_3171_1047.n6 23.0313
R2181 a_3171_1047.t0 a_3171_1047.t1 5.61777
R2182 a_3171_1047.n6 a_3171_1047.n5 4.61291
R2183 a_3171_1047.n5 a_3171_1047.n4 4.61291
R2184 a_3171_1047.n4 a_3171_1047.n3 4.61291
R2185 a_3171_1047.n3 a_3171_1047.n2 4.61291
R2186 a_3171_1047.n2 a_3171_1047.n1 4.61291
R2187 a_3171_1047.n1 a_3171_1047.n0 4.61291
R2188 a_2595_1047.n0 a_2595_1047.t2 37.7691
R2189 a_2595_1047.n0 a_2595_1047.t3 33.1567
R2190 a_2595_1047.n1 a_2595_1047.t4 33.1567
R2191 a_2595_1047.n2 a_2595_1047.t5 33.1567
R2192 a_2595_1047.n3 a_2595_1047.t6 33.1567
R2193 a_2595_1047.n4 a_2595_1047.t7 33.1567
R2194 a_2595_1047.n5 a_2595_1047.t8 33.1567
R2195 a_2595_1047.n6 a_2595_1047.t9 33.1567
R2196 a_2595_1047.t1 a_2595_1047.n6 22.7941
R2197 a_2595_1047.t0 a_2595_1047.t1 5.65522
R2198 a_2595_1047.n6 a_2595_1047.n5 4.61291
R2199 a_2595_1047.n5 a_2595_1047.n4 4.61291
R2200 a_2595_1047.n4 a_2595_1047.n3 4.61291
R2201 a_2595_1047.n3 a_2595_1047.n2 4.61291
R2202 a_2595_1047.n2 a_2595_1047.n1 4.61291
R2203 a_2595_1047.n1 a_2595_1047.n0 4.61291
R2204 a_2019_1047.n0 a_2019_1047.t2 37.9701
R2205 a_2019_1047.n0 a_2019_1047.t3 33.3577
R2206 a_2019_1047.n1 a_2019_1047.t4 33.3577
R2207 a_2019_1047.n2 a_2019_1047.t5 33.3577
R2208 a_2019_1047.n3 a_2019_1047.t6 33.3577
R2209 a_2019_1047.n4 a_2019_1047.t7 33.3577
R2210 a_2019_1047.n5 a_2019_1047.t8 33.3577
R2211 a_2019_1047.t1 a_2019_1047.t9 22.5945
R2212 a_2019_1047.t0 a_2019_1047.t1 5.62052
R2213 a_2019_1047.t9 a_2019_1047.n5 4.61291
R2214 a_2019_1047.n5 a_2019_1047.n4 4.61291
R2215 a_2019_1047.n4 a_2019_1047.n3 4.61291
R2216 a_2019_1047.n3 a_2019_1047.n2 4.61291
R2217 a_2019_1047.n2 a_2019_1047.n1 4.61291
R2218 a_2019_1047.n1 a_2019_1047.n0 4.61291
C1105 MUX_OUT VSS 3.24058f
C1106 MUX_SEL4 VSS 1.60778f
C1107 MUX_SEL3 VSS 0.90686f
C1108 MUX_SEL2 VSS 1.81137f
C1109 MUX_SEL1 VSS 0.95076f
C1110 MUX_SEL0 VSS 1.55166f
C1111 DELAY_VBIASN VSS 12.41106f
C1112 DELAY_OUT_LAST VSS 0.39284f
C1113 DELAY_VBIASP VSS 4.13999f
C1114 DELAY_IN VSS 1.91954f
C1115 VDD VSS 46.2831f
C1116 a_26985_519# VSS 0.17928f ; **FLOATING
C1117 a_23945_519# VSS 0.17928f ; **FLOATING
C1118 a_20905_519# VSS 0.17928f ; **FLOATING
C1119 a_17865_519# VSS 0.17593f ; **FLOATING
C1120 a_16851_309# VSS 0.38699f ; **FLOATING
C1121 a_16108_289# VSS 3.85084f ; **FLOATING
C1122 a_15964_289# VSS 0.17613f ; **FLOATING
C1123 a_15765_463# VSS 0.36132f ; **FLOATING
C1124 a_14825_519# VSS 0.17928f ; **FLOATING
C1125 a_11785_519# VSS 0.17928f ; **FLOATING
C1126 a_8745_519# VSS 0.17928f ; **FLOATING
C1127 a_5731_289# VSS 3.39133f ; **FLOATING
C1128 a_2019_311# VSS 1.61601f ; **FLOATING
C1129 a_5705_519# VSS 0.17638f ; **FLOATING
C1130 a_3449_331# VSS 0.18478f ; **FLOATING
C1131 a_2873_331# VSS 0.18321f ; **FLOATING
C1132 a_2297_331# VSS 0.18321f ; **FLOATING
C1133 a_1721_331# VSS 0.17001f ; **FLOATING
C1134 a_1544_289# VSS 0.30014f ; **FLOATING
C1135 a_1256_289# VSS 0.84266f ; **FLOATING
C1136 a_27991_1008# VSS 0.18706f ; **FLOATING
C1137 a_27915_1044# VSS 0.10926f ; **FLOATING
C1138 a_27124_1008# VSS 0.17878f ; **FLOATING
C1139 a_27048_1044# VSS 0.12122f ; **FLOATING
C1140 a_26471_1008# VSS 0.18175f ; **FLOATING
C1141 a_26395_1044# VSS 0.11073f ; **FLOATING
C1142 a_25604_1008# VSS 0.18087f ; **FLOATING
C1143 a_25630_1044# VSS 0.34158f ; **FLOATING
C1144 a_25528_1044# VSS 0.12433f ; **FLOATING
C1145 a_24951_1008# VSS 0.18335f ; **FLOATING
C1146 a_24875_1044# VSS 0.11016f ; **FLOATING
C1147 a_24084_1008# VSS 0.17878f ; **FLOATING
C1148 a_24008_1044# VSS 0.12122f ; **FLOATING
C1149 a_23431_1008# VSS 0.18175f ; **FLOATING
C1150 a_23355_1044# VSS 0.11073f ; **FLOATING
C1151 a_22564_1008# VSS 0.18087f ; **FLOATING
C1152 a_22590_1044# VSS 0.33314f ; **FLOATING
C1153 a_22488_1044# VSS 0.12433f ; **FLOATING
C1154 a_21911_1008# VSS 0.18335f ; **FLOATING
C1155 a_21835_1044# VSS 0.11016f ; **FLOATING
C1156 a_21044_1008# VSS 0.17878f ; **FLOATING
C1157 a_20968_1044# VSS 0.12122f ; **FLOATING
C1158 a_20391_1008# VSS 0.18175f ; **FLOATING
C1159 a_20315_1044# VSS 0.11073f ; **FLOATING
C1160 a_19524_1008# VSS 0.18087f ; **FLOATING
C1161 a_19550_1044# VSS 0.33563f ; **FLOATING
C1162 a_19448_1044# VSS 0.12433f ; **FLOATING
C1163 a_18871_1008# VSS 0.18335f ; **FLOATING
C1164 a_18795_1044# VSS 0.11016f ; **FLOATING
C1165 a_18004_1008# VSS 0.17878f ; **FLOATING
C1166 a_17928_1044# VSS 0.12122f ; **FLOATING
C1167 a_17351_1008# VSS 0.18022f ; **FLOATING
C1168 a_17275_1044# VSS 0.10926f ; **FLOATING
C1169 a_16484_1008# VSS 0.18023f ; **FLOATING
C1170 a_16510_1044# VSS 0.28935f ; **FLOATING
C1171 a_16408_1044# VSS 0.1229f ; **FLOATING
C1172 a_15831_1008# VSS 0.17846f ; **FLOATING
C1173 a_15755_1044# VSS 0.10926f ; **FLOATING
C1174 a_14964_1008# VSS 0.17878f ; **FLOATING
C1175 a_14888_1044# VSS 0.12122f ; **FLOATING
C1176 a_14311_1008# VSS 0.18175f ; **FLOATING
C1177 a_14235_1044# VSS 0.11073f ; **FLOATING
C1178 a_13444_1008# VSS 0.18087f ; **FLOATING
C1179 a_13470_1044# VSS 0.30333f ; **FLOATING
C1180 a_13368_1044# VSS 0.12433f ; **FLOATING
C1181 a_12791_1008# VSS 0.18335f ; **FLOATING
C1182 a_12715_1044# VSS 0.11016f ; **FLOATING
C1183 a_11924_1008# VSS 0.17878f ; **FLOATING
C1184 a_11848_1044# VSS 0.12122f ; **FLOATING
C1185 a_11271_1008# VSS 0.18175f ; **FLOATING
C1186 a_11195_1044# VSS 0.11073f ; **FLOATING
C1187 a_10404_1008# VSS 0.18087f ; **FLOATING
C1188 a_10430_1044# VSS 0.31665f ; **FLOATING
C1189 a_10328_1044# VSS 0.12433f ; **FLOATING
C1190 a_9751_1008# VSS 0.18335f ; **FLOATING
C1191 a_9675_1044# VSS 0.11016f ; **FLOATING
C1192 a_8884_1008# VSS 0.17878f ; **FLOATING
C1193 a_8808_1044# VSS 0.12122f ; **FLOATING
C1194 a_8231_1008# VSS 0.18175f ; **FLOATING
C1195 a_8155_1044# VSS 0.11073f ; **FLOATING
C1196 a_7364_1008# VSS 0.18087f ; **FLOATING
C1197 a_7390_1044# VSS 0.31357f ; **FLOATING
C1198 a_7288_1044# VSS 0.12433f ; **FLOATING
C1199 a_6711_1008# VSS 0.18335f ; **FLOATING
C1200 a_6635_1044# VSS 0.11016f ; **FLOATING
C1201 a_5844_1008# VSS 0.17878f ; **FLOATING
C1202 a_5768_1044# VSS 0.12122f ; **FLOATING
C1203 a_5191_1008# VSS 0.18022f ; **FLOATING
C1204 a_5115_1044# VSS 0.10926f ; **FLOATING
C1205 a_4324_1008# VSS 0.18023f ; **FLOATING
C1206 a_4350_1044# VSS 0.26655f ; **FLOATING
C1207 a_4248_1044# VSS 0.12443f ; **FLOATING
C1208 a_27705_1044# VSS 0.25296f ; **FLOATING
C1209 a_26185_1044# VSS 0.23475f ; **FLOATING
C1210 a_24665_1044# VSS 0.25432f ; **FLOATING
C1211 a_23145_1044# VSS 0.23475f ; **FLOATING
C1212 a_21625_1044# VSS 0.25432f ; **FLOATING
C1213 a_20105_1044# VSS 0.23475f ; **FLOATING
C1214 a_18585_1044# VSS 0.25432f ; **FLOATING
C1215 a_17065_1044# VSS 0.23385f ; **FLOATING
C1216 a_15545_1044# VSS 0.25296f ; **FLOATING
C1217 a_14025_1044# VSS 0.23475f ; **FLOATING
C1218 a_12505_1044# VSS 0.25432f ; **FLOATING
C1219 a_10985_1044# VSS 0.23475f ; **FLOATING
C1220 a_9465_1044# VSS 0.25432f ; **FLOATING
C1221 a_7945_1044# VSS 0.23475f ; **FLOATING
C1222 a_6425_1044# VSS 0.25432f ; **FLOATING
C1223 a_4905_1044# VSS 0.23549f ; **FLOATING
C1224 a_4157_1313# VSS 0.32875f ; **FLOATING
C1225 a_3449_1395# VSS 0.18629f ; **FLOATING
C1226 a_2873_1395# VSS 0.18349f ; **FLOATING
C1227 a_2297_1395# VSS 0.18349f ; **FLOATING
C1228 a_1721_1395# VSS 0.17029f ; **FLOATING
C1229 a_1544_1044# VSS 0.29829f ; **FLOATING
C1230 a_1256_1044# VSS 0.82978f ; **FLOATING
C1231 a_27671_1842# VSS 0.01336f ; **FLOATING
C1232 a_26911_1842# VSS 0.01336f ; **FLOATING
C1233 a_26151_1842# VSS 0.01336f ; **FLOATING
C1234 a_25391_1842# VSS 0.01336f ; **FLOATING
C1235 a_24631_1842# VSS 0.01336f ; **FLOATING
C1236 a_23871_1842# VSS 0.01336f ; **FLOATING
C1237 a_23111_1842# VSS 0.01336f ; **FLOATING
C1238 a_22351_1842# VSS 0.01336f ; **FLOATING
C1239 a_21591_1842# VSS 0.01336f ; **FLOATING
C1240 a_20831_1842# VSS 0.01336f ; **FLOATING
C1241 a_20071_1842# VSS 0.01336f ; **FLOATING
C1242 a_19311_1842# VSS 0.01336f ; **FLOATING
C1243 a_18551_1842# VSS 0.01336f ; **FLOATING
C1244 a_17791_1842# VSS 0.01336f ; **FLOATING
C1245 a_17031_1842# VSS 0.01336f ; **FLOATING
C1246 a_16271_1842# VSS 0.01336f ; **FLOATING
C1247 a_15511_1842# VSS 0.01336f ; **FLOATING
C1248 a_14751_1842# VSS 0.01336f ; **FLOATING
C1249 a_13991_1842# VSS 0.01336f ; **FLOATING
C1250 a_13231_1842# VSS 0.01336f ; **FLOATING
C1251 a_12471_1842# VSS 0.01336f ; **FLOATING
C1252 a_11711_1842# VSS 0.01336f ; **FLOATING
C1253 a_10951_1842# VSS 0.01336f ; **FLOATING
C1254 a_10191_1842# VSS 0.01336f ; **FLOATING
C1255 a_9431_1842# VSS 0.01336f ; **FLOATING
C1256 a_8671_1842# VSS 0.01336f ; **FLOATING
C1257 a_7911_1842# VSS 0.01336f ; **FLOATING
C1258 a_7151_1842# VSS 0.01336f ; **FLOATING
C1259 a_6391_1842# VSS 0.01336f ; **FLOATING
C1260 a_5631_1842# VSS 0.01336f ; **FLOATING
C1261 a_4871_1842# VSS 0.01336f ; **FLOATING
C1262 a_4111_1842# VSS 0.0139f ; **FLOATING
C1263 a_27563_1842# VSS 0.51284f ; **FLOATING
C1264 a_27997_1842# VSS 0.6533f ; **FLOATING
C1265 a_27433_1842# VSS 0.45843f ; **FLOATING
C1266 a_26803_1842# VSS 0.50902f ; **FLOATING
C1267 a_27237_1842# VSS 0.93747f ; **FLOATING
C1268 a_26673_1842# VSS 0.45994f ; **FLOATING
C1269 a_26043_1842# VSS 0.51137f ; **FLOATING
C1270 a_26477_1842# VSS 0.96549f ; **FLOATING
C1271 a_25913_1842# VSS 0.46292f ; **FLOATING
C1272 a_25283_1842# VSS 0.50906f ; **FLOATING
C1273 a_25717_1842# VSS 0.87619f ; **FLOATING
C1274 a_25153_1842# VSS 0.45997f ; **FLOATING
C1275 a_24523_1842# VSS 0.51043f ; **FLOATING
C1276 a_24957_1842# VSS 0.97121f ; **FLOATING
C1277 a_24393_1842# VSS 0.45843f ; **FLOATING
C1278 a_23763_1842# VSS 0.50902f ; **FLOATING
C1279 a_24197_1842# VSS 0.93322f ; **FLOATING
C1280 a_23633_1842# VSS 0.45994f ; **FLOATING
C1281 a_23003_1842# VSS 0.51137f ; **FLOATING
C1282 a_23437_1842# VSS 0.96549f ; **FLOATING
C1283 a_22873_1842# VSS 0.46292f ; **FLOATING
C1284 a_22243_1842# VSS 0.50906f ; **FLOATING
C1285 a_22677_1842# VSS 0.87619f ; **FLOATING
C1286 a_22113_1842# VSS 0.45997f ; **FLOATING
C1287 a_21483_1842# VSS 0.51043f ; **FLOATING
C1288 a_21917_1842# VSS 0.97121f ; **FLOATING
C1289 a_21353_1842# VSS 0.45843f ; **FLOATING
C1290 a_20723_1842# VSS 0.50902f ; **FLOATING
C1291 a_21157_1842# VSS 0.93322f ; **FLOATING
C1292 a_20593_1842# VSS 0.45994f ; **FLOATING
C1293 a_19963_1842# VSS 0.51137f ; **FLOATING
C1294 a_20397_1842# VSS 0.96549f ; **FLOATING
C1295 a_19833_1842# VSS 0.46292f ; **FLOATING
C1296 a_19203_1842# VSS 0.50906f ; **FLOATING
C1297 a_19637_1842# VSS 0.87619f ; **FLOATING
C1298 a_19073_1842# VSS 0.45997f ; **FLOATING
C1299 a_18443_1842# VSS 0.51043f ; **FLOATING
C1300 a_18877_1842# VSS 0.97121f ; **FLOATING
C1301 a_18313_1842# VSS 0.45843f ; **FLOATING
C1302 a_17683_1842# VSS 0.50902f ; **FLOATING
C1303 a_18117_1842# VSS 0.93322f ; **FLOATING
C1304 a_17553_1842# VSS 0.45994f ; **FLOATING
C1305 a_16923_1842# VSS 0.51133f ; **FLOATING
C1306 a_17357_1842# VSS 0.96549f ; **FLOATING
C1307 a_16793_1842# VSS 0.46262f ; **FLOATING
C1308 a_16163_1842# VSS 0.50902f ; **FLOATING
C1309 a_16597_1842# VSS 0.87137f ; **FLOATING
C1310 a_16033_1842# VSS 0.45859f ; **FLOATING
C1311 a_15403_1842# VSS 0.51041f ; **FLOATING
C1312 a_15837_1842# VSS 0.9618f ; **FLOATING
C1313 a_15273_1842# VSS 0.45843f ; **FLOATING
C1314 a_14643_1842# VSS 0.50902f ; **FLOATING
C1315 a_15077_1842# VSS 0.93209f ; **FLOATING
C1316 a_14513_1842# VSS 0.45994f ; **FLOATING
C1317 a_13883_1842# VSS 0.51137f ; **FLOATING
C1318 a_14317_1842# VSS 0.96549f ; **FLOATING
C1319 a_13753_1842# VSS 0.46292f ; **FLOATING
C1320 a_13123_1842# VSS 0.50904f ; **FLOATING
C1321 a_13557_1842# VSS 0.87619f ; **FLOATING
C1322 a_12993_1842# VSS 0.45997f ; **FLOATING
C1323 a_12363_1842# VSS 0.51043f ; **FLOATING
C1324 a_12797_1842# VSS 0.96954f ; **FLOATING
C1325 a_12233_1842# VSS 0.45843f ; **FLOATING
C1326 a_11603_1842# VSS 0.50902f ; **FLOATING
C1327 a_12037_1842# VSS 0.93322f ; **FLOATING
C1328 a_11473_1842# VSS 0.45994f ; **FLOATING
C1329 a_10843_1842# VSS 0.51137f ; **FLOATING
C1330 a_11277_1842# VSS 0.96549f ; **FLOATING
C1331 a_10713_1842# VSS 0.46292f ; **FLOATING
C1332 a_10083_1842# VSS 0.50904f ; **FLOATING
C1333 a_10517_1842# VSS 0.87619f ; **FLOATING
C1334 a_9953_1842# VSS 0.45997f ; **FLOATING
C1335 a_9323_1842# VSS 0.51043f ; **FLOATING
C1336 a_9757_1842# VSS 0.96954f ; **FLOATING
C1337 a_9193_1842# VSS 0.45843f ; **FLOATING
C1338 a_8563_1842# VSS 0.50902f ; **FLOATING
C1339 a_8997_1842# VSS 0.93322f ; **FLOATING
C1340 a_8433_1842# VSS 0.45994f ; **FLOATING
C1341 a_7803_1842# VSS 0.51137f ; **FLOATING
C1342 a_8237_1842# VSS 0.96549f ; **FLOATING
C1343 a_7673_1842# VSS 0.46292f ; **FLOATING
C1344 a_7043_1842# VSS 0.50904f ; **FLOATING
C1345 a_7477_1842# VSS 0.87619f ; **FLOATING
C1346 a_6913_1842# VSS 0.45997f ; **FLOATING
C1347 a_6283_1842# VSS 0.51043f ; **FLOATING
C1348 a_6717_1842# VSS 0.96895f ; **FLOATING
C1349 a_6153_1842# VSS 0.45843f ; **FLOATING
C1350 a_5523_1842# VSS 0.50902f ; **FLOATING
C1351 a_5957_1842# VSS 0.93322f ; **FLOATING
C1352 a_5393_1842# VSS 0.45994f ; **FLOATING
C1353 a_4763_1842# VSS 0.51133f ; **FLOATING
C1354 a_5197_1842# VSS 0.96549f ; **FLOATING
C1355 a_4633_1842# VSS 0.4629f ; **FLOATING
C1356 a_4003_1842# VSS 0.58899f ; **FLOATING
C1357 a_4437_1842# VSS 0.87666f ; **FLOATING
C1358 a_2019_1047.t2 VSS 0.93017f ; **FLOATING
C1359 a_2019_1047.t3 VSS 0.70616f ; **FLOATING
C1360 a_2019_1047.n0 VSS 5.0083f ; **FLOATING
C1361 a_2019_1047.t4 VSS 0.70616f ; **FLOATING
C1362 a_2019_1047.n1 VSS 3.38825f ; **FLOATING
C1363 a_2019_1047.t5 VSS 0.70616f ; **FLOATING
C1364 a_2019_1047.n2 VSS 3.38825f ; **FLOATING
C1365 a_2019_1047.t6 VSS 0.70616f ; **FLOATING
C1366 a_2019_1047.n3 VSS 3.38825f ; **FLOATING
C1367 a_2019_1047.t7 VSS 0.70616f ; **FLOATING
C1368 a_2019_1047.n4 VSS 3.38825f ; **FLOATING
C1369 a_2019_1047.t8 VSS 0.70616f ; **FLOATING
C1370 a_2019_1047.n5 VSS 3.38825f ; **FLOATING
C1371 a_2019_1047.t9 VSS 5.45426f ; **FLOATING
C1372 a_2019_1047.t1 VSS 1.07246f ; **FLOATING
C1373 a_2019_1047.t0 VSS 0.30482f ; **FLOATING
C1374 a_2595_1047.t2 VSS 1.36702f ; **FLOATING
C1375 a_2595_1047.t3 VSS 1.02093f ; **FLOATING
C1376 a_2595_1047.n0 VSS 7.7612f ; **FLOATING
C1377 a_2595_1047.t4 VSS 1.02093f ; **FLOATING
C1378 a_2595_1047.n1 VSS 5.27337f ; **FLOATING
C1379 a_2595_1047.t5 VSS 1.02093f ; **FLOATING
C1380 a_2595_1047.n2 VSS 5.27337f ; **FLOATING
C1381 a_2595_1047.t6 VSS 1.02093f ; **FLOATING
C1382 a_2595_1047.n3 VSS 5.27337f ; **FLOATING
C1383 a_2595_1047.t7 VSS 1.02093f ; **FLOATING
C1384 a_2595_1047.n4 VSS 5.27337f ; **FLOATING
C1385 a_2595_1047.t8 VSS 1.02093f ; **FLOATING
C1386 a_2595_1047.n5 VSS 5.27337f ; **FLOATING
C1387 a_2595_1047.t9 VSS 1.02093f ; **FLOATING
C1388 a_2595_1047.n6 VSS 7.58543f ; **FLOATING
C1389 a_2595_1047.t1 VSS 1.75118f ; **FLOATING
C1390 a_2595_1047.t0 VSS 0.48227f ; **FLOATING
C1391 a_3171_1047.t2 VSS 1.38442f ; **FLOATING
C1392 a_3171_1047.t3 VSS 1.03733f ; **FLOATING
C1393 a_3171_1047.n0 VSS 7.77854f ; **FLOATING
C1394 a_3171_1047.t4 VSS 1.03733f ; **FLOATING
C1395 a_3171_1047.n1 VSS 5.28082f ; **FLOATING
C1396 a_3171_1047.t5 VSS 1.03733f ; **FLOATING
C1397 a_3171_1047.n2 VSS 5.28082f ; **FLOATING
C1398 a_3171_1047.t6 VSS 1.03733f ; **FLOATING
C1399 a_3171_1047.n3 VSS 5.28082f ; **FLOATING
C1400 a_3171_1047.t7 VSS 1.03733f ; **FLOATING
C1401 a_3171_1047.n4 VSS 5.28082f ; **FLOATING
C1402 a_3171_1047.t8 VSS 1.03733f ; **FLOATING
C1403 a_3171_1047.n5 VSS 5.28082f ; **FLOATING
C1404 a_3171_1047.t9 VSS 1.03733f ; **FLOATING
C1405 a_3171_1047.n6 VSS 7.68345f ; **FLOATING
C1406 a_3171_1047.t1 VSS 1.77026f ; **FLOATING
C1407 a_3171_1047.t0 VSS 0.48084f ; **FLOATING
C1408 a_3747_1047.t2 VSS 0.96886f ; **FLOATING
C1409 a_3747_1047.t3 VSS 0.73761f ; **FLOATING
C1410 a_3747_1047.n0 VSS 5.16753f ; **FLOATING
C1411 a_3747_1047.t4 VSS 0.73761f ; **FLOATING
C1412 a_3747_1047.n1 VSS 3.49318f ; **FLOATING
C1413 a_3747_1047.t5 VSS 0.73761f ; **FLOATING
C1414 a_3747_1047.n2 VSS 3.49318f ; **FLOATING
C1415 a_3747_1047.t6 VSS 0.73761f ; **FLOATING
C1416 a_3747_1047.n3 VSS 3.49318f ; **FLOATING
C1417 a_3747_1047.t7 VSS 0.73761f ; **FLOATING
C1418 a_3747_1047.n4 VSS 3.49318f ; **FLOATING
C1419 a_3747_1047.t8 VSS 0.73761f ; **FLOATING
C1420 a_3747_1047.n5 VSS 3.49318f ; **FLOATING
C1421 a_3747_1047.t9 VSS 0.73761f ; **FLOATING
C1422 a_3747_1047.n6 VSS 5.18697f ; **FLOATING
C1423 a_3747_1047.t1 VSS 1.18537f ; **FLOATING
C1424 a_3747_1047.t0 VSS 0.31338f ; **FLOATING
C1425 a_2595_311.t1 VSS 3.27037f ; **FLOATING
C1426 a_2595_311.t2 VSS 5.04145f ; **FLOATING
C1427 a_2595_311.t3 VSS 1.20632f ; **FLOATING
C1428 a_2595_311.n0 VSS 26.8668f ; **FLOATING
C1429 a_2595_311.t0 VSS 0.49572f ; **FLOATING
C1430 a_3171_311.t2 VSS 5.05009f ; **FLOATING
C1431 a_3171_311.t3 VSS 1.21149f ; **FLOATING
C1432 a_3171_311.n0 VSS 29.8499f ; **FLOATING
C1433 a_3171_311.t1 VSS 4.61154f ; **FLOATING
C1434 a_3171_311.t0 VSS 0.4973f ; **FLOATING
C1435 a_3747_311.t2 VSS 3.09203f ; **FLOATING
C1436 a_3747_311.t3 VSS 0.74422f ; **FLOATING
C1437 a_3747_311.n0 VSS 19.8885f ; **FLOATING
C1438 a_3747_311.t1 VSS 3.68893f ; **FLOATING
C1439 a_3747_311.t0 VSS 0.30537f ; **FLOATING
C1440 DELAY_VBIASP.n0 VSS 0.14465f ; **FLOATING
C1441 DELAY_VBIASP.t31 VSS 0.37042f ; **FLOATING
C1442 DELAY_VBIASP.t30 VSS 0.36213f ; **FLOATING
C1443 DELAY_VBIASP.n1 VSS 0.64895f ; **FLOATING
C1444 DELAY_VBIASP.t29 VSS 0.36213f ; **FLOATING
C1445 DELAY_VBIASP.n2 VSS 0.44908f ; **FLOATING
C1446 DELAY_VBIASP.t28 VSS 0.36213f ; **FLOATING
C1447 DELAY_VBIASP.n3 VSS 0.44908f ; **FLOATING
C1448 DELAY_VBIASP.t27 VSS 0.36213f ; **FLOATING
C1449 DELAY_VBIASP.n4 VSS 0.44908f ; **FLOATING
C1450 DELAY_VBIASP.t26 VSS 0.36213f ; **FLOATING
C1451 DELAY_VBIASP.n5 VSS 0.44908f ; **FLOATING
C1452 DELAY_VBIASP.t25 VSS 0.36213f ; **FLOATING
C1453 DELAY_VBIASP.n6 VSS 0.44908f ; **FLOATING
C1454 DELAY_VBIASP.t24 VSS 0.36213f ; **FLOATING
C1455 DELAY_VBIASP.n7 VSS 0.44908f ; **FLOATING
C1456 DELAY_VBIASP.t23 VSS 0.36213f ; **FLOATING
C1457 DELAY_VBIASP.n8 VSS 0.44908f ; **FLOATING
C1458 DELAY_VBIASP.t22 VSS 0.36213f ; **FLOATING
C1459 DELAY_VBIASP.n9 VSS 0.44908f ; **FLOATING
C1460 DELAY_VBIASP.t21 VSS 0.36213f ; **FLOATING
C1461 DELAY_VBIASP.n10 VSS 0.44908f ; **FLOATING
C1462 DELAY_VBIASP.t20 VSS 0.36213f ; **FLOATING
C1463 DELAY_VBIASP.n11 VSS 0.44908f ; **FLOATING
C1464 DELAY_VBIASP.t19 VSS 0.36213f ; **FLOATING
C1465 DELAY_VBIASP.n12 VSS 0.44908f ; **FLOATING
C1466 DELAY_VBIASP.t18 VSS 0.36213f ; **FLOATING
C1467 DELAY_VBIASP.n13 VSS 0.44908f ; **FLOATING
C1468 DELAY_VBIASP.t17 VSS 0.36213f ; **FLOATING
C1469 DELAY_VBIASP.n14 VSS 0.44908f ; **FLOATING
C1470 DELAY_VBIASP.t16 VSS 0.36213f ; **FLOATING
C1471 DELAY_VBIASP.n15 VSS 0.44908f ; **FLOATING
C1472 DELAY_VBIASP.t15 VSS 0.36213f ; **FLOATING
C1473 DELAY_VBIASP.n16 VSS 0.44908f ; **FLOATING
C1474 DELAY_VBIASP.t14 VSS 0.36213f ; **FLOATING
C1475 DELAY_VBIASP.n17 VSS 0.44908f ; **FLOATING
C1476 DELAY_VBIASP.t13 VSS 0.36213f ; **FLOATING
C1477 DELAY_VBIASP.n18 VSS 0.44908f ; **FLOATING
C1478 DELAY_VBIASP.t12 VSS 0.36213f ; **FLOATING
C1479 DELAY_VBIASP.n19 VSS 0.44908f ; **FLOATING
C1480 DELAY_VBIASP.t11 VSS 0.36213f ; **FLOATING
C1481 DELAY_VBIASP.n20 VSS 0.44908f ; **FLOATING
C1482 DELAY_VBIASP.t10 VSS 0.36213f ; **FLOATING
C1483 DELAY_VBIASP.n21 VSS 0.44908f ; **FLOATING
C1484 DELAY_VBIASP.t9 VSS 0.36213f ; **FLOATING
C1485 DELAY_VBIASP.n22 VSS 0.44908f ; **FLOATING
C1486 DELAY_VBIASP.t8 VSS 0.36213f ; **FLOATING
C1487 DELAY_VBIASP.n23 VSS 0.44908f ; **FLOATING
C1488 DELAY_VBIASP.t7 VSS 0.36213f ; **FLOATING
C1489 DELAY_VBIASP.n24 VSS 0.44908f ; **FLOATING
C1490 DELAY_VBIASP.t6 VSS 0.36213f ; **FLOATING
C1491 DELAY_VBIASP.n25 VSS 0.44908f ; **FLOATING
C1492 DELAY_VBIASP.t5 VSS 0.36213f ; **FLOATING
C1493 DELAY_VBIASP.n26 VSS 0.44908f ; **FLOATING
C1494 DELAY_VBIASP.t4 VSS 0.36213f ; **FLOATING
C1495 DELAY_VBIASP.n27 VSS 0.44908f ; **FLOATING
C1496 DELAY_VBIASP.t3 VSS 0.36213f ; **FLOATING
C1497 DELAY_VBIASP.n28 VSS 0.44908f ; **FLOATING
C1498 DELAY_VBIASP.t2 VSS 0.36213f ; **FLOATING
C1499 DELAY_VBIASP.n29 VSS 0.44908f ; **FLOATING
C1500 DELAY_VBIASP.t1 VSS 0.36213f ; **FLOATING
C1501 DELAY_VBIASP.n30 VSS 0.44908f ; **FLOATING
C1502 DELAY_VBIASP.t0 VSS 0.36213f ; **FLOATING
C1503 DELAY_VBIASN.n0 VSS 0.37703f ; **FLOATING
C1504 DELAY_VBIASN.t31 VSS 0.22492f ; **FLOATING
C1505 DELAY_VBIASN.t30 VSS 0.21832f ; **FLOATING
C1506 DELAY_VBIASN.n1 VSS 0.51667f ; **FLOATING
C1507 DELAY_VBIASN.t29 VSS 0.21832f ; **FLOATING
C1508 DELAY_VBIASN.n2 VSS 0.35838f ; **FLOATING
C1509 DELAY_VBIASN.t28 VSS 0.21832f ; **FLOATING
C1510 DELAY_VBIASN.n3 VSS 0.35838f ; **FLOATING
C1511 DELAY_VBIASN.t27 VSS 0.21832f ; **FLOATING
C1512 DELAY_VBIASN.n4 VSS 0.35838f ; **FLOATING
C1513 DELAY_VBIASN.t26 VSS 0.21832f ; **FLOATING
C1514 DELAY_VBIASN.n5 VSS 0.35838f ; **FLOATING
C1515 DELAY_VBIASN.t25 VSS 0.21832f ; **FLOATING
C1516 DELAY_VBIASN.n6 VSS 0.35838f ; **FLOATING
C1517 DELAY_VBIASN.t24 VSS 0.21832f ; **FLOATING
C1518 DELAY_VBIASN.n7 VSS 0.35838f ; **FLOATING
C1519 DELAY_VBIASN.t23 VSS 0.21832f ; **FLOATING
C1520 DELAY_VBIASN.n8 VSS 0.35838f ; **FLOATING
C1521 DELAY_VBIASN.t22 VSS 0.21832f ; **FLOATING
C1522 DELAY_VBIASN.n9 VSS 0.35838f ; **FLOATING
C1523 DELAY_VBIASN.t21 VSS 0.21832f ; **FLOATING
C1524 DELAY_VBIASN.n10 VSS 0.35838f ; **FLOATING
C1525 DELAY_VBIASN.t20 VSS 0.21832f ; **FLOATING
C1526 DELAY_VBIASN.n11 VSS 0.35838f ; **FLOATING
C1527 DELAY_VBIASN.t19 VSS 0.21832f ; **FLOATING
C1528 DELAY_VBIASN.n12 VSS 0.35838f ; **FLOATING
C1529 DELAY_VBIASN.t18 VSS 0.21832f ; **FLOATING
C1530 DELAY_VBIASN.n13 VSS 0.35838f ; **FLOATING
C1531 DELAY_VBIASN.t17 VSS 0.21832f ; **FLOATING
C1532 DELAY_VBIASN.n14 VSS 0.35838f ; **FLOATING
C1533 DELAY_VBIASN.t16 VSS 0.21832f ; **FLOATING
C1534 DELAY_VBIASN.n15 VSS 0.35838f ; **FLOATING
C1535 DELAY_VBIASN.t15 VSS 0.21832f ; **FLOATING
C1536 DELAY_VBIASN.n16 VSS 0.35838f ; **FLOATING
C1537 DELAY_VBIASN.t14 VSS 0.21832f ; **FLOATING
C1538 DELAY_VBIASN.n17 VSS 0.35838f ; **FLOATING
C1539 DELAY_VBIASN.t13 VSS 0.21832f ; **FLOATING
C1540 DELAY_VBIASN.n18 VSS 0.35838f ; **FLOATING
C1541 DELAY_VBIASN.t12 VSS 0.21832f ; **FLOATING
C1542 DELAY_VBIASN.n19 VSS 0.35838f ; **FLOATING
C1543 DELAY_VBIASN.t11 VSS 0.21832f ; **FLOATING
C1544 DELAY_VBIASN.n20 VSS 0.35838f ; **FLOATING
C1545 DELAY_VBIASN.t10 VSS 0.21832f ; **FLOATING
C1546 DELAY_VBIASN.n21 VSS 0.35838f ; **FLOATING
C1547 DELAY_VBIASN.t9 VSS 0.21832f ; **FLOATING
C1548 DELAY_VBIASN.n22 VSS 0.35838f ; **FLOATING
C1549 DELAY_VBIASN.t8 VSS 0.21832f ; **FLOATING
C1550 DELAY_VBIASN.n23 VSS 0.35838f ; **FLOATING
C1551 DELAY_VBIASN.t7 VSS 0.21832f ; **FLOATING
C1552 DELAY_VBIASN.n24 VSS 0.35838f ; **FLOATING
C1553 DELAY_VBIASN.t6 VSS 0.21832f ; **FLOATING
C1554 DELAY_VBIASN.n25 VSS 0.35838f ; **FLOATING
C1555 DELAY_VBIASN.t5 VSS 0.21832f ; **FLOATING
C1556 DELAY_VBIASN.n26 VSS 0.35838f ; **FLOATING
C1557 DELAY_VBIASN.t4 VSS 0.21832f ; **FLOATING
C1558 DELAY_VBIASN.n27 VSS 0.35838f ; **FLOATING
C1559 DELAY_VBIASN.t3 VSS 0.21832f ; **FLOATING
C1560 DELAY_VBIASN.n28 VSS 0.35838f ; **FLOATING
C1561 DELAY_VBIASN.t2 VSS 0.21832f ; **FLOATING
C1562 DELAY_VBIASN.n29 VSS 0.35838f ; **FLOATING
C1563 DELAY_VBIASN.t1 VSS 0.21832f ; **FLOATING
C1564 DELAY_VBIASN.n30 VSS 0.35838f ; **FLOATING
C1565 DELAY_VBIASN.t0 VSS 0.21832f ; **FLOATING
.ends
