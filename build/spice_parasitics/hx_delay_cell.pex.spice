* NGSPICE file created from hx_delay_cell.ext - technology: ihp-sg13g2

.subckt hx_delay_cell DELAY_CELL_IN DELAY_CELL_OUT DELAY_CELL_OUT_INV DELAY_VBIASP
+ DELAY_VBIASN VSS VDD
X0 VDD a_121_203# DELAY_CELL_OUT VDD sg13_lv_pmos ad=0.2128p pd=1.5u as=0.3808p ps=2.92u w=1.12u l=0.13u
X1 a_229_831# DELAY_CELL_IN a_121_203# VDD sg13_lv_pmos ad=0.2128p pd=1.5u as=0.3808p ps=2.92u w=1.12u l=0.2u
X2 DELAY_CELL_OUT_INV DELAY_CELL_OUT VDD VDD sg13_lv_pmos ad=0.3808p pd=2.92u as=0.2128p ps=1.5u w=1.12u l=0.13u
X3 VSS.t1 DELAY_VBIASN a_229_203# VSS.t4 sg13_lv_nmos ad=0.2516p pd=2.16u as=0.1406p ps=1.12u w=0.74u l=0.6u
X4 VSS.t1 a_121_203# DELAY_CELL_OUT VSS.t3 sg13_lv_nmos ad=0.1406p pd=1.12u as=0.2516p ps=2.16u w=0.74u l=0.13u
X5 a_229_203# DELAY_CELL_IN a_121_203# VSS.t2 sg13_lv_nmos ad=0.1406p pd=1.12u as=0.2516p ps=2.16u w=0.74u l=0.2u
X6 DELAY_CELL_OUT_INV DELAY_CELL_OUT VSS.t1 VSS.t0 sg13_lv_nmos ad=0.2516p pd=2.16u as=0.1406p ps=1.12u w=0.74u l=0.13u
X7 VDD DELAY_VBIASP a_229_831# VDD sg13_lv_pmos ad=0.3808p pd=2.92u as=0.2128p ps=1.5u w=1.12u l=0.6u
C0 a_121_203# a_229_831# 0.01697f
C1 a_229_203# a_121_203# 0.01163f
C2 a_121_203# DELAY_VBIASN 0.06129f
C3 DELAY_VBIASP a_121_203# 0.0573f
C4 a_121_203# VDD 0.85896f
C5 DELAY_CELL_OUT a_121_203# 0.69646f
C6 VDD a_229_831# 0.02372f
C7 DELAY_VBIASP VDD 1.04737f
C8 DELAY_CELL_OUT DELAY_VBIASN 0.03836f
C9 DELAY_CELL_IN a_121_203# 0.52957f
C10 DELAY_VBIASP DELAY_CELL_OUT 0.03757f
C11 DELAY_CELL_OUT VDD 0.79778f
C12 DELAY_CELL_IN DELAY_VBIASN 0.06913f
C13 DELAY_VBIASP DELAY_CELL_IN 0.07324f
C14 DELAY_CELL_IN VDD 0.36939f
C15 DELAY_VBIASN DELAY_CELL_OUT_INV 0.03989f
C16 DELAY_CELL_IN DELAY_CELL_OUT 0.01139f
C17 DELAY_VBIASP DELAY_CELL_OUT_INV 0.04319f
C18 VDD DELAY_CELL_OUT_INV 0.36979f
C19 DELAY_CELL_OUT DELAY_CELL_OUT_INV 0.65743f
R0 VSS.n10 VSS.t4 373.135
R1 VSS.n13 VSS.t2 363.185
R2 VSS.n7 VSS.t0 348.26
R3 VSS.n8 VSS.t3 218.905
R4 VSS.t3 VSS.n7 159.204
R5 VSS.n4 VSS.n5 8.50181
R6 VSS.n2 VSS.n11 31.1964
R7 VSS.n1 VSS.n9 31.1964
R8 VSS.n3 VSS.n13 17.0005
R9 VSS.n3 VSS.n6 17.0005
R10 VSS.n3 VSS.n4 8.50106
R11 VSS.n3 VSS.n7 17.0005
R12 VSS.n3 VSS.n8 17.0005
R13 VSS.n13 VSS.n5 17.0005
R14 VSS.n12 VSS.n5 17.0005
R15 VSS.n10 VSS.n5 17.0005
R16 VSS.n7 VSS.n5 17.0005
R17 VSS.n12 VSS.n2 15.5985
R18 VSS.n11 VSS.n6 15.5985
R19 VSS.n9 VSS.n8 15.5985
R20 VSS.n1 VSS.n10 15.5985
R21 VSS.n4 VSS.t0 33.9189
R22 VSS.t2 VSS.n12 14.9259
R23 VSS.t1 VSS.n0 0.96878
R24 VSS.t1 VSS.n3 1.60801
R25 VSS.n0 VSS.n5 1.63382
R26 VSS.t4 VSS.n6 4.97562
R27 VSS.n3 VSS.n1 0.70277
R28 VSS.n3 VSS.n2 0.70227
R29 VSS.n11 VSS.n5 0.70227
R30 VSS.n9 VSS.n5 0.70227
R31 VSS VSS.t1 6.30942
R32 VSS VSS.n0 4.77539
C20 DELAY_VBIASN VSS 1.11056f
C21 DELAY_CELL_OUT_INV VSS 0.56456f
C22 DELAY_CELL_OUT VSS 0.70493f
C23 DELAY_VBIASP VSS 0.05118f
C24 DELAY_CELL_IN VSS 0.64927f
C25 VDD VSS 1.31136f
C26 a_229_203# VSS 0.01732f ; **FLOATING
C27 a_121_203# VSS 0.91567f ; **FLOATING
.ends
