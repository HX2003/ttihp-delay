* NGSPICE file created from hx_delay_cell.ext - technology: ihp-sg13g2

.subckt hx_delay_cell VDD VSS DELAY_CELL_OUT_INV DELAY_CELL_OUT DELAY_CELL_IN DELAY_VBIASP
+ DELAY_VBIASN
X0 VDD a_121_203# DELAY_CELL_OUT VDD sg13_lv_pmos ad=0.2128p pd=1.5u as=0.3808p ps=2.92u w=1.12u l=0.13u
X1 a_229_831# DELAY_CELL_IN a_121_203# VDD sg13_lv_pmos ad=0.2128p pd=1.5u as=0.3808p ps=2.92u w=1.12u l=0.2u
X2 DELAY_CELL_OUT_INV DELAY_CELL_OUT VDD VDD sg13_lv_pmos ad=0.3808p pd=2.92u as=0.2128p ps=1.5u w=1.12u l=0.13u
X3 VSS DELAY_VBIASN a_229_203# VSS.t3 sg13_lv_nmos ad=0.2516p pd=2.16u as=0.1406p ps=1.12u w=0.74u l=0.6u
X4 VSS a_121_203# DELAY_CELL_OUT VSS.t2 sg13_lv_nmos ad=0.1406p pd=1.12u as=0.2516p ps=2.16u w=0.74u l=0.13u
X5 a_229_203# DELAY_CELL_IN a_121_203# VSS.t1 sg13_lv_nmos ad=0.1406p pd=1.12u as=0.2516p ps=2.16u w=0.74u l=0.2u
X6 DELAY_CELL_OUT_INV DELAY_CELL_OUT VSS VSS.t0 sg13_lv_nmos ad=0.2516p pd=2.16u as=0.1406p ps=1.12u w=0.74u l=0.13u
X7 VDD DELAY_VBIASP a_229_831# VDD sg13_lv_pmos ad=0.3808p pd=2.92u as=0.2128p ps=1.5u w=1.12u l=0.6u
C0 a_229_831# a_121_203# 0.01697f
C1 DELAY_CELL_IN DELAY_VBIASP 0.07376f
C2 DELAY_VBIASN DELAY_VBIASP 0.03919f
C3 a_229_203# a_121_203# 0.01163f
C4 DELAY_CELL_OUT DELAY_CELL_IN 0.01139f
C5 DELAY_VBIASN DELAY_CELL_OUT 0.04166f
C6 DELAY_CELL_OUT_INV DELAY_VBIASP 0.04482f
C7 VDD a_121_203# 0.49292f
C8 a_229_831# VDD 0.01806f
C9 DELAY_CELL_OUT DELAY_CELL_OUT_INV 0.65743f
C10 DELAY_CELL_OUT DELAY_VBIASP 0.03981f
C11 DELAY_CELL_IN a_121_203# 0.53891f
C12 DELAY_VBIASN a_121_203# 0.06486f
C13 DELAY_CELL_IN VDD 0.24558f
C14 DELAY_VBIASN VDD 0.02108f
C15 a_121_203# DELAY_VBIASP 0.05987f
C16 VDD DELAY_CELL_OUT_INV 0.27119f
C17 DELAY_CELL_OUT a_121_203# 0.69646f
C18 DELAY_VBIASN DELAY_CELL_IN 0.06986f
C19 VDD DELAY_VBIASP 0.4038f
C20 DELAY_VBIASN DELAY_CELL_OUT_INV 0.04219f
C21 DELAY_CELL_OUT VDD 0.72866f
R0 VSS.n4 VSS.t3 377.291
R1 VSS.n8 VSS.t1 363.185
R2 VSS.t0 VSS.n5 348.26
R3 VSS.n7 VSS.t2 218.905
R4 VSS.t2 VSS.n5 159.204
R5 VSS.n6 VSS.t0 33.919
R6 VSS.n4 VSS.n3 8.31419
R7 VSS.n2 VSS.n1 8.31419
R8 VSS.n5 VSS.n1 17.0005
R9 VSS.n7 VSS.n1 17.0005
R10 VSS.n8 VSS.n1 17.0005
R11 VSS.n3 VSS.n8 17.0005
R12 VSS.n3 VSS.n0 17.0005
R13 VSS.n3 VSS.n5 17.0005
R14 VSS.n1 VSS.n0 15.5985
R15 VSS.n4 VSS.n1 8.33035
R16 VSS.n3 VSS.n7 15.5985
R17 VSS.t1 VSS.n0 14.9259
R18 VSS.n3 VSS.n6 8.50175
R19 VSS.n6 VSS.n1 8.501
R20 VSS.t3 VSS.n2 9.13272
R21 VSS VSS.n1 1.84122
R22 VSS VSS.n3 1.57521
R23 VSS.n3 VSS.n2 9.03212
C22 DELAY_VBIASN VSS 0.53242f
C23 DELAY_CELL_OUT_INV VSS 0.48954f
C24 DELAY_CELL_OUT VSS 0.68608f
C25 DELAY_VBIASP VSS 0.17046f
C26 DELAY_CELL_IN VSS 0.54536f
C27 VDD VSS 0.5504f
C28 a_229_203# VSS 0.01336f ; **FLOATING
C29 a_121_203# VSS 0.60176f ; **FLOATING
.ends
