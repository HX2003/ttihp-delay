* NGSPICE file created from hx_loop_capacitor.ext - technology: ihp-sg13g2

.subckt hx_loop_capacitor SIGP VSS
X0 VSS.t10 SIGP VSS.t12 VSS.t11 sg13_lv_nmos ad=1.33p pd=7.38u as=0 ps=0 w=7u l=7u
X1 VSS.t30 SIGP VSS.t28 VSS.t13 sg13_lv_nmos ad=1.33p pd=7.38u as=0 ps=0 w=7u l=7u
X2 VSS.t6 SIGP VSS.t8 VSS.t7 sg13_lv_nmos ad=1.33p pd=7.38u as=0 ps=0 w=7u l=7u
X3 VSS.t32 SIGP VSS.t30 VSS.t15 sg13_lv_nmos ad=1.33p pd=7.38u as=0 ps=0 w=7u l=7u
X4 VSS.t2 SIGP VSS.t1 VSS.t0 sg13_lv_nmos ad=2.38p pd=14.68u as=0 ps=0 w=7u l=7u
X5 VSS.t28 SIGP VSS.t26 VSS.t11 sg13_lv_nmos ad=1.33p pd=7.38u as=0 ps=0 w=7u l=7u
X6 VSS.t1 SIGP VSS.t4 VSS.t3 sg13_lv_nmos ad=1.33p pd=7.38u as=0 ps=0 w=7u l=7u
X7 VSS.t8 SIGP VSS.t10 VSS.t9 sg13_lv_nmos ad=1.33p pd=7.38u as=0 ps=0 w=7u l=7u
X8 VSS.t26 SIGP VSS.t24 VSS.t9 sg13_lv_nmos ad=1.33p pd=7.38u as=0 ps=0 w=7u l=7u
X9 VSS.t14 SIGP VSS.t16 VSS.t15 sg13_lv_nmos ad=1.33p pd=7.38u as=0 ps=0 w=7u l=7u
X10 VSS.t18 SIGP VSS.t17 VSS.t0 sg13_lv_nmos ad=2.38p pd=14.68u as=0 ps=0 w=7u l=7u
X11 VSS.t22 SIGP VSS.t20 VSS.t5 sg13_lv_nmos ad=1.33p pd=7.38u as=0 ps=0 w=7u l=7u
X12 VSS.t24 SIGP VSS.t22 VSS.t7 sg13_lv_nmos ad=1.33p pd=7.38u as=0 ps=0 w=7u l=7u
X13 VSS.t12 SIGP VSS.t14 VSS.t13 sg13_lv_nmos ad=1.33p pd=7.38u as=0 ps=0 w=7u l=7u
X14 VSS.t20 SIGP VSS.t18 VSS.t3 sg13_lv_nmos ad=1.33p pd=7.38u as=0 ps=0 w=7u l=7u
X15 VSS.t4 SIGP VSS.t6 VSS.t5 sg13_lv_nmos ad=1.33p pd=7.38u as=0 ps=0 w=7u l=7u
R0 VSS.t5 VSS.t0 15.9935
R1 VSS.t9 VSS.t0 19.6204
R2 VSS.t0 VSS.t13 20.5277
R3 VSS.n0 VSS.t0 0.384998
R4 VSS.t0 VSS.t15 12.0625
R5 VSS.t11 VSS.t0 9.64913
R6 VSS.t0 VSS.n1 8.47732
R7 VSS.t16 VSS.n0 0.00229882
R8 VSS.n2 VSS.t17 1.21013
R9 VSS.n3 VSS.n2 1.19613
R10 VSS.t20 VSS.t22 1.18726
R11 VSS.t8 VSS.t6 1.18726
R12 VSS.t12 VSS.t10 1.18188
R13 VSS.t6 VSS.t4 1.17786
R14 VSS.t22 VSS.t24 1.17786
R15 VSS.t16 VSS.t14 1.17463
R16 VSS.t1 VSS.t2 1.17241
R17 VSS.t26 VSS.t28 1.17241
R18 VSS.t17 VSS.t18 1.16092
R19 VSS.t30 VSS.t32 1.15741
R20 VSS.t28 VSS.t30 1.13252
R21 VSS.t12 VSS.t14 1.13154
R22 VSS.t18 VSS.t20 1.12501
R23 VSS.t24 VSS.t26 1.11752
R24 VSS.t4 VSS.t1 1.11752
R25 VSS.t10 VSS.t8 1.10748
R26 VSS.t16 VSS 0.39266
R27 VSS.t22 VSS.t0 0.150099
R28 VSS.t6 VSS.t0 0.150099
R29 VSS.t30 VSS.t0 0.139355
R30 VSS.t26 VSS.t0 0.139355
R31 VSS.t1 VSS.t0 0.139355
R32 VSS.t10 VSS.t0 0.139321
R33 VSS.t14 VSS.t0 0.129264
R34 VSS.t18 VSS.t0 0.119905
R35 VSS.n2 VSS.t0 0.110538
R36 VSS.n3 VSS.n1 0.0846176
R37 VSS.t2 VSS.n1 0.0708676
R38 VSS.t32 VSS.n0 0.0945117
R39 VSS.t17 VSS 0.05425
R40 VSS VSS.n3 0.05425
R41 VSS.t7 VSS.t0 15.9929
R42 VSS.t3 VSS.t0 19.6182
C0 SIGP VSS 96.6152f
.ends
