* NGSPICE file created from hx_loop_capacitor.ext - technology: ihp-sg13g2

.subckt hx_loop_capacitor SIGP VSS
X0 VSS.t10 SIGP VSS.t12 VSS.t11 sg13_lv_nmos ad=1.33p pd=7.38u as=0 ps=0 w=7u l=7u
X1 VSS.t30 SIGP VSS.t28 VSS.t13 sg13_lv_nmos ad=1.33p pd=7.38u as=0 ps=0 w=7u l=7u
X2 VSS.t6 SIGP VSS.t8 VSS.t7 sg13_lv_nmos ad=1.33p pd=7.38u as=0 ps=0 w=7u l=7u
X3 VSS.t32 SIGP VSS.t30 VSS.t15 sg13_lv_nmos ad=1.33p pd=7.38u as=0 ps=0 w=7u l=7u
X4 VSS.t2 SIGP VSS.t1 VSS.t0 sg13_lv_nmos ad=2.38p pd=14.68u as=0 ps=0 w=7u l=7u
X5 VSS.t28 SIGP VSS.t26 VSS.t11 sg13_lv_nmos ad=1.33p pd=7.38u as=0 ps=0 w=7u l=7u
X6 VSS.t1 SIGP VSS.t4 VSS.t3 sg13_lv_nmos ad=1.33p pd=7.38u as=0 ps=0 w=7u l=7u
X7 VSS.t8 SIGP VSS.t10 VSS.t9 sg13_lv_nmos ad=1.33p pd=7.38u as=0 ps=0 w=7u l=7u
X8 VSS.t26 SIGP VSS.t24 VSS.t9 sg13_lv_nmos ad=1.33p pd=7.38u as=0 ps=0 w=7u l=7u
X9 VSS.t14 SIGP VSS.t16 VSS.t15 sg13_lv_nmos ad=1.33p pd=7.38u as=0 ps=0 w=7u l=7u
X10 VSS.t18 SIGP VSS.t17 VSS.t0 sg13_lv_nmos ad=2.38p pd=14.68u as=0 ps=0 w=7u l=7u
X11 VSS.t22 SIGP VSS.t20 VSS.t5 sg13_lv_nmos ad=1.33p pd=7.38u as=0 ps=0 w=7u l=7u
X12 VSS.t24 SIGP VSS.t22 VSS.t7 sg13_lv_nmos ad=1.33p pd=7.38u as=0 ps=0 w=7u l=7u
X13 VSS.t12 SIGP VSS.t14 VSS.t13 sg13_lv_nmos ad=1.33p pd=7.38u as=0 ps=0 w=7u l=7u
X14 VSS.t20 SIGP VSS.t18 VSS.t3 sg13_lv_nmos ad=1.33p pd=7.38u as=0 ps=0 w=7u l=7u
X15 VSS.t4 SIGP VSS.t6 VSS.t5 sg13_lv_nmos ad=1.33p pd=7.38u as=0 ps=0 w=7u l=7u
R0 VSS.t13 VSS.t0 20.527
R1 VSS.t15 VSS.t0 12.0633
R2 VSS.t5 VSS.t0 15.9945
R3 VSS.t0 VSS.t7 15.9938
R4 VSS.t0 VSS.t9 19.6184
R5 VSS.n466 VSS.t0 17.0005
R6 VSS.t24 VSS.t0 17.0005
R7 VSS.n22 VSS.t0 17.0005
R8 VSS.t18 VSS.t0 17.0005
R9 VSS.t1 VSS.t0 17.0005
R10 VSS.n144 VSS.t0 17.0005
R11 VSS.t8 VSS.t0 17.0005
R12 VSS.n112 VSS.t0 17.0005
R13 VSS.t16 VSS.t0 17.0005
R14 VSS.t11 VSS.t0 9.64734
R15 VSS.n387 VSS.n382 9.11631
R16 VSS.n381 VSS.n79 9.11631
R17 VSS.n612 VSS.n611 9.0005
R18 VSS.n610 VSS.n3 9.0005
R19 VSS.n609 VSS.n608 9.0005
R20 VSS.n5 VSS.n4 9.0005
R21 VSS.n600 VSS.n599 9.0005
R22 VSS.n598 VSS.n7 9.0005
R23 VSS.n597 VSS.n596 9.0005
R24 VSS.n9 VSS.n8 9.0005
R25 VSS.n588 VSS.n587 9.0005
R26 VSS.n586 VSS.n11 9.0005
R27 VSS.n585 VSS.n584 9.0005
R28 VSS.n13 VSS.n12 9.0005
R29 VSS.n577 VSS.n576 9.0005
R30 VSS.n575 VSS.n15 9.0005
R31 VSS.n574 VSS.n573 9.0005
R32 VSS.n17 VSS.n16 9.0005
R33 VSS.n565 VSS.n564 9.0005
R34 VSS.n563 VSS.n19 9.0005
R35 VSS.n562 VSS.n561 9.0005
R36 VSS.n21 VSS.n20 9.0005
R37 VSS.n554 VSS.n553 9.0005
R38 VSS.n552 VSS.n23 9.0005
R39 VSS.n551 VSS.n550 9.0005
R40 VSS.n25 VSS.n24 9.0005
R41 VSS.n542 VSS.n541 9.0005
R42 VSS.n540 VSS.n27 9.0005
R43 VSS.n539 VSS.n538 9.0005
R44 VSS.n29 VSS.n28 9.0005
R45 VSS.n530 VSS.n529 9.0005
R46 VSS.n528 VSS.n31 9.0005
R47 VSS.n527 VSS.n526 9.0005
R48 VSS.n33 VSS.n32 9.0005
R49 VSS.n519 VSS.n518 9.0005
R50 VSS.n517 VSS.n35 9.0005
R51 VSS.n516 VSS.n515 9.0005
R52 VSS.n37 VSS.n36 9.0005
R53 VSS.n507 VSS.n506 9.0005
R54 VSS.n505 VSS.n39 9.0005
R55 VSS.n504 VSS.n503 9.0005
R56 VSS.n41 VSS.n40 9.0005
R57 VSS.n496 VSS.n495 9.0005
R58 VSS.n494 VSS.n43 9.0005
R59 VSS.n493 VSS.n492 9.0005
R60 VSS.n45 VSS.n44 9.0005
R61 VSS.n484 VSS.n483 9.0005
R62 VSS.n482 VSS.n47 9.0005
R63 VSS.n481 VSS.n480 9.0005
R64 VSS.n49 VSS.n48 9.0005
R65 VSS.n472 VSS.n471 9.0005
R66 VSS.n470 VSS.n51 9.0005
R67 VSS.n469 VSS.n468 9.0005
R68 VSS.n53 VSS.n52 9.0005
R69 VSS.n461 VSS.n460 9.0005
R70 VSS.n459 VSS.n55 9.0005
R71 VSS.n458 VSS.n457 9.0005
R72 VSS.n57 VSS.n56 9.0005
R73 VSS.n449 VSS.n448 9.0005
R74 VSS.n447 VSS.n59 9.0005
R75 VSS.n446 VSS.n445 9.0005
R76 VSS.n61 VSS.n60 9.0005
R77 VSS.n438 VSS.n437 9.0005
R78 VSS.n436 VSS.n63 9.0005
R79 VSS.n435 VSS.n434 9.0005
R80 VSS.n65 VSS.n64 9.0005
R81 VSS.n426 VSS.n425 9.0005
R82 VSS.n424 VSS.n67 9.0005
R83 VSS.n423 VSS.n422 9.0005
R84 VSS.n69 VSS.n68 9.0005
R85 VSS.n414 VSS.n413 9.0005
R86 VSS.n412 VSS.n70 9.0005
R87 VSS.n411 VSS.n410 9.0005
R88 VSS.n72 VSS.n71 9.0005
R89 VSS.n402 VSS.n401 9.0005
R90 VSS.n400 VSS.n74 9.0005
R91 VSS.n399 VSS.n398 9.0005
R92 VSS.n76 VSS.n75 9.0005
R93 VSS.n390 VSS.n389 9.0005
R94 VSS.n388 VSS.n78 9.0005
R95 VSS.n613 VSS.n612 9.0005
R96 VSS.n605 VSS.n3 9.0005
R97 VSS.n608 VSS.n607 9.0005
R98 VSS.n603 VSS.n5 9.0005
R99 VSS.n601 VSS.n600 9.0005
R100 VSS.n593 VSS.n7 9.0005
R101 VSS.n596 VSS.n595 9.0005
R102 VSS.n591 VSS.n9 9.0005
R103 VSS.n589 VSS.n588 9.0005
R104 VSS.n583 VSS.n11 9.0005
R105 VSS.n584 VSS.n582 9.0005
R106 VSS.n580 VSS.n13 9.0005
R107 VSS.n578 VSS.n577 9.0005
R108 VSS.n570 VSS.n15 9.0005
R109 VSS.n573 VSS.n572 9.0005
R110 VSS.n568 VSS.n17 9.0005
R111 VSS.n566 VSS.n565 9.0005
R112 VSS.n558 VSS.n19 9.0005
R113 VSS.n561 VSS.n560 9.0005
R114 VSS.n556 VSS.n21 9.0005
R115 VSS.t20 VSS.n554 9.0005
R116 VSS.n547 VSS.n23 9.0005
R117 VSS.n550 VSS.n549 9.0005
R118 VSS.n545 VSS.n25 9.0005
R119 VSS.n543 VSS.n542 9.0005
R120 VSS.n535 VSS.n27 9.0005
R121 VSS.n538 VSS.n537 9.0005
R122 VSS.n533 VSS.n29 9.0005
R123 VSS.n531 VSS.n530 9.0005
R124 VSS.n525 VSS.n31 9.0005
R125 VSS.n526 VSS.t22 9.0005
R126 VSS.n522 VSS.n33 9.0005
R127 VSS.n520 VSS.n519 9.0005
R128 VSS.n512 VSS.n35 9.0005
R129 VSS.n515 VSS.n514 9.0005
R130 VSS.n510 VSS.n37 9.0005
R131 VSS.n508 VSS.n507 9.0005
R132 VSS.n500 VSS.n39 9.0005
R133 VSS.n503 VSS.n502 9.0005
R134 VSS.n498 VSS.n41 9.0005
R135 VSS.n497 VSS.n496 9.0005
R136 VSS.n489 VSS.n43 9.0005
R137 VSS.n492 VSS.n491 9.0005
R138 VSS.n487 VSS.n45 9.0005
R139 VSS.n485 VSS.n484 9.0005
R140 VSS.n477 VSS.n47 9.0005
R141 VSS.n480 VSS.n479 9.0005
R142 VSS.n475 VSS.n49 9.0005
R143 VSS.n473 VSS.n472 9.0005
R144 VSS.t26 VSS.n51 9.0005
R145 VSS.n468 VSS.n467 9.0005
R146 VSS.n464 VSS.n53 9.0005
R147 VSS.n462 VSS.n461 9.0005
R148 VSS.n454 VSS.n55 9.0005
R149 VSS.n457 VSS.n456 9.0005
R150 VSS.n452 VSS.n57 9.0005
R151 VSS.n450 VSS.n449 9.0005
R152 VSS.n442 VSS.n59 9.0005
R153 VSS.n445 VSS.n444 9.0005
R154 VSS.t28 VSS.n61 9.0005
R155 VSS.n439 VSS.n438 9.0005
R156 VSS.n431 VSS.n63 9.0005
R157 VSS.n434 VSS.n433 9.0005
R158 VSS.n429 VSS.n65 9.0005
R159 VSS.n427 VSS.n426 9.0005
R160 VSS.n419 VSS.n67 9.0005
R161 VSS.n422 VSS.n421 9.0005
R162 VSS.n417 VSS.n69 9.0005
R163 VSS.n415 VSS.n414 9.0005
R164 VSS.n407 VSS.n70 9.0005
R165 VSS.n410 VSS.n409 9.0005
R166 VSS.n405 VSS.n72 9.0005
R167 VSS.n403 VSS.n402 9.0005
R168 VSS.n395 VSS.n74 9.0005
R169 VSS.n398 VSS.n397 9.0005
R170 VSS.n393 VSS.n76 9.0005
R171 VSS.n391 VSS.n390 9.0005
R172 VSS.n385 VSS.n78 9.0005
R173 VSS.n386 VSS.t32 9.0005
R174 VSS.n616 VSS.n615 9.0005
R175 VSS.n243 VSS.n240 9.0005
R176 VSS.n247 VSS.n162 9.0005
R177 VSS.n251 VSS.n160 9.0005
R178 VSS.n255 VSS.n158 9.0005
R179 VSS.n155 VSS.n156 9.0005
R180 VSS.n261 VSS.n153 9.0005
R181 VSS.n265 VSS.n151 9.0005
R182 VSS.n269 VSS.n149 9.0005
R183 VSS.n273 VSS.n147 9.0005
R184 VSS.t4 VSS.n145 9.0005
R185 VSS.n279 VSS.n142 9.0005
R186 VSS.n283 VSS.n140 9.0005
R187 VSS.n287 VSS.n138 9.0005
R188 VSS.n291 VSS.n136 9.0005
R189 VSS.t6 VSS.n133 9.0005
R190 VSS.n297 VSS.n131 9.0005
R191 VSS.n301 VSS.n129 9.0005
R192 VSS.n305 VSS.n127 9.0005
R193 VSS.n309 VSS.n125 9.0005
R194 VSS.n311 VSS.n122 9.0005
R195 VSS.n315 VSS.n120 9.0005
R196 VSS.n319 VSS.n118 9.0005
R197 VSS.n323 VSS.n116 9.0005
R198 VSS.n327 VSS.n114 9.0005
R199 VSS.n329 VSS.n111 9.0005
R200 VSS.n333 VSS.n109 9.0005
R201 VSS.n337 VSS.n107 9.0005
R202 VSS.n341 VSS.n105 9.0005
R203 VSS.n345 VSS.n103 9.0005
R204 VSS.n347 VSS.n100 9.0005
R205 VSS.n351 VSS.n98 9.0005
R206 VSS.n355 VSS.n96 9.0005
R207 VSS.n359 VSS.n94 9.0005
R208 VSS.n363 VSS.n92 9.0005
R209 VSS.n365 VSS.n89 9.0005
R210 VSS.n369 VSS.n87 9.0005
R211 VSS.n373 VSS.n85 9.0005
R212 VSS.n377 VSS.n83 9.0005
R213 VSS.n80 VSS.n81 9.0005
R214 VSS.n379 VSS.n82 9.0005
R215 VSS.n375 VSS.n84 9.0005
R216 VSS.n371 VSS.n86 9.0005
R217 VSS.n367 VSS.n88 9.0005
R218 VSS.n91 VSS.n90 9.0005
R219 VSS.n361 VSS.n93 9.0005
R220 VSS.n357 VSS.n95 9.0005
R221 VSS.n353 VSS.n97 9.0005
R222 VSS.n349 VSS.n99 9.0005
R223 VSS.t12 VSS.n101 9.0005
R224 VSS.n343 VSS.n104 9.0005
R225 VSS.n339 VSS.n106 9.0005
R226 VSS.n335 VSS.n108 9.0005
R227 VSS.n331 VSS.n110 9.0005
R228 VSS.t10 VSS.n113 9.0005
R229 VSS.n325 VSS.n115 9.0005
R230 VSS.n321 VSS.n117 9.0005
R231 VSS.n317 VSS.n119 9.0005
R232 VSS.n313 VSS.n121 9.0005
R233 VSS.n123 VSS.n124 9.0005
R234 VSS.n307 VSS.n126 9.0005
R235 VSS.n303 VSS.n128 9.0005
R236 VSS.n299 VSS.n130 9.0005
R237 VSS.n295 VSS.n132 9.0005
R238 VSS.n293 VSS.n135 9.0005
R239 VSS.n289 VSS.n137 9.0005
R240 VSS.n285 VSS.n139 9.0005
R241 VSS.n281 VSS.n141 9.0005
R242 VSS.n277 VSS.n143 9.0005
R243 VSS.n275 VSS.n146 9.0005
R244 VSS.n271 VSS.n148 9.0005
R245 VSS.n267 VSS.n150 9.0005
R246 VSS.n263 VSS.n152 9.0005
R247 VSS.n259 VSS.n154 9.0005
R248 VSS.n257 VSS.n157 9.0005
R249 VSS.n253 VSS.n159 9.0005
R250 VSS.n249 VSS.n161 9.0005
R251 VSS.n245 VSS.n163 9.0005
R252 VSS.n241 VSS.n2 9.0005
R253 VSS.n617 VSS.n616 9.0005
R254 VSS.n2 VSS.n1 9.0005
R255 VSS.n240 VSS.n239 9.0005
R256 VSS.n238 VSS.n163 9.0005
R257 VSS.n237 VSS.n162 9.0005
R258 VSS.n236 VSS.n161 9.0005
R259 VSS.n235 VSS.n160 9.0005
R260 VSS.n234 VSS.n159 9.0005
R261 VSS.n233 VSS.n158 9.0005
R262 VSS.n232 VSS.n157 9.0005
R263 VSS.n231 VSS.n156 9.0005
R264 VSS.n230 VSS.n154 9.0005
R265 VSS.n229 VSS.n153 9.0005
R266 VSS.n228 VSS.n152 9.0005
R267 VSS.n227 VSS.n151 9.0005
R268 VSS.n226 VSS.n150 9.0005
R269 VSS.n225 VSS.n149 9.0005
R270 VSS.n224 VSS.n148 9.0005
R271 VSS.n223 VSS.n147 9.0005
R272 VSS.n222 VSS.n146 9.0005
R273 VSS.n221 VSS.n145 9.0005
R274 VSS.n220 VSS.n143 9.0005
R275 VSS.n219 VSS.n142 9.0005
R276 VSS.n218 VSS.n141 9.0005
R277 VSS.n217 VSS.n140 9.0005
R278 VSS.n216 VSS.n139 9.0005
R279 VSS.n215 VSS.n138 9.0005
R280 VSS.n214 VSS.n137 9.0005
R281 VSS.n213 VSS.n136 9.0005
R282 VSS.n212 VSS.n135 9.0005
R283 VSS.n211 VSS.n133 9.0005
R284 VSS.n210 VSS.n132 9.0005
R285 VSS.n209 VSS.n131 9.0005
R286 VSS.n208 VSS.n130 9.0005
R287 VSS.n207 VSS.n129 9.0005
R288 VSS.n206 VSS.n128 9.0005
R289 VSS.n205 VSS.n127 9.0005
R290 VSS.n204 VSS.n126 9.0005
R291 VSS.n203 VSS.n125 9.0005
R292 VSS.n202 VSS.n124 9.0005
R293 VSS.n201 VSS.n122 9.0005
R294 VSS.n200 VSS.n121 9.0005
R295 VSS.n199 VSS.n120 9.0005
R296 VSS.n198 VSS.n119 9.0005
R297 VSS.n197 VSS.n118 9.0005
R298 VSS.n196 VSS.n117 9.0005
R299 VSS.n195 VSS.n116 9.0005
R300 VSS.n194 VSS.n115 9.0005
R301 VSS.n193 VSS.n114 9.0005
R302 VSS.n192 VSS.n113 9.0005
R303 VSS.n191 VSS.n111 9.0005
R304 VSS.n190 VSS.n110 9.0005
R305 VSS.n189 VSS.n109 9.0005
R306 VSS.n188 VSS.n108 9.0005
R307 VSS.n187 VSS.n107 9.0005
R308 VSS.n186 VSS.n106 9.0005
R309 VSS.n185 VSS.n105 9.0005
R310 VSS.n184 VSS.n104 9.0005
R311 VSS.n183 VSS.n103 9.0005
R312 VSS.n182 VSS.n101 9.0005
R313 VSS.n181 VSS.n100 9.0005
R314 VSS.n180 VSS.n99 9.0005
R315 VSS.n179 VSS.n98 9.0005
R316 VSS.n178 VSS.n97 9.0005
R317 VSS.n177 VSS.n96 9.0005
R318 VSS.n176 VSS.n95 9.0005
R319 VSS.n175 VSS.n94 9.0005
R320 VSS.n174 VSS.n93 9.0005
R321 VSS.n173 VSS.n92 9.0005
R322 VSS.n172 VSS.n90 9.0005
R323 VSS.n171 VSS.n89 9.0005
R324 VSS.n170 VSS.n88 9.0005
R325 VSS.n169 VSS.n87 9.0005
R326 VSS.n168 VSS.n86 9.0005
R327 VSS.n167 VSS.n85 9.0005
R328 VSS.n166 VSS.n84 9.0005
R329 VSS.n165 VSS.n83 9.0005
R330 VSS.n164 VSS.n82 9.0005
R331 VSS.n383 VSS.t0 8.48665
R332 VSS.n382 VSS.n0 1.22718
R333 VSS.n381 VSS.n0 1.13391
R334 VSS.n77 VSS.t0 8.47732
R335 VSS.n392 VSS.t0 8.47732
R336 VSS.n394 VSS.t0 8.47732
R337 VSS.n396 VSS.t0 8.47732
R338 VSS.n73 VSS.t0 8.47732
R339 VSS.n404 VSS.t0 8.47732
R340 VSS.n406 VSS.t0 8.47732
R341 VSS.n408 VSS.t0 8.47732
R342 VSS.t30 VSS.t0 8.47732
R343 VSS.n416 VSS.t0 8.47732
R344 VSS.n418 VSS.t0 8.47732
R345 VSS.n420 VSS.t0 8.47732
R346 VSS.n66 VSS.t0 8.47732
R347 VSS.n428 VSS.t0 8.47732
R348 VSS.n430 VSS.t0 8.47732
R349 VSS.n432 VSS.t0 8.47732
R350 VSS.n62 VSS.t0 8.47732
R351 VSS.n440 VSS.t0 8.47732
R352 VSS.n441 VSS.t0 8.47732
R353 VSS.n443 VSS.t0 8.47732
R354 VSS.n58 VSS.t0 8.47732
R355 VSS.n451 VSS.t0 8.47732
R356 VSS.n453 VSS.t0 8.47732
R357 VSS.n455 VSS.t0 8.47732
R358 VSS.n54 VSS.t0 8.47732
R359 VSS.n463 VSS.t0 8.47732
R360 VSS.n465 VSS.t0 8.47732
R361 VSS.n474 VSS.t0 8.47732
R362 VSS.n476 VSS.t0 8.47732
R363 VSS.n478 VSS.t0 8.47732
R364 VSS.n46 VSS.t0 8.47732
R365 VSS.n486 VSS.t0 8.47732
R366 VSS.n488 VSS.t0 8.47732
R367 VSS.n490 VSS.t0 8.47732
R368 VSS.n42 VSS.t0 8.47732
R369 VSS.n501 VSS.t0 8.47732
R370 VSS.n38 VSS.t0 8.47732
R371 VSS.n509 VSS.t0 8.47732
R372 VSS.n511 VSS.t0 8.47732
R373 VSS.n513 VSS.t0 8.47732
R374 VSS.n34 VSS.t0 8.47732
R375 VSS.n521 VSS.t0 8.47732
R376 VSS.n523 VSS.t0 8.47732
R377 VSS.n524 VSS.t0 8.47732
R378 VSS.n30 VSS.t0 8.47732
R379 VSS.n532 VSS.t0 8.47732
R380 VSS.n534 VSS.t0 8.47732
R381 VSS.n536 VSS.t0 8.47732
R382 VSS.n26 VSS.t0 8.47732
R383 VSS.n544 VSS.t0 8.47732
R384 VSS.n546 VSS.t0 8.47732
R385 VSS.n548 VSS.t0 8.47732
R386 VSS.n557 VSS.t0 8.47732
R387 VSS.n559 VSS.t0 8.47732
R388 VSS.n18 VSS.t0 8.47732
R389 VSS.n567 VSS.t0 8.47732
R390 VSS.n569 VSS.t0 8.47732
R391 VSS.n571 VSS.t0 8.47732
R392 VSS.n14 VSS.t0 8.47732
R393 VSS.n579 VSS.t0 8.47732
R394 VSS.n10 VSS.t0 8.47732
R395 VSS.n590 VSS.t0 8.47732
R396 VSS.n592 VSS.t0 8.47732
R397 VSS.n594 VSS.t0 8.47732
R398 VSS.n6 VSS.t0 8.47732
R399 VSS.n602 VSS.t0 8.47732
R400 VSS.n604 VSS.t0 8.47732
R401 VSS.n606 VSS.t0 8.47732
R402 VSS.t17 VSS.t0 8.47732
R403 VSS.t0 VSS.t2 8.47732
R404 VSS.n242 VSS.t0 8.47732
R405 VSS.n244 VSS.t0 8.47732
R406 VSS.n246 VSS.t0 8.47732
R407 VSS.n248 VSS.t0 8.47732
R408 VSS.n250 VSS.t0 8.47732
R409 VSS.n252 VSS.t0 8.47732
R410 VSS.n254 VSS.t0 8.47732
R411 VSS.n256 VSS.t0 8.47732
R412 VSS.n260 VSS.t0 8.47732
R413 VSS.n262 VSS.t0 8.47732
R414 VSS.n264 VSS.t0 8.47732
R415 VSS.n266 VSS.t0 8.47732
R416 VSS.n268 VSS.t0 8.47732
R417 VSS.n270 VSS.t0 8.47732
R418 VSS.n272 VSS.t0 8.47732
R419 VSS.n274 VSS.t0 8.47732
R420 VSS.n278 VSS.t0 8.47732
R421 VSS.n280 VSS.t0 8.47732
R422 VSS.n282 VSS.t0 8.47732
R423 VSS.n284 VSS.t0 8.47732
R424 VSS.n286 VSS.t0 8.47732
R425 VSS.n288 VSS.t0 8.47732
R426 VSS.n290 VSS.t0 8.47732
R427 VSS.n292 VSS.t0 8.47732
R428 VSS.n134 VSS.t0 8.47732
R429 VSS.n294 VSS.t0 8.47732
R430 VSS.n296 VSS.t0 8.47732
R431 VSS.n298 VSS.t0 8.47732
R432 VSS.n300 VSS.t0 8.47732
R433 VSS.n302 VSS.t0 8.47732
R434 VSS.n304 VSS.t0 8.47732
R435 VSS.n306 VSS.t0 8.47732
R436 VSS.n308 VSS.t0 8.47732
R437 VSS.n312 VSS.t0 8.47732
R438 VSS.n314 VSS.t0 8.47732
R439 VSS.n316 VSS.t0 8.47732
R440 VSS.n318 VSS.t0 8.47732
R441 VSS.n320 VSS.t0 8.47732
R442 VSS.n322 VSS.t0 8.47732
R443 VSS.n324 VSS.t0 8.47732
R444 VSS.n326 VSS.t0 8.47732
R445 VSS.n330 VSS.t0 8.47732
R446 VSS.n332 VSS.t0 8.47732
R447 VSS.n334 VSS.t0 8.47732
R448 VSS.n336 VSS.t0 8.47732
R449 VSS.n338 VSS.t0 8.47732
R450 VSS.n340 VSS.t0 8.47732
R451 VSS.n342 VSS.t0 8.47732
R452 VSS.n344 VSS.t0 8.47732
R453 VSS.n102 VSS.t0 8.47732
R454 VSS.n346 VSS.t0 8.47732
R455 VSS.n348 VSS.t0 8.47732
R456 VSS.n350 VSS.t0 8.47732
R457 VSS.n352 VSS.t0 8.47732
R458 VSS.n354 VSS.t0 8.47732
R459 VSS.n356 VSS.t0 8.47732
R460 VSS.n358 VSS.t0 8.47732
R461 VSS.n360 VSS.t0 8.47732
R462 VSS.n362 VSS.t0 8.47732
R463 VSS.t14 VSS.t0 8.47732
R464 VSS.n364 VSS.t0 8.47732
R465 VSS.n366 VSS.t0 8.47732
R466 VSS.n368 VSS.t0 8.47732
R467 VSS.n370 VSS.t0 8.47732
R468 VSS.n372 VSS.t0 8.47732
R469 VSS.n374 VSS.t0 8.47732
R470 VSS.n376 VSS.t0 8.47732
R471 VSS.n378 VSS.t0 8.47732
R472 VSS.n0 VSS.t0 0.105271
R473 VSS.n384 VSS.t0 5.62581
R474 VSS.n50 VSS.t0 5.62581
R475 VSS.n499 VSS.t0 5.62581
R476 VSS.n555 VSS.t0 5.62581
R477 VSS.n581 VSS.t0 5.62581
R478 VSS.n258 VSS.t0 5.62581
R479 VSS.n276 VSS.t0 5.62581
R480 VSS.n310 VSS.t0 5.62581
R481 VSS.n328 VSS.t0 5.62581
R482 VSS.n380 VSS.t0 5.62581
R483 VSS.n388 VSS.n387 4.73162
R484 VSS.n164 VSS.n79 4.73162
R485 VSS.n614 VSS.n613 1.24638
R486 VSS.n615 VSS.n614 1.23238
R487 VSS.n611 VSS.n610 0.231121
R488 VSS.n610 VSS.n609 0.231121
R489 VSS.n609 VSS.n4 0.231121
R490 VSS.n599 VSS.n4 0.231121
R491 VSS.n599 VSS.n598 0.231121
R492 VSS.n598 VSS.n597 0.231121
R493 VSS.n597 VSS.n8 0.231121
R494 VSS.n587 VSS.n8 0.231121
R495 VSS.n587 VSS.n586 0.231121
R496 VSS.n586 VSS.n585 0.231121
R497 VSS.n585 VSS.n12 0.231121
R498 VSS.n576 VSS.n12 0.231121
R499 VSS.n576 VSS.n575 0.231121
R500 VSS.n575 VSS.n574 0.231121
R501 VSS.n574 VSS.n16 0.231121
R502 VSS.n564 VSS.n16 0.231121
R503 VSS.n564 VSS.n563 0.231121
R504 VSS.n563 VSS.n562 0.231121
R505 VSS.n562 VSS.n20 0.231121
R506 VSS.n553 VSS.n20 0.231121
R507 VSS.n553 VSS.n552 0.231121
R508 VSS.n552 VSS.n551 0.231121
R509 VSS.n551 VSS.n24 0.231121
R510 VSS.n541 VSS.n24 0.231121
R511 VSS.n541 VSS.n540 0.231121
R512 VSS.n540 VSS.n539 0.231121
R513 VSS.n539 VSS.n28 0.231121
R514 VSS.n529 VSS.n28 0.231121
R515 VSS.n529 VSS.n528 0.231121
R516 VSS.n528 VSS.n527 0.231121
R517 VSS.n527 VSS.n32 0.231121
R518 VSS.n518 VSS.n32 0.231121
R519 VSS.n518 VSS.n517 0.231121
R520 VSS.n517 VSS.n516 0.231121
R521 VSS.n516 VSS.n36 0.231121
R522 VSS.n506 VSS.n36 0.231121
R523 VSS.n506 VSS.n505 0.231121
R524 VSS.n505 VSS.n504 0.231121
R525 VSS.n504 VSS.n40 0.231121
R526 VSS.n495 VSS.n40 0.231121
R527 VSS.n495 VSS.n494 0.231121
R528 VSS.n494 VSS.n493 0.231121
R529 VSS.n493 VSS.n44 0.231121
R530 VSS.n483 VSS.n44 0.231121
R531 VSS.n483 VSS.n482 0.231121
R532 VSS.n482 VSS.n481 0.231121
R533 VSS.n481 VSS.n48 0.231121
R534 VSS.n471 VSS.n48 0.231121
R535 VSS.n471 VSS.n470 0.231121
R536 VSS.n470 VSS.n469 0.231121
R537 VSS.n469 VSS.n52 0.231121
R538 VSS.n460 VSS.n52 0.231121
R539 VSS.n460 VSS.n459 0.231121
R540 VSS.n459 VSS.n458 0.231121
R541 VSS.n458 VSS.n56 0.231121
R542 VSS.n448 VSS.n56 0.231121
R543 VSS.n448 VSS.n447 0.231121
R544 VSS.n447 VSS.n446 0.231121
R545 VSS.n446 VSS.n60 0.231121
R546 VSS.n437 VSS.n60 0.231121
R547 VSS.n437 VSS.n436 0.231121
R548 VSS.n436 VSS.n435 0.231121
R549 VSS.n435 VSS.n64 0.231121
R550 VSS.n425 VSS.n64 0.231121
R551 VSS.n425 VSS.n424 0.231121
R552 VSS.n424 VSS.n423 0.231121
R553 VSS.n423 VSS.n68 0.231121
R554 VSS.n413 VSS.n68 0.231121
R555 VSS.n413 VSS.n412 0.231121
R556 VSS.n412 VSS.n411 0.231121
R557 VSS.n411 VSS.n71 0.231121
R558 VSS.n401 VSS.n71 0.231121
R559 VSS.n401 VSS.n400 0.231121
R560 VSS.n400 VSS.n399 0.231121
R561 VSS.n399 VSS.n75 0.231121
R562 VSS.n389 VSS.n75 0.231121
R563 VSS.n389 VSS.n388 0.231121
R564 VSS.n612 VSS.n3 0.231121
R565 VSS.n608 VSS.n3 0.231121
R566 VSS.n608 VSS.n5 0.231121
R567 VSS.n600 VSS.n5 0.231121
R568 VSS.n600 VSS.n7 0.231121
R569 VSS.n596 VSS.n7 0.231121
R570 VSS.n596 VSS.n9 0.231121
R571 VSS.n588 VSS.n9 0.231121
R572 VSS.n588 VSS.n11 0.231121
R573 VSS.n584 VSS.n11 0.231121
R574 VSS.n584 VSS.n13 0.231121
R575 VSS.n577 VSS.n13 0.231121
R576 VSS.n577 VSS.n15 0.231121
R577 VSS.n573 VSS.n15 0.231121
R578 VSS.n573 VSS.n17 0.231121
R579 VSS.n565 VSS.n17 0.231121
R580 VSS.n565 VSS.n19 0.231121
R581 VSS.n561 VSS.n19 0.231121
R582 VSS.n561 VSS.n21 0.231121
R583 VSS.n554 VSS.n21 0.231121
R584 VSS.n554 VSS.n23 0.231121
R585 VSS.n550 VSS.n23 0.231121
R586 VSS.n550 VSS.n25 0.231121
R587 VSS.n542 VSS.n25 0.231121
R588 VSS.n542 VSS.n27 0.231121
R589 VSS.n538 VSS.n27 0.231121
R590 VSS.n538 VSS.n29 0.231121
R591 VSS.n530 VSS.n29 0.231121
R592 VSS.n530 VSS.n31 0.231121
R593 VSS.n526 VSS.n31 0.231121
R594 VSS.n526 VSS.n33 0.231121
R595 VSS.n519 VSS.n33 0.231121
R596 VSS.n519 VSS.n35 0.231121
R597 VSS.n515 VSS.n35 0.231121
R598 VSS.n515 VSS.n37 0.231121
R599 VSS.n507 VSS.n37 0.231121
R600 VSS.n507 VSS.n39 0.231121
R601 VSS.n503 VSS.n39 0.231121
R602 VSS.n503 VSS.n41 0.231121
R603 VSS.n496 VSS.n41 0.231121
R604 VSS.n496 VSS.n43 0.231121
R605 VSS.n492 VSS.n43 0.231121
R606 VSS.n492 VSS.n45 0.231121
R607 VSS.n484 VSS.n45 0.231121
R608 VSS.n484 VSS.n47 0.231121
R609 VSS.n480 VSS.n47 0.231121
R610 VSS.n480 VSS.n49 0.231121
R611 VSS.n472 VSS.n49 0.231121
R612 VSS.n472 VSS.n51 0.231121
R613 VSS.n468 VSS.n51 0.231121
R614 VSS.n468 VSS.n53 0.231121
R615 VSS.n461 VSS.n53 0.231121
R616 VSS.n461 VSS.n55 0.231121
R617 VSS.n457 VSS.n55 0.231121
R618 VSS.n457 VSS.n57 0.231121
R619 VSS.n449 VSS.n57 0.231121
R620 VSS.n449 VSS.n59 0.231121
R621 VSS.n445 VSS.n59 0.231121
R622 VSS.n445 VSS.n61 0.231121
R623 VSS.n438 VSS.n61 0.231121
R624 VSS.n438 VSS.n63 0.231121
R625 VSS.n434 VSS.n63 0.231121
R626 VSS.n434 VSS.n65 0.231121
R627 VSS.n426 VSS.n65 0.231121
R628 VSS.n426 VSS.n67 0.231121
R629 VSS.n422 VSS.n67 0.231121
R630 VSS.n422 VSS.n69 0.231121
R631 VSS.n414 VSS.n69 0.231121
R632 VSS.n414 VSS.n70 0.231121
R633 VSS.n410 VSS.n70 0.231121
R634 VSS.n410 VSS.n72 0.231121
R635 VSS.n402 VSS.n72 0.231121
R636 VSS.n402 VSS.n74 0.231121
R637 VSS.n398 VSS.n74 0.231121
R638 VSS.n398 VSS.n76 0.231121
R639 VSS.n390 VSS.n76 0.231121
R640 VSS.n390 VSS.n78 0.231121
R641 VSS.n386 VSS.n78 0.231121
R642 VSS.n616 VSS.n2 0.231121
R643 VSS.n240 VSS.n2 0.231121
R644 VSS.n240 VSS.n163 0.231121
R645 VSS.n163 VSS.n162 0.231121
R646 VSS.n162 VSS.n161 0.231121
R647 VSS.n161 VSS.n160 0.231121
R648 VSS.n160 VSS.n159 0.231121
R649 VSS.n159 VSS.n158 0.231121
R650 VSS.n158 VSS.n157 0.231121
R651 VSS.n157 VSS.n156 0.231121
R652 VSS.n156 VSS.n154 0.231121
R653 VSS.n154 VSS.n153 0.231121
R654 VSS.n153 VSS.n152 0.231121
R655 VSS.n152 VSS.n151 0.231121
R656 VSS.n151 VSS.n150 0.231121
R657 VSS.n150 VSS.n149 0.231121
R658 VSS.n149 VSS.n148 0.231121
R659 VSS.n148 VSS.n147 0.231121
R660 VSS.n147 VSS.n146 0.231121
R661 VSS.n146 VSS.n145 0.231121
R662 VSS.n145 VSS.n143 0.231121
R663 VSS.n143 VSS.n142 0.231121
R664 VSS.n142 VSS.n141 0.231121
R665 VSS.n141 VSS.n140 0.231121
R666 VSS.n140 VSS.n139 0.231121
R667 VSS.n139 VSS.n138 0.231121
R668 VSS.n138 VSS.n137 0.231121
R669 VSS.n137 VSS.n136 0.231121
R670 VSS.n136 VSS.n135 0.231121
R671 VSS.n135 VSS.n133 0.231121
R672 VSS.n133 VSS.n132 0.231121
R673 VSS.n132 VSS.n131 0.231121
R674 VSS.n131 VSS.n130 0.231121
R675 VSS.n130 VSS.n129 0.231121
R676 VSS.n129 VSS.n128 0.231121
R677 VSS.n128 VSS.n127 0.231121
R678 VSS.n127 VSS.n126 0.231121
R679 VSS.n126 VSS.n125 0.231121
R680 VSS.n125 VSS.n124 0.231121
R681 VSS.n124 VSS.n122 0.231121
R682 VSS.n122 VSS.n121 0.231121
R683 VSS.n121 VSS.n120 0.231121
R684 VSS.n120 VSS.n119 0.231121
R685 VSS.n119 VSS.n118 0.231121
R686 VSS.n118 VSS.n117 0.231121
R687 VSS.n117 VSS.n116 0.231121
R688 VSS.n116 VSS.n115 0.231121
R689 VSS.n115 VSS.n114 0.231121
R690 VSS.n114 VSS.n113 0.231121
R691 VSS.n113 VSS.n111 0.231121
R692 VSS.n111 VSS.n110 0.231121
R693 VSS.n110 VSS.n109 0.231121
R694 VSS.n109 VSS.n108 0.231121
R695 VSS.n108 VSS.n107 0.231121
R696 VSS.n107 VSS.n106 0.231121
R697 VSS.n106 VSS.n105 0.231121
R698 VSS.n105 VSS.n104 0.231121
R699 VSS.n104 VSS.n103 0.231121
R700 VSS.n103 VSS.n101 0.231121
R701 VSS.n101 VSS.n100 0.231121
R702 VSS.n100 VSS.n99 0.231121
R703 VSS.n99 VSS.n98 0.231121
R704 VSS.n98 VSS.n97 0.231121
R705 VSS.n97 VSS.n96 0.231121
R706 VSS.n96 VSS.n95 0.231121
R707 VSS.n95 VSS.n94 0.231121
R708 VSS.n94 VSS.n93 0.231121
R709 VSS.n93 VSS.n92 0.231121
R710 VSS.n92 VSS.n90 0.231121
R711 VSS.n90 VSS.n89 0.231121
R712 VSS.n89 VSS.n88 0.231121
R713 VSS.n88 VSS.n87 0.231121
R714 VSS.n87 VSS.n86 0.231121
R715 VSS.n86 VSS.n85 0.231121
R716 VSS.n85 VSS.n84 0.231121
R717 VSS.n84 VSS.n83 0.231121
R718 VSS.n83 VSS.n82 0.231121
R719 VSS.n82 VSS.n81 0.231121
R720 VSS.n617 VSS.n1 0.231121
R721 VSS.n239 VSS.n1 0.231121
R722 VSS.n239 VSS.n238 0.231121
R723 VSS.n238 VSS.n237 0.231121
R724 VSS.n237 VSS.n236 0.231121
R725 VSS.n236 VSS.n235 0.231121
R726 VSS.n235 VSS.n234 0.231121
R727 VSS.n234 VSS.n233 0.231121
R728 VSS.n233 VSS.n232 0.231121
R729 VSS.n232 VSS.n231 0.231121
R730 VSS.n231 VSS.n230 0.231121
R731 VSS.n230 VSS.n229 0.231121
R732 VSS.n229 VSS.n228 0.231121
R733 VSS.n228 VSS.n227 0.231121
R734 VSS.n227 VSS.n226 0.231121
R735 VSS.n226 VSS.n225 0.231121
R736 VSS.n225 VSS.n224 0.231121
R737 VSS.n224 VSS.n223 0.231121
R738 VSS.n223 VSS.n222 0.231121
R739 VSS.n222 VSS.n221 0.231121
R740 VSS.n221 VSS.n220 0.231121
R741 VSS.n220 VSS.n219 0.231121
R742 VSS.n219 VSS.n218 0.231121
R743 VSS.n218 VSS.n217 0.231121
R744 VSS.n217 VSS.n216 0.231121
R745 VSS.n216 VSS.n215 0.231121
R746 VSS.n215 VSS.n214 0.231121
R747 VSS.n214 VSS.n213 0.231121
R748 VSS.n213 VSS.n212 0.231121
R749 VSS.n212 VSS.n211 0.231121
R750 VSS.n211 VSS.n210 0.231121
R751 VSS.n210 VSS.n209 0.231121
R752 VSS.n209 VSS.n208 0.231121
R753 VSS.n208 VSS.n207 0.231121
R754 VSS.n207 VSS.n206 0.231121
R755 VSS.n206 VSS.n205 0.231121
R756 VSS.n205 VSS.n204 0.231121
R757 VSS.n204 VSS.n203 0.231121
R758 VSS.n203 VSS.n202 0.231121
R759 VSS.n202 VSS.n201 0.231121
R760 VSS.n201 VSS.n200 0.231121
R761 VSS.n200 VSS.n199 0.231121
R762 VSS.n199 VSS.n198 0.231121
R763 VSS.n198 VSS.n197 0.231121
R764 VSS.n197 VSS.n196 0.231121
R765 VSS.n196 VSS.n195 0.231121
R766 VSS.n195 VSS.n194 0.231121
R767 VSS.n194 VSS.n193 0.231121
R768 VSS.n193 VSS.n192 0.231121
R769 VSS.n192 VSS.n191 0.231121
R770 VSS.n191 VSS.n190 0.231121
R771 VSS.n190 VSS.n189 0.231121
R772 VSS.n189 VSS.n188 0.231121
R773 VSS.n188 VSS.n187 0.231121
R774 VSS.n187 VSS.n186 0.231121
R775 VSS.n186 VSS.n185 0.231121
R776 VSS.n185 VSS.n184 0.231121
R777 VSS.n184 VSS.n183 0.231121
R778 VSS.n183 VSS.n182 0.231121
R779 VSS.n182 VSS.n181 0.231121
R780 VSS.n181 VSS.n180 0.231121
R781 VSS.n180 VSS.n179 0.231121
R782 VSS.n179 VSS.n178 0.231121
R783 VSS.n178 VSS.n177 0.231121
R784 VSS.n177 VSS.n176 0.231121
R785 VSS.n176 VSS.n175 0.231121
R786 VSS.n175 VSS.n174 0.231121
R787 VSS.n174 VSS.n173 0.231121
R788 VSS.n173 VSS.n172 0.231121
R789 VSS.n172 VSS.n171 0.231121
R790 VSS.n171 VSS.n170 0.231121
R791 VSS.n170 VSS.n169 0.231121
R792 VSS.n169 VSS.n168 0.231121
R793 VSS.n168 VSS.n167 0.231121
R794 VSS.n167 VSS.n166 0.231121
R795 VSS.n166 VSS.n165 0.231121
R796 VSS.n165 VSS.n164 0.231121
R797 VSS.n607 VSS.n606 0.143368
R798 VSS.n604 VSS.n603 0.143368
R799 VSS.n602 VSS.n601 0.143368
R800 VSS.n593 VSS.n6 0.143368
R801 VSS.n595 VSS.n594 0.143368
R802 VSS.n592 VSS.n591 0.143368
R803 VSS.n590 VSS.n589 0.143368
R804 VSS.n583 VSS.n10 0.143368
R805 VSS.n579 VSS.n578 0.143368
R806 VSS.n570 VSS.n14 0.143368
R807 VSS.n572 VSS.n571 0.143368
R808 VSS.n569 VSS.n568 0.143368
R809 VSS.n567 VSS.n566 0.143368
R810 VSS.n558 VSS.n18 0.143368
R811 VSS.n560 VSS.n559 0.143368
R812 VSS.n557 VSS.n556 0.143368
R813 VSS.n549 VSS.n548 0.143368
R814 VSS.n546 VSS.n545 0.143368
R815 VSS.n544 VSS.n543 0.143368
R816 VSS.n535 VSS.n26 0.143368
R817 VSS.n537 VSS.n536 0.143368
R818 VSS.n534 VSS.n533 0.143368
R819 VSS.n532 VSS.n531 0.143368
R820 VSS.n525 VSS.n30 0.143368
R821 VSS.n523 VSS.n522 0.143368
R822 VSS.n521 VSS.n520 0.143368
R823 VSS.n512 VSS.n34 0.143368
R824 VSS.n514 VSS.n513 0.143368
R825 VSS.n511 VSS.n510 0.143368
R826 VSS.n509 VSS.n508 0.143368
R827 VSS.n500 VSS.n38 0.143368
R828 VSS.n502 VSS.n501 0.143368
R829 VSS.n489 VSS.n42 0.143368
R830 VSS.n491 VSS.n490 0.143368
R831 VSS.n488 VSS.n487 0.143368
R832 VSS.n486 VSS.n485 0.143368
R833 VSS.n477 VSS.n46 0.143368
R834 VSS.n479 VSS.n478 0.143368
R835 VSS.n476 VSS.n475 0.143368
R836 VSS.n474 VSS.n473 0.143368
R837 VSS.n465 VSS.n464 0.143368
R838 VSS.n463 VSS.n462 0.143368
R839 VSS.n454 VSS.n54 0.143368
R840 VSS.n456 VSS.n455 0.143368
R841 VSS.n453 VSS.n452 0.143368
R842 VSS.n451 VSS.n450 0.143368
R843 VSS.n442 VSS.n58 0.143368
R844 VSS.n444 VSS.n443 0.143368
R845 VSS.n440 VSS.n439 0.143368
R846 VSS.n431 VSS.n62 0.143368
R847 VSS.n433 VSS.n432 0.143368
R848 VSS.n430 VSS.n429 0.143368
R849 VSS.n428 VSS.n427 0.143368
R850 VSS.n419 VSS.n66 0.143368
R851 VSS.n421 VSS.n420 0.143368
R852 VSS.n418 VSS.n417 0.143368
R853 VSS.n416 VSS.n415 0.143368
R854 VSS.n409 VSS.n408 0.143368
R855 VSS.n406 VSS.n405 0.143368
R856 VSS.n404 VSS.n403 0.143368
R857 VSS.n395 VSS.n73 0.143368
R858 VSS.n397 VSS.n396 0.143368
R859 VSS.n394 VSS.n393 0.143368
R860 VSS.n392 VSS.n391 0.143368
R861 VSS.n385 VSS.n77 0.143368
R862 VSS.n243 VSS.n242 0.143368
R863 VSS.n245 VSS.n244 0.143368
R864 VSS.n247 VSS.n246 0.143368
R865 VSS.n249 VSS.n248 0.143368
R866 VSS.n251 VSS.n250 0.143368
R867 VSS.n253 VSS.n252 0.143368
R868 VSS.n255 VSS.n254 0.143368
R869 VSS.n257 VSS.n256 0.143368
R870 VSS.n261 VSS.n260 0.143368
R871 VSS.n263 VSS.n262 0.143368
R872 VSS.n265 VSS.n264 0.143368
R873 VSS.n267 VSS.n266 0.143368
R874 VSS.n269 VSS.n268 0.143368
R875 VSS.n271 VSS.n270 0.143368
R876 VSS.n273 VSS.n272 0.143368
R877 VSS.n275 VSS.n274 0.143368
R878 VSS.n279 VSS.n278 0.143368
R879 VSS.n281 VSS.n280 0.143368
R880 VSS.n283 VSS.n282 0.143368
R881 VSS.n285 VSS.n284 0.143368
R882 VSS.n287 VSS.n286 0.143368
R883 VSS.n289 VSS.n288 0.143368
R884 VSS.n291 VSS.n290 0.143368
R885 VSS.n293 VSS.n292 0.143368
R886 VSS.n295 VSS.n294 0.143368
R887 VSS.n297 VSS.n296 0.143368
R888 VSS.n299 VSS.n298 0.143368
R889 VSS.n301 VSS.n300 0.143368
R890 VSS.n303 VSS.n302 0.143368
R891 VSS.n305 VSS.n304 0.143368
R892 VSS.n307 VSS.n306 0.143368
R893 VSS.n309 VSS.n308 0.143368
R894 VSS.n313 VSS.n312 0.143368
R895 VSS.n315 VSS.n314 0.143368
R896 VSS.n317 VSS.n316 0.143368
R897 VSS.n319 VSS.n318 0.143368
R898 VSS.n321 VSS.n320 0.143368
R899 VSS.n323 VSS.n322 0.143368
R900 VSS.n325 VSS.n324 0.143368
R901 VSS.n327 VSS.n326 0.143368
R902 VSS.n331 VSS.n330 0.143368
R903 VSS.n333 VSS.n332 0.143368
R904 VSS.n335 VSS.n334 0.143368
R905 VSS.n337 VSS.n336 0.143368
R906 VSS.n339 VSS.n338 0.143368
R907 VSS.n341 VSS.n340 0.143368
R908 VSS.n343 VSS.n342 0.143368
R909 VSS.n345 VSS.n344 0.143368
R910 VSS.n347 VSS.n346 0.143368
R911 VSS.n349 VSS.n348 0.143368
R912 VSS.n351 VSS.n350 0.143368
R913 VSS.n353 VSS.n352 0.143368
R914 VSS.n355 VSS.n354 0.143368
R915 VSS.n357 VSS.n356 0.143368
R916 VSS.n359 VSS.n358 0.143368
R917 VSS.n361 VSS.n360 0.143368
R918 VSS.n363 VSS.n362 0.143368
R919 VSS.n365 VSS.n364 0.143368
R920 VSS.n367 VSS.n366 0.143368
R921 VSS.n369 VSS.n368 0.143368
R922 VSS.n371 VSS.n370 0.143368
R923 VSS.n373 VSS.n372 0.143368
R924 VSS.n375 VSS.n374 0.143368
R925 VSS.n377 VSS.n376 0.143368
R926 VSS.n379 VSS.n378 0.143368
R927 VSS.n605 VSS.t17 0.143368
R928 VSS.t22 VSS.n524 0.143368
R929 VSS.n441 VSS.t28 0.143368
R930 VSS.n407 VSS.t30 0.143368
R931 VSS.n91 VSS.t14 0.143368
R932 VSS.t12 VSS.n102 0.143368
R933 VSS.t6 VSS.n134 0.143368
R934 VSS.n241 VSS.t2 0.143368
R935 VSS.t32 VSS.n383 0.124701
R936 VSS.n387 VSS.n386 0.113429
R937 VSS.n81 VSS.n79 0.113429
R938 VSS.n614 VSS.t0 0.110538
R939 VSS.n611 VSS 0.109741
R940 VSS VSS.n617 0.109741
R941 VSS.n384 VSS.n385 0.0961384
R942 VSS.n473 VSS.n50 0.0961384
R943 VSS.n502 VSS.n499 0.0961384
R944 VSS.n556 VSS.n555 0.0961384
R945 VSS.n581 VSS.n583 0.0961384
R946 VSS.n155 VSS.n258 0.0961384
R947 VSS.t4 VSS.n276 0.0961384
R948 VSS.n123 VSS.n310 0.0961384
R949 VSS.t10 VSS.n328 0.0961384
R950 VSS.n80 VSS.n380 0.0961384
R951 VSS.t32 VSS.n384 0.0958002
R952 VSS.t26 VSS.n50 0.0958002
R953 VSS.n582 VSS.n581 0.0958002
R954 VSS.n555 VSS.t20 0.0958002
R955 VSS.n499 VSS.n498 0.0958002
R956 VSS.n258 VSS.n257 0.0958002
R957 VSS.n276 VSS.n275 0.0958002
R958 VSS.n310 VSS.n309 0.0958002
R959 VSS.n328 VSS.n327 0.0958002
R960 VSS.n380 VSS.n379 0.0958002
R961 VSS.t18 VSS.n580 0.0955
R962 VSS.n547 VSS.n22 0.0955
R963 VSS.t24 VSS.n497 0.0955
R964 VSS.n467 VSS.n466 0.0955
R965 VSS.n259 VSS.t1 0.0955
R966 VSS.n277 VSS.n144 0.0955
R967 VSS.n311 VSS.t8 0.0955
R968 VSS.n329 VSS.n112 0.0955
R969 VSS.n582 VSS.t18 0.0955
R970 VSS.n498 VSS.t24 0.0955
R971 VSS.n466 VSS.t26 0.0955
R972 VSS.t16 VSS.n80 0.0955
R973 VSS.n112 VSS.t10 0.0955
R974 VSS.t8 VSS.n123 0.0955
R975 VSS.n144 VSS.t4 0.0955
R976 VSS.t1 VSS.n155 0.0955
R977 VSS.n22 VSS.t20 0.0955
R978 VSS.n381 VSS.t16 0.058
R979 VSS.n391 VSS.n77 0.0483676
R980 VSS.n393 VSS.n392 0.0483676
R981 VSS.n397 VSS.n394 0.0483676
R982 VSS.n396 VSS.n395 0.0483676
R983 VSS.n403 VSS.n73 0.0483676
R984 VSS.n405 VSS.n404 0.0483676
R985 VSS.n409 VSS.n406 0.0483676
R986 VSS.n408 VSS.n407 0.0483676
R987 VSS.n415 VSS.t30 0.0483676
R988 VSS.n417 VSS.n416 0.0483676
R989 VSS.n421 VSS.n418 0.0483676
R990 VSS.n420 VSS.n419 0.0483676
R991 VSS.n427 VSS.n66 0.0483676
R992 VSS.n429 VSS.n428 0.0483676
R993 VSS.n433 VSS.n430 0.0483676
R994 VSS.n432 VSS.n431 0.0483676
R995 VSS.n439 VSS.n62 0.0483676
R996 VSS.t28 VSS.n440 0.0483676
R997 VSS.n444 VSS.n441 0.0483676
R998 VSS.n443 VSS.n442 0.0483676
R999 VSS.n450 VSS.n58 0.0483676
R1000 VSS.n452 VSS.n451 0.0483676
R1001 VSS.n456 VSS.n453 0.0483676
R1002 VSS.n455 VSS.n454 0.0483676
R1003 VSS.n462 VSS.n54 0.0483676
R1004 VSS.n464 VSS.n463 0.0483676
R1005 VSS.n467 VSS.n465 0.0483676
R1006 VSS.n475 VSS.n474 0.0483676
R1007 VSS.n479 VSS.n476 0.0483676
R1008 VSS.n478 VSS.n477 0.0483676
R1009 VSS.n485 VSS.n46 0.0483676
R1010 VSS.n487 VSS.n486 0.0483676
R1011 VSS.n491 VSS.n488 0.0483676
R1012 VSS.n490 VSS.n489 0.0483676
R1013 VSS.n497 VSS.n42 0.0483676
R1014 VSS.n501 VSS.n500 0.0483676
R1015 VSS.n508 VSS.n38 0.0483676
R1016 VSS.n510 VSS.n509 0.0483676
R1017 VSS.n514 VSS.n511 0.0483676
R1018 VSS.n513 VSS.n512 0.0483676
R1019 VSS.n520 VSS.n34 0.0483676
R1020 VSS.n522 VSS.n521 0.0483676
R1021 VSS.t22 VSS.n523 0.0483676
R1022 VSS.n524 VSS.n525 0.0483676
R1023 VSS.n531 VSS.n30 0.0483676
R1024 VSS.n533 VSS.n532 0.0483676
R1025 VSS.n537 VSS.n534 0.0483676
R1026 VSS.n536 VSS.n535 0.0483676
R1027 VSS.n543 VSS.n26 0.0483676
R1028 VSS.n545 VSS.n544 0.0483676
R1029 VSS.n549 VSS.n546 0.0483676
R1030 VSS.n548 VSS.n547 0.0483676
R1031 VSS.n560 VSS.n557 0.0483676
R1032 VSS.n559 VSS.n558 0.0483676
R1033 VSS.n566 VSS.n18 0.0483676
R1034 VSS.n568 VSS.n567 0.0483676
R1035 VSS.n572 VSS.n569 0.0483676
R1036 VSS.n571 VSS.n570 0.0483676
R1037 VSS.n578 VSS.n14 0.0483676
R1038 VSS.n580 VSS.n579 0.0483676
R1039 VSS.n589 VSS.n10 0.0483676
R1040 VSS.n591 VSS.n590 0.0483676
R1041 VSS.n595 VSS.n592 0.0483676
R1042 VSS.n594 VSS.n593 0.0483676
R1043 VSS.n601 VSS.n6 0.0483676
R1044 VSS.n603 VSS.n602 0.0483676
R1045 VSS.n607 VSS.n604 0.0483676
R1046 VSS.n606 VSS.n605 0.0483676
R1047 VSS.n613 VSS.t17 0.0483676
R1048 VSS.n615 VSS.t2 0.0483676
R1049 VSS.n242 VSS.n241 0.0483676
R1050 VSS.n244 VSS.n243 0.0483676
R1051 VSS.n246 VSS.n245 0.0483676
R1052 VSS.n248 VSS.n247 0.0483676
R1053 VSS.n250 VSS.n249 0.0483676
R1054 VSS.n252 VSS.n251 0.0483676
R1055 VSS.n254 VSS.n253 0.0483676
R1056 VSS.n256 VSS.n255 0.0483676
R1057 VSS.n260 VSS.n259 0.0483676
R1058 VSS.n262 VSS.n261 0.0483676
R1059 VSS.n264 VSS.n263 0.0483676
R1060 VSS.n266 VSS.n265 0.0483676
R1061 VSS.n268 VSS.n267 0.0483676
R1062 VSS.n270 VSS.n269 0.0483676
R1063 VSS.n272 VSS.n271 0.0483676
R1064 VSS.n274 VSS.n273 0.0483676
R1065 VSS.n278 VSS.n277 0.0483676
R1066 VSS.n280 VSS.n279 0.0483676
R1067 VSS.n282 VSS.n281 0.0483676
R1068 VSS.n284 VSS.n283 0.0483676
R1069 VSS.n286 VSS.n285 0.0483676
R1070 VSS.n288 VSS.n287 0.0483676
R1071 VSS.n290 VSS.n289 0.0483676
R1072 VSS.n292 VSS.n291 0.0483676
R1073 VSS.n134 VSS.n293 0.0483676
R1074 VSS.n294 VSS.t6 0.0483676
R1075 VSS.n296 VSS.n295 0.0483676
R1076 VSS.n298 VSS.n297 0.0483676
R1077 VSS.n300 VSS.n299 0.0483676
R1078 VSS.n302 VSS.n301 0.0483676
R1079 VSS.n304 VSS.n303 0.0483676
R1080 VSS.n306 VSS.n305 0.0483676
R1081 VSS.n308 VSS.n307 0.0483676
R1082 VSS.n312 VSS.n311 0.0483676
R1083 VSS.n314 VSS.n313 0.0483676
R1084 VSS.n316 VSS.n315 0.0483676
R1085 VSS.n318 VSS.n317 0.0483676
R1086 VSS.n320 VSS.n319 0.0483676
R1087 VSS.n322 VSS.n321 0.0483676
R1088 VSS.n324 VSS.n323 0.0483676
R1089 VSS.n326 VSS.n325 0.0483676
R1090 VSS.n330 VSS.n329 0.0483676
R1091 VSS.n332 VSS.n331 0.0483676
R1092 VSS.n334 VSS.n333 0.0483676
R1093 VSS.n336 VSS.n335 0.0483676
R1094 VSS.n338 VSS.n337 0.0483676
R1095 VSS.n340 VSS.n339 0.0483676
R1096 VSS.n342 VSS.n341 0.0483676
R1097 VSS.n344 VSS.n343 0.0483676
R1098 VSS.n102 VSS.n345 0.0483676
R1099 VSS.n346 VSS.t12 0.0483676
R1100 VSS.n348 VSS.n347 0.0483676
R1101 VSS.n350 VSS.n349 0.0483676
R1102 VSS.n352 VSS.n351 0.0483676
R1103 VSS.n354 VSS.n353 0.0483676
R1104 VSS.n356 VSS.n355 0.0483676
R1105 VSS.n358 VSS.n357 0.0483676
R1106 VSS.n360 VSS.n359 0.0483676
R1107 VSS.n362 VSS.n361 0.0483676
R1108 VSS.t14 VSS.n363 0.0483676
R1109 VSS.n364 VSS.n91 0.0483676
R1110 VSS.n366 VSS.n365 0.0483676
R1111 VSS.n368 VSS.n367 0.0483676
R1112 VSS.n370 VSS.n369 0.0483676
R1113 VSS.n372 VSS.n371 0.0483676
R1114 VSS.n374 VSS.n373 0.0483676
R1115 VSS.n376 VSS.n375 0.0483676
R1116 VSS.n378 VSS.n377 0.0483676
R1117 VSS.n383 VSS.n382 0.0297015
R1118 VSS.t3 VSS.t0 19.6202
C0 SIGP VSS 0.10216p
.ends
