* NGSPICE file created from hx_loop_capacitor.ext - technology: ihp-sg13g2

.subckt hx_loop_capacitor SIGP VSS
X0 VSS.t10 SIGP VSS.t12 VSS.t11 sg13_lv_nmos ad=1.33p pd=7.38u as=0 ps=0 w=7u l=7u
X1 VSS.t30 SIGP VSS.t28 VSS.t13 sg13_lv_nmos ad=1.33p pd=7.38u as=0 ps=0 w=7u l=7u
X2 VSS.t6 SIGP VSS.t8 VSS.t7 sg13_lv_nmos ad=1.33p pd=7.38u as=0 ps=0 w=7u l=7u
X3 VSS.t32 SIGP VSS.t30 VSS.t15 sg13_lv_nmos ad=1.33p pd=7.38u as=0 ps=0 w=7u l=7u
X4 VSS.t2 SIGP VSS.t1 VSS.t0 sg13_lv_nmos ad=2.38p pd=14.68u as=0 ps=0 w=7u l=7u
X5 VSS.t28 SIGP VSS.t26 VSS.t11 sg13_lv_nmos ad=1.33p pd=7.38u as=0 ps=0 w=7u l=7u
X6 VSS.t1 SIGP VSS.t4 VSS.t3 sg13_lv_nmos ad=1.33p pd=7.38u as=0 ps=0 w=7u l=7u
X7 VSS.t8 SIGP VSS.t10 VSS.t9 sg13_lv_nmos ad=1.33p pd=7.38u as=0 ps=0 w=7u l=7u
X8 VSS.t26 SIGP VSS.t24 VSS.t9 sg13_lv_nmos ad=1.33p pd=7.38u as=0 ps=0 w=7u l=7u
X9 VSS.t14 SIGP VSS.t16 VSS.t15 sg13_lv_nmos ad=1.33p pd=7.38u as=0 ps=0 w=7u l=7u
X10 VSS.t18 SIGP VSS.t17 VSS.t0 sg13_lv_nmos ad=2.38p pd=14.68u as=0 ps=0 w=7u l=7u
X11 VSS.t22 SIGP VSS.t20 VSS.t5 sg13_lv_nmos ad=1.33p pd=7.38u as=0 ps=0 w=7u l=7u
X12 VSS.t24 SIGP VSS.t22 VSS.t7 sg13_lv_nmos ad=1.33p pd=7.38u as=0 ps=0 w=7u l=7u
X13 VSS.t12 SIGP VSS.t14 VSS.t13 sg13_lv_nmos ad=1.33p pd=7.38u as=0 ps=0 w=7u l=7u
X14 VSS.t20 SIGP VSS.t18 VSS.t3 sg13_lv_nmos ad=1.33p pd=7.38u as=0 ps=0 w=7u l=7u
X15 VSS.t4 SIGP VSS.t6 VSS.t5 sg13_lv_nmos ad=1.33p pd=7.38u as=0 ps=0 w=7u l=7u
R0 VSS.n3 VSS.t11 9.64651
R1 VSS.t15 VSS.n14 67.5624
R2 VSS.t5 VSS.n13 60.5129
R3 VSS.n0 VSS.n1 0.00138979
R4 VSS.n13 VSS.t3 49.9369
R5 VSS.n14 VSS.t13 42.8902
R6 VSS.t3 VSS.t0 32.3143
R7 VSS.n0 VSS.t9 19.6191
R8 VSS.t7 VSS.n1 15.9922
R9 VSS.n21 VSS.n0 17.0005
R10 VSS.n15 VSS.t15 14.6832
R11 VSS.n3 VSS.n0 0.00107205
R12 VSS.n16 VSS.n15 9.18959
R13 VSS.n16 VSS.n6 1.54537
R14 VSS.n16 VSS.n4 1.21324
R15 VSS.n16 VSS.n8 2.83417
R16 VSS.n8 VSS.n9 0.00410344
R17 VSS.n16 VSS.n10 4.25113
R18 VSS.n5 VSS.n6 0.00944536
R19 VSS.n19 VSS.n5 0.849282
R20 VSS.n19 VSS.n7 4.25075
R21 VSS.n19 VSS.n9 2.12564
R22 VSS.n9 VSS.n10 0.00381222
R23 VSS.n0 VSS.n2 8.47732
R24 VSS.n17 VSS.n16 5.66778
R25 VSS.n16 VSS.n12 5.66778
R26 VSS.n6 VSS.n11 0.00572454
R27 VSS.n19 VSS.n18 5.66717
R28 VSS.n19 VSS.n11 5.66717
R29 VSS.n5 VSS.n4 0.00865849
R30 VSS.n20 VSS.n0 2.83429
R31 VSS.n22 VSS.t17 1.2096
R32 VSS.n23 VSS.n22 1.19657
R33 VSS.t20 VSS.t22 1.18726
R34 VSS.t8 VSS.t6 1.18726
R35 VSS.t12 VSS.t10 1.18188
R36 VSS.t6 VSS.t4 1.17786
R37 VSS.t22 VSS.t24 1.17786
R38 VSS.t16 VSS.t14 1.17463
R39 VSS.t1 VSS.t2 1.17241
R40 VSS.t26 VSS.t28 1.17241
R41 VSS.t17 VSS.t18 1.16092
R42 VSS.t30 VSS.t32 1.15741
R43 VSS.t28 VSS.t30 1.13252
R44 VSS.t12 VSS.t14 1.13154
R45 VSS.t18 VSS.t20 1.12501
R46 VSS.t24 VSS.t26 1.11752
R47 VSS.t4 VSS.t1 1.11752
R48 VSS.t10 VSS.t8 1.10748
R49 VSS.t16 VSS 0.39266
R50 VSS.t22 VSS.n0 0.150099
R51 VSS.t6 VSS.n0 0.150099
R52 VSS.t30 VSS.n0 0.139355
R53 VSS.t26 VSS.n0 0.139355
R54 VSS.t1 VSS.n0 0.139355
R55 VSS.t10 VSS.n0 0.139321
R56 VSS.t14 VSS.n0 0.129264
R57 VSS.t18 VSS.n0 0.119905
R58 VSS.n22 VSS.n0 0.110075
R59 VSS.n23 VSS.n2 0.0846176
R60 VSS.t2 VSS.n2 0.0708676
R61 VSS.n21 VSS.t16 0.058
R62 VSS.t17 VSS 0.05425
R63 VSS VSS.n23 0.05425
R64 VSS.t32 VSS.n21 0.038
R65 VSS.n4 VSS.n7 0.00913161
R66 VSS.t16 VSS.n20 0.00353004
R67 VSS.n7 VSS.n8 0.00383305
R68 VSS.n10 VSS.n0 0.00224999
R69 VSS.n20 VSS.n19 0.00190174
R70 VSS.n18 VSS.n17 0.00166667
R71 VSS.n12 VSS.n11 0.00166667
R72 VSS.n13 VSS.n0 0.00150001
R73 VSS.t0 VSS.n0 0.00143221
R74 VSS.n18 VSS.n12 0.00133332
R75 VSS.n17 VSS.n0 0.00133332
R76 VSS.n14 VSS.n0 0.00103108
R77 VSS.t13 VSS.n3 39.3612
R78 VSS.n15 VSS.n0 0.00169713
R79 VSS.t5 VSS.n1 21.7346
C0 SIGP VSS 96.6152f
.ends
