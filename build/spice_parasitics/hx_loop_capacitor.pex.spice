* NGSPICE file created from hx_loop_capacitor.ext - technology: ihp-sg13g2

.subckt hx_loop_capacitor SIGP VSS
X0 VSS.t0 SIGP VSS.t10 VSS.t9 sg13_lv_nmos ad=1.33p pd=7.38u as=0 ps=0 w=7u l=7u
X1 VSS.t24 SIGP VSS.t22 VSS.t11 sg13_lv_nmos ad=1.33p pd=7.38u as=0 ps=0 w=7u l=7u
X2 VSS.t0 SIGP VSS.t7 VSS.t6 sg13_lv_nmos ad=1.33p pd=7.38u as=0 ps=0 w=7u l=7u
X3 VSS.t26 SIGP VSS.t24 VSS.t12 sg13_lv_nmos ad=1.33p pd=7.38u as=0 ps=0 w=7u l=7u
X4 VSS.t2 SIGP VSS.t1 VSS.t0 sg13_lv_nmos ad=2.38p pd=14.68u as=0 ps=0 w=7u l=7u
X5 VSS.t22 SIGP VSS.t0 VSS.t9 sg13_lv_nmos ad=1.33p pd=7.38u as=0 ps=0 w=7u l=7u
X6 VSS.t1 SIGP VSS.t4 VSS.t3 sg13_lv_nmos ad=1.33p pd=7.38u as=0 ps=0 w=7u l=7u
X7 VSS.t7 SIGP VSS.t0 VSS.t8 sg13_lv_nmos ad=1.33p pd=7.38u as=0 ps=0 w=7u l=7u
X8 VSS.t0 SIGP VSS.t19 VSS.t8 sg13_lv_nmos ad=1.33p pd=7.38u as=0 ps=0 w=7u l=7u
X9 VSS.t0 SIGP VSS.t13 VSS.t12 sg13_lv_nmos ad=1.33p pd=7.38u as=0 ps=0 w=7u l=7u
X10 VSS.t0 SIGP VSS.t14 VSS.t0 sg13_lv_nmos ad=2.38p pd=14.68u as=0 ps=0 w=7u l=7u
X11 VSS.t0 SIGP VSS.t16 VSS.t5 sg13_lv_nmos ad=1.33p pd=7.38u as=0 ps=0 w=7u l=7u
X12 VSS.t19 SIGP VSS.t0 VSS.t6 sg13_lv_nmos ad=1.33p pd=7.38u as=0 ps=0 w=7u l=7u
X13 VSS.t10 SIGP VSS.t0 VSS.t11 sg13_lv_nmos ad=1.33p pd=7.38u as=0 ps=0 w=7u l=7u
X14 VSS.t16 SIGP VSS.t0 VSS.t3 sg13_lv_nmos ad=1.33p pd=7.38u as=0 ps=0 w=7u l=7u
X15 VSS.t4 SIGP VSS.t0 VSS.t5 sg13_lv_nmos ad=1.33p pd=7.38u as=0 ps=0 w=7u l=7u
R0 VSS.t0 VSS.t9 9.64731
R1 VSS.t5 VSS.t0 15.9916
R2 VSS.t0 VSS.t11 20.531
R3 VSS.t3 VSS.t0 19.6201
R4 VSS.t0 VSS.t8 19.62
R5 VSS.t6 VSS.t0 15.9931
R6 VSS.t0 VSS.t14 0.538502
R7 VSS.n2 VSS.t0 1.0398
R8 VSS.t7 VSS.t0 0.538676
R9 VSS.t10 VSS.t0 0.546108
R10 VSS.n0 VSS.t4 0.541487
R11 VSS.n1 VSS.t0 0.29073
R12 VSS.t1 VSS.t2 1.17241
R13 VSS.t0 VSS.t22 0.544078
R14 VSS.t24 VSS.t26 1.15741
R15 VSS.t0 VSS.t16 0.543298
R16 VSS.t19 VSS.t0 0.541487
R17 VSS.n0 VSS.t1 0.0647437
R18 VSS.t13 VSS 0.39266
R19 VSS.n0 VSS.t0 0.0681871
R20 VSS VSS.n2 0.0650583
R21 VSS.t2 VSS.n2 0.144452
R22 VSS.n1 VSS.t13 0.00235474
R23 VSS.t14 VSS 0.05425
R24 VSS.t26 VSS.n1 0.0954537
R25 VSS.t12 VSS.t0 12.0633
R26 VSS.t0 VSS.t24 1.02817
C0 SIGP VSS 96.6152f
.ends
