* NGSPICE file created from hx_loop_capacitor.ext - technology: ihp-sg13g2

.subckt hx_loop_capacitor SIGP VSS
X0 VSS.t10 SIGP VSS.t12 VSS.t11 sg13_lv_nmos ad=1.33p pd=7.38u as=0 ps=0 w=7u l=7u
X1 VSS.t30 SIGP VSS.t28 VSS.t13 sg13_lv_nmos ad=1.33p pd=7.38u as=0 ps=0 w=7u l=7u
X2 VSS.t6 SIGP VSS.t8 VSS.t7 sg13_lv_nmos ad=1.33p pd=7.38u as=0 ps=0 w=7u l=7u
X3 VSS.t32 SIGP VSS.t30 VSS.t15 sg13_lv_nmos ad=1.33p pd=7.38u as=0 ps=0 w=7u l=7u
X4 VSS.t2 SIGP VSS.t1 VSS.t0 sg13_lv_nmos ad=2.38p pd=14.68u as=0 ps=0 w=7u l=7u
X5 VSS.t28 SIGP VSS.t26 VSS.t11 sg13_lv_nmos ad=1.33p pd=7.38u as=0 ps=0 w=7u l=7u
X6 VSS.t1 SIGP VSS.t4 VSS.t3 sg13_lv_nmos ad=1.33p pd=7.38u as=0 ps=0 w=7u l=7u
X7 VSS.t8 SIGP VSS.t10 VSS.t9 sg13_lv_nmos ad=1.33p pd=7.38u as=0 ps=0 w=7u l=7u
X8 VSS.t26 SIGP VSS.t24 VSS.t9 sg13_lv_nmos ad=1.33p pd=7.38u as=0 ps=0 w=7u l=7u
X9 VSS.t14 SIGP VSS.t16 VSS.t15 sg13_lv_nmos ad=1.33p pd=7.38u as=0 ps=0 w=7u l=7u
X10 VSS.t18 SIGP VSS.t17 VSS.t0 sg13_lv_nmos ad=2.38p pd=14.68u as=0 ps=0 w=7u l=7u
X11 VSS.t22 SIGP VSS.t20 VSS.t5 sg13_lv_nmos ad=1.33p pd=7.38u as=0 ps=0 w=7u l=7u
X12 VSS.t24 SIGP VSS.t22 VSS.t7 sg13_lv_nmos ad=1.33p pd=7.38u as=0 ps=0 w=7u l=7u
X13 VSS.t12 SIGP VSS.t14 VSS.t13 sg13_lv_nmos ad=1.33p pd=7.38u as=0 ps=0 w=7u l=7u
X14 VSS.t20 SIGP VSS.t18 VSS.t3 sg13_lv_nmos ad=1.33p pd=7.38u as=0 ps=0 w=7u l=7u
X15 VSS.t4 SIGP VSS.t6 VSS.t5 sg13_lv_nmos ad=1.33p pd=7.38u as=0 ps=0 w=7u l=7u
R0 VSS.t5 VSS.t0 15.9919
R1 VSS.t9 VSS.t0 19.621
R2 VSS.t0 VSS.t13 20.5247
R3 VSS.t3 VSS.t0 19.6191
R4 VSS.t7 VSS.t0 15.9925
R5 VSS.n495 VSS.t0 17.0005
R6 VSS.t24 VSS.t0 17.0005
R7 VSS.n44 VSS.t0 17.0005
R8 VSS.t18 VSS.t0 17.0005
R9 VSS.t1 VSS.t0 17.0005
R10 VSS.n166 VSS.t0 17.0005
R11 VSS.t8 VSS.t0 17.0005
R12 VSS.n134 VSS.t0 17.0005
R13 VSS.t16 VSS.t0 17.0005
R14 VSS.n1 VSS.t15 12.0624
R15 VSS.t11 VSS.t0 9.64794
R16 VSS.n416 VSS.n411 9.11631
R17 VSS.n403 VSS.n101 9.11631
R18 VSS.n641 VSS.n640 9.0005
R19 VSS.n639 VSS.n25 9.0005
R20 VSS.n638 VSS.n637 9.0005
R21 VSS.n27 VSS.n26 9.0005
R22 VSS.n629 VSS.n628 9.0005
R23 VSS.n627 VSS.n29 9.0005
R24 VSS.n626 VSS.n625 9.0005
R25 VSS.n31 VSS.n30 9.0005
R26 VSS.n617 VSS.n616 9.0005
R27 VSS.n615 VSS.n33 9.0005
R28 VSS.n614 VSS.n613 9.0005
R29 VSS.n35 VSS.n34 9.0005
R30 VSS.n606 VSS.n605 9.0005
R31 VSS.n604 VSS.n37 9.0005
R32 VSS.n603 VSS.n602 9.0005
R33 VSS.n39 VSS.n38 9.0005
R34 VSS.n594 VSS.n593 9.0005
R35 VSS.n592 VSS.n41 9.0005
R36 VSS.n591 VSS.n590 9.0005
R37 VSS.n43 VSS.n42 9.0005
R38 VSS.n583 VSS.n582 9.0005
R39 VSS.n581 VSS.n45 9.0005
R40 VSS.n580 VSS.n579 9.0005
R41 VSS.n47 VSS.n46 9.0005
R42 VSS.n571 VSS.n570 9.0005
R43 VSS.n569 VSS.n49 9.0005
R44 VSS.n568 VSS.n567 9.0005
R45 VSS.n51 VSS.n50 9.0005
R46 VSS.n559 VSS.n558 9.0005
R47 VSS.n557 VSS.n53 9.0005
R48 VSS.n556 VSS.n555 9.0005
R49 VSS.n55 VSS.n54 9.0005
R50 VSS.n548 VSS.n547 9.0005
R51 VSS.n546 VSS.n57 9.0005
R52 VSS.n545 VSS.n544 9.0005
R53 VSS.n59 VSS.n58 9.0005
R54 VSS.n536 VSS.n535 9.0005
R55 VSS.n534 VSS.n61 9.0005
R56 VSS.n533 VSS.n532 9.0005
R57 VSS.n63 VSS.n62 9.0005
R58 VSS.n525 VSS.n524 9.0005
R59 VSS.n523 VSS.n65 9.0005
R60 VSS.n522 VSS.n521 9.0005
R61 VSS.n67 VSS.n66 9.0005
R62 VSS.n513 VSS.n512 9.0005
R63 VSS.n511 VSS.n69 9.0005
R64 VSS.n510 VSS.n509 9.0005
R65 VSS.n71 VSS.n70 9.0005
R66 VSS.n501 VSS.n500 9.0005
R67 VSS.n499 VSS.n73 9.0005
R68 VSS.n498 VSS.n497 9.0005
R69 VSS.n75 VSS.n74 9.0005
R70 VSS.n490 VSS.n489 9.0005
R71 VSS.n488 VSS.n77 9.0005
R72 VSS.n487 VSS.n486 9.0005
R73 VSS.n79 VSS.n78 9.0005
R74 VSS.n478 VSS.n477 9.0005
R75 VSS.n476 VSS.n81 9.0005
R76 VSS.n475 VSS.n474 9.0005
R77 VSS.n83 VSS.n82 9.0005
R78 VSS.n467 VSS.n466 9.0005
R79 VSS.n465 VSS.n85 9.0005
R80 VSS.n464 VSS.n463 9.0005
R81 VSS.n87 VSS.n86 9.0005
R82 VSS.n455 VSS.n454 9.0005
R83 VSS.n453 VSS.n89 9.0005
R84 VSS.n452 VSS.n451 9.0005
R85 VSS.n91 VSS.n90 9.0005
R86 VSS.n443 VSS.n442 9.0005
R87 VSS.n441 VSS.n92 9.0005
R88 VSS.n440 VSS.n439 9.0005
R89 VSS.n94 VSS.n93 9.0005
R90 VSS.n431 VSS.n430 9.0005
R91 VSS.n429 VSS.n96 9.0005
R92 VSS.n428 VSS.n427 9.0005
R93 VSS.n98 VSS.n97 9.0005
R94 VSS.n419 VSS.n418 9.0005
R95 VSS.n417 VSS.n100 9.0005
R96 VSS.n642 VSS.n641 9.0005
R97 VSS.n634 VSS.n25 9.0005
R98 VSS.n637 VSS.n636 9.0005
R99 VSS.n632 VSS.n27 9.0005
R100 VSS.n630 VSS.n629 9.0005
R101 VSS.n622 VSS.n29 9.0005
R102 VSS.n625 VSS.n624 9.0005
R103 VSS.n620 VSS.n31 9.0005
R104 VSS.n618 VSS.n617 9.0005
R105 VSS.n612 VSS.n33 9.0005
R106 VSS.n613 VSS.n611 9.0005
R107 VSS.n609 VSS.n35 9.0005
R108 VSS.n607 VSS.n606 9.0005
R109 VSS.n599 VSS.n37 9.0005
R110 VSS.n602 VSS.n601 9.0005
R111 VSS.n597 VSS.n39 9.0005
R112 VSS.n595 VSS.n594 9.0005
R113 VSS.n587 VSS.n41 9.0005
R114 VSS.n590 VSS.n589 9.0005
R115 VSS.n585 VSS.n43 9.0005
R116 VSS.t20 VSS.n583 9.0005
R117 VSS.n576 VSS.n45 9.0005
R118 VSS.n579 VSS.n578 9.0005
R119 VSS.n574 VSS.n47 9.0005
R120 VSS.n572 VSS.n571 9.0005
R121 VSS.n564 VSS.n49 9.0005
R122 VSS.n567 VSS.n566 9.0005
R123 VSS.n562 VSS.n51 9.0005
R124 VSS.n560 VSS.n559 9.0005
R125 VSS.n554 VSS.n53 9.0005
R126 VSS.n555 VSS.t22 9.0005
R127 VSS.n551 VSS.n55 9.0005
R128 VSS.n549 VSS.n548 9.0005
R129 VSS.n541 VSS.n57 9.0005
R130 VSS.n544 VSS.n543 9.0005
R131 VSS.n539 VSS.n59 9.0005
R132 VSS.n537 VSS.n536 9.0005
R133 VSS.n529 VSS.n61 9.0005
R134 VSS.n532 VSS.n531 9.0005
R135 VSS.n527 VSS.n63 9.0005
R136 VSS.n526 VSS.n525 9.0005
R137 VSS.n518 VSS.n65 9.0005
R138 VSS.n521 VSS.n520 9.0005
R139 VSS.n516 VSS.n67 9.0005
R140 VSS.n514 VSS.n513 9.0005
R141 VSS.n506 VSS.n69 9.0005
R142 VSS.n509 VSS.n508 9.0005
R143 VSS.n504 VSS.n71 9.0005
R144 VSS.n502 VSS.n501 9.0005
R145 VSS.t26 VSS.n73 9.0005
R146 VSS.n497 VSS.n496 9.0005
R147 VSS.n493 VSS.n75 9.0005
R148 VSS.n491 VSS.n490 9.0005
R149 VSS.n483 VSS.n77 9.0005
R150 VSS.n486 VSS.n485 9.0005
R151 VSS.n481 VSS.n79 9.0005
R152 VSS.n479 VSS.n478 9.0005
R153 VSS.n471 VSS.n81 9.0005
R154 VSS.n474 VSS.n473 9.0005
R155 VSS.t28 VSS.n83 9.0005
R156 VSS.n468 VSS.n467 9.0005
R157 VSS.n460 VSS.n85 9.0005
R158 VSS.n463 VSS.n462 9.0005
R159 VSS.n458 VSS.n87 9.0005
R160 VSS.n456 VSS.n455 9.0005
R161 VSS.n448 VSS.n89 9.0005
R162 VSS.n451 VSS.n450 9.0005
R163 VSS.n446 VSS.n91 9.0005
R164 VSS.n444 VSS.n443 9.0005
R165 VSS.n436 VSS.n92 9.0005
R166 VSS.n439 VSS.n438 9.0005
R167 VSS.n434 VSS.n94 9.0005
R168 VSS.n432 VSS.n431 9.0005
R169 VSS.n424 VSS.n96 9.0005
R170 VSS.n427 VSS.n426 9.0005
R171 VSS.n422 VSS.n98 9.0005
R172 VSS.n420 VSS.n419 9.0005
R173 VSS.n414 VSS.n100 9.0005
R174 VSS.n415 VSS.t32 9.0005
R175 VSS.n645 VSS.n644 9.0005
R176 VSS.n265 VSS.n262 9.0005
R177 VSS.n269 VSS.n184 9.0005
R178 VSS.n273 VSS.n182 9.0005
R179 VSS.n277 VSS.n180 9.0005
R180 VSS.n177 VSS.n178 9.0005
R181 VSS.n283 VSS.n175 9.0005
R182 VSS.n287 VSS.n173 9.0005
R183 VSS.n291 VSS.n171 9.0005
R184 VSS.n295 VSS.n169 9.0005
R185 VSS.t4 VSS.n167 9.0005
R186 VSS.n301 VSS.n164 9.0005
R187 VSS.n305 VSS.n162 9.0005
R188 VSS.n309 VSS.n160 9.0005
R189 VSS.n313 VSS.n158 9.0005
R190 VSS.t6 VSS.n155 9.0005
R191 VSS.n319 VSS.n153 9.0005
R192 VSS.n323 VSS.n151 9.0005
R193 VSS.n327 VSS.n149 9.0005
R194 VSS.n331 VSS.n147 9.0005
R195 VSS.n333 VSS.n144 9.0005
R196 VSS.n337 VSS.n142 9.0005
R197 VSS.n341 VSS.n140 9.0005
R198 VSS.n345 VSS.n138 9.0005
R199 VSS.n349 VSS.n136 9.0005
R200 VSS.n351 VSS.n133 9.0005
R201 VSS.n355 VSS.n131 9.0005
R202 VSS.n359 VSS.n129 9.0005
R203 VSS.n363 VSS.n127 9.0005
R204 VSS.n367 VSS.n125 9.0005
R205 VSS.n369 VSS.n122 9.0005
R206 VSS.n373 VSS.n120 9.0005
R207 VSS.n377 VSS.n118 9.0005
R208 VSS.n381 VSS.n116 9.0005
R209 VSS.n385 VSS.n114 9.0005
R210 VSS.n387 VSS.n111 9.0005
R211 VSS.n391 VSS.n109 9.0005
R212 VSS.n395 VSS.n107 9.0005
R213 VSS.n399 VSS.n105 9.0005
R214 VSS.n102 VSS.n103 9.0005
R215 VSS.n401 VSS.n104 9.0005
R216 VSS.n397 VSS.n106 9.0005
R217 VSS.n393 VSS.n108 9.0005
R218 VSS.n389 VSS.n110 9.0005
R219 VSS.n113 VSS.n112 9.0005
R220 VSS.n383 VSS.n115 9.0005
R221 VSS.n379 VSS.n117 9.0005
R222 VSS.n375 VSS.n119 9.0005
R223 VSS.n371 VSS.n121 9.0005
R224 VSS.t12 VSS.n123 9.0005
R225 VSS.n365 VSS.n126 9.0005
R226 VSS.n361 VSS.n128 9.0005
R227 VSS.n357 VSS.n130 9.0005
R228 VSS.n353 VSS.n132 9.0005
R229 VSS.t10 VSS.n135 9.0005
R230 VSS.n347 VSS.n137 9.0005
R231 VSS.n343 VSS.n139 9.0005
R232 VSS.n339 VSS.n141 9.0005
R233 VSS.n335 VSS.n143 9.0005
R234 VSS.n145 VSS.n146 9.0005
R235 VSS.n329 VSS.n148 9.0005
R236 VSS.n325 VSS.n150 9.0005
R237 VSS.n321 VSS.n152 9.0005
R238 VSS.n317 VSS.n154 9.0005
R239 VSS.n315 VSS.n157 9.0005
R240 VSS.n311 VSS.n159 9.0005
R241 VSS.n307 VSS.n161 9.0005
R242 VSS.n303 VSS.n163 9.0005
R243 VSS.n299 VSS.n165 9.0005
R244 VSS.n297 VSS.n168 9.0005
R245 VSS.n293 VSS.n170 9.0005
R246 VSS.n289 VSS.n172 9.0005
R247 VSS.n285 VSS.n174 9.0005
R248 VSS.n281 VSS.n176 9.0005
R249 VSS.n279 VSS.n179 9.0005
R250 VSS.n275 VSS.n181 9.0005
R251 VSS.n271 VSS.n183 9.0005
R252 VSS.n267 VSS.n185 9.0005
R253 VSS.n263 VSS.n24 9.0005
R254 VSS.n646 VSS.n645 9.0005
R255 VSS.n24 VSS.n23 9.0005
R256 VSS.n262 VSS.n261 9.0005
R257 VSS.n260 VSS.n185 9.0005
R258 VSS.n259 VSS.n184 9.0005
R259 VSS.n258 VSS.n183 9.0005
R260 VSS.n257 VSS.n182 9.0005
R261 VSS.n256 VSS.n181 9.0005
R262 VSS.n255 VSS.n180 9.0005
R263 VSS.n254 VSS.n179 9.0005
R264 VSS.n253 VSS.n178 9.0005
R265 VSS.n252 VSS.n176 9.0005
R266 VSS.n251 VSS.n175 9.0005
R267 VSS.n250 VSS.n174 9.0005
R268 VSS.n249 VSS.n173 9.0005
R269 VSS.n248 VSS.n172 9.0005
R270 VSS.n247 VSS.n171 9.0005
R271 VSS.n246 VSS.n170 9.0005
R272 VSS.n245 VSS.n169 9.0005
R273 VSS.n244 VSS.n168 9.0005
R274 VSS.n243 VSS.n167 9.0005
R275 VSS.n242 VSS.n165 9.0005
R276 VSS.n241 VSS.n164 9.0005
R277 VSS.n240 VSS.n163 9.0005
R278 VSS.n239 VSS.n162 9.0005
R279 VSS.n238 VSS.n161 9.0005
R280 VSS.n237 VSS.n160 9.0005
R281 VSS.n236 VSS.n159 9.0005
R282 VSS.n235 VSS.n158 9.0005
R283 VSS.n234 VSS.n157 9.0005
R284 VSS.n233 VSS.n155 9.0005
R285 VSS.n232 VSS.n154 9.0005
R286 VSS.n231 VSS.n153 9.0005
R287 VSS.n230 VSS.n152 9.0005
R288 VSS.n229 VSS.n151 9.0005
R289 VSS.n228 VSS.n150 9.0005
R290 VSS.n227 VSS.n149 9.0005
R291 VSS.n226 VSS.n148 9.0005
R292 VSS.n225 VSS.n147 9.0005
R293 VSS.n224 VSS.n146 9.0005
R294 VSS.n223 VSS.n144 9.0005
R295 VSS.n222 VSS.n143 9.0005
R296 VSS.n221 VSS.n142 9.0005
R297 VSS.n220 VSS.n141 9.0005
R298 VSS.n219 VSS.n140 9.0005
R299 VSS.n218 VSS.n139 9.0005
R300 VSS.n217 VSS.n138 9.0005
R301 VSS.n216 VSS.n137 9.0005
R302 VSS.n215 VSS.n136 9.0005
R303 VSS.n214 VSS.n135 9.0005
R304 VSS.n213 VSS.n133 9.0005
R305 VSS.n212 VSS.n132 9.0005
R306 VSS.n211 VSS.n131 9.0005
R307 VSS.n210 VSS.n130 9.0005
R308 VSS.n209 VSS.n129 9.0005
R309 VSS.n208 VSS.n128 9.0005
R310 VSS.n207 VSS.n127 9.0005
R311 VSS.n206 VSS.n126 9.0005
R312 VSS.n205 VSS.n125 9.0005
R313 VSS.n204 VSS.n123 9.0005
R314 VSS.n203 VSS.n122 9.0005
R315 VSS.n202 VSS.n121 9.0005
R316 VSS.n201 VSS.n120 9.0005
R317 VSS.n200 VSS.n119 9.0005
R318 VSS.n199 VSS.n118 9.0005
R319 VSS.n198 VSS.n117 9.0005
R320 VSS.n197 VSS.n116 9.0005
R321 VSS.n196 VSS.n115 9.0005
R322 VSS.n195 VSS.n114 9.0005
R323 VSS.n194 VSS.n112 9.0005
R324 VSS.n193 VSS.n111 9.0005
R325 VSS.n192 VSS.n110 9.0005
R326 VSS.n191 VSS.n109 9.0005
R327 VSS.n190 VSS.n108 9.0005
R328 VSS.n189 VSS.n107 9.0005
R329 VSS.n188 VSS.n106 9.0005
R330 VSS.n187 VSS.n105 9.0005
R331 VSS.n186 VSS.n104 9.0005
R332 VSS.n8 VSS.n408 1.41746
R333 VSS.n8 VSS.n22 0.00283296
R334 VSS.n408 VSS.n18 3.40102
R335 VSS.n408 VSS.n17 2.83428
R336 VSS.n408 VSS.n16 4.251
R337 VSS.n408 VSS.n12 3.40102
R338 VSS.n408 VSS.n9 1.88961
R339 VSS.n412 VSS.t0 8.48665
R340 VSS.n410 VSS.t0 8.47784
R341 VSS.n22 VSS.n21 8.47784
R342 VSS.n3 VSS.n2 3.32786
R343 VSS.n20 VSS.n19 4.19355
R344 VSS.n405 VSS.n17 8.47784
R345 VSS.n406 VSS.n15 8.47784
R346 VSS.n407 VSS.n16 8.47784
R347 VSS.n407 VSS.n5 0.325253
R348 VSS.n5 VSS.n14 0.463892
R349 VSS.n14 VSS.n11 0.418412
R350 VSS.n11 VSS.n10 4.19355
R351 VSS.n6 VSS.n0 4.19355
R352 VSS.n99 VSS.t0 8.47732
R353 VSS.n421 VSS.t0 8.47732
R354 VSS.n423 VSS.t0 8.47732
R355 VSS.n425 VSS.t0 8.47732
R356 VSS.n95 VSS.t0 8.47732
R357 VSS.n433 VSS.t0 8.47732
R358 VSS.n435 VSS.t0 8.47732
R359 VSS.n437 VSS.t0 8.47732
R360 VSS.t30 VSS.t0 8.47732
R361 VSS.n445 VSS.t0 8.47732
R362 VSS.n447 VSS.t0 8.47732
R363 VSS.n449 VSS.t0 8.47732
R364 VSS.n88 VSS.t0 8.47732
R365 VSS.n457 VSS.t0 8.47732
R366 VSS.n459 VSS.t0 8.47732
R367 VSS.n461 VSS.t0 8.47732
R368 VSS.n84 VSS.t0 8.47732
R369 VSS.n469 VSS.t0 8.47732
R370 VSS.n470 VSS.t0 8.47732
R371 VSS.n472 VSS.t0 8.47732
R372 VSS.n80 VSS.t0 8.47732
R373 VSS.n480 VSS.t0 8.47732
R374 VSS.n482 VSS.t0 8.47732
R375 VSS.n484 VSS.t0 8.47732
R376 VSS.n76 VSS.t0 8.47732
R377 VSS.n492 VSS.t0 8.47732
R378 VSS.n494 VSS.t0 8.47732
R379 VSS.n503 VSS.t0 8.47732
R380 VSS.n505 VSS.t0 8.47732
R381 VSS.n507 VSS.t0 8.47732
R382 VSS.n68 VSS.t0 8.47732
R383 VSS.n515 VSS.t0 8.47732
R384 VSS.n517 VSS.t0 8.47732
R385 VSS.n519 VSS.t0 8.47732
R386 VSS.n64 VSS.t0 8.47732
R387 VSS.n530 VSS.t0 8.47732
R388 VSS.n60 VSS.t0 8.47732
R389 VSS.n538 VSS.t0 8.47732
R390 VSS.n540 VSS.t0 8.47732
R391 VSS.n542 VSS.t0 8.47732
R392 VSS.n56 VSS.t0 8.47732
R393 VSS.n550 VSS.t0 8.47732
R394 VSS.n552 VSS.t0 8.47732
R395 VSS.n553 VSS.t0 8.47732
R396 VSS.n52 VSS.t0 8.47732
R397 VSS.n561 VSS.t0 8.47732
R398 VSS.n563 VSS.t0 8.47732
R399 VSS.n565 VSS.t0 8.47732
R400 VSS.n48 VSS.t0 8.47732
R401 VSS.n573 VSS.t0 8.47732
R402 VSS.n575 VSS.t0 8.47732
R403 VSS.n577 VSS.t0 8.47732
R404 VSS.n586 VSS.t0 8.47732
R405 VSS.n588 VSS.t0 8.47732
R406 VSS.n40 VSS.t0 8.47732
R407 VSS.n596 VSS.t0 8.47732
R408 VSS.n598 VSS.t0 8.47732
R409 VSS.n600 VSS.t0 8.47732
R410 VSS.n36 VSS.t0 8.47732
R411 VSS.n608 VSS.t0 8.47732
R412 VSS.n32 VSS.t0 8.47732
R413 VSS.n619 VSS.t0 8.47732
R414 VSS.n621 VSS.t0 8.47732
R415 VSS.n623 VSS.t0 8.47732
R416 VSS.n28 VSS.t0 8.47732
R417 VSS.n631 VSS.t0 8.47732
R418 VSS.n633 VSS.t0 8.47732
R419 VSS.n635 VSS.t0 8.47732
R420 VSS.t17 VSS.t0 8.47732
R421 VSS.t0 VSS.t2 8.47732
R422 VSS.n264 VSS.t0 8.47732
R423 VSS.n266 VSS.t0 8.47732
R424 VSS.n268 VSS.t0 8.47732
R425 VSS.n270 VSS.t0 8.47732
R426 VSS.n272 VSS.t0 8.47732
R427 VSS.n274 VSS.t0 8.47732
R428 VSS.n276 VSS.t0 8.47732
R429 VSS.n278 VSS.t0 8.47732
R430 VSS.n282 VSS.t0 8.47732
R431 VSS.n284 VSS.t0 8.47732
R432 VSS.n286 VSS.t0 8.47732
R433 VSS.n288 VSS.t0 8.47732
R434 VSS.n290 VSS.t0 8.47732
R435 VSS.n292 VSS.t0 8.47732
R436 VSS.n294 VSS.t0 8.47732
R437 VSS.n296 VSS.t0 8.47732
R438 VSS.n300 VSS.t0 8.47732
R439 VSS.n302 VSS.t0 8.47732
R440 VSS.n304 VSS.t0 8.47732
R441 VSS.n306 VSS.t0 8.47732
R442 VSS.n308 VSS.t0 8.47732
R443 VSS.n310 VSS.t0 8.47732
R444 VSS.n312 VSS.t0 8.47732
R445 VSS.n314 VSS.t0 8.47732
R446 VSS.n156 VSS.t0 8.47732
R447 VSS.n316 VSS.t0 8.47732
R448 VSS.n318 VSS.t0 8.47732
R449 VSS.n320 VSS.t0 8.47732
R450 VSS.n322 VSS.t0 8.47732
R451 VSS.n324 VSS.t0 8.47732
R452 VSS.n326 VSS.t0 8.47732
R453 VSS.n328 VSS.t0 8.47732
R454 VSS.n330 VSS.t0 8.47732
R455 VSS.n334 VSS.t0 8.47732
R456 VSS.n336 VSS.t0 8.47732
R457 VSS.n338 VSS.t0 8.47732
R458 VSS.n340 VSS.t0 8.47732
R459 VSS.n342 VSS.t0 8.47732
R460 VSS.n344 VSS.t0 8.47732
R461 VSS.n346 VSS.t0 8.47732
R462 VSS.n348 VSS.t0 8.47732
R463 VSS.n352 VSS.t0 8.47732
R464 VSS.n354 VSS.t0 8.47732
R465 VSS.n356 VSS.t0 8.47732
R466 VSS.n358 VSS.t0 8.47732
R467 VSS.n360 VSS.t0 8.47732
R468 VSS.n362 VSS.t0 8.47732
R469 VSS.n364 VSS.t0 8.47732
R470 VSS.n366 VSS.t0 8.47732
R471 VSS.n124 VSS.t0 8.47732
R472 VSS.n368 VSS.t0 8.47732
R473 VSS.n370 VSS.t0 8.47732
R474 VSS.n372 VSS.t0 8.47732
R475 VSS.n374 VSS.t0 8.47732
R476 VSS.n376 VSS.t0 8.47732
R477 VSS.n378 VSS.t0 8.47732
R478 VSS.n380 VSS.t0 8.47732
R479 VSS.n382 VSS.t0 8.47732
R480 VSS.n384 VSS.t0 8.47732
R481 VSS.t14 VSS.t0 8.47732
R482 VSS.n386 VSS.t0 8.47732
R483 VSS.n388 VSS.t0 8.47732
R484 VSS.n390 VSS.t0 8.47732
R485 VSS.n392 VSS.t0 8.47732
R486 VSS.n394 VSS.t0 8.47732
R487 VSS.n396 VSS.t0 8.47732
R488 VSS.n398 VSS.t0 8.47732
R489 VSS.n400 VSS.t0 8.47732
R490 VSS.n8 VSS.n7 0.00216621
R491 VSS.n12 VSS.n4 0.00229996
R492 VSS.n9 VSS.n13 0.00377745
R493 VSS.n409 VSS.n7 5.62674
R494 VSS.n5 VSS.n4 3.32786
R495 VSS.n14 VSS.n13 3.32786
R496 VSS.n413 VSS.t0 5.62581
R497 VSS.n72 VSS.t0 5.62581
R498 VSS.n528 VSS.t0 5.62581
R499 VSS.n584 VSS.t0 5.62581
R500 VSS.n610 VSS.t0 5.62581
R501 VSS.n280 VSS.t0 5.62581
R502 VSS.n298 VSS.t0 5.62581
R503 VSS.n332 VSS.t0 5.62581
R504 VSS.n350 VSS.t0 5.62581
R505 VSS.n402 VSS.t0 5.62581
R506 VSS.n404 VSS.t0 5.62352
R507 VSS.n417 VSS.n416 4.73162
R508 VSS.n186 VSS.n101 4.73162
R509 VSS.n643 VSS.n642 1.24638
R510 VSS.n644 VSS.n643 1.23238
R511 VSS.n6 VSS.n404 0.331329
R512 VSS.n409 VSS.n21 0.233757
R513 VSS.n410 VSS.n409 0.233419
R514 VSS.n3 VSS.n21 0.325253
R515 VSS.n640 VSS.n639 0.231121
R516 VSS.n639 VSS.n638 0.231121
R517 VSS.n638 VSS.n26 0.231121
R518 VSS.n628 VSS.n26 0.231121
R519 VSS.n628 VSS.n627 0.231121
R520 VSS.n627 VSS.n626 0.231121
R521 VSS.n626 VSS.n30 0.231121
R522 VSS.n616 VSS.n30 0.231121
R523 VSS.n616 VSS.n615 0.231121
R524 VSS.n615 VSS.n614 0.231121
R525 VSS.n614 VSS.n34 0.231121
R526 VSS.n605 VSS.n34 0.231121
R527 VSS.n605 VSS.n604 0.231121
R528 VSS.n604 VSS.n603 0.231121
R529 VSS.n603 VSS.n38 0.231121
R530 VSS.n593 VSS.n38 0.231121
R531 VSS.n593 VSS.n592 0.231121
R532 VSS.n592 VSS.n591 0.231121
R533 VSS.n591 VSS.n42 0.231121
R534 VSS.n582 VSS.n42 0.231121
R535 VSS.n582 VSS.n581 0.231121
R536 VSS.n581 VSS.n580 0.231121
R537 VSS.n580 VSS.n46 0.231121
R538 VSS.n570 VSS.n46 0.231121
R539 VSS.n570 VSS.n569 0.231121
R540 VSS.n569 VSS.n568 0.231121
R541 VSS.n568 VSS.n50 0.231121
R542 VSS.n558 VSS.n50 0.231121
R543 VSS.n558 VSS.n557 0.231121
R544 VSS.n557 VSS.n556 0.231121
R545 VSS.n556 VSS.n54 0.231121
R546 VSS.n547 VSS.n54 0.231121
R547 VSS.n547 VSS.n546 0.231121
R548 VSS.n546 VSS.n545 0.231121
R549 VSS.n545 VSS.n58 0.231121
R550 VSS.n535 VSS.n58 0.231121
R551 VSS.n535 VSS.n534 0.231121
R552 VSS.n534 VSS.n533 0.231121
R553 VSS.n533 VSS.n62 0.231121
R554 VSS.n524 VSS.n62 0.231121
R555 VSS.n524 VSS.n523 0.231121
R556 VSS.n523 VSS.n522 0.231121
R557 VSS.n522 VSS.n66 0.231121
R558 VSS.n512 VSS.n66 0.231121
R559 VSS.n512 VSS.n511 0.231121
R560 VSS.n511 VSS.n510 0.231121
R561 VSS.n510 VSS.n70 0.231121
R562 VSS.n500 VSS.n70 0.231121
R563 VSS.n500 VSS.n499 0.231121
R564 VSS.n499 VSS.n498 0.231121
R565 VSS.n498 VSS.n74 0.231121
R566 VSS.n489 VSS.n74 0.231121
R567 VSS.n489 VSS.n488 0.231121
R568 VSS.n488 VSS.n487 0.231121
R569 VSS.n487 VSS.n78 0.231121
R570 VSS.n477 VSS.n78 0.231121
R571 VSS.n477 VSS.n476 0.231121
R572 VSS.n476 VSS.n475 0.231121
R573 VSS.n475 VSS.n82 0.231121
R574 VSS.n466 VSS.n82 0.231121
R575 VSS.n466 VSS.n465 0.231121
R576 VSS.n465 VSS.n464 0.231121
R577 VSS.n464 VSS.n86 0.231121
R578 VSS.n454 VSS.n86 0.231121
R579 VSS.n454 VSS.n453 0.231121
R580 VSS.n453 VSS.n452 0.231121
R581 VSS.n452 VSS.n90 0.231121
R582 VSS.n442 VSS.n90 0.231121
R583 VSS.n442 VSS.n441 0.231121
R584 VSS.n441 VSS.n440 0.231121
R585 VSS.n440 VSS.n93 0.231121
R586 VSS.n430 VSS.n93 0.231121
R587 VSS.n430 VSS.n429 0.231121
R588 VSS.n429 VSS.n428 0.231121
R589 VSS.n428 VSS.n97 0.231121
R590 VSS.n418 VSS.n97 0.231121
R591 VSS.n418 VSS.n417 0.231121
R592 VSS.n641 VSS.n25 0.231121
R593 VSS.n637 VSS.n25 0.231121
R594 VSS.n637 VSS.n27 0.231121
R595 VSS.n629 VSS.n27 0.231121
R596 VSS.n629 VSS.n29 0.231121
R597 VSS.n625 VSS.n29 0.231121
R598 VSS.n625 VSS.n31 0.231121
R599 VSS.n617 VSS.n31 0.231121
R600 VSS.n617 VSS.n33 0.231121
R601 VSS.n613 VSS.n33 0.231121
R602 VSS.n613 VSS.n35 0.231121
R603 VSS.n606 VSS.n35 0.231121
R604 VSS.n606 VSS.n37 0.231121
R605 VSS.n602 VSS.n37 0.231121
R606 VSS.n602 VSS.n39 0.231121
R607 VSS.n594 VSS.n39 0.231121
R608 VSS.n594 VSS.n41 0.231121
R609 VSS.n590 VSS.n41 0.231121
R610 VSS.n590 VSS.n43 0.231121
R611 VSS.n583 VSS.n43 0.231121
R612 VSS.n583 VSS.n45 0.231121
R613 VSS.n579 VSS.n45 0.231121
R614 VSS.n579 VSS.n47 0.231121
R615 VSS.n571 VSS.n47 0.231121
R616 VSS.n571 VSS.n49 0.231121
R617 VSS.n567 VSS.n49 0.231121
R618 VSS.n567 VSS.n51 0.231121
R619 VSS.n559 VSS.n51 0.231121
R620 VSS.n559 VSS.n53 0.231121
R621 VSS.n555 VSS.n53 0.231121
R622 VSS.n555 VSS.n55 0.231121
R623 VSS.n548 VSS.n55 0.231121
R624 VSS.n548 VSS.n57 0.231121
R625 VSS.n544 VSS.n57 0.231121
R626 VSS.n544 VSS.n59 0.231121
R627 VSS.n536 VSS.n59 0.231121
R628 VSS.n536 VSS.n61 0.231121
R629 VSS.n532 VSS.n61 0.231121
R630 VSS.n532 VSS.n63 0.231121
R631 VSS.n525 VSS.n63 0.231121
R632 VSS.n525 VSS.n65 0.231121
R633 VSS.n521 VSS.n65 0.231121
R634 VSS.n521 VSS.n67 0.231121
R635 VSS.n513 VSS.n67 0.231121
R636 VSS.n513 VSS.n69 0.231121
R637 VSS.n509 VSS.n69 0.231121
R638 VSS.n509 VSS.n71 0.231121
R639 VSS.n501 VSS.n71 0.231121
R640 VSS.n501 VSS.n73 0.231121
R641 VSS.n497 VSS.n73 0.231121
R642 VSS.n497 VSS.n75 0.231121
R643 VSS.n490 VSS.n75 0.231121
R644 VSS.n490 VSS.n77 0.231121
R645 VSS.n486 VSS.n77 0.231121
R646 VSS.n486 VSS.n79 0.231121
R647 VSS.n478 VSS.n79 0.231121
R648 VSS.n478 VSS.n81 0.231121
R649 VSS.n474 VSS.n81 0.231121
R650 VSS.n474 VSS.n83 0.231121
R651 VSS.n467 VSS.n83 0.231121
R652 VSS.n467 VSS.n85 0.231121
R653 VSS.n463 VSS.n85 0.231121
R654 VSS.n463 VSS.n87 0.231121
R655 VSS.n455 VSS.n87 0.231121
R656 VSS.n455 VSS.n89 0.231121
R657 VSS.n451 VSS.n89 0.231121
R658 VSS.n451 VSS.n91 0.231121
R659 VSS.n443 VSS.n91 0.231121
R660 VSS.n443 VSS.n92 0.231121
R661 VSS.n439 VSS.n92 0.231121
R662 VSS.n439 VSS.n94 0.231121
R663 VSS.n431 VSS.n94 0.231121
R664 VSS.n431 VSS.n96 0.231121
R665 VSS.n427 VSS.n96 0.231121
R666 VSS.n427 VSS.n98 0.231121
R667 VSS.n419 VSS.n98 0.231121
R668 VSS.n419 VSS.n100 0.231121
R669 VSS.n415 VSS.n100 0.231121
R670 VSS.n645 VSS.n24 0.231121
R671 VSS.n262 VSS.n24 0.231121
R672 VSS.n262 VSS.n185 0.231121
R673 VSS.n185 VSS.n184 0.231121
R674 VSS.n184 VSS.n183 0.231121
R675 VSS.n183 VSS.n182 0.231121
R676 VSS.n182 VSS.n181 0.231121
R677 VSS.n181 VSS.n180 0.231121
R678 VSS.n180 VSS.n179 0.231121
R679 VSS.n179 VSS.n178 0.231121
R680 VSS.n178 VSS.n176 0.231121
R681 VSS.n176 VSS.n175 0.231121
R682 VSS.n175 VSS.n174 0.231121
R683 VSS.n174 VSS.n173 0.231121
R684 VSS.n173 VSS.n172 0.231121
R685 VSS.n172 VSS.n171 0.231121
R686 VSS.n171 VSS.n170 0.231121
R687 VSS.n170 VSS.n169 0.231121
R688 VSS.n169 VSS.n168 0.231121
R689 VSS.n168 VSS.n167 0.231121
R690 VSS.n167 VSS.n165 0.231121
R691 VSS.n165 VSS.n164 0.231121
R692 VSS.n164 VSS.n163 0.231121
R693 VSS.n163 VSS.n162 0.231121
R694 VSS.n162 VSS.n161 0.231121
R695 VSS.n161 VSS.n160 0.231121
R696 VSS.n160 VSS.n159 0.231121
R697 VSS.n159 VSS.n158 0.231121
R698 VSS.n158 VSS.n157 0.231121
R699 VSS.n157 VSS.n155 0.231121
R700 VSS.n155 VSS.n154 0.231121
R701 VSS.n154 VSS.n153 0.231121
R702 VSS.n153 VSS.n152 0.231121
R703 VSS.n152 VSS.n151 0.231121
R704 VSS.n151 VSS.n150 0.231121
R705 VSS.n150 VSS.n149 0.231121
R706 VSS.n149 VSS.n148 0.231121
R707 VSS.n148 VSS.n147 0.231121
R708 VSS.n147 VSS.n146 0.231121
R709 VSS.n146 VSS.n144 0.231121
R710 VSS.n144 VSS.n143 0.231121
R711 VSS.n143 VSS.n142 0.231121
R712 VSS.n142 VSS.n141 0.231121
R713 VSS.n141 VSS.n140 0.231121
R714 VSS.n140 VSS.n139 0.231121
R715 VSS.n139 VSS.n138 0.231121
R716 VSS.n138 VSS.n137 0.231121
R717 VSS.n137 VSS.n136 0.231121
R718 VSS.n136 VSS.n135 0.231121
R719 VSS.n135 VSS.n133 0.231121
R720 VSS.n133 VSS.n132 0.231121
R721 VSS.n132 VSS.n131 0.231121
R722 VSS.n131 VSS.n130 0.231121
R723 VSS.n130 VSS.n129 0.231121
R724 VSS.n129 VSS.n128 0.231121
R725 VSS.n128 VSS.n127 0.231121
R726 VSS.n127 VSS.n126 0.231121
R727 VSS.n126 VSS.n125 0.231121
R728 VSS.n125 VSS.n123 0.231121
R729 VSS.n123 VSS.n122 0.231121
R730 VSS.n122 VSS.n121 0.231121
R731 VSS.n121 VSS.n120 0.231121
R732 VSS.n120 VSS.n119 0.231121
R733 VSS.n119 VSS.n118 0.231121
R734 VSS.n118 VSS.n117 0.231121
R735 VSS.n117 VSS.n116 0.231121
R736 VSS.n116 VSS.n115 0.231121
R737 VSS.n115 VSS.n114 0.231121
R738 VSS.n114 VSS.n112 0.231121
R739 VSS.n112 VSS.n111 0.231121
R740 VSS.n111 VSS.n110 0.231121
R741 VSS.n110 VSS.n109 0.231121
R742 VSS.n109 VSS.n108 0.231121
R743 VSS.n108 VSS.n107 0.231121
R744 VSS.n107 VSS.n106 0.231121
R745 VSS.n106 VSS.n105 0.231121
R746 VSS.n105 VSS.n104 0.231121
R747 VSS.n104 VSS.n103 0.231121
R748 VSS.n646 VSS.n23 0.231121
R749 VSS.n261 VSS.n23 0.231121
R750 VSS.n261 VSS.n260 0.231121
R751 VSS.n260 VSS.n259 0.231121
R752 VSS.n259 VSS.n258 0.231121
R753 VSS.n258 VSS.n257 0.231121
R754 VSS.n257 VSS.n256 0.231121
R755 VSS.n256 VSS.n255 0.231121
R756 VSS.n255 VSS.n254 0.231121
R757 VSS.n254 VSS.n253 0.231121
R758 VSS.n253 VSS.n252 0.231121
R759 VSS.n252 VSS.n251 0.231121
R760 VSS.n251 VSS.n250 0.231121
R761 VSS.n250 VSS.n249 0.231121
R762 VSS.n249 VSS.n248 0.231121
R763 VSS.n248 VSS.n247 0.231121
R764 VSS.n247 VSS.n246 0.231121
R765 VSS.n246 VSS.n245 0.231121
R766 VSS.n245 VSS.n244 0.231121
R767 VSS.n244 VSS.n243 0.231121
R768 VSS.n243 VSS.n242 0.231121
R769 VSS.n242 VSS.n241 0.231121
R770 VSS.n241 VSS.n240 0.231121
R771 VSS.n240 VSS.n239 0.231121
R772 VSS.n239 VSS.n238 0.231121
R773 VSS.n238 VSS.n237 0.231121
R774 VSS.n237 VSS.n236 0.231121
R775 VSS.n236 VSS.n235 0.231121
R776 VSS.n235 VSS.n234 0.231121
R777 VSS.n234 VSS.n233 0.231121
R778 VSS.n233 VSS.n232 0.231121
R779 VSS.n232 VSS.n231 0.231121
R780 VSS.n231 VSS.n230 0.231121
R781 VSS.n230 VSS.n229 0.231121
R782 VSS.n229 VSS.n228 0.231121
R783 VSS.n228 VSS.n227 0.231121
R784 VSS.n227 VSS.n226 0.231121
R785 VSS.n226 VSS.n225 0.231121
R786 VSS.n225 VSS.n224 0.231121
R787 VSS.n224 VSS.n223 0.231121
R788 VSS.n223 VSS.n222 0.231121
R789 VSS.n222 VSS.n221 0.231121
R790 VSS.n221 VSS.n220 0.231121
R791 VSS.n220 VSS.n219 0.231121
R792 VSS.n219 VSS.n218 0.231121
R793 VSS.n218 VSS.n217 0.231121
R794 VSS.n217 VSS.n216 0.231121
R795 VSS.n216 VSS.n215 0.231121
R796 VSS.n215 VSS.n214 0.231121
R797 VSS.n214 VSS.n213 0.231121
R798 VSS.n213 VSS.n212 0.231121
R799 VSS.n212 VSS.n211 0.231121
R800 VSS.n211 VSS.n210 0.231121
R801 VSS.n210 VSS.n209 0.231121
R802 VSS.n209 VSS.n208 0.231121
R803 VSS.n208 VSS.n207 0.231121
R804 VSS.n207 VSS.n206 0.231121
R805 VSS.n206 VSS.n205 0.231121
R806 VSS.n205 VSS.n204 0.231121
R807 VSS.n204 VSS.n203 0.231121
R808 VSS.n203 VSS.n202 0.231121
R809 VSS.n202 VSS.n201 0.231121
R810 VSS.n201 VSS.n200 0.231121
R811 VSS.n200 VSS.n199 0.231121
R812 VSS.n199 VSS.n198 0.231121
R813 VSS.n198 VSS.n197 0.231121
R814 VSS.n197 VSS.n196 0.231121
R815 VSS.n196 VSS.n195 0.231121
R816 VSS.n195 VSS.n194 0.231121
R817 VSS.n194 VSS.n193 0.231121
R818 VSS.n193 VSS.n192 0.231121
R819 VSS.n192 VSS.n191 0.231121
R820 VSS.n191 VSS.n190 0.231121
R821 VSS.n190 VSS.n189 0.231121
R822 VSS.n189 VSS.n188 0.231121
R823 VSS.n188 VSS.n187 0.231121
R824 VSS.n187 VSS.n186 0.231121
R825 VSS.n20 VSS.n3 0.418412
R826 VSS.n405 VSS.n20 0.279772
R827 VSS.n406 VSS.n405 0.187025
R828 VSS.n407 VSS.n406 0.187025
R829 VSS.n6 VSS.n11 0.37252
R830 VSS.n411 VSS.n410 0.154873
R831 VSS.n636 VSS.n635 0.143368
R832 VSS.n633 VSS.n632 0.143368
R833 VSS.n631 VSS.n630 0.143368
R834 VSS.n622 VSS.n28 0.143368
R835 VSS.n624 VSS.n623 0.143368
R836 VSS.n621 VSS.n620 0.143368
R837 VSS.n619 VSS.n618 0.143368
R838 VSS.n612 VSS.n32 0.143368
R839 VSS.n608 VSS.n607 0.143368
R840 VSS.n599 VSS.n36 0.143368
R841 VSS.n601 VSS.n600 0.143368
R842 VSS.n598 VSS.n597 0.143368
R843 VSS.n596 VSS.n595 0.143368
R844 VSS.n587 VSS.n40 0.143368
R845 VSS.n589 VSS.n588 0.143368
R846 VSS.n586 VSS.n585 0.143368
R847 VSS.n578 VSS.n577 0.143368
R848 VSS.n575 VSS.n574 0.143368
R849 VSS.n573 VSS.n572 0.143368
R850 VSS.n564 VSS.n48 0.143368
R851 VSS.n566 VSS.n565 0.143368
R852 VSS.n563 VSS.n562 0.143368
R853 VSS.n561 VSS.n560 0.143368
R854 VSS.n554 VSS.n52 0.143368
R855 VSS.n552 VSS.n551 0.143368
R856 VSS.n550 VSS.n549 0.143368
R857 VSS.n541 VSS.n56 0.143368
R858 VSS.n543 VSS.n542 0.143368
R859 VSS.n540 VSS.n539 0.143368
R860 VSS.n538 VSS.n537 0.143368
R861 VSS.n529 VSS.n60 0.143368
R862 VSS.n531 VSS.n530 0.143368
R863 VSS.n518 VSS.n64 0.143368
R864 VSS.n520 VSS.n519 0.143368
R865 VSS.n517 VSS.n516 0.143368
R866 VSS.n515 VSS.n514 0.143368
R867 VSS.n506 VSS.n68 0.143368
R868 VSS.n508 VSS.n507 0.143368
R869 VSS.n505 VSS.n504 0.143368
R870 VSS.n503 VSS.n502 0.143368
R871 VSS.n494 VSS.n493 0.143368
R872 VSS.n492 VSS.n491 0.143368
R873 VSS.n483 VSS.n76 0.143368
R874 VSS.n485 VSS.n484 0.143368
R875 VSS.n482 VSS.n481 0.143368
R876 VSS.n480 VSS.n479 0.143368
R877 VSS.n471 VSS.n80 0.143368
R878 VSS.n473 VSS.n472 0.143368
R879 VSS.n469 VSS.n468 0.143368
R880 VSS.n460 VSS.n84 0.143368
R881 VSS.n462 VSS.n461 0.143368
R882 VSS.n459 VSS.n458 0.143368
R883 VSS.n457 VSS.n456 0.143368
R884 VSS.n448 VSS.n88 0.143368
R885 VSS.n450 VSS.n449 0.143368
R886 VSS.n447 VSS.n446 0.143368
R887 VSS.n445 VSS.n444 0.143368
R888 VSS.n438 VSS.n437 0.143368
R889 VSS.n435 VSS.n434 0.143368
R890 VSS.n433 VSS.n432 0.143368
R891 VSS.n424 VSS.n95 0.143368
R892 VSS.n426 VSS.n425 0.143368
R893 VSS.n423 VSS.n422 0.143368
R894 VSS.n421 VSS.n420 0.143368
R895 VSS.n414 VSS.n99 0.143368
R896 VSS.n265 VSS.n264 0.143368
R897 VSS.n267 VSS.n266 0.143368
R898 VSS.n269 VSS.n268 0.143368
R899 VSS.n271 VSS.n270 0.143368
R900 VSS.n273 VSS.n272 0.143368
R901 VSS.n275 VSS.n274 0.143368
R902 VSS.n277 VSS.n276 0.143368
R903 VSS.n279 VSS.n278 0.143368
R904 VSS.n283 VSS.n282 0.143368
R905 VSS.n285 VSS.n284 0.143368
R906 VSS.n287 VSS.n286 0.143368
R907 VSS.n289 VSS.n288 0.143368
R908 VSS.n291 VSS.n290 0.143368
R909 VSS.n293 VSS.n292 0.143368
R910 VSS.n295 VSS.n294 0.143368
R911 VSS.n297 VSS.n296 0.143368
R912 VSS.n301 VSS.n300 0.143368
R913 VSS.n303 VSS.n302 0.143368
R914 VSS.n305 VSS.n304 0.143368
R915 VSS.n307 VSS.n306 0.143368
R916 VSS.n309 VSS.n308 0.143368
R917 VSS.n311 VSS.n310 0.143368
R918 VSS.n313 VSS.n312 0.143368
R919 VSS.n315 VSS.n314 0.143368
R920 VSS.n317 VSS.n316 0.143368
R921 VSS.n319 VSS.n318 0.143368
R922 VSS.n321 VSS.n320 0.143368
R923 VSS.n323 VSS.n322 0.143368
R924 VSS.n325 VSS.n324 0.143368
R925 VSS.n327 VSS.n326 0.143368
R926 VSS.n329 VSS.n328 0.143368
R927 VSS.n331 VSS.n330 0.143368
R928 VSS.n335 VSS.n334 0.143368
R929 VSS.n337 VSS.n336 0.143368
R930 VSS.n339 VSS.n338 0.143368
R931 VSS.n341 VSS.n340 0.143368
R932 VSS.n343 VSS.n342 0.143368
R933 VSS.n345 VSS.n344 0.143368
R934 VSS.n347 VSS.n346 0.143368
R935 VSS.n349 VSS.n348 0.143368
R936 VSS.n353 VSS.n352 0.143368
R937 VSS.n355 VSS.n354 0.143368
R938 VSS.n357 VSS.n356 0.143368
R939 VSS.n359 VSS.n358 0.143368
R940 VSS.n361 VSS.n360 0.143368
R941 VSS.n363 VSS.n362 0.143368
R942 VSS.n365 VSS.n364 0.143368
R943 VSS.n367 VSS.n366 0.143368
R944 VSS.n369 VSS.n368 0.143368
R945 VSS.n371 VSS.n370 0.143368
R946 VSS.n373 VSS.n372 0.143368
R947 VSS.n375 VSS.n374 0.143368
R948 VSS.n377 VSS.n376 0.143368
R949 VSS.n379 VSS.n378 0.143368
R950 VSS.n381 VSS.n380 0.143368
R951 VSS.n383 VSS.n382 0.143368
R952 VSS.n385 VSS.n384 0.143368
R953 VSS.n387 VSS.n386 0.143368
R954 VSS.n389 VSS.n388 0.143368
R955 VSS.n391 VSS.n390 0.143368
R956 VSS.n393 VSS.n392 0.143368
R957 VSS.n395 VSS.n394 0.143368
R958 VSS.n397 VSS.n396 0.143368
R959 VSS.n399 VSS.n398 0.143368
R960 VSS.n401 VSS.n400 0.143368
R961 VSS.n634 VSS.t17 0.143368
R962 VSS.t22 VSS.n553 0.143368
R963 VSS.n470 VSS.t28 0.143368
R964 VSS.n436 VSS.t30 0.143368
R965 VSS.n113 VSS.t14 0.143368
R966 VSS.t12 VSS.n124 0.143368
R967 VSS.t6 VSS.n156 0.143368
R968 VSS.n263 VSS.t2 0.143368
R969 VSS.t32 VSS.n412 0.124701
R970 VSS.n416 VSS.n415 0.113429
R971 VSS.n103 VSS.n101 0.113429
R972 VSS.n643 VSS.t0 0.110538
R973 VSS.n640 VSS 0.109741
R974 VSS VSS.n646 0.109741
R975 VSS.n404 VSS.n403 0.103387
R976 VSS.n413 VSS.n414 0.0961384
R977 VSS.n502 VSS.n72 0.0961384
R978 VSS.n531 VSS.n528 0.0961384
R979 VSS.n585 VSS.n584 0.0961384
R980 VSS.n610 VSS.n612 0.0961384
R981 VSS.n177 VSS.n280 0.0961384
R982 VSS.t4 VSS.n298 0.0961384
R983 VSS.n145 VSS.n332 0.0961384
R984 VSS.t10 VSS.n350 0.0961384
R985 VSS.n102 VSS.n402 0.0961384
R986 VSS.t32 VSS.n413 0.0958002
R987 VSS.t26 VSS.n72 0.0958002
R988 VSS.n611 VSS.n610 0.0958002
R989 VSS.n584 VSS.t20 0.0958002
R990 VSS.n528 VSS.n527 0.0958002
R991 VSS.n280 VSS.n279 0.0958002
R992 VSS.n298 VSS.n297 0.0958002
R993 VSS.n332 VSS.n331 0.0958002
R994 VSS.n350 VSS.n349 0.0958002
R995 VSS.n402 VSS.n401 0.0958002
R996 VSS.t18 VSS.n609 0.0955
R997 VSS.n576 VSS.n44 0.0955
R998 VSS.t24 VSS.n526 0.0955
R999 VSS.n496 VSS.n495 0.0955
R1000 VSS.n281 VSS.t1 0.0955
R1001 VSS.n299 VSS.n166 0.0955
R1002 VSS.n333 VSS.t8 0.0955
R1003 VSS.n351 VSS.n134 0.0955
R1004 VSS.n611 VSS.t18 0.0955
R1005 VSS.n527 VSS.t24 0.0955
R1006 VSS.n495 VSS.t26 0.0955
R1007 VSS.t16 VSS.n102 0.0955
R1008 VSS.n134 VSS.t10 0.0955
R1009 VSS.t8 VSS.n145 0.0955
R1010 VSS.n166 VSS.t4 0.0955
R1011 VSS.t1 VSS.n177 0.0955
R1012 VSS.n44 VSS.t20 0.0955
R1013 VSS.n403 VSS.t16 0.058
R1014 VSS.n420 VSS.n99 0.0483676
R1015 VSS.n422 VSS.n421 0.0483676
R1016 VSS.n426 VSS.n423 0.0483676
R1017 VSS.n425 VSS.n424 0.0483676
R1018 VSS.n432 VSS.n95 0.0483676
R1019 VSS.n434 VSS.n433 0.0483676
R1020 VSS.n438 VSS.n435 0.0483676
R1021 VSS.n437 VSS.n436 0.0483676
R1022 VSS.n444 VSS.t30 0.0483676
R1023 VSS.n446 VSS.n445 0.0483676
R1024 VSS.n450 VSS.n447 0.0483676
R1025 VSS.n449 VSS.n448 0.0483676
R1026 VSS.n456 VSS.n88 0.0483676
R1027 VSS.n458 VSS.n457 0.0483676
R1028 VSS.n462 VSS.n459 0.0483676
R1029 VSS.n461 VSS.n460 0.0483676
R1030 VSS.n468 VSS.n84 0.0483676
R1031 VSS.t28 VSS.n469 0.0483676
R1032 VSS.n473 VSS.n470 0.0483676
R1033 VSS.n472 VSS.n471 0.0483676
R1034 VSS.n479 VSS.n80 0.0483676
R1035 VSS.n481 VSS.n480 0.0483676
R1036 VSS.n485 VSS.n482 0.0483676
R1037 VSS.n484 VSS.n483 0.0483676
R1038 VSS.n491 VSS.n76 0.0483676
R1039 VSS.n493 VSS.n492 0.0483676
R1040 VSS.n496 VSS.n494 0.0483676
R1041 VSS.n504 VSS.n503 0.0483676
R1042 VSS.n508 VSS.n505 0.0483676
R1043 VSS.n507 VSS.n506 0.0483676
R1044 VSS.n514 VSS.n68 0.0483676
R1045 VSS.n516 VSS.n515 0.0483676
R1046 VSS.n520 VSS.n517 0.0483676
R1047 VSS.n519 VSS.n518 0.0483676
R1048 VSS.n526 VSS.n64 0.0483676
R1049 VSS.n530 VSS.n529 0.0483676
R1050 VSS.n537 VSS.n60 0.0483676
R1051 VSS.n539 VSS.n538 0.0483676
R1052 VSS.n543 VSS.n540 0.0483676
R1053 VSS.n542 VSS.n541 0.0483676
R1054 VSS.n549 VSS.n56 0.0483676
R1055 VSS.n551 VSS.n550 0.0483676
R1056 VSS.t22 VSS.n552 0.0483676
R1057 VSS.n553 VSS.n554 0.0483676
R1058 VSS.n560 VSS.n52 0.0483676
R1059 VSS.n562 VSS.n561 0.0483676
R1060 VSS.n566 VSS.n563 0.0483676
R1061 VSS.n565 VSS.n564 0.0483676
R1062 VSS.n572 VSS.n48 0.0483676
R1063 VSS.n574 VSS.n573 0.0483676
R1064 VSS.n578 VSS.n575 0.0483676
R1065 VSS.n577 VSS.n576 0.0483676
R1066 VSS.n589 VSS.n586 0.0483676
R1067 VSS.n588 VSS.n587 0.0483676
R1068 VSS.n595 VSS.n40 0.0483676
R1069 VSS.n597 VSS.n596 0.0483676
R1070 VSS.n601 VSS.n598 0.0483676
R1071 VSS.n600 VSS.n599 0.0483676
R1072 VSS.n607 VSS.n36 0.0483676
R1073 VSS.n609 VSS.n608 0.0483676
R1074 VSS.n618 VSS.n32 0.0483676
R1075 VSS.n620 VSS.n619 0.0483676
R1076 VSS.n624 VSS.n621 0.0483676
R1077 VSS.n623 VSS.n622 0.0483676
R1078 VSS.n630 VSS.n28 0.0483676
R1079 VSS.n632 VSS.n631 0.0483676
R1080 VSS.n636 VSS.n633 0.0483676
R1081 VSS.n635 VSS.n634 0.0483676
R1082 VSS.n642 VSS.t17 0.0483676
R1083 VSS.n644 VSS.t2 0.0483676
R1084 VSS.n264 VSS.n263 0.0483676
R1085 VSS.n266 VSS.n265 0.0483676
R1086 VSS.n268 VSS.n267 0.0483676
R1087 VSS.n270 VSS.n269 0.0483676
R1088 VSS.n272 VSS.n271 0.0483676
R1089 VSS.n274 VSS.n273 0.0483676
R1090 VSS.n276 VSS.n275 0.0483676
R1091 VSS.n278 VSS.n277 0.0483676
R1092 VSS.n282 VSS.n281 0.0483676
R1093 VSS.n284 VSS.n283 0.0483676
R1094 VSS.n286 VSS.n285 0.0483676
R1095 VSS.n288 VSS.n287 0.0483676
R1096 VSS.n290 VSS.n289 0.0483676
R1097 VSS.n292 VSS.n291 0.0483676
R1098 VSS.n294 VSS.n293 0.0483676
R1099 VSS.n296 VSS.n295 0.0483676
R1100 VSS.n300 VSS.n299 0.0483676
R1101 VSS.n302 VSS.n301 0.0483676
R1102 VSS.n304 VSS.n303 0.0483676
R1103 VSS.n306 VSS.n305 0.0483676
R1104 VSS.n308 VSS.n307 0.0483676
R1105 VSS.n310 VSS.n309 0.0483676
R1106 VSS.n312 VSS.n311 0.0483676
R1107 VSS.n314 VSS.n313 0.0483676
R1108 VSS.n156 VSS.n315 0.0483676
R1109 VSS.n316 VSS.t6 0.0483676
R1110 VSS.n318 VSS.n317 0.0483676
R1111 VSS.n320 VSS.n319 0.0483676
R1112 VSS.n322 VSS.n321 0.0483676
R1113 VSS.n324 VSS.n323 0.0483676
R1114 VSS.n326 VSS.n325 0.0483676
R1115 VSS.n328 VSS.n327 0.0483676
R1116 VSS.n330 VSS.n329 0.0483676
R1117 VSS.n334 VSS.n333 0.0483676
R1118 VSS.n336 VSS.n335 0.0483676
R1119 VSS.n338 VSS.n337 0.0483676
R1120 VSS.n340 VSS.n339 0.0483676
R1121 VSS.n342 VSS.n341 0.0483676
R1122 VSS.n344 VSS.n343 0.0483676
R1123 VSS.n346 VSS.n345 0.0483676
R1124 VSS.n348 VSS.n347 0.0483676
R1125 VSS.n352 VSS.n351 0.0483676
R1126 VSS.n354 VSS.n353 0.0483676
R1127 VSS.n356 VSS.n355 0.0483676
R1128 VSS.n358 VSS.n357 0.0483676
R1129 VSS.n360 VSS.n359 0.0483676
R1130 VSS.n362 VSS.n361 0.0483676
R1131 VSS.n364 VSS.n363 0.0483676
R1132 VSS.n366 VSS.n365 0.0483676
R1133 VSS.n124 VSS.n367 0.0483676
R1134 VSS.n368 VSS.t12 0.0483676
R1135 VSS.n370 VSS.n369 0.0483676
R1136 VSS.n372 VSS.n371 0.0483676
R1137 VSS.n374 VSS.n373 0.0483676
R1138 VSS.n376 VSS.n375 0.0483676
R1139 VSS.n378 VSS.n377 0.0483676
R1140 VSS.n380 VSS.n379 0.0483676
R1141 VSS.n382 VSS.n381 0.0483676
R1142 VSS.n384 VSS.n383 0.0483676
R1143 VSS.t14 VSS.n385 0.0483676
R1144 VSS.n386 VSS.n113 0.0483676
R1145 VSS.n388 VSS.n387 0.0483676
R1146 VSS.n390 VSS.n389 0.0483676
R1147 VSS.n392 VSS.n391 0.0483676
R1148 VSS.n394 VSS.n393 0.0483676
R1149 VSS.n396 VSS.n395 0.0483676
R1150 VSS.n398 VSS.n397 0.0483676
R1151 VSS.n400 VSS.n399 0.0483676
R1152 VSS.n412 VSS.n411 0.0297015
R1153 VSS.n17 VSS.n15 0.00399977
R1154 VSS.n22 VSS.n2 0.00299994
R1155 VSS.n10 VSS.n0 0.00299994
R1156 VSS.n18 VSS.n2 0.00279996
R1157 VSS.n13 VSS.n12 0.00269993
R1158 VSS.n10 VSS.n9 0.00222181
R1159 VSS.n19 VSS.n17 0.0025
R1160 VSS.n7 VSS.t0 0.00249998
R1161 VSS.n16 VSS.n15 0.00249997
R1162 VSS.n16 VSS.n4 0.00199997
R1163 VSS.n19 VSS.n18 0.00169993
R1164 VSS.n1 VSS.t0 0.00277842
R1165 VSS.t0 VSS.n0 0.00394651
R1166 VSS.n408 VSS.n1 9.19136
C0 SIGP VSS 0.10216p
.ends
