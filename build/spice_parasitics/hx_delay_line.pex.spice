* NGSPICE file created from hx_delay_line.ext - technology: ihp-sg13g2

.subckt hx_delay_line VSS VDD DELAY_OUT_LAST DELAY_OUT_TAP1 DELAY_OUT_TAP2 DELAY_OUT_TAP3
+ DELAY_OUT_TAP4 DELAY_OUT_TAP5 DELAY_OUT_TAP6 DELAY_OUT_TAP7 DELAY_OUT_TAP8 DELAY_OUT_TAP9
+ DELAY_OUT_TAP10 DELAY_OUT_TAP11 DELAY_OUT_TAP12 DELAY_OUT_TAP13 DELAY_OUT_TAP14
+ DELAY_OUT_TAP15 DELAY_OUT_TAP16 DELAY_OUT_TAP17 DELAY_OUT_TAP18 DELAY_OUT_TAP19
+ DELAY_OUT_TAP20 DELAY_OUT_TAP21 DELAY_OUT_TAP22 DELAY_OUT_TAP23 DELAY_OUT_TAP24
+ DELAY_OUT_TAP25 DELAY_OUT_TAP26 DELAY_OUT_TAP27 DELAY_OUT_TAP28 DELAY_OUT_TAP29
+ DELAY_OUT_TAP30 DELAY_OUT_TAP31 DELAY_IN DELAY_VBIASN DELAY_VBIASP
X0 VDD.t92 DELAY_VBIASP.t3 a_25131_2470# VDD.t0 sg13_lv_pmos ad=0.3808p pd=2.92u as=0.2128p ps=1.5u w=1.12u l=0.6u
X1 VSS.t59 a_5263_1842# DELAY_OUT_TAP3 VSS.t58 sg13_lv_nmos ad=0.1406p pd=1.12u as=0.2516p ps=2.16u w=0.74u l=0.13u
X2 VDD.t73 DELAY_VBIASP.t31 a_3851_2470# VDD.t0 sg13_lv_pmos ad=0.3808p pd=2.92u as=0.2128p ps=1.5u w=1.12u l=0.6u
X3 a_27411_2470# a_27173_1842# a_27303_1842# VDD.t0 sg13_lv_pmos ad=0.2128p pd=1.5u as=0.3808p ps=2.92u w=1.12u l=0.2u
X4 a_9171_1842# a_8933_1842# a_9063_1842# VSS.t18 sg13_lv_nmos ad=0.1406p pd=1.12u as=0.2516p ps=2.16u w=0.74u l=0.2u
X5 a_18053_1842# DELAY_OUT_TAP19 VSS.t75 VSS.t87 sg13_lv_nmos ad=0.2516p pd=2.16u as=0.1406p ps=1.12u w=0.74u l=0.13u
X6 a_15013_1842# DELAY_OUT_TAP15 VDD.t48 VDD.t0 sg13_lv_pmos ad=0.3808p pd=2.92u as=0.2128p ps=1.5u w=1.12u l=0.13u
X7 VDD.t65 DELAY_VBIASP.t15 a_16011_2470# VDD.t0 sg13_lv_pmos ad=0.3808p pd=2.92u as=0.2128p ps=1.5u w=1.12u l=0.6u
X8 VSS.t41 a_7543_1842# DELAY_OUT_TAP6 VSS.t40 sg13_lv_nmos ad=0.1406p pd=1.12u as=0.2516p ps=2.16u w=0.74u l=0.13u
X9 VDD.t68 DELAY_VBIASP.t28 a_6131_2470# VDD.t0 sg13_lv_pmos ad=0.3808p pd=2.92u as=0.2128p ps=1.5u w=1.12u l=0.6u
X10 VDD.t52 a_25783_1842# DELAY_OUT_TAP30 VDD.t0 sg13_lv_pmos ad=0.2128p pd=1.5u as=0.3808p ps=2.92u w=1.12u l=0.13u
X11 a_14491_1842# a_14253_1842# a_14383_1842# VSS.t170 sg13_lv_nmos ad=0.1406p pd=1.12u as=0.2516p ps=2.16u w=0.74u l=0.2u
X12 a_8411_2470# a_8173_1842# a_8303_1842# VDD.t0 sg13_lv_pmos ad=0.2128p pd=1.5u as=0.3808p ps=2.92u w=1.12u l=0.2u
X13 a_17293_1842# DELAY_OUT_TAP18 VDD.t47 VDD.t0 sg13_lv_pmos ad=0.3808p pd=2.92u as=0.2128p ps=1.5u w=1.12u l=0.13u
X14 VSS.t11 VSS.t7 VSS.t7 VSS.t9 sg13_lv_nmos ad=0.1406p pd=1.12u as=0 ps=0 w=0.74u l=0.13u
X15 VDD.t34 a_17423_1842# DELAY_OUT_TAP19 VDD.t0 sg13_lv_pmos ad=0.2128p pd=1.5u as=0.3808p ps=2.92u w=1.12u l=0.13u
X16 a_21093_1842# DELAY_OUT_TAP23 VDD.t56 VDD.t0 sg13_lv_pmos ad=0.3808p pd=2.92u as=0.2128p ps=1.5u w=1.12u l=0.13u
X17 a_22851_2470# a_22613_1842# a_22743_1842# VDD.t0 sg13_lv_pmos ad=0.2128p pd=1.5u as=0.3808p ps=2.92u w=1.12u l=0.2u
X18 VSS.t32 a_12863_1842# DELAY_OUT_TAP13 VSS.t31 sg13_lv_nmos ad=0.1406p pd=1.12u as=0.2516p ps=2.16u w=0.74u l=0.13u
X19 VDD.t26 a_6783_1842# DELAY_OUT_TAP5 VDD.t0 sg13_lv_pmos ad=0.2128p pd=1.5u as=0.3808p ps=2.92u w=1.12u l=0.13u
X20 VDD.t77 DELAY_VBIASP.t21 a_11451_2470# VDD.t0 sg13_lv_pmos ad=0.3808p pd=2.92u as=0.2128p ps=1.5u w=1.12u l=0.6u
X21 VDD.t51 a_21223_1842# DELAY_OUT_TAP24 VDD.t0 sg13_lv_pmos ad=0.2128p pd=1.5u as=0.3808p ps=2.92u w=1.12u l=0.13u
X22 a_12733_1842# DELAY_OUT_TAP12 VDD.t15 VDD.t0 sg13_lv_pmos ad=0.3808p pd=2.92u as=0.2128p ps=1.5u w=1.12u l=0.13u
X23 a_13731_2470# a_13493_1842# a_13623_1842# VDD.t0 sg13_lv_pmos ad=0.2128p pd=1.5u as=0.3808p ps=2.92u w=1.12u l=0.2u
X24 a_3851_2470# DELAY_IN a_3743_1842# VDD.t0 sg13_lv_pmos ad=0.2128p pd=1.5u as=0.3808p ps=2.92u w=1.12u l=0.2u
X25 VSS.t72 DELAY_VBIASN.t12 a_18291_1842# VSS.t139 sg13_lv_nmos ad=0.2516p pd=2.16u as=0.1406p ps=1.12u w=0.74u l=0.6u
X26 VDD.t50 a_23503_1842# DELAY_OUT_TAP27 VDD.t0 sg13_lv_pmos ad=0.2128p pd=1.5u as=0.3808p ps=2.92u w=1.12u l=0.13u
X27 VDD.t93 DELAY_VBIASP.t1 a_26651_2470# VDD.t0 sg13_lv_pmos ad=0.3808p pd=2.92u as=0.2128p ps=1.5u w=1.12u l=0.6u
X28 VSS.t20 DELAY_VBIASN.t7 a_22091_1842# VSS.t143 sg13_lv_nmos ad=0.2516p pd=2.16u as=0.1406p ps=1.12u w=0.74u l=0.6u
X29 a_19573_1842# DELAY_OUT_TAP21 VSS.t67 VSS.t83 sg13_lv_nmos ad=0.2516p pd=2.16u as=0.1406p ps=1.12u w=0.74u l=0.13u
X30 VDD.t39 a_4503_1842# DELAY_OUT_TAP2 VDD.t0 sg13_lv_pmos ad=0.2128p pd=1.5u as=0.3808p ps=2.92u w=1.12u l=0.13u
X31 DELAY_OUT_LAST a_27737_1842# VDD.t103 VDD.t0 sg13_lv_pmos ad=0.3808p pd=2.92u as=0.2128p ps=1.5u w=1.12u l=0.13u
X32 VSS.t62 a_9063_1842# DELAY_OUT_TAP8 VSS.t61 sg13_lv_nmos ad=0.1406p pd=1.12u as=0.2516p ps=2.16u w=0.74u l=0.13u
X33 a_23373_1842# DELAY_OUT_TAP26 VSS.t38 VSS.t105 sg13_lv_nmos ad=0.2516p pd=2.16u as=0.1406p ps=1.12u w=0.74u l=0.13u
X34 VDD.t62 DELAY_VBIASP.t26 a_7651_2470# VDD.t0 sg13_lv_pmos ad=0.3808p pd=2.92u as=0.2128p ps=1.5u w=1.12u l=0.6u
X35 VSS.t116 DELAY_VBIASN.t18 a_13731_1842# VSS.t122 sg13_lv_nmos ad=0.2516p pd=2.16u as=0.1406p ps=1.12u w=0.74u l=0.6u
X36 a_9931_2470# a_9693_1842# a_9823_1842# VDD.t0 sg13_lv_pmos ad=0.2128p pd=1.5u as=0.3808p ps=2.92u w=1.12u l=0.2u
X37 a_11451_2470# a_11213_1842# a_11343_1842# VDD.t0 sg13_lv_pmos ad=0.2128p pd=1.5u as=0.3808p ps=2.92u w=1.12u l=0.2u
X38 a_18813_1842# DELAY_OUT_TAP20 VDD.t33 VDD.t0 sg13_lv_pmos ad=0.3808p pd=2.92u as=0.2128p ps=1.5u w=1.12u l=0.13u
X39 a_16011_1842# a_15773_1842# a_15903_1842# VSS.t166 sg13_lv_nmos ad=0.1406p pd=1.12u as=0.2516p ps=2.16u w=0.74u l=0.2u
X40 a_8933_1842# DELAY_OUT_TAP7 VDD.t1 VDD.t0 sg13_lv_pmos ad=0.3808p pd=2.92u as=0.2128p ps=1.5u w=1.12u l=0.13u
X41 VDD.t24 a_9823_1842# DELAY_OUT_TAP9 VDD.t0 sg13_lv_pmos ad=0.2128p pd=1.5u as=0.3808p ps=2.92u w=1.12u l=0.13u
X42 a_22613_1842# DELAY_OUT_TAP25 VDD.t14 VDD.t0 sg13_lv_pmos ad=0.3808p pd=2.92u as=0.2128p ps=1.5u w=1.12u l=0.13u
X43 a_4373_1842# DELAY_OUT_TAP1 VSS.t46 VSS.t82 sg13_lv_nmos ad=0.2516p pd=2.16u as=0.1406p ps=1.12u w=0.74u l=0.13u
X44 VSS.t93 a_14383_1842# DELAY_OUT_TAP15 VSS.t171 sg13_lv_nmos ad=0.1406p pd=1.12u as=0.2516p ps=2.16u w=0.74u l=0.13u
X45 a_18291_1842# a_18053_1842# a_18183_1842# VSS.t73 sg13_lv_nmos ad=0.1406p pd=1.12u as=0.2516p ps=2.16u w=0.74u l=0.2u
X46 a_26651_2470# a_26413_1842# a_26543_1842# VDD.t0 sg13_lv_pmos ad=0.2128p pd=1.5u as=0.3808p ps=2.92u w=1.12u l=0.2u
X47 a_22091_1842# a_21853_1842# a_21983_1842# VSS.t160 sg13_lv_nmos ad=0.1406p pd=1.12u as=0.2516p ps=2.16u w=0.74u l=0.2u
X48 VSS.t91 a_16663_1842# DELAY_OUT_TAP18 VSS.t154 sg13_lv_nmos ad=0.1406p pd=1.12u as=0.2516p ps=2.16u w=0.74u l=0.13u
X49 VDD.t80 DELAY_VBIASP.t16 a_15251_2470# VDD.t0 sg13_lv_pmos ad=0.3808p pd=2.92u as=0.2128p ps=1.5u w=1.12u l=0.6u
X50 VSS.t36 DELAY_VBIASN.t10 a_19811_1842# VSS.t140 sg13_lv_nmos ad=0.2516p pd=2.16u as=0.1406p ps=1.12u w=0.74u l=0.6u
X51 VDD.t46 a_25023_1842# DELAY_OUT_TAP29 VDD.t0 sg13_lv_pmos ad=0.2128p pd=1.5u as=0.3808p ps=2.92u w=1.12u l=0.13u
X52 VSS.t97 DELAY_VBIASN.t5 a_23611_1842# VSS.t147 sg13_lv_nmos ad=0.2516p pd=2.16u as=0.1406p ps=1.12u w=0.74u l=0.6u
X53 a_17531_2470# a_17293_1842# a_17423_1842# VDD.t0 sg13_lv_pmos ad=0.2128p pd=1.5u as=0.3808p ps=2.92u w=1.12u l=0.2u
X54 a_7651_2470# a_7413_1842# a_7543_1842# VDD.t0 sg13_lv_pmos ad=0.2128p pd=1.5u as=0.3808p ps=2.92u w=1.12u l=0.2u
X55 a_16533_1842# DELAY_OUT_TAP17 VDD.t16 VDD.t0 sg13_lv_pmos ad=0.3808p pd=2.92u as=0.2128p ps=1.5u w=1.12u l=0.13u
X56 a_20333_1842# DELAY_OUT_TAP22 VDD.t19 VDD.t0 sg13_lv_pmos ad=0.3808p pd=2.92u as=0.2128p ps=1.5u w=1.12u l=0.13u
X57 a_21331_2470# a_21093_1842# a_21223_1842# VDD.t0 sg13_lv_pmos ad=0.2128p pd=1.5u as=0.3808p ps=2.92u w=1.12u l=0.2u
X58 a_24893_1842# DELAY_OUT_TAP28 VSS.t69 VSS.t68 sg13_lv_nmos ad=0.2516p pd=2.16u as=0.1406p ps=1.12u w=0.74u l=0.13u
X59 VSS.t24 a_12103_1842# DELAY_OUT_TAP12 VSS.t23 sg13_lv_nmos ad=0.1406p pd=1.12u as=0.2516p ps=2.16u w=0.74u l=0.13u
X60 VDD.t27 a_6023_1842# DELAY_OUT_TAP4 VDD.t0 sg13_lv_pmos ad=0.2128p pd=1.5u as=0.3808p ps=2.92u w=1.12u l=0.13u
X61 VSS.t81 DELAY_VBIASN.t30 a_4611_1842# VSS.t130 sg13_lv_nmos ad=0.2516p pd=2.16u as=0.1406p ps=1.12u w=0.74u l=0.6u
X62 a_11213_1842# DELAY_OUT_TAP10 VDD.t30 VDD.t0 sg13_lv_pmos ad=0.3808p pd=2.92u as=0.2128p ps=1.5u w=1.12u l=0.13u
X63 a_12971_2470# a_12733_1842# a_12863_1842# VDD.t0 sg13_lv_pmos ad=0.2128p pd=1.5u as=0.3808p ps=2.92u w=1.12u l=0.2u
X64 VDD.t2 a_11343_1842# DELAY_OUT_TAP11 VDD.t0 sg13_lv_pmos ad=0.2128p pd=1.5u as=0.3808p ps=2.92u w=1.12u l=0.13u
X65 a_5893_1842# DELAY_OUT_TAP3 VSS.t59 VSS.t79 sg13_lv_nmos ad=0.2516p pd=2.16u as=0.1406p ps=1.12u w=0.74u l=0.13u
X66 a_27173_1842# DELAY_OUT_TAP31 VSS.t30 VSS.t117 sg13_lv_nmos ad=0.2516p pd=2.16u as=0.1406p ps=1.12u w=0.74u l=0.13u
X67 VSS.t75 DELAY_VBIASN.t13 a_17531_1842# VSS.t123 sg13_lv_nmos ad=0.2516p pd=2.16u as=0.1406p ps=1.12u w=0.74u l=0.6u
X68 VSS.t164 a_27303_1842# a_27737_1842# VSS.t168 sg13_lv_nmos ad=0.1406p pd=1.12u as=0.2516p ps=2.16u w=0.74u l=0.13u
X69 VSS.t99 DELAY_VBIASN.t8 a_21331_1842# VSS.t142 sg13_lv_nmos ad=0.2516p pd=2.16u as=0.1406p ps=1.12u w=0.74u l=0.6u
X70 a_15251_2470# a_15013_1842# a_15143_1842# VDD.t0 sg13_lv_pmos ad=0.2128p pd=1.5u as=0.3808p ps=2.92u w=1.12u l=0.2u
X71 VSS.t14 VSS.t16 VSS.t16 VSS.t17 sg13_lv_nmos ad=0.1406p pd=1.12u as=0 ps=0 w=0.74u l=0.2u
X72 a_19811_1842# a_19573_1842# a_19703_1842# VSS.t21 sg13_lv_nmos ad=0.1406p pd=1.12u as=0.2516p ps=2.16u w=0.74u l=0.2u
X73 a_8173_1842# DELAY_OUT_TAP6 VSS.t41 VSS.t103 sg13_lv_nmos ad=0.2516p pd=2.16u as=0.1406p ps=1.12u w=0.74u l=0.13u
X74 a_23611_1842# a_23373_1842# a_23503_1842# VSS.t162 sg13_lv_nmos ad=0.1406p pd=1.12u as=0.2516p ps=2.16u w=0.74u l=0.2u
X75 VDD.t95 a_13623_1842# DELAY_OUT_TAP14 VDD.t0 sg13_lv_pmos ad=0.2128p pd=1.5u as=0.3808p ps=2.92u w=1.12u l=0.13u
X76 a_26413_1842# DELAY_OUT_TAP30 VDD.t52 VDD.t0 sg13_lv_pmos ad=0.3808p pd=2.92u as=0.2128p ps=1.5u w=1.12u l=0.13u
X77 VSS.t1 a_8303_1842# DELAY_OUT_TAP7 VSS.t0 sg13_lv_nmos ad=0.1406p pd=1.12u as=0.2516p ps=2.16u w=0.74u l=0.13u
X78 VSS.t72 a_18183_1842# DELAY_OUT_TAP20 VSS.t71 sg13_lv_nmos ad=0.1406p pd=1.12u as=0.2516p ps=2.16u w=0.74u l=0.13u
X79 VSS.t24 DELAY_VBIASN.t20 a_12211_1842# VSS.t126 sg13_lv_nmos ad=0.2516p pd=2.16u as=0.1406p ps=1.12u w=0.74u l=0.6u
X80 VDD.t85 DELAY_VBIASP.t14 a_16771_2470# VDD.t0 sg13_lv_pmos ad=0.3808p pd=2.92u as=0.2128p ps=1.5u w=1.12u l=0.6u
X81 VSS.t20 a_21983_1842# DELAY_OUT_TAP25 VSS.t19 sg13_lv_nmos ad=0.1406p pd=1.12u as=0.2516p ps=2.16u w=0.74u l=0.13u
X82 VDD.t90 DELAY_VBIASP.t9 a_20571_2470# VDD.t0 sg13_lv_pmos ad=0.3808p pd=2.92u as=0.2128p ps=1.5u w=1.12u l=0.6u
X83 a_4611_1842# a_4373_1842# a_4503_1842# VSS.t47 sg13_lv_nmos ad=0.1406p pd=1.12u as=0.2516p ps=2.16u w=0.74u l=0.2u
X84 a_13493_1842# DELAY_OUT_TAP13 VSS.t32 VSS.t104 sg13_lv_nmos ad=0.2516p pd=2.16u as=0.1406p ps=1.12u w=0.74u l=0.13u
X85 a_7413_1842# DELAY_OUT_TAP5 VDD.t26 VDD.t0 sg13_lv_pmos ad=0.3808p pd=2.92u as=0.2128p ps=1.5u w=1.12u l=0.13u
X86 VDD.t86 DELAY_VBIASP.t11 a_19051_2470# VDD.t0 sg13_lv_pmos ad=0.3808p pd=2.92u as=0.2128p ps=1.5u w=1.12u l=0.6u
X87 a_21853_1842# DELAY_OUT_TAP24 VDD.t51 VDD.t0 sg13_lv_pmos ad=0.3808p pd=2.92u as=0.2128p ps=1.5u w=1.12u l=0.13u
X88 VSS.t150 DELAY_VBIASN.t0 a_27411_1842# VSS.t149 sg13_lv_nmos ad=0.2516p pd=2.16u as=0.1406p ps=1.12u w=0.74u l=0.6u
X89 a_25131_2470# a_24893_1842# a_25023_1842# VDD.t0 sg13_lv_pmos ad=0.2128p pd=1.5u as=0.3808p ps=2.92u w=1.12u l=0.2u
X90 VSS.t26 a_15903_1842# DELAY_OUT_TAP17 VSS.t25 sg13_lv_nmos ad=0.1406p pd=1.12u as=0.2516p ps=2.16u w=0.74u l=0.13u
X91 a_24133_1842# DELAY_OUT_TAP27 VDD.t50 VDD.t0 sg13_lv_pmos ad=0.3808p pd=2.92u as=0.2128p ps=1.5u w=1.12u l=0.13u
X92 VSS.t52 DELAY_VBIASN.t23 a_9931_1842# VSS.t132 sg13_lv_nmos ad=0.2516p pd=2.16u as=0.1406p ps=1.12u w=0.74u l=0.6u
X93 VSS.t1 DELAY_VBIASN.t25 a_8411_1842# VSS.t135 sg13_lv_nmos ad=0.2516p pd=2.16u as=0.1406p ps=1.12u w=0.74u l=0.6u
X94 VSS.t36 a_19703_1842# DELAY_OUT_TAP22 VSS.t35 sg13_lv_nmos ad=0.1406p pd=1.12u as=0.2516p ps=2.16u w=0.74u l=0.13u
X95 a_16771_2470# a_16533_1842# a_16663_1842# VDD.t0 sg13_lv_pmos ad=0.2128p pd=1.5u as=0.3808p ps=2.92u w=1.12u l=0.2u
X96 VSS.t38 DELAY_VBIASN.t6 a_22851_1842# VSS.t120 sg13_lv_nmos ad=0.2516p pd=2.16u as=0.1406p ps=1.12u w=0.74u l=0.6u
X97 a_12211_1842# a_11973_1842# a_12103_1842# VSS.t33 sg13_lv_nmos ad=0.1406p pd=1.12u as=0.2516p ps=2.16u w=0.74u l=0.2u
X98 a_6131_2470# a_5893_1842# a_6023_1842# VDD.t0 sg13_lv_pmos ad=0.2128p pd=1.5u as=0.3808p ps=2.92u w=1.12u l=0.2u
X99 a_5133_1842# DELAY_OUT_TAP2 VDD.t39 VDD.t0 sg13_lv_pmos ad=0.3808p pd=2.92u as=0.2128p ps=1.5u w=1.12u l=0.13u
X100 VDD.t22 a_15143_1842# DELAY_OUT_TAP16 VDD.t0 sg13_lv_pmos ad=0.2128p pd=1.5u as=0.3808p ps=2.92u w=1.12u l=0.13u
X101 a_20571_2470# a_20333_1842# a_20463_1842# VDD.t0 sg13_lv_pmos ad=0.2128p pd=1.5u as=0.3808p ps=2.92u w=1.12u l=0.2u
X102 a_9693_1842# DELAY_OUT_TAP8 VSS.t62 VSS.t111 sg13_lv_nmos ad=0.2516p pd=2.16u as=0.1406p ps=1.12u w=0.74u l=0.13u
X103 VSS.t64 a_10583_1842# DELAY_OUT_TAP10 VSS.t63 sg13_lv_nmos ad=0.1406p pd=1.12u as=0.2516p ps=2.16u w=0.74u l=0.13u
X104 VSS.t46 DELAY_VBIASN.t31 a_3851_1842# VSS.t125 sg13_lv_nmos ad=0.2516p pd=2.16u as=0.1406p ps=1.12u w=0.74u l=0.6u
X105 VSS.t89 DELAY_VBIASN.t3 a_25131_1842# VSS.t148 sg13_lv_nmos ad=0.2516p pd=2.16u as=0.1406p ps=1.12u w=0.74u l=0.6u
X106 a_19051_2470# a_18813_1842# a_18943_1842# VDD.t0 sg13_lv_pmos ad=0.2128p pd=1.5u as=0.3808p ps=2.92u w=1.12u l=0.2u
X107 a_10453_1842# DELAY_OUT_TAP9 VDD.t24 VDD.t0 sg13_lv_pmos ad=0.3808p pd=2.92u as=0.2128p ps=1.5u w=1.12u l=0.13u
X108 a_27411_1842# a_27173_1842# a_27303_1842# VSS.t39 sg13_lv_nmos ad=0.1406p pd=1.12u as=0.2516p ps=2.16u w=0.74u l=0.2u
X109 a_15013_1842# DELAY_OUT_TAP15 VSS.t93 VSS.t92 sg13_lv_nmos ad=0.2516p pd=2.16u as=0.1406p ps=1.12u w=0.74u l=0.13u
X110 VSS.t101 a_25783_1842# DELAY_OUT_TAP30 VSS.t169 sg13_lv_nmos ad=0.1406p pd=1.12u as=0.2516p ps=2.16u w=0.74u l=0.13u
X111 VSS.t26 DELAY_VBIASN.t15 a_16011_1842# VSS.t131 sg13_lv_nmos ad=0.2516p pd=2.16u as=0.1406p ps=1.12u w=0.74u l=0.6u
X112 VDD.t63 DELAY_VBIASP.t4 a_24371_2470# VDD.t0 sg13_lv_pmos ad=0.3808p pd=2.92u as=0.2128p ps=1.5u w=1.12u l=0.6u
X113 VSS.t57 DELAY_VBIASN.t28 a_6131_1842# VSS.t134 sg13_lv_nmos ad=0.2516p pd=2.16u as=0.1406p ps=1.12u w=0.74u l=0.6u
X114 VDD.t5 VDD.t3 VDD.t4 VDD.t0 sg13_lv_pmos ad=0.3808p pd=2.92u as=0 ps=0 w=1.12u l=0.13u
X115 a_8411_1842# a_8173_1842# a_8303_1842# VSS.t2 sg13_lv_nmos ad=0.1406p pd=1.12u as=0.2516p ps=2.16u w=0.74u l=0.2u
X116 a_22851_1842# a_22613_1842# a_22743_1842# VSS.t27 sg13_lv_nmos ad=0.1406p pd=1.12u as=0.2516p ps=2.16u w=0.74u l=0.2u
X117 a_17293_1842# DELAY_OUT_TAP18 VSS.t91 VSS.t90 sg13_lv_nmos ad=0.2516p pd=2.16u as=0.1406p ps=1.12u w=0.74u l=0.13u
X118 a_25653_1842# DELAY_OUT_TAP29 VDD.t46 VDD.t0 sg13_lv_pmos ad=0.3808p pd=2.92u as=0.2128p ps=1.5u w=1.12u l=0.13u
X119 VSS.t55 a_6783_1842# DELAY_OUT_TAP5 VSS.t54 sg13_lv_nmos ad=0.1406p pd=1.12u as=0.2516p ps=2.16u w=0.74u l=0.13u
X120 a_21093_1842# DELAY_OUT_TAP23 VSS.t107 VSS.t106 sg13_lv_nmos ad=0.2516p pd=2.16u as=0.1406p ps=1.12u w=0.74u l=0.13u
X121 VSS.t75 a_17423_1842# DELAY_OUT_TAP19 VSS.t74 sg13_lv_nmos ad=0.1406p pd=1.12u as=0.2516p ps=2.16u w=0.74u l=0.13u
X122 VDD.t69 DELAY_VBIASP.t29 a_5371_2470# VDD.t0 sg13_lv_pmos ad=0.3808p pd=2.92u as=0.2128p ps=1.5u w=1.12u l=0.6u
X123 VSS.t99 a_21223_1842# DELAY_OUT_TAP24 VSS.t158 sg13_lv_nmos ad=0.1406p pd=1.12u as=0.2516p ps=2.16u w=0.74u l=0.13u
X124 VSS.t4 DELAY_VBIASN.t21 a_11451_1842# VSS.t128 sg13_lv_nmos ad=0.2516p pd=2.16u as=0.1406p ps=1.12u w=0.74u l=0.6u
X125 a_3851_1842# DELAY_IN a_3743_1842# VSS.t95 sg13_lv_nmos ad=0.1406p pd=1.12u as=0.2516p ps=2.16u w=0.74u l=0.2u
X126 a_13731_1842# a_13493_1842# a_13623_1842# VSS.t34 sg13_lv_nmos ad=0.1406p pd=1.12u as=0.2516p ps=2.16u w=0.74u l=0.2u
X127 a_12733_1842# DELAY_OUT_TAP12 VSS.t24 VSS.t108 sg13_lv_nmos ad=0.2516p pd=2.16u as=0.1406p ps=1.12u w=0.74u l=0.13u
X128 a_6653_1842# DELAY_OUT_TAP4 VDD.t27 VDD.t0 sg13_lv_pmos ad=0.3808p pd=2.92u as=0.2128p ps=1.5u w=1.12u l=0.13u
X129 VSS.t97 a_23503_1842# DELAY_OUT_TAP27 VSS.t157 sg13_lv_nmos ad=0.1406p pd=1.12u as=0.2516p ps=2.16u w=0.74u l=0.13u
X130 VDD.t78 DELAY_VBIASP.t22 a_10691_2470# VDD.t0 sg13_lv_pmos ad=0.3808p pd=2.92u as=0.2128p ps=1.5u w=1.12u l=0.6u
X131 VDD.t56 a_20463_1842# DELAY_OUT_TAP23 VDD.t0 sg13_lv_pmos ad=0.2128p pd=1.5u as=0.3808p ps=2.92u w=1.12u l=0.13u
X132 VSS.t30 DELAY_VBIASN.t1 a_26651_1842# VSS.t144 sg13_lv_nmos ad=0.2516p pd=2.16u as=0.1406p ps=1.12u w=0.74u l=0.6u
X133 a_24371_2470# a_24133_1842# a_24263_1842# VDD.t0 sg13_lv_pmos ad=0.2128p pd=1.5u as=0.3808p ps=2.92u w=1.12u l=0.2u
X134 a_11973_1842# DELAY_OUT_TAP11 VDD.t2 VDD.t0 sg13_lv_pmos ad=0.3808p pd=2.92u as=0.2128p ps=1.5u w=1.12u l=0.13u
X135 VDD.t70 DELAY_VBIASP.t19 a_12971_2470# VDD.t0 sg13_lv_pmos ad=0.3808p pd=2.92u as=0.2128p ps=1.5u w=1.12u l=0.6u
X136 VDD.t31 a_18943_1842# DELAY_OUT_TAP21 VDD.t0 sg13_lv_pmos ad=0.2128p pd=1.5u as=0.3808p ps=2.92u w=1.12u l=0.13u
X137 VSS.t81 a_4503_1842# DELAY_OUT_TAP2 VSS.t94 sg13_lv_nmos ad=0.1406p pd=1.12u as=0.2516p ps=2.16u w=0.74u l=0.13u
X138 DELAY_OUT_LAST a_27737_1842# VSS.t164 VSS.t163 sg13_lv_nmos ad=0.2516p pd=2.16u as=0.1406p ps=1.12u w=0.74u l=0.13u
X139 VDD.t20 a_22743_1842# DELAY_OUT_TAP26 VDD.t0 sg13_lv_pmos ad=0.2128p pd=1.5u as=0.3808p ps=2.92u w=1.12u l=0.13u
X140 VSS.t41 DELAY_VBIASN.t26 a_7651_1842# VSS.t121 sg13_lv_nmos ad=0.2516p pd=2.16u as=0.1406p ps=1.12u w=0.74u l=0.6u
X141 VDD.t83 DELAY_VBIASP.t2 a_25891_2470# VDD.t0 sg13_lv_pmos ad=0.3808p pd=2.92u as=0.2128p ps=1.5u w=1.12u l=0.6u
X142 a_11451_1842# a_11213_1842# a_11343_1842# VSS.t65 sg13_lv_nmos ad=0.1406p pd=1.12u as=0.2516p ps=2.16u w=0.74u l=0.2u
X143 a_5371_2470# a_5133_1842# a_5263_1842# VDD.t0 sg13_lv_pmos ad=0.2128p pd=1.5u as=0.3808p ps=2.92u w=1.12u l=0.2u
X144 a_14253_1842# DELAY_OUT_TAP14 VDD.t95 VDD.t0 sg13_lv_pmos ad=0.3808p pd=2.92u as=0.2128p ps=1.5u w=1.12u l=0.13u
X145 a_9931_1842# a_9693_1842# a_9823_1842# VSS.t102 sg13_lv_nmos ad=0.1406p pd=1.12u as=0.2516p ps=2.16u w=0.74u l=0.2u
X146 a_18813_1842# DELAY_OUT_TAP20 VSS.t72 VSS.t85 sg13_lv_nmos ad=0.2516p pd=2.16u as=0.1406p ps=1.12u w=0.74u l=0.13u
X147 a_8933_1842# DELAY_OUT_TAP7 VSS.t1 VSS.t112 sg13_lv_nmos ad=0.2516p pd=2.16u as=0.1406p ps=1.12u w=0.74u l=0.13u
X148 a_22613_1842# DELAY_OUT_TAP25 VSS.t20 VSS.t77 sg13_lv_nmos ad=0.2516p pd=2.16u as=0.1406p ps=1.12u w=0.74u l=0.13u
X149 VSS.t52 a_9823_1842# DELAY_OUT_TAP9 VSS.t51 sg13_lv_nmos ad=0.1406p pd=1.12u as=0.2516p ps=2.16u w=0.74u l=0.13u
X150 VDD.t23 a_3743_1842# DELAY_OUT_TAP1 VDD.t0 sg13_lv_pmos ad=0.2128p pd=1.5u as=0.3808p ps=2.92u w=1.12u l=0.13u
X151 VDD.t67 DELAY_VBIASP.t27 a_6891_2470# VDD.t0 sg13_lv_pmos ad=0.3808p pd=2.92u as=0.2128p ps=1.5u w=1.12u l=0.6u
X152 a_10691_2470# a_10453_1842# a_10583_1842# VDD.t0 sg13_lv_pmos ad=0.2128p pd=1.5u as=0.3808p ps=2.92u w=1.12u l=0.2u
X153 a_26651_1842# a_26413_1842# a_26543_1842# VSS.t165 sg13_lv_nmos ad=0.1406p pd=1.12u as=0.2516p ps=2.16u w=0.74u l=0.2u
X154 VSS.t44 DELAY_VBIASN.t16 a_15251_1842# VSS.t137 sg13_lv_nmos ad=0.2516p pd=2.16u as=0.1406p ps=1.12u w=0.74u l=0.6u
X155 VDD.t75 DELAY_VBIASP.t24 a_9171_2470# VDD.t0 sg13_lv_pmos ad=0.3808p pd=2.92u as=0.2128p ps=1.5u w=1.12u l=0.6u
X156 VSS.t89 a_25023_1842# DELAY_OUT_TAP29 VSS.t161 sg13_lv_nmos ad=0.1406p pd=1.12u as=0.2516p ps=2.16u w=0.74u l=0.13u
X157 a_17531_1842# a_17293_1842# a_17423_1842# VSS.t113 sg13_lv_nmos ad=0.1406p pd=1.12u as=0.2516p ps=2.16u w=0.74u l=0.2u
X158 a_7651_1842# a_7413_1842# a_7543_1842# VSS.t60 sg13_lv_nmos ad=0.1406p pd=1.12u as=0.2516p ps=2.16u w=0.74u l=0.2u
X159 a_21331_1842# a_21093_1842# a_21223_1842# VSS.t152 sg13_lv_nmos ad=0.1406p pd=1.12u as=0.2516p ps=2.16u w=0.74u l=0.2u
X160 a_16533_1842# DELAY_OUT_TAP17 VSS.t26 VSS.t86 sg13_lv_nmos ad=0.2516p pd=2.16u as=0.1406p ps=1.12u w=0.74u l=0.13u
X161 a_25891_2470# a_25653_1842# a_25783_1842# VDD.t0 sg13_lv_pmos ad=0.2128p pd=1.5u as=0.3808p ps=2.92u w=1.12u l=0.2u
X162 VSS.t57 a_6023_1842# DELAY_OUT_TAP4 VSS.t56 sg13_lv_nmos ad=0.1406p pd=1.12u as=0.2516p ps=2.16u w=0.74u l=0.13u
X163 a_20333_1842# DELAY_OUT_TAP22 VSS.t36 VSS.t53 sg13_lv_nmos ad=0.2516p pd=2.16u as=0.1406p ps=1.12u w=0.74u l=0.13u
X164 VDD.t66 DELAY_VBIASP.t17 a_14491_2470# VDD.t0 sg13_lv_pmos ad=0.3808p pd=2.92u as=0.2128p ps=1.5u w=1.12u l=0.6u
X165 VDD.t32 a_24263_1842# DELAY_OUT_TAP28 VDD.t0 sg13_lv_pmos ad=0.2128p pd=1.5u as=0.3808p ps=2.92u w=1.12u l=0.13u
X166 a_6891_2470# a_6653_1842# a_6783_1842# VDD.t0 sg13_lv_pmos ad=0.2128p pd=1.5u as=0.3808p ps=2.92u w=1.12u l=0.2u
X167 a_15773_1842# DELAY_OUT_TAP16 VDD.t22 VDD.t0 sg13_lv_pmos ad=0.3808p pd=2.92u as=0.2128p ps=1.5u w=1.12u l=0.13u
X168 VDD.t10 VDD.t8 VDD.t9 VDD.t0 sg13_lv_pmos ad=0.3808p pd=2.92u as=0 ps=0 w=1.12u l=0.6u
X169 a_12971_1842# a_12733_1842# a_12863_1842# VSS.t42 sg13_lv_nmos ad=0.1406p pd=1.12u as=0.2516p ps=2.16u w=0.74u l=0.2u
X170 a_11213_1842# DELAY_OUT_TAP10 VSS.t64 VSS.t114 sg13_lv_nmos ad=0.2516p pd=2.16u as=0.1406p ps=1.12u w=0.74u l=0.13u
X171 VDD.t17 a_26543_1842# DELAY_OUT_TAP31 VDD.t0 sg13_lv_pmos ad=0.2128p pd=1.5u as=0.3808p ps=2.92u w=1.12u l=0.13u
X172 VSS.t4 a_11343_1842# DELAY_OUT_TAP11 VSS.t3 sg13_lv_nmos ad=0.1406p pd=1.12u as=0.2516p ps=2.16u w=0.74u l=0.13u
X173 VDD.t28 a_5263_1842# DELAY_OUT_TAP3 VDD.t0 sg13_lv_pmos ad=0.2128p pd=1.5u as=0.3808p ps=2.92u w=1.12u l=0.13u
X174 a_15251_1842# a_15013_1842# a_15143_1842# VSS.t173 sg13_lv_nmos ad=0.1406p pd=1.12u as=0.2516p ps=2.16u w=0.74u l=0.2u
X175 a_9171_2470# a_8933_1842# a_9063_1842# VDD.t0 sg13_lv_pmos ad=0.2128p pd=1.5u as=0.3808p ps=2.92u w=1.12u l=0.2u
X176 a_18053_1842# DELAY_OUT_TAP19 VDD.t34 VDD.t0 sg13_lv_pmos ad=0.3808p pd=2.92u as=0.2128p ps=1.5u w=1.12u l=0.13u
X177 VSS.t116 a_13623_1842# DELAY_OUT_TAP14 VSS.t172 sg13_lv_nmos ad=0.1406p pd=1.12u as=0.2516p ps=2.16u w=0.74u l=0.13u
X178 VDD.t21 a_7543_1842# DELAY_OUT_TAP6 VDD.t0 sg13_lv_pmos ad=0.2128p pd=1.5u as=0.3808p ps=2.92u w=1.12u l=0.13u
X179 a_26413_1842# DELAY_OUT_TAP30 VSS.t101 VSS.t100 sg13_lv_nmos ad=0.2516p pd=2.16u as=0.1406p ps=1.12u w=0.74u l=0.13u
X180 VSS.t91 DELAY_VBIASN.t14 a_16771_1842# VSS.t127 sg13_lv_nmos ad=0.2516p pd=2.16u as=0.1406p ps=1.12u w=0.74u l=0.6u
X181 a_14491_2470# a_14253_1842# a_14383_1842# VDD.t0 sg13_lv_pmos ad=0.2128p pd=1.5u as=0.3808p ps=2.92u w=1.12u l=0.2u
X182 VSS.t107 DELAY_VBIASN.t9 a_20571_1842# VSS.t141 sg13_lv_nmos ad=0.2516p pd=2.16u as=0.1406p ps=1.12u w=0.74u l=0.6u
X183 VDD.t5 VDD.t6 VDD.t7 VDD.t0 sg13_lv_pmos ad=0.2128p pd=1.5u as=0 ps=0 w=1.12u l=0.13u
X184 VDD.t18 a_12863_1842# DELAY_OUT_TAP13 VDD.t0 sg13_lv_pmos ad=0.2128p pd=1.5u as=0.3808p ps=2.92u w=1.12u l=0.13u
X185 a_7413_1842# DELAY_OUT_TAP5 VSS.t55 VSS.t76 sg13_lv_nmos ad=0.2516p pd=2.16u as=0.1406p ps=1.12u w=0.74u l=0.13u
X186 a_21853_1842# DELAY_OUT_TAP24 VSS.t99 VSS.t98 sg13_lv_nmos ad=0.2516p pd=2.16u as=0.1406p ps=1.12u w=0.74u l=0.13u
X187 VSS.t67 DELAY_VBIASN.t11 a_19051_1842# VSS.t138 sg13_lv_nmos ad=0.2516p pd=2.16u as=0.1406p ps=1.12u w=0.74u l=0.6u
X188 a_25131_1842# a_24893_1842# a_25023_1842# VSS.t159 sg13_lv_nmos ad=0.1406p pd=1.12u as=0.2516p ps=2.16u w=0.74u l=0.2u
X189 VDD.t87 DELAY_VBIASP.t12 a_18291_2470# VDD.t0 sg13_lv_pmos ad=0.3808p pd=2.92u as=0.2128p ps=1.5u w=1.12u l=0.6u
X190 a_24133_1842# DELAY_OUT_TAP27 VSS.t97 VSS.t96 sg13_lv_nmos ad=0.2516p pd=2.16u as=0.1406p ps=1.12u w=0.74u l=0.13u
X191 VDD.t91 DELAY_VBIASP.t7 a_22091_2470# VDD.t0 sg13_lv_pmos ad=0.3808p pd=2.92u as=0.2128p ps=1.5u w=1.12u l=0.6u
X192 a_16771_1842# a_16533_1842# a_16663_1842# VSS.t151 sg13_lv_nmos ad=0.1406p pd=1.12u as=0.2516p ps=2.16u w=0.74u l=0.2u
X193 a_19573_1842# DELAY_OUT_TAP21 VDD.t31 VDD.t0 sg13_lv_pmos ad=0.3808p pd=2.92u as=0.2128p ps=1.5u w=1.12u l=0.13u
X194 a_6131_1842# a_5893_1842# a_6023_1842# VSS.t49 sg13_lv_nmos ad=0.1406p pd=1.12u as=0.2516p ps=2.16u w=0.74u l=0.2u
X195 a_20571_1842# a_20333_1842# a_20463_1842# VSS.t155 sg13_lv_nmos ad=0.1406p pd=1.12u as=0.2516p ps=2.16u w=0.74u l=0.2u
X196 a_23373_1842# DELAY_OUT_TAP26 VDD.t20 VDD.t0 sg13_lv_pmos ad=0.3808p pd=2.92u as=0.2128p ps=1.5u w=1.12u l=0.13u
X197 a_5133_1842# DELAY_OUT_TAP2 VSS.t81 VSS.t80 sg13_lv_nmos ad=0.2516p pd=2.16u as=0.1406p ps=1.12u w=0.74u l=0.13u
X198 VSS.t44 a_15143_1842# DELAY_OUT_TAP16 VSS.t43 sg13_lv_nmos ad=0.1406p pd=1.12u as=0.2516p ps=2.16u w=0.74u l=0.13u
X199 VDD.t29 a_9063_1842# DELAY_OUT_TAP8 VDD.t0 sg13_lv_pmos ad=0.2128p pd=1.5u as=0.3808p ps=2.92u w=1.12u l=0.13u
X200 VDD.t79 DELAY_VBIASP.t18 a_13731_2470# VDD.t0 sg13_lv_pmos ad=0.3808p pd=2.92u as=0.2128p ps=1.5u w=1.12u l=0.6u
X201 a_19051_1842# a_18813_1842# a_18943_1842# VSS.t70 sg13_lv_nmos ad=0.1406p pd=1.12u as=0.2516p ps=2.16u w=0.74u l=0.2u
X202 a_16011_2470# a_15773_1842# a_15903_1842# VDD.t0 sg13_lv_pmos ad=0.2128p pd=1.5u as=0.3808p ps=2.92u w=1.12u l=0.2u
X203 a_10453_1842# DELAY_OUT_TAP9 VSS.t52 VSS.t110 sg13_lv_nmos ad=0.2516p pd=2.16u as=0.1406p ps=1.12u w=0.74u l=0.13u
X204 a_4373_1842# DELAY_OUT_TAP1 VDD.t23 VDD.t0 sg13_lv_pmos ad=0.3808p pd=2.92u as=0.2128p ps=1.5u w=1.12u l=0.13u
X205 VDD.t48 a_14383_1842# DELAY_OUT_TAP15 VDD.t0 sg13_lv_pmos ad=0.2128p pd=1.5u as=0.3808p ps=2.92u w=1.12u l=0.13u
X206 VSS.t69 DELAY_VBIASN.t4 a_24371_1842# VSS.t145 sg13_lv_nmos ad=0.2516p pd=2.16u as=0.1406p ps=1.12u w=0.74u l=0.6u
X207 a_18291_2470# a_18053_1842# a_18183_1842# VDD.t0 sg13_lv_pmos ad=0.2128p pd=1.5u as=0.3808p ps=2.92u w=1.12u l=0.2u
X208 a_22091_2470# a_21853_1842# a_21983_1842# VDD.t0 sg13_lv_pmos ad=0.2128p pd=1.5u as=0.3808p ps=2.92u w=1.12u l=0.2u
X209 VSS.t8 VSS.t5 VSS.t7 VSS.t6 sg13_lv_nmos ad=0.2516p pd=2.16u as=0 ps=0 w=0.74u l=0.13u
X210 VDD.t47 a_16663_1842# DELAY_OUT_TAP18 VDD.t0 sg13_lv_pmos ad=0.2128p pd=1.5u as=0.3808p ps=2.92u w=1.12u l=0.13u
X211 VDD.t89 DELAY_VBIASP.t10 a_19811_2470# VDD.t0 sg13_lv_pmos ad=0.3808p pd=2.92u as=0.2128p ps=1.5u w=1.12u l=0.6u
X212 a_25653_1842# DELAY_OUT_TAP29 VSS.t89 VSS.t88 sg13_lv_nmos ad=0.2516p pd=2.16u as=0.1406p ps=1.12u w=0.74u l=0.13u
X213 VSS.t59 DELAY_VBIASN.t29 a_5371_1842# VSS.t124 sg13_lv_nmos ad=0.2516p pd=2.16u as=0.1406p ps=1.12u w=0.74u l=0.6u
X214 VDD.t64 DELAY_VBIASP.t5 a_23611_2470# VDD.t0 sg13_lv_pmos ad=0.3808p pd=2.92u as=0.2128p ps=1.5u w=1.12u l=0.6u
X215 VDD.t15 a_12103_1842# DELAY_OUT_TAP12 VDD.t0 sg13_lv_pmos ad=0.2128p pd=1.5u as=0.3808p ps=2.92u w=1.12u l=0.13u
X216 a_24893_1842# DELAY_OUT_TAP28 VDD.t32 VDD.t0 sg13_lv_pmos ad=0.3808p pd=2.92u as=0.2128p ps=1.5u w=1.12u l=0.13u
X217 a_6653_1842# DELAY_OUT_TAP4 VSS.t57 VSS.t78 sg13_lv_nmos ad=0.2516p pd=2.16u as=0.1406p ps=1.12u w=0.74u l=0.13u
X218 VSS.t107 a_20463_1842# DELAY_OUT_TAP23 VSS.t156 sg13_lv_nmos ad=0.1406p pd=1.12u as=0.2516p ps=2.16u w=0.74u l=0.13u
X219 VSS.t64 DELAY_VBIASN.t22 a_10691_1842# VSS.t118 sg13_lv_nmos ad=0.2516p pd=2.16u as=0.1406p ps=1.12u w=0.74u l=0.6u
X220 VDD.t72 DELAY_VBIASP.t30 a_4611_2470# VDD.t0 sg13_lv_pmos ad=0.3808p pd=2.92u as=0.2128p ps=1.5u w=1.12u l=0.6u
X221 a_24371_1842# a_24133_1842# a_24263_1842# VSS.t167 sg13_lv_nmos ad=0.1406p pd=1.12u as=0.2516p ps=2.16u w=0.74u l=0.2u
X222 VSS.t67 a_18943_1842# DELAY_OUT_TAP21 VSS.t66 sg13_lv_nmos ad=0.1406p pd=1.12u as=0.2516p ps=2.16u w=0.74u l=0.13u
X223 a_11973_1842# DELAY_OUT_TAP11 VSS.t4 VSS.t109 sg13_lv_nmos ad=0.2516p pd=2.16u as=0.1406p ps=1.12u w=0.74u l=0.13u
X224 a_5893_1842# DELAY_OUT_TAP3 VDD.t28 VDD.t0 sg13_lv_pmos ad=0.3808p pd=2.92u as=0.2128p ps=1.5u w=1.12u l=0.13u
X225 VDD.t82 DELAY_VBIASP.t13 a_17531_2470# VDD.t0 sg13_lv_pmos ad=0.3808p pd=2.92u as=0.2128p ps=1.5u w=1.12u l=0.6u
X226 a_27173_1842# DELAY_OUT_TAP31 VDD.t17 VDD.t0 sg13_lv_pmos ad=0.3808p pd=2.92u as=0.2128p ps=1.5u w=1.12u l=0.13u
X227 VSS.t32 DELAY_VBIASN.t19 a_12971_1842# VSS.t129 sg13_lv_nmos ad=0.2516p pd=2.16u as=0.1406p ps=1.12u w=0.74u l=0.6u
X228 VDD.t103 a_27303_1842# a_27737_1842# VDD.t0 sg13_lv_pmos ad=0.2128p pd=1.5u as=0.3808p ps=2.92u w=1.12u l=0.13u
X229 VSS.t101 DELAY_VBIASN.t2 a_25891_1842# VSS.t146 sg13_lv_nmos ad=0.2516p pd=2.16u as=0.1406p ps=1.12u w=0.74u l=0.6u
X230 VSS.t38 a_22743_1842# DELAY_OUT_TAP26 VSS.t37 sg13_lv_nmos ad=0.1406p pd=1.12u as=0.2516p ps=2.16u w=0.74u l=0.13u
X231 a_19811_2470# a_19573_1842# a_19703_1842# VDD.t0 sg13_lv_pmos ad=0.2128p pd=1.5u as=0.3808p ps=2.92u w=1.12u l=0.2u
X232 VDD.t88 DELAY_VBIASP.t8 a_21331_2470# VDD.t0 sg13_lv_pmos ad=0.3808p pd=2.92u as=0.2128p ps=1.5u w=1.12u l=0.6u
X233 VDD.t13 VDD.t11 VDD.t10 VDD.t0 sg13_lv_pmos ad=0.2128p pd=1.5u as=0 ps=0 w=1.12u l=0.2u
X234 a_5371_1842# a_5133_1842# a_5263_1842# VSS.t50 sg13_lv_nmos ad=0.1406p pd=1.12u as=0.2516p ps=2.16u w=0.74u l=0.2u
X235 a_14253_1842# DELAY_OUT_TAP14 VSS.t116 VSS.t115 sg13_lv_nmos ad=0.2516p pd=2.16u as=0.1406p ps=1.12u w=0.74u l=0.13u
X236 a_8173_1842# DELAY_OUT_TAP6 VDD.t21 VDD.t0 sg13_lv_pmos ad=0.3808p pd=2.92u as=0.2128p ps=1.5u w=1.12u l=0.13u
X237 VDD.t33 a_18183_1842# DELAY_OUT_TAP20 VDD.t0 sg13_lv_pmos ad=0.2128p pd=1.5u as=0.3808p ps=2.92u w=1.12u l=0.13u
X238 a_23611_2470# a_23373_1842# a_23503_1842# VDD.t0 sg13_lv_pmos ad=0.2128p pd=1.5u as=0.3808p ps=2.92u w=1.12u l=0.2u
X239 VSS.t46 a_3743_1842# DELAY_OUT_TAP1 VSS.t45 sg13_lv_nmos ad=0.1406p pd=1.12u as=0.2516p ps=2.16u w=0.74u l=0.13u
X240 VDD.t1 a_8303_1842# DELAY_OUT_TAP7 VDD.t0 sg13_lv_pmos ad=0.2128p pd=1.5u as=0.3808p ps=2.92u w=1.12u l=0.13u
X241 VDD.t71 DELAY_VBIASP.t20 a_12211_2470# VDD.t0 sg13_lv_pmos ad=0.3808p pd=2.92u as=0.2128p ps=1.5u w=1.12u l=0.6u
X242 VDD.t14 a_21983_1842# DELAY_OUT_TAP25 VDD.t0 sg13_lv_pmos ad=0.2128p pd=1.5u as=0.3808p ps=2.92u w=1.12u l=0.13u
X243 VSS.t55 DELAY_VBIASN.t27 a_6891_1842# VSS.t133 sg13_lv_nmos ad=0.2516p pd=2.16u as=0.1406p ps=1.12u w=0.74u l=0.6u
X244 a_4611_2470# a_4373_1842# a_4503_1842# VDD.t0 sg13_lv_pmos ad=0.2128p pd=1.5u as=0.3808p ps=2.92u w=1.12u l=0.2u
X245 a_13493_1842# DELAY_OUT_TAP13 VDD.t18 VDD.t0 sg13_lv_pmos ad=0.3808p pd=2.92u as=0.2128p ps=1.5u w=1.12u l=0.13u
X246 a_10691_1842# a_10453_1842# a_10583_1842# VSS.t22 sg13_lv_nmos ad=0.1406p pd=1.12u as=0.2516p ps=2.16u w=0.74u l=0.2u
X247 VDD.t81 DELAY_VBIASP.t0 a_27411_2470# VDD.t0 sg13_lv_pmos ad=0.3808p pd=2.92u as=0.2128p ps=1.5u w=1.12u l=0.6u
X248 VSS.t62 DELAY_VBIASN.t24 a_9171_1842# VSS.t136 sg13_lv_nmos ad=0.2516p pd=2.16u as=0.1406p ps=1.12u w=0.74u l=0.6u
X249 a_25891_1842# a_25653_1842# a_25783_1842# VSS.t28 sg13_lv_nmos ad=0.1406p pd=1.12u as=0.2516p ps=2.16u w=0.74u l=0.2u
X250 VDD.t76 DELAY_VBIASP.t23 a_9931_2470# VDD.t0 sg13_lv_pmos ad=0.3808p pd=2.92u as=0.2128p ps=1.5u w=1.12u l=0.6u
X251 VDD.t16 a_15903_1842# DELAY_OUT_TAP17 VDD.t0 sg13_lv_pmos ad=0.2128p pd=1.5u as=0.3808p ps=2.92u w=1.12u l=0.13u
X252 VSS.t93 DELAY_VBIASN.t17 a_14491_1842# VSS.t119 sg13_lv_nmos ad=0.2516p pd=2.16u as=0.1406p ps=1.12u w=0.74u l=0.6u
X253 VDD.t74 DELAY_VBIASP.t25 a_8411_2470# VDD.t0 sg13_lv_pmos ad=0.3808p pd=2.92u as=0.2128p ps=1.5u w=1.12u l=0.6u
X254 VDD.t19 a_19703_1842# DELAY_OUT_TAP22 VDD.t0 sg13_lv_pmos ad=0.2128p pd=1.5u as=0.3808p ps=2.92u w=1.12u l=0.13u
X255 VSS.t69 a_24263_1842# DELAY_OUT_TAP28 VSS.t153 sg13_lv_nmos ad=0.1406p pd=1.12u as=0.2516p ps=2.16u w=0.74u l=0.13u
X256 a_12211_2470# a_11973_1842# a_12103_1842# VDD.t0 sg13_lv_pmos ad=0.2128p pd=1.5u as=0.3808p ps=2.92u w=1.12u l=0.2u
X257 VDD.t84 DELAY_VBIASP.t6 a_22851_2470# VDD.t0 sg13_lv_pmos ad=0.3808p pd=2.92u as=0.2128p ps=1.5u w=1.12u l=0.6u
X258 a_6891_1842# a_6653_1842# a_6783_1842# VSS.t48 sg13_lv_nmos ad=0.1406p pd=1.12u as=0.2516p ps=2.16u w=0.74u l=0.2u
X259 VSS.t15 VSS.t12 VSS.t14 VSS.t13 sg13_lv_nmos ad=0.2516p pd=2.16u as=0 ps=0 w=0.74u l=0.6u
X260 a_15773_1842# DELAY_OUT_TAP16 VSS.t44 VSS.t84 sg13_lv_nmos ad=0.2516p pd=2.16u as=0.1406p ps=1.12u w=0.74u l=0.13u
X261 a_9693_1842# DELAY_OUT_TAP8 VDD.t29 VDD.t0 sg13_lv_pmos ad=0.3808p pd=2.92u as=0.2128p ps=1.5u w=1.12u l=0.13u
X262 VDD.t30 a_10583_1842# DELAY_OUT_TAP10 VDD.t0 sg13_lv_pmos ad=0.2128p pd=1.5u as=0.3808p ps=2.92u w=1.12u l=0.13u
X263 VSS.t30 a_26543_1842# DELAY_OUT_TAP31 VSS.t29 sg13_lv_nmos ad=0.1406p pd=1.12u as=0.2516p ps=2.16u w=0.74u l=0.13u
C0 a_14253_1842# DELAY_VBIASP 0.11222f
C1 a_22613_1842# VDD 0.4916f
C2 a_14253_1842# DELAY_OUT_TAP14 0.70708f
C3 DELAY_VBIASN a_9693_1842# 0.10601f
C4 VDD DELAY_OUT_TAP12 0.72899f
C5 a_23373_1842# DELAY_OUT_TAP27 0.0114f
C6 a_24263_1842# DELAY_VBIASP 0.06627f
C7 a_20333_1842# DELAY_OUT_TAP22 0.70708f
C8 DELAY_VBIASN a_7413_1842# 0.10601f
C9 VDD DELAY_OUT_TAP10 0.72899f
C10 a_7651_2470# a_7543_1842# 0.01697f
C11 a_13731_2470# a_13623_1842# 0.01697f
C12 VDD a_12863_1842# 0.49633f
C13 a_25023_1842# DELAY_OUT_TAP29 0.69646f
C14 DELAY_VBIASN a_27173_1842# 0.10602f
C15 a_21983_1842# a_22091_1842# 0.01163f
C16 a_27737_1842# DELAY_VBIASP 0.04001f
C17 DELAY_VBIASN DELAY_OUT_TAP11 0.04353f
C18 a_5263_1842# DELAY_OUT_TAP3 0.69646f
C19 a_6783_1842# a_6891_1842# 0.01163f
C20 VDD DELAY_OUT_TAP23 0.72899f
C21 a_9063_1842# DELAY_VBIASN 0.07258f
C22 a_18053_1842# DELAY_VBIASN 0.10601f
C23 a_21223_1842# a_21331_1842# 0.01163f
C24 a_18183_1842# DELAY_VBIASP 0.06627f
C25 a_10583_1842# DELAY_OUT_TAP10 0.69646f
C26 a_17531_2470# a_17423_1842# 0.01697f
C27 VDD DELAY_OUT_TAP4 0.72899f
C28 DELAY_OUT_TAP31 a_26543_1842# 0.69646f
C29 a_24893_1842# VDD 0.4916f
C30 a_24133_1842# DELAY_OUT_TAP27 0.70708f
C31 VDD DELAY_OUT_TAP31 0.72899f
C32 DELAY_VBIASP DELAY_OUT_TAP2 0.04137f
C33 DELAY_OUT_TAP12 a_12733_1842# 0.70708f
C34 a_12103_1842# DELAY_VBIASP 0.06627f
C35 a_15773_1842# a_15903_1842# 0.70845f
C36 a_5893_1842# DELAY_VBIASN 0.10601f
C37 DELAY_OUT_TAP8 DELAY_VBIASP 0.04137f
C38 DELAY_VBIASN DELAY_OUT_TAP5 0.04353f
C39 a_5133_1842# DELAY_VBIASN 0.10601f
C40 a_19703_1842# VDD 0.49633f
C41 a_6023_1842# a_6131_2470# 0.01697f
C42 DELAY_OUT_TAP20 DELAY_VBIASP 0.04137f
C43 a_12733_1842# a_12863_1842# 0.70845f
C44 a_20333_1842# DELAY_VBIASN 0.10601f
C45 a_20463_1842# DELAY_VBIASP 0.06627f
C46 DELAY_OUT_TAP24 a_21853_1842# 0.70708f
C47 VDD a_26543_1842# 0.49633f
C48 a_24371_2470# VDD 0.01806f
C49 a_11343_1842# DELAY_OUT_TAP11 0.69646f
C50 a_6653_1842# DELAY_OUT_TAP5 0.0114f
C51 a_23373_1842# DELAY_VBIASP 0.11222f
C52 a_24133_1842# DELAY_OUT_TAP28 0.0114f
C53 DELAY_OUT_TAP9 a_9693_1842# 0.0114f
C54 VDD DELAY_OUT_TAP7 0.72899f
C55 DELAY_OUT_TAP20 a_18813_1842# 0.70708f
C56 a_15143_1842# VDD 0.49633f
C57 a_8303_1842# VDD 0.49633f
C58 DELAY_VBIASN a_13493_1842# 0.10601f
C59 DELAY_VBIASP a_13623_1842# 0.06627f
C60 a_8303_1842# DELAY_OUT_TAP7 0.69646f
C61 DELAY_OUT_TAP30 DELAY_VBIASP 0.04137f
C62 VDD a_21223_1842# 0.49633f
C63 DELAY_OUT_TAP14 a_13623_1842# 0.69646f
C64 a_4503_1842# a_4611_1842# 0.01163f
C65 a_25023_1842# a_25131_2470# 0.01697f
C66 a_10583_1842# VDD 0.49633f
C67 a_27303_1842# DELAY_VBIASN 0.07259f
C68 DELAY_VBIASP DELAY_OUT_TAP29 0.04137f
C69 a_25783_1842# a_25891_2470# 0.01697f
C70 a_23373_1842# DELAY_OUT_TAP26 0.70708f
C71 a_24133_1842# DELAY_VBIASP 0.11222f
C72 a_6131_1842# a_6023_1842# 0.01163f
C73 a_3743_1842# DELAY_IN 0.53924f
C74 a_22613_1842# DELAY_VBIASN 0.10601f
C75 a_19703_1842# DELAY_OUT_TAP22 0.69646f
C76 a_5263_1842# a_5371_1842# 0.01163f
C77 a_22743_1842# DELAY_VBIASP 0.06627f
C78 DELAY_VBIASN DELAY_OUT_TAP12 0.04353f
C79 DELAY_VBIASP DELAY_OUT_TAP13 0.04137f
C80 VDD a_12733_1842# 0.4916f
C81 a_5893_1842# DELAY_OUT_TAP3 0.70708f
C82 a_17293_1842# a_17423_1842# 0.70845f
C83 DELAY_VBIASN DELAY_OUT_TAP10 0.04353f
C84 a_5133_1842# DELAY_OUT_TAP3 0.0114f
C85 DELAY_VBIASP DELAY_OUT_TAP6 0.04137f
C86 a_17423_1842# DELAY_VBIASP 0.06627f
C87 VDD DELAY_OUT_TAP22 0.72899f
C88 DELAY_VBIASN a_12863_1842# 0.07258f
C89 a_8933_1842# a_9063_1842# 0.70845f
C90 a_10453_1842# DELAY_OUT_TAP10 0.0114f
C91 a_19573_1842# a_19703_1842# 0.70845f
C92 DELAY_OUT_TAP31 a_26413_1842# 0.0114f
C93 DELAY_OUT_TAP15 DELAY_VBIASP 0.04137f
C94 DELAY_VBIASN DELAY_OUT_TAP23 0.04353f
C95 VDD DELAY_OUT_TAP19 0.72899f
C96 a_22743_1842# DELAY_OUT_TAP26 0.69646f
C97 a_3743_1842# DELAY_OUT_TAP1 0.69646f
C98 a_24371_1842# a_24263_1842# 0.01163f
C99 a_21093_1842# DELAY_OUT_TAP23 0.70708f
C100 a_9931_2470# a_9823_1842# 0.01697f
C101 a_11973_1842# DELAY_VBIASP 0.11222f
C102 DELAY_VBIASN DELAY_OUT_TAP4 0.04353f
C103 a_24893_1842# DELAY_VBIASN 0.10601f
C104 a_25023_1842# DELAY_VBIASP 0.06627f
C105 DELAY_OUT_TAP31 DELAY_VBIASN 0.04353f
C106 a_3743_1842# DELAY_VBIASP 0.05992f
C107 a_19573_1842# VDD 0.4916f
C108 a_18943_1842# DELAY_VBIASP 0.06627f
C109 a_7543_1842# DELAY_OUT_TAP6 0.69646f
C110 a_26413_1842# a_26543_1842# 0.70845f
C111 DELAY_VBIASP DELAY_OUT_TAP27 0.04137f
C112 a_19703_1842# DELAY_VBIASN 0.07258f
C113 VDD a_26413_1842# 0.4916f
C114 a_27173_1842# a_27737_1842# 0.0114f
C115 a_12103_1842# a_12211_1842# 0.01163f
C116 a_6653_1842# DELAY_OUT_TAP4 0.70708f
C117 VDD a_21983_1842# 0.49633f
C118 DELAY_IN DELAY_OUT_TAP1 0.01139f
C119 DELAY_OUT_TAP8 a_9693_1842# 0.70708f
C120 a_18183_1842# a_18291_1842# 0.01163f
C121 a_18813_1842# a_18943_1842# 0.70845f
C122 DELAY_VBIASN a_26543_1842# 0.07258f
C123 a_17293_1842# DELAY_OUT_TAP18 0.70708f
C124 a_15013_1842# VDD 0.4916f
C125 a_8173_1842# VDD 0.4916f
C126 VDD DELAY_VBIASN 0.85759f
C127 DELAY_IN DELAY_VBIASP 0.0738f
C128 a_8173_1842# DELAY_OUT_TAP7 0.0114f
C129 a_16663_1842# VDD 0.49633f
C130 a_25023_1842# a_25131_1842# 0.01163f
C131 DELAY_VBIASP DELAY_OUT_TAP18 0.04137f
C132 DELAY_VBIASN DELAY_OUT_TAP7 0.04353f
C133 VDD a_21093_1842# 0.4916f
C134 a_8411_2470# VDD 0.01806f
C135 a_8173_1842# a_8303_1842# 0.70845f
C136 a_15013_1842# a_15143_1842# 0.70845f
C137 a_15143_1842# DELAY_VBIASN 0.07258f
C138 a_8303_1842# DELAY_VBIASN 0.07258f
C139 a_25783_1842# VDD 0.49633f
C140 a_18053_1842# a_18183_1842# 0.70845f
C141 a_8303_1842# a_8411_2470# 0.01697f
C142 a_10453_1842# VDD 0.4916f
C143 DELAY_VBIASN a_21223_1842# 0.07258f
C144 DELAY_VBIASP DELAY_OUT_TAP28 0.04137f
C145 a_21093_1842# a_21223_1842# 0.70845f
C146 VDD a_14383_1842# 0.49633f
C147 a_19573_1842# DELAY_OUT_TAP22 0.0114f
C148 a_9063_1842# DELAY_OUT_TAP8 0.69646f
C149 a_6653_1842# VDD 0.4916f
C150 a_10583_1842# DELAY_VBIASN 0.07258f
C151 a_22743_1842# a_22851_2470# 0.01697f
C152 a_9063_1842# a_9171_1842# 0.01163f
C153 a_22613_1842# DELAY_OUT_TAP25 0.70708f
C154 a_18053_1842# DELAY_OUT_TAP20 0.0114f
C155 a_5133_1842# DELAY_OUT_TAP2 0.70708f
C156 DELAY_VBIASP DELAY_OUT_TAP1 0.04137f
C157 a_13731_1842# a_13623_1842# 0.01163f
C158 a_17293_1842# DELAY_VBIASP 0.11222f
C159 a_10453_1842# a_10583_1842# 0.70845f
C160 a_5371_2470# a_5263_1842# 0.01697f
C161 DELAY_VBIASN a_12733_1842# 0.10601f
C162 VDD a_11343_1842# 0.49633f
C163 DELAY_OUT_TAP14 DELAY_VBIASP 0.04137f
C164 DELAY_VBIASN DELAY_OUT_TAP22 0.04353f
C165 VDD a_4503_1842# 0.49633f
C166 DELAY_OUT_TAP17 DELAY_VBIASP 0.04137f
C167 a_27303_1842# a_27737_1842# 0.69646f
C168 DELAY_VBIASN DELAY_OUT_TAP19 0.04353f
C169 a_18813_1842# DELAY_VBIASP 0.11222f
C170 VDD a_4373_1842# 0.4916f
C171 VDD DELAY_OUT_TAP3 0.72899f
C172 a_7413_1842# DELAY_OUT_TAP6 0.0114f
C173 a_20333_1842# a_20463_1842# 0.70845f
C174 DELAY_VBIASP a_9823_1842# 0.06627f
C175 DELAY_OUT_TAP9 VDD 0.72899f
C176 DELAY_VBIASP DELAY_OUT_TAP26 0.04137f
C177 a_19573_1842# DELAY_VBIASN 0.10601f
C178 a_7543_1842# DELAY_VBIASP 0.06627f
C179 a_3743_1842# a_3851_1842# 0.01163f
C180 DELAY_OUT_TAP21 VDD 0.72899f
C181 a_15903_1842# VDD 0.49633f
C182 VDD a_21853_1842# 0.4916f
C183 a_7651_1842# a_7543_1842# 0.01163f
C184 DELAY_VBIASN a_26413_1842# 0.10601f
C185 a_11213_1842# DELAY_VBIASP 0.11222f
C186 a_8933_1842# VDD 0.4916f
C187 a_3743_1842# a_3851_2470# 0.01697f
C188 a_8933_1842# DELAY_OUT_TAP7 0.70708f
C189 VDD DELAY_OUT_LAST 0.45735f
C190 a_16533_1842# VDD 0.4916f
C191 DELAY_VBIASN a_21983_1842# 0.07258f
C192 a_23503_1842# VDD 0.49633f
C193 a_12103_1842# DELAY_OUT_TAP12 0.69646f
C194 a_7651_2470# VDD 0.01806f
C195 VDD DELAY_OUT_TAP25 0.72899f
C196 a_12971_2470# a_12863_1842# 0.01697f
C197 a_11973_1842# DELAY_OUT_TAP11 0.70708f
C198 a_8173_1842# DELAY_VBIASN 0.10601f
C199 a_15013_1842# DELAY_VBIASN 0.10601f
C200 a_25653_1842# VDD 0.4916f
C201 VDD a_6131_2470# 0.01806f
C202 VDD a_16011_2470# 0.01806f
C203 a_13493_1842# a_13623_1842# 0.70845f
C204 a_16663_1842# DELAY_VBIASN 0.07258f
C205 DELAY_VBIASN a_21093_1842# 0.10601f
C206 a_25783_1842# DELAY_VBIASN 0.07258f
C207 a_6023_1842# DELAY_VBIASP 0.06627f
C208 VDD a_14253_1842# 0.4916f
C209 a_5263_1842# DELAY_VBIASP 0.06627f
C210 a_10453_1842# DELAY_VBIASN 0.10601f
C211 a_16663_1842# a_16771_1842# 0.01163f
C212 a_24371_2470# a_24263_1842# 0.01697f
C213 DELAY_VBIASN a_14383_1842# 0.07258f
C214 a_15773_1842# DELAY_VBIASP 0.11222f
C215 VDD a_24263_1842# 0.49633f
C216 a_6653_1842# DELAY_VBIASN 0.10601f
C217 a_6783_1842# DELAY_VBIASP 0.06627f
C218 a_26543_1842# a_26651_1842# 0.01163f
C219 a_11451_2470# VDD 0.01806f
C220 a_13493_1842# DELAY_OUT_TAP13 0.70708f
C221 DELAY_OUT_TAP17 a_15773_1842# 0.0114f
C222 a_20463_1842# DELAY_OUT_TAP23 0.69646f
C223 VDD a_27737_1842# 0.75775f
C224 DELAY_OUT_TAP24 DELAY_VBIASP 0.04137f
C225 a_27303_1842# a_27411_1842# 0.01163f
C226 DELAY_OUT_TAP16 DELAY_VBIASP 0.04137f
C227 DELAY_VBIASN a_11343_1842# 0.07258f
C228 a_22613_1842# a_22743_1842# 0.70845f
C229 a_18183_1842# VDD 0.49633f
C230 VDD a_12971_2470# 0.01806f
C231 DELAY_OUT_TAP21 a_19573_1842# 0.70708f
C232 DELAY_VBIASN a_4503_1842# 0.07258f
C233 VDD DELAY_OUT_TAP2 0.72899f
C234 a_12103_1842# VDD 0.49633f
C235 DELAY_VBIASP a_9693_1842# 0.11222f
C236 DELAY_OUT_TAP8 VDD 0.72899f
C237 DELAY_VBIASN a_4373_1842# 0.10601f
C238 a_19051_2470# VDD 0.01806f
C239 a_7413_1842# DELAY_VBIASP 0.11222f
C240 DELAY_VBIASN DELAY_OUT_TAP3 0.04353f
C241 DELAY_OUT_TAP13 a_12863_1842# 0.69646f
C242 DELAY_OUT_TAP20 VDD 0.72899f
C243 DELAY_OUT_TAP9 DELAY_VBIASN 0.04353f
C244 a_21853_1842# a_21983_1842# 0.70845f
C245 a_14491_2470# VDD 0.01806f
C246 a_9063_1842# a_9171_2470# 0.01697f
C247 a_20463_1842# VDD 0.49633f
C248 a_24893_1842# DELAY_OUT_TAP29 0.0114f
C249 a_27173_1842# DELAY_VBIASP 0.11222f
C250 DELAY_VBIASP DELAY_OUT_TAP11 0.04137f
C251 DELAY_OUT_TAP21 DELAY_VBIASN 0.04353f
C252 a_15903_1842# DELAY_VBIASN 0.07258f
C253 DELAY_VBIASN a_21853_1842# 0.10601f
C254 a_23373_1842# VDD 0.4916f
C255 DELAY_OUT_TAP9 a_10453_1842# 0.70708f
C256 a_11973_1842# DELAY_OUT_TAP12 0.0114f
C257 a_9693_1842# a_9823_1842# 0.70845f
C258 a_8933_1842# DELAY_VBIASN 0.10601f
C259 a_9063_1842# DELAY_VBIASP 0.06627f
C260 a_18053_1842# DELAY_VBIASP 0.11222f
C261 DELAY_OUT_TAP25 a_21983_1842# 0.69646f
C262 DELAY_OUT_LAST DELAY_VBIASN 0.04786f
C263 a_16533_1842# DELAY_VBIASN 0.10601f
C264 a_23503_1842# DELAY_VBIASN 0.07258f
C265 a_16533_1842# a_16663_1842# 0.70845f
C266 VDD a_13623_1842# 0.49633f
C267 a_22091_2470# VDD 0.01806f
C268 VDD DELAY_OUT_TAP30 0.72899f
C269 a_7413_1842# a_7543_1842# 0.70845f
C270 DELAY_VBIASN DELAY_OUT_TAP25 0.04353f
C271 a_5893_1842# DELAY_VBIASP 0.11222f
C272 a_25653_1842# DELAY_VBIASN 0.10601f
C273 DELAY_VBIASP DELAY_OUT_TAP5 0.04137f
C274 a_5133_1842# DELAY_VBIASP 0.11222f
C275 VDD DELAY_OUT_TAP29 0.72899f
C276 a_25653_1842# a_25783_1842# 0.70845f
C277 VDD a_20571_2470# 0.01806f
C278 DELAY_VBIASN a_14253_1842# 0.10601f
C279 VDD a_24133_1842# 0.4916f
C280 a_22743_1842# VDD 0.49633f
C281 a_20333_1842# DELAY_VBIASP 0.11222f
C282 a_24893_1842# a_25023_1842# 0.70845f
C283 a_4373_1842# a_4503_1842# 0.70845f
C284 a_9931_2470# VDD 0.01806f
C285 VDD DELAY_OUT_TAP13 0.72899f
C286 a_22743_1842# a_22851_1842# 0.01163f
C287 a_11213_1842# DELAY_OUT_TAP11 0.0114f
C288 a_24263_1842# DELAY_VBIASN 0.07258f
C289 DELAY_OUT_TAP16 a_15773_1842# 0.70708f
C290 VDD DELAY_OUT_TAP6 0.72899f
C291 a_17423_1842# VDD 0.49633f
C292 a_14253_1842# a_14383_1842# 0.70845f
C293 a_10583_1842# a_10691_1842# 0.01163f
C294 DELAY_VBIASP a_13493_1842# 0.11222f
C295 DELAY_VBIASN a_27737_1842# 0.04176f
C296 DELAY_OUT_TAP14 a_13493_1842# 0.0114f
C297 VDD a_12211_2470# 0.01806f
C298 VDD DELAY_OUT_TAP15 0.72899f
C299 a_17531_2470# VDD 0.01806f
C300 a_11973_1842# VDD 0.4916f
C301 a_18183_1842# DELAY_VBIASN 0.07258f
C302 a_14491_1842# a_14383_1842# 0.01163f
C303 a_19703_1842# a_19811_1842# 0.01163f
C304 a_5371_2470# VDD 0.01806f
C305 a_8303_1842# a_8411_1842# 0.01163f
C306 a_27303_1842# DELAY_VBIASP 0.06629f
C307 a_25023_1842# VDD 0.49633f
C308 a_3743_1842# VDD 0.61241f
C309 a_18291_2470# VDD 0.01806f
C310 a_17423_1842# a_17531_1842# 0.01163f
C311 DELAY_VBIASN DELAY_OUT_TAP2 0.04353f
C312 VDD a_18943_1842# 0.49633f
C313 a_22613_1842# DELAY_VBIASP 0.11222f
C314 a_12103_1842# DELAY_VBIASN 0.07258f
C315 DELAY_OUT_TAP13 a_12733_1842# 0.0114f
C316 DELAY_OUT_TAP8 DELAY_VBIASN 0.04353f
C317 a_13731_2470# VDD 0.01806f
C318 DELAY_VBIASP DELAY_OUT_TAP12 0.04137f
C319 a_24893_1842# DELAY_OUT_TAP28 0.70708f
C320 VDD DELAY_OUT_TAP27 0.72899f
C321 a_11343_1842# a_11451_1842# 0.01163f
C322 DELAY_VBIASP DELAY_OUT_TAP10 0.04137f
C323 a_5893_1842# a_6023_1842# 0.70845f
C324 DELAY_OUT_TAP20 DELAY_VBIASN 0.04353f
C325 a_11451_2470# a_11343_1842# 0.01697f
C326 a_5133_1842# a_5263_1842# 0.70845f
C327 DELAY_VBIASP a_12863_1842# 0.06627f
C328 a_20463_1842# DELAY_VBIASN 0.07258f
C329 DELAY_OUT_TAP25 a_21853_1842# 0.0114f
C330 DELAY_OUT_TAP30 a_26413_1842# 0.70708f
C331 a_25131_2470# VDD 0.01806f
C332 a_15903_1842# a_16011_2470# 0.01697f
C333 a_23373_1842# DELAY_VBIASN 0.10601f
C334 a_6783_1842# a_6891_2470# 0.01697f
C335 a_6783_1842# DELAY_OUT_TAP5 0.69646f
C336 a_21331_2470# VDD 0.01806f
C337 a_22091_2470# a_21983_1842# 0.01697f
C338 VDD DELAY_IN 0.45518f
C339 DELAY_VBIASP DELAY_OUT_TAP23 0.04137f
C340 VDD DELAY_OUT_TAP18 0.72899f
C341 a_22613_1842# DELAY_OUT_TAP26 0.0114f
C342 a_9931_1842# a_9823_1842# 0.01163f
C343 a_17423_1842# DELAY_OUT_TAP19 0.69646f
C344 DELAY_VBIASP DELAY_OUT_TAP4 0.04137f
C345 a_24893_1842# DELAY_VBIASP 0.11222f
C346 a_14491_2470# a_14383_1842# 0.01697f
C347 DELAY_VBIASN a_13623_1842# 0.07258f
C348 DELAY_OUT_TAP30 DELAY_VBIASN 0.04353f
C349 DELAY_OUT_TAP31 DELAY_VBIASP 0.04137f
C350 a_21331_2470# a_21223_1842# 0.01697f
C351 a_12971_1842# a_12863_1842# 0.01163f
C352 VDD DELAY_OUT_TAP28 0.72899f
C353 a_25783_1842# DELAY_OUT_TAP30 0.69646f
C354 a_19703_1842# DELAY_VBIASP 0.06627f
C355 DELAY_VBIASN DELAY_OUT_TAP29 0.04353f
C356 a_4503_1842# DELAY_OUT_TAP2 0.69646f
C357 a_9171_2470# VDD 0.01806f
C358 a_11213_1842# DELAY_OUT_TAP10 0.70708f
C359 a_24133_1842# DELAY_VBIASN 0.10601f
C360 a_22743_1842# DELAY_VBIASN 0.07258f
C361 VDD DELAY_OUT_TAP1 0.72899f
C362 a_4373_1842# DELAY_OUT_TAP2 0.0114f
C363 a_17293_1842# VDD 0.4916f
C364 DELAY_VBIASN DELAY_OUT_TAP13 0.04353f
C365 a_26543_1842# DELAY_VBIASP 0.06627f
C366 a_7413_1842# DELAY_OUT_TAP5 0.70708f
C367 a_8173_1842# DELAY_OUT_TAP6 0.70708f
C368 VDD DELAY_VBIASP 13.2523f
C369 DELAY_OUT_LAST a_27737_1842# 0.70955f
C370 DELAY_VBIASN DELAY_OUT_TAP6 0.04353f
C371 DELAY_VBIASP DELAY_OUT_TAP7 0.04137f
C372 a_25783_1842# a_25891_1842# 0.01163f
C373 a_17423_1842# DELAY_VBIASN 0.07258f
C374 a_23611_2470# VDD 0.01806f
C375 VDD DELAY_OUT_TAP14 0.72899f
C376 a_15143_1842# DELAY_VBIASP 0.06627f
C377 a_16771_2470# VDD 0.01806f
C378 a_8303_1842# DELAY_VBIASP 0.06627f
C379 DELAY_OUT_TAP17 VDD 0.72899f
C380 a_15013_1842# DELAY_OUT_TAP15 0.70708f
C381 a_21223_1842# DELAY_VBIASP 0.06627f
C382 a_4611_2470# VDD 0.01806f
C383 DELAY_VBIASN DELAY_OUT_TAP15 0.04353f
C384 VDD a_18813_1842# 0.4916f
C385 a_8933_1842# DELAY_OUT_TAP8 0.0114f
C386 a_11973_1842# DELAY_VBIASN 0.10601f
C387 a_10583_1842# DELAY_VBIASP 0.06627f
C388 VDD a_9823_1842# 0.49633f
C389 a_25023_1842# DELAY_VBIASN 0.07258f
C390 a_3743_1842# DELAY_VBIASN 0.0649f
C391 VDD DELAY_OUT_TAP26 0.72899f
C392 DELAY_VBIASN a_18943_1842# 0.07258f
C393 VDD a_7543_1842# 0.49633f
C394 a_6023_1842# DELAY_OUT_TAP4 0.69646f
C395 a_14383_1842# DELAY_OUT_TAP15 0.69646f
C396 DELAY_VBIASP a_12733_1842# 0.11222f
C397 DELAY_VBIASN DELAY_OUT_TAP27 0.04353f
C398 VDD a_11213_1842# 0.4916f
C399 a_23373_1842# a_23503_1842# 0.70845f
C400 DELAY_VBIASP DELAY_OUT_TAP22 0.04137f
C401 a_17293_1842# DELAY_OUT_TAP19 0.0114f
C402 a_27303_1842# a_27173_1842# 0.70845f
C403 DELAY_IN DELAY_VBIASN 0.06969f
C404 DELAY_VBIASN DELAY_OUT_TAP18 0.04353f
C405 a_16663_1842# DELAY_OUT_TAP18 0.69646f
C406 DELAY_VBIASP DELAY_OUT_TAP19 0.04137f
C407 VDD a_6023_1842# 0.49633f
C408 a_25653_1842# DELAY_OUT_TAP30 0.0114f
C409 a_5263_1842# VDD 0.49633f
C410 a_19573_1842# DELAY_VBIASP 0.11222f
C411 DELAY_VBIASN DELAY_OUT_TAP28 0.04353f
C412 a_15773_1842# VDD 0.4916f
C413 a_15143_1842# a_15251_1842# 0.01163f
C414 a_6783_1842# VDD 0.49633f
C415 a_25653_1842# DELAY_OUT_TAP29 0.70708f
C416 a_26413_1842# DELAY_VBIASP 0.11222f
C417 a_18183_1842# DELAY_OUT_TAP20 0.69646f
C418 a_21983_1842# DELAY_VBIASP 0.06627f
C419 DELAY_VBIASN DELAY_OUT_TAP1 0.04353f
C420 a_22851_2470# VDD 0.01806f
C421 a_17293_1842# DELAY_VBIASN 0.10601f
C422 VDD DELAY_OUT_TAP24 0.72899f
C423 a_15013_1842# DELAY_VBIASP 0.11222f
C424 a_8173_1842# DELAY_VBIASP 0.11222f
C425 VDD a_15251_2470# 0.01806f
C426 DELAY_VBIASN DELAY_VBIASP 3.50557f
C427 a_16663_1842# DELAY_VBIASP 0.06627f
C428 DELAY_OUT_TAP16 VDD 0.72899f
C429 a_21093_1842# DELAY_VBIASP 0.11222f
C430 a_26543_1842# a_26651_2470# 0.01697f
C431 DELAY_OUT_TAP31 a_27173_1842# 0.70708f
C432 DELAY_VBIASN DELAY_OUT_TAP14 0.04353f
C433 a_15143_1842# a_15251_2470# 0.01697f
C434 a_24133_1842# a_24263_1842# 0.70845f
C435 DELAY_OUT_TAP16 a_15143_1842# 0.69646f
C436 DELAY_OUT_TAP21 a_18943_1842# 0.69646f
C437 a_16771_2470# a_16663_1842# 0.01697f
C438 a_25783_1842# DELAY_VBIASP 0.06627f
C439 a_21223_1842# DELAY_OUT_TAP24 0.69646f
C440 VDD a_26651_2470# 0.01806f
C441 DELAY_OUT_TAP17 DELAY_VBIASN 0.04353f
C442 a_10453_1842# DELAY_VBIASP 0.11222f
C443 VDD a_9693_1842# 0.4916f
C444 VDD a_3851_2470# 0.01866f
C445 a_27303_1842# a_27411_2470# 0.01697f
C446 DELAY_VBIASN a_18813_1842# 0.10601f
C447 a_14383_1842# DELAY_VBIASP 0.06627f
C448 VDD a_7413_1842# 0.4916f
C449 a_6653_1842# DELAY_VBIASP 0.11222f
C450 a_10691_2470# VDD 0.01806f
C451 a_5893_1842# DELAY_OUT_TAP4 0.0114f
C452 a_20463_1842# a_20571_1842# 0.01163f
C453 a_14253_1842# DELAY_OUT_TAP15 0.0114f
C454 DELAY_VBIASN a_9823_1842# 0.07258f
C455 DELAY_VBIASN DELAY_OUT_TAP26 0.04353f
C456 a_23503_1842# DELAY_OUT_TAP27 0.69646f
C457 DELAY_VBIASN a_7543_1842# 0.07258f
C458 a_20333_1842# DELAY_OUT_TAP23 0.0114f
C459 VDD DELAY_OUT_TAP11 0.72899f
C460 VDD a_27173_1842# 0.4916f
C461 DELAY_VBIASN a_11213_1842# 0.10601f
C462 a_11343_1842# DELAY_VBIASP 0.06627f
C463 a_9063_1842# VDD 0.49633f
C464 a_18053_1842# VDD 0.4916f
C465 a_10583_1842# a_10691_2470# 0.01697f
C466 a_16533_1842# DELAY_OUT_TAP18 0.0114f
C467 a_4503_1842# DELAY_VBIASP 0.06627f
C468 a_4373_1842# DELAY_OUT_TAP1 0.70708f
C469 a_23503_1842# a_23611_1842# 0.01163f
C470 VDD a_5893_1842# 0.4916f
C471 VDD a_6891_2470# 0.01806f
C472 VDD DELAY_OUT_TAP5 0.72899f
C473 a_5133_1842# VDD 0.4916f
C474 a_18943_1842# a_19051_1842# 0.01163f
C475 a_20463_1842# a_20571_2470# 0.01697f
C476 a_15903_1842# a_16011_1842# 0.01163f
C477 a_4373_1842# DELAY_VBIASP 0.11222f
C478 DELAY_VBIASP DELAY_OUT_TAP3 0.04137f
C479 a_6023_1842# DELAY_VBIASN 0.07258f
C480 a_4611_2470# a_4503_1842# 0.01697f
C481 DELAY_OUT_TAP9 DELAY_VBIASP 0.04137f
C482 a_5263_1842# DELAY_VBIASN 0.07258f
C483 a_12103_1842# a_12211_2470# 0.01697f
C484 a_20333_1842# VDD 0.4916f
C485 a_18183_1842# a_18291_2470# 0.01697f
C486 a_11973_1842# a_12103_1842# 0.70845f
C487 a_15773_1842# DELAY_VBIASN 0.10601f
C488 DELAY_OUT_TAP21 DELAY_VBIASP 0.04137f
C489 a_15903_1842# DELAY_VBIASP 0.06627f
C490 a_21853_1842# DELAY_VBIASP 0.11222f
C491 a_6783_1842# DELAY_VBIASN 0.07258f
C492 a_8933_1842# DELAY_VBIASP 0.11222f
C493 a_11213_1842# a_11343_1842# 0.70845f
C494 DELAY_OUT_LAST DELAY_VBIASP 0.21225f
C495 DELAY_OUT_TAP17 a_15903_1842# 0.69646f
C496 a_16533_1842# DELAY_VBIASP 0.11222f
C497 VDD a_13493_1842# 0.4916f
C498 a_23503_1842# DELAY_VBIASP 0.06627f
C499 a_19703_1842# a_19811_2470# 0.01697f
C500 VDD a_27411_2470# 0.01806f
C501 a_19051_2470# a_18943_1842# 0.01697f
C502 DELAY_OUT_TAP9 a_9823_1842# 0.69646f
C503 a_24263_1842# DELAY_OUT_TAP28 0.69646f
C504 a_23503_1842# a_23611_2470# 0.01697f
C505 DELAY_VBIASN DELAY_OUT_TAP24 0.04353f
C506 DELAY_OUT_TAP25 DELAY_VBIASP 0.04137f
C507 DELAY_OUT_TAP16 a_15013_1842# 0.0114f
C508 a_25653_1842# DELAY_VBIASP 0.11222f
C509 DELAY_OUT_TAP21 a_18813_1842# 0.0114f
C510 VDD a_25891_2470# 0.01806f
C511 a_21093_1842# DELAY_OUT_TAP24 0.0114f
C512 DELAY_OUT_TAP16 DELAY_VBIASN 0.04353f
C513 DELAY_OUT_TAP17 a_16533_1842# 0.70708f
C514 a_6653_1842# a_6783_1842# 0.70845f
C515 a_18053_1842# DELAY_OUT_TAP19 0.70708f
C516 VDD a_27303_1842# 0.49714f
C517 VDD a_19811_2470# 0.01806f
R0 DELAY_VBIASN.n1 DELAY_VBIASN.t31 34.3755
R1 DELAY_VBIASN.n1 DELAY_VBIASN.t30 33.0005
R2 DELAY_VBIASN.n2 DELAY_VBIASN.t29 33.0005
R3 DELAY_VBIASN.n3 DELAY_VBIASN.t28 33.0005
R4 DELAY_VBIASN.n4 DELAY_VBIASN.t27 33.0005
R5 DELAY_VBIASN.n5 DELAY_VBIASN.t26 33.0005
R6 DELAY_VBIASN.n6 DELAY_VBIASN.t25 33.0005
R7 DELAY_VBIASN.n7 DELAY_VBIASN.t24 33.0005
R8 DELAY_VBIASN.n8 DELAY_VBIASN.t23 33.0005
R9 DELAY_VBIASN.n9 DELAY_VBIASN.t22 33.0005
R10 DELAY_VBIASN.n10 DELAY_VBIASN.t21 33.0005
R11 DELAY_VBIASN.n11 DELAY_VBIASN.t20 33.0005
R12 DELAY_VBIASN.n12 DELAY_VBIASN.t19 33.0005
R13 DELAY_VBIASN.n13 DELAY_VBIASN.t18 33.0005
R14 DELAY_VBIASN.n14 DELAY_VBIASN.t17 33.0005
R15 DELAY_VBIASN.n15 DELAY_VBIASN.t16 33.0005
R16 DELAY_VBIASN.n16 DELAY_VBIASN.t15 33.0005
R17 DELAY_VBIASN.n17 DELAY_VBIASN.t14 33.0005
R18 DELAY_VBIASN.n18 DELAY_VBIASN.t13 33.0005
R19 DELAY_VBIASN.n19 DELAY_VBIASN.t12 33.0005
R20 DELAY_VBIASN.n20 DELAY_VBIASN.t11 33.0005
R21 DELAY_VBIASN.n21 DELAY_VBIASN.t10 33.0005
R22 DELAY_VBIASN.n22 DELAY_VBIASN.t9 33.0005
R23 DELAY_VBIASN.n23 DELAY_VBIASN.t8 33.0005
R24 DELAY_VBIASN.n24 DELAY_VBIASN.t7 33.0005
R25 DELAY_VBIASN.n25 DELAY_VBIASN.t6 33.0005
R26 DELAY_VBIASN.n26 DELAY_VBIASN.t5 33.0005
R27 DELAY_VBIASN.n27 DELAY_VBIASN.t4 33.0005
R28 DELAY_VBIASN.n28 DELAY_VBIASN.t3 33.0005
R29 DELAY_VBIASN.n29 DELAY_VBIASN.t2 33.0005
R30 DELAY_VBIASN.n30 DELAY_VBIASN.t1 33.0005
R31 DELAY_VBIASN.n0 DELAY_VBIASN.t0 33.0005
R32 DELAY_VBIASN DELAY_VBIASN.n0 1.55517
R33 DELAY_VBIASN.n0 DELAY_VBIASN.n30 1.3755
R34 DELAY_VBIASN.n30 DELAY_VBIASN.n29 1.3755
R35 DELAY_VBIASN.n29 DELAY_VBIASN.n28 1.3755
R36 DELAY_VBIASN.n28 DELAY_VBIASN.n27 1.3755
R37 DELAY_VBIASN.n27 DELAY_VBIASN.n26 1.3755
R38 DELAY_VBIASN.n26 DELAY_VBIASN.n25 1.3755
R39 DELAY_VBIASN.n25 DELAY_VBIASN.n24 1.3755
R40 DELAY_VBIASN.n24 DELAY_VBIASN.n23 1.3755
R41 DELAY_VBIASN.n23 DELAY_VBIASN.n22 1.3755
R42 DELAY_VBIASN.n22 DELAY_VBIASN.n21 1.3755
R43 DELAY_VBIASN.n21 DELAY_VBIASN.n20 1.3755
R44 DELAY_VBIASN.n20 DELAY_VBIASN.n19 1.3755
R45 DELAY_VBIASN.n19 DELAY_VBIASN.n18 1.3755
R46 DELAY_VBIASN.n18 DELAY_VBIASN.n17 1.3755
R47 DELAY_VBIASN.n17 DELAY_VBIASN.n16 1.3755
R48 DELAY_VBIASN.n16 DELAY_VBIASN.n15 1.3755
R49 DELAY_VBIASN.n15 DELAY_VBIASN.n14 1.3755
R50 DELAY_VBIASN.n14 DELAY_VBIASN.n13 1.3755
R51 DELAY_VBIASN.n13 DELAY_VBIASN.n12 1.3755
R52 DELAY_VBIASN.n12 DELAY_VBIASN.n11 1.3755
R53 DELAY_VBIASN.n11 DELAY_VBIASN.n10 1.3755
R54 DELAY_VBIASN.n10 DELAY_VBIASN.n9 1.3755
R55 DELAY_VBIASN.n9 DELAY_VBIASN.n8 1.3755
R56 DELAY_VBIASN.n8 DELAY_VBIASN.n7 1.3755
R57 DELAY_VBIASN.n7 DELAY_VBIASN.n6 1.3755
R58 DELAY_VBIASN.n6 DELAY_VBIASN.n5 1.3755
R59 DELAY_VBIASN.n5 DELAY_VBIASN.n4 1.3755
R60 DELAY_VBIASN.n4 DELAY_VBIASN.n3 1.3755
R61 DELAY_VBIASN.n3 DELAY_VBIASN.n2 1.3755
R62 DELAY_VBIASN.n2 DELAY_VBIASN.n1 1.3755
R63 DELAY_VBIASP.n1 DELAY_VBIASP.t31 34.3685
R64 DELAY_VBIASP.n1 DELAY_VBIASP.t30 33.0005
R65 DELAY_VBIASP.n2 DELAY_VBIASP.t29 33.0005
R66 DELAY_VBIASP.n3 DELAY_VBIASP.t28 33.0005
R67 DELAY_VBIASP.n4 DELAY_VBIASP.t27 33.0005
R68 DELAY_VBIASP.n5 DELAY_VBIASP.t26 33.0005
R69 DELAY_VBIASP.n6 DELAY_VBIASP.t25 33.0005
R70 DELAY_VBIASP.n7 DELAY_VBIASP.t24 33.0005
R71 DELAY_VBIASP.n8 DELAY_VBIASP.t23 33.0005
R72 DELAY_VBIASP.n9 DELAY_VBIASP.t22 33.0005
R73 DELAY_VBIASP.n10 DELAY_VBIASP.t21 33.0005
R74 DELAY_VBIASP.n11 DELAY_VBIASP.t20 33.0005
R75 DELAY_VBIASP.n12 DELAY_VBIASP.t19 33.0005
R76 DELAY_VBIASP.n13 DELAY_VBIASP.t18 33.0005
R77 DELAY_VBIASP.n14 DELAY_VBIASP.t17 33.0005
R78 DELAY_VBIASP.n15 DELAY_VBIASP.t16 33.0005
R79 DELAY_VBIASP.n16 DELAY_VBIASP.t15 33.0005
R80 DELAY_VBIASP.n17 DELAY_VBIASP.t14 33.0005
R81 DELAY_VBIASP.n18 DELAY_VBIASP.t13 33.0005
R82 DELAY_VBIASP.n19 DELAY_VBIASP.t12 33.0005
R83 DELAY_VBIASP.n20 DELAY_VBIASP.t11 33.0005
R84 DELAY_VBIASP.n21 DELAY_VBIASP.t10 33.0005
R85 DELAY_VBIASP.n22 DELAY_VBIASP.t9 33.0005
R86 DELAY_VBIASP.n23 DELAY_VBIASP.t8 33.0005
R87 DELAY_VBIASP.n24 DELAY_VBIASP.t7 33.0005
R88 DELAY_VBIASP.n25 DELAY_VBIASP.t6 33.0005
R89 DELAY_VBIASP.n26 DELAY_VBIASP.t5 33.0005
R90 DELAY_VBIASP.n27 DELAY_VBIASP.t4 33.0005
R91 DELAY_VBIASP.n28 DELAY_VBIASP.t3 33.0005
R92 DELAY_VBIASP.n29 DELAY_VBIASP.t2 33.0005
R93 DELAY_VBIASP.n30 DELAY_VBIASP.t1 33.0005
R94 DELAY_VBIASP.n0 DELAY_VBIASP.t0 33.0005
R95 DELAY_VBIASP DELAY_VBIASP.n0 1.70586
R96 DELAY_VBIASP.n0 DELAY_VBIASP.n30 1.36852
R97 DELAY_VBIASP.n30 DELAY_VBIASP.n29 1.36852
R98 DELAY_VBIASP.n29 DELAY_VBIASP.n28 1.36852
R99 DELAY_VBIASP.n28 DELAY_VBIASP.n27 1.36852
R100 DELAY_VBIASP.n27 DELAY_VBIASP.n26 1.36852
R101 DELAY_VBIASP.n26 DELAY_VBIASP.n25 1.36852
R102 DELAY_VBIASP.n25 DELAY_VBIASP.n24 1.36852
R103 DELAY_VBIASP.n24 DELAY_VBIASP.n23 1.36852
R104 DELAY_VBIASP.n23 DELAY_VBIASP.n22 1.36852
R105 DELAY_VBIASP.n22 DELAY_VBIASP.n21 1.36852
R106 DELAY_VBIASP.n21 DELAY_VBIASP.n20 1.36852
R107 DELAY_VBIASP.n20 DELAY_VBIASP.n19 1.36852
R108 DELAY_VBIASP.n19 DELAY_VBIASP.n18 1.36852
R109 DELAY_VBIASP.n18 DELAY_VBIASP.n17 1.36852
R110 DELAY_VBIASP.n17 DELAY_VBIASP.n16 1.36852
R111 DELAY_VBIASP.n16 DELAY_VBIASP.n15 1.36852
R112 DELAY_VBIASP.n15 DELAY_VBIASP.n14 1.36852
R113 DELAY_VBIASP.n14 DELAY_VBIASP.n13 1.36852
R114 DELAY_VBIASP.n13 DELAY_VBIASP.n12 1.36852
R115 DELAY_VBIASP.n12 DELAY_VBIASP.n11 1.36852
R116 DELAY_VBIASP.n11 DELAY_VBIASP.n10 1.36852
R117 DELAY_VBIASP.n10 DELAY_VBIASP.n9 1.36852
R118 DELAY_VBIASP.n9 DELAY_VBIASP.n8 1.36852
R119 DELAY_VBIASP.n8 DELAY_VBIASP.n7 1.36852
R120 DELAY_VBIASP.n7 DELAY_VBIASP.n6 1.36852
R121 DELAY_VBIASP.n6 DELAY_VBIASP.n5 1.36852
R122 DELAY_VBIASP.n5 DELAY_VBIASP.n4 1.36852
R123 DELAY_VBIASP.n4 DELAY_VBIASP.n3 1.36852
R124 DELAY_VBIASP.n3 DELAY_VBIASP.n2 1.36852
R125 DELAY_VBIASP.n2 DELAY_VBIASP.n1 1.36852
R126 VDD.n21 VDD.t8 15.1333
R127 VDD.n21 VDD.t11 15.0005
R128 VDD.n28 VDD.t3 15.0005
R129 VDD.n29 VDD 1.59504
R130 VDD.t0 VDD.t23 6.09923
R131 VDD.t0 VDD.t39 6.09923
R132 VDD.t0 VDD.t28 6.09923
R133 VDD.t0 VDD.t27 6.09923
R134 VDD.t0 VDD.t26 6.09923
R135 VDD.n35 VDD.t21 6.09923
R136 VDD.n31 VDD.t1 6.09923
R137 VDD.t0 VDD.t29 6.09923
R138 VDD.n51 VDD.t24 6.09923
R139 VDD.n37 VDD.t30 6.09923
R140 VDD.t0 VDD.t2 6.09923
R141 VDD.n39 VDD.t15 6.09923
R142 VDD.n33 VDD.t18 6.09923
R143 VDD.t0 VDD.t95 6.09923
R144 VDD.n49 VDD.t48 6.09923
R145 VDD.n17 VDD.t22 6.09923
R146 VDD.n17 VDD.t16 6.09923
R147 VDD.t0 VDD.t47 6.09923
R148 VDD.t0 VDD.t34 6.09923
R149 VDD.t0 VDD.t33 6.09923
R150 VDD.t0 VDD.t31 6.09923
R151 VDD.t0 VDD.t19 6.09923
R152 VDD.n45 VDD.t56 6.09923
R153 VDD.t0 VDD.t51 6.09923
R154 VDD.n25 VDD.t14 6.09923
R155 VDD.n25 VDD.t20 6.09923
R156 VDD.n43 VDD.t50 6.09923
R157 VDD.n27 VDD.t32 6.09923
R158 VDD.n47 VDD.t46 6.09923
R159 VDD.n41 VDD.t52 6.09923
R160 VDD.t0 VDD.t17 6.09923
R161 VDD.t0 VDD.t103 6.09923
R162 VDD.t0 VDD.n27 0.609213
R163 VDD.t0 VDD.n41 0.505438
R164 VDD.n28 VDD.t4 5.60969
R165 VDD.t0 VDD.t13 5.60347
R166 VDD.n21 VDD.t10 5.82803
R167 VDD.n10 VDD.t73 5.59675
R168 VDD.n11 VDD.t72 5.59675
R169 VDD.n5 VDD.t69 5.59675
R170 VDD.n7 VDD.t68 5.59675
R171 VDD.n4 VDD.t67 5.59675
R172 VDD.n34 VDD.t62 5.59675
R173 VDD.n30 VDD.t74 5.59675
R174 VDD.n8 VDD.t75 5.59675
R175 VDD.n50 VDD.t76 5.59675
R176 VDD.n36 VDD.t78 5.59675
R177 VDD.n3 VDD.t77 5.59675
R178 VDD.n38 VDD.t71 5.59675
R179 VDD.n32 VDD.t70 5.59675
R180 VDD.n12 VDD.t79 5.59675
R181 VDD.n48 VDD.t66 5.59675
R182 VDD.n15 VDD.t80 5.59675
R183 VDD.n16 VDD.t65 5.59675
R184 VDD.n14 VDD.t85 5.59675
R185 VDD.n2 VDD.t82 5.59675
R186 VDD.n1 VDD.t87 5.59675
R187 VDD.n13 VDD.t86 5.59675
R188 VDD.n9 VDD.t89 5.59675
R189 VDD.n44 VDD.t90 5.59675
R190 VDD.n0 VDD.t88 5.59675
R191 VDD.n24 VDD.t91 5.59675
R192 VDD.n23 VDD.t84 5.59675
R193 VDD.n42 VDD.t64 5.59675
R194 VDD.n26 VDD.t63 5.59675
R195 VDD.n46 VDD.t92 5.59675
R196 VDD.n40 VDD.t83 5.59675
R197 VDD.n6 VDD.t93 5.59675
R198 VDD.n29 VDD.n28 0.71648
R199 VDD VDD.n29 1.59504
R200 VDD.n28 VDD.n112 0.313704
R201 VDD.n22 VDD.n37 0.09196
R202 VDD.n19 VDD.n31 0.0918639
R203 VDD.n47 VDD.n41 0.409777
R204 VDD.n18 VDD.n33 0.0919169
R205 VDD.n43 VDD.n27 0.40971
R206 VDD.t0 VDD.n76 1.55397
R207 VDD.t0 VDD.n69 1.55381
R208 VDD.t0 VDD.n58 1.55374
R209 VDD.t0 VDD.n60 1.55373
R210 VDD.t0 VDD.n72 1.55361
R211 VDD.t0 VDD.n80 1.5536
R212 VDD.t0 VDD.n53 1.55354
R213 VDD.t0 VDD.n55 1.55354
R214 VDD.t0 VDD.n57 1.55352
R215 VDD.t0 VDD.n54 1.55351
R216 VDD.t0 VDD.n77 1.55347
R217 VDD.t0 VDD.n62 1.55347
R218 VDD.t0 VDD.n78 1.55347
R219 VDD.t0 VDD.n20 0.567307
R220 VDD.t0 VDD.n79 1.55347
R221 VDD.t0 VDD.n73 1.55344
R222 VDD.t0 VDD.n71 1.55342
R223 VDD.t0 VDD.n75 1.5534
R224 VDD.t0 VDD.n61 1.55339
R225 VDD.t0 VDD.n74 1.55338
R226 VDD.t0 VDD.n52 1.55337
R227 VDD.t0 VDD.n70 1.55335
R228 VDD.t0 VDD.n56 1.55334
R229 VDD.t0 VDD.n68 1.55334
R230 VDD.t0 VDD.n81 1.55334
R231 VDD.t0 VDD.n59 1.55333
R232 VDD.t0 VDD.n63 1.55333
R233 VDD.t0 VDD.n67 1.55333
R234 VDD.t0 VDD.n66 1.55332
R235 VDD.t0 VDD.n65 1.55327
R236 VDD.t0 VDD.n64 1.55327
R237 VDD.n28 VDD.t5 6.0145
R238 VDD.n10 VDD.n112 0.495398
R239 VDD.n11 VDD.n111 0.495398
R240 VDD.n5 VDD.n110 0.495398
R241 VDD.n7 VDD.n109 0.495398
R242 VDD.n4 VDD.n108 0.495398
R243 VDD.n34 VDD.n107 0.495398
R244 VDD.n30 VDD.n106 0.495398
R245 VDD.n8 VDD.n105 0.495398
R246 VDD.n50 VDD.n104 0.495398
R247 VDD.n36 VDD.n103 0.495398
R248 VDD.n3 VDD.n102 0.495398
R249 VDD.n38 VDD.n101 0.495398
R250 VDD.n32 VDD.n100 0.495398
R251 VDD.n12 VDD.n99 0.495398
R252 VDD.n48 VDD.n98 0.495398
R253 VDD.n15 VDD.n97 0.495398
R254 VDD.n16 VDD.n96 0.495398
R255 VDD.n14 VDD.n95 0.495398
R256 VDD.n2 VDD.n94 0.495398
R257 VDD.n1 VDD.n93 0.495398
R258 VDD.n13 VDD.n92 0.495398
R259 VDD.n9 VDD.n91 0.495398
R260 VDD.n44 VDD.n90 0.495398
R261 VDD.n0 VDD.n89 0.495398
R262 VDD.n24 VDD.n88 0.495398
R263 VDD.n23 VDD.n87 0.495398
R264 VDD.n42 VDD.n86 0.495398
R265 VDD.n26 VDD.n85 0.495398
R266 VDD.n46 VDD.n84 0.495398
R267 VDD.n40 VDD.n83 0.495398
R268 VDD.n6 VDD.n82 0.495398
R269 VDD.t0 VDD.n10 0.478641
R270 VDD.t0 VDD.n11 0.478641
R271 VDD.t0 VDD.n5 0.478641
R272 VDD.t0 VDD.n7 0.478641
R273 VDD.t0 VDD.n4 0.478641
R274 VDD.n35 VDD.n34 0.478641
R275 VDD.n31 VDD.n30 0.478641
R276 VDD.t0 VDD.n8 0.478641
R277 VDD.n51 VDD.n50 0.478641
R278 VDD.n37 VDD.n36 0.478641
R279 VDD.t0 VDD.n3 0.478641
R280 VDD.n39 VDD.n38 0.478641
R281 VDD.n33 VDD.n32 0.478641
R282 VDD.t0 VDD.n12 0.478641
R283 VDD.n49 VDD.n48 0.478641
R284 VDD.n17 VDD.n15 0.478641
R285 VDD.n17 VDD.n16 0.478641
R286 VDD.t0 VDD.n14 0.478641
R287 VDD.t0 VDD.n2 0.478641
R288 VDD.t0 VDD.n1 0.478641
R289 VDD.t0 VDD.n13 0.478641
R290 VDD.t0 VDD.n9 0.478641
R291 VDD.n45 VDD.n44 0.478641
R292 VDD.t0 VDD.n0 0.478641
R293 VDD.n25 VDD.n24 0.478641
R294 VDD.n25 VDD.n23 0.478641
R295 VDD.n43 VDD.n42 0.478641
R296 VDD.n27 VDD.n26 0.478641
R297 VDD.n47 VDD.n46 0.478641
R298 VDD.n41 VDD.n40 0.478641
R299 VDD.t0 VDD.n6 0.478641
R300 VDD.t0 VDD.t81 5.72284
R301 VDD.n21 VDD.t9 6.19118
R302 VDD.n88 VDD.n76 0.467573
R303 VDD.n95 VDD.n69 0.467341
R304 VDD.n104 VDD.n60 0.467195
R305 VDD.n92 VDD.n72 0.467143
R306 VDD.n107 VDD.n57 0.467091
R307 VDD.n85 VDD.n79 0.467033
R308 VDD.n87 VDD.n77 0.466955
R309 VDD.n109 VDD.n55 0.466912
R310 VDD.n106 VDD.n58 0.466908
R311 VDD.n102 VDD.n62 0.46682
R312 VDD.n86 VDD.n78 0.46682
R313 VDD.n82 VDD.n20 0.689237
R314 VDD.n90 VDD.n74 0.466801
R315 VDD.n91 VDD.n73 0.466798
R316 VDD.n103 VDD.n61 0.466761
R317 VDD.n96 VDD.n68 0.466699
R318 VDD.n83 VDD.n81 0.466699
R319 VDD.n112 VDD.n52 0.466493
R320 VDD.n99 VDD.n65 0.46646
R321 VDD.n94 VDD.n70 0.466454
R322 VDD.n100 VDD.n64 0.466439
R323 VDD.n105 VDD.n59 0.466372
R324 VDD.n98 VDD.n66 0.466314
R325 VDD.n110 VDD.n54 0.466288
R326 VDD.n93 VDD.n71 0.466273
R327 VDD.n101 VDD.n63 0.466257
R328 VDD.n97 VDD.n67 0.466257
R329 VDD.n108 VDD.n56 0.466253
R330 VDD.n89 VDD.n75 0.466025
R331 VDD.n111 VDD.n53 0.466015
R332 VDD.n84 VDD.n80 0.465833
R333 VDD.n83 VDD.n80 0.452137
R334 VDD.n110 VDD.n53 0.451912
R335 VDD.n88 VDD.n75 0.451904
R336 VDD.n107 VDD.n56 0.451699
R337 VDD.n96 VDD.n67 0.451693
R338 VDD.n100 VDD.n63 0.451693
R339 VDD.n109 VDD.n54 0.451656
R340 VDD.n92 VDD.n71 0.451619
R341 VDD.n104 VDD.n59 0.451585
R342 VDD.n97 VDD.n66 0.451566
R343 VDD.n99 VDD.n64 0.451469
R344 VDD.n98 VDD.n65 0.45146
R345 VDD.n93 VDD.n70 0.451423
R346 VDD.n111 VDD.n52 0.451366
R347 VDD.n95 VDD.n68 0.451252
R348 VDD.n82 VDD.n81 0.451252
R349 VDD.n102 VDD.n61 0.451204
R350 VDD.n101 VDD.n62 0.451146
R351 VDD.n85 VDD.n78 0.451146
R352 VDD.n90 VDD.n73 0.451129
R353 VDD.n89 VDD.n74 0.451113
R354 VDD.n108 VDD.n55 0.451015
R355 VDD.n105 VDD.n58 0.451006
R356 VDD.n86 VDD.n77 0.450971
R357 VDD.n84 VDD.n79 0.450933
R358 VDD.n106 VDD.n57 0.450884
R359 VDD.n91 VDD.n72 0.450828
R360 VDD.n103 VDD.n60 0.450767
R361 VDD.n94 VDD.n69 0.450618
R362 VDD.n87 VDD.n76 0.450429
R363 VDD.t7 VDD.n28 5.71158
R364 VDD.n28 VDD.t6 15.0661
R365 VDD.t0 VDD.n25 1.295
R366 VDD.t0 VDD.n18 1.27566
R367 VDD.t0 VDD.n19 1.26415
R368 VDD.t0 VDD.n22 1.2381
R369 VDD.n19 VDD.n35 0.240051
R370 VDD.n18 VDD.n39 0.240172
R371 VDD.n27 VDD.n47 1.23746
R372 VDD.n17 VDD.t0 0.375183
R373 VDD.n25 VDD.n43 1.2374
R374 VDD.n45 VDD.t0 1.03691
R375 VDD.n20 VDD.n21 0.165333
R376 VDD.n49 VDD.n17 0.395089
R377 VDD.n22 VDD.n51 0.240245
R378 VDD.t0 VDD.n28 1.03492
R379 VSS.n88 VSS.t125 108.746
R380 VSS.n86 VSS.t130 108.746
R381 VSS.n84 VSS.t124 108.746
R382 VSS.t134 VSS.n0 108.746
R383 VSS.n81 VSS.t133 108.746
R384 VSS.n79 VSS.t121 108.746
R385 VSS.t118 VSS.n2 108.746
R386 VSS.t128 VSS.n3 108.746
R387 VSS.n69 VSS.t129 108.746
R388 VSS.t122 VSS.n5 108.746
R389 VSS.t119 VSS.n6 108.746
R390 VSS.t137 VSS.n8 108.746
R391 VSS.t127 VSS.n11 108.746
R392 VSS.n65 VSS.t123 108.746
R393 VSS.n63 VSS.t138 108.746
R394 VSS.n62 VSS.t140 108.746
R395 VSS.t142 VSS.n17 108.746
R396 VSS.t143 VSS.n18 108.746
R397 VSS.t120 VSS.n19 108.746
R398 VSS.t147 VSS.n21 108.746
R399 VSS.n57 VSS.t145 108.746
R400 VSS.n90 VSS.n91 0.0415131
R401 VSS.n77 VSS.t135 108.746
R402 VSS.n76 VSS.t136 108.746
R403 VSS.n74 VSS.t132 108.746
R404 VSS.n70 VSS.t126 108.746
R405 VSS.n66 VSS.t131 108.746
R406 VSS.n64 VSS.t139 108.746
R407 VSS.n60 VSS.t141 108.746
R408 VSS.n54 VSS.t149 108.746
R409 VSS.n75 VSS.t102 106.056
R410 VSS.n71 VSS.t33 106.056
R411 VSS.n68 VSS.t34 106.056
R412 VSS.n67 VSS.t170 106.056
R413 VSS.n59 VSS.t160 106.056
R414 VSS.n56 VSS.t165 106.056
R415 VSS.n55 VSS.t39 106.056
R416 VSS.n89 VSS.t95 106.056
R417 VSS.n87 VSS.t47 106.056
R418 VSS.n85 VSS.t50 106.056
R419 VSS.n83 VSS.t49 106.056
R420 VSS.n82 VSS.t48 106.056
R421 VSS.n80 VSS.t60 106.056
R422 VSS.n78 VSS.t2 106.056
R423 VSS.t18 VSS.n1 106.056
R424 VSS.n73 VSS.t22 106.056
R425 VSS.n72 VSS.t65 106.056
R426 VSS.t42 VSS.n4 106.056
R427 VSS.t173 VSS.n7 106.056
R428 VSS.t166 VSS.n9 106.056
R429 VSS.t151 VSS.n10 106.056
R430 VSS.t113 VSS.n12 106.056
R431 VSS.t73 VSS.n13 106.056
R432 VSS.t70 VSS.n14 106.056
R433 VSS.t21 VSS.n15 106.056
R434 VSS.n61 VSS.t155 106.056
R435 VSS.t152 VSS.n16 106.056
R436 VSS.n58 VSS.t27 106.056
R437 VSS.t162 VSS.n20 106.056
R438 VSS.t167 VSS.n22 106.056
R439 VSS.t159 VSS.n23 106.056
R440 VSS.n90 VSS.n93 0.0773482
R441 VSS.t9 VSS.t6 99.7537
R442 VSS.t82 VSS.n141 94.1709
R443 VSS.t80 VSS.n144 94.1709
R444 VSS.t79 VSS.n147 94.1709
R445 VSS.t78 VSS.n150 94.1709
R446 VSS.t76 VSS.n153 94.1709
R447 VSS.t103 VSS.n156 94.1709
R448 VSS.n159 VSS.t112 94.1709
R449 VSS.t111 VSS.n162 94.1709
R450 VSS.t110 VSS.n165 94.1709
R451 VSS.t114 VSS.n168 94.1709
R452 VSS.t109 VSS.n171 94.1709
R453 VSS.n174 VSS.t108 94.1709
R454 VSS.t104 VSS.n177 94.1709
R455 VSS.t115 VSS.n180 94.1709
R456 VSS.n183 VSS.t92 94.1709
R457 VSS.n186 VSS.t84 94.1709
R458 VSS.n189 VSS.t86 94.1709
R459 VSS.n192 VSS.t90 94.1709
R460 VSS.n195 VSS.t87 94.1709
R461 VSS.n198 VSS.t85 94.1709
R462 VSS.n201 VSS.t83 94.1709
R463 VSS.t53 VSS.n204 94.1709
R464 VSS.n207 VSS.t106 94.1709
R465 VSS.t98 VSS.n210 94.1709
R466 VSS.t77 VSS.n213 94.1709
R467 VSS.n216 VSS.t105 94.1709
R468 VSS.n219 VSS.t96 94.1709
R469 VSS.n222 VSS.t68 94.1709
R470 VSS.n92 VSS.t161 28.2988
R471 VSS.t100 VSS.n94 97.257
R472 VSS.t117 VSS.n96 97.257
R473 VSS.t168 VSS.n100 49.7977
R474 VSS.n77 VSS.t0 67.0429
R475 VSS.n76 VSS.t61 67.0429
R476 VSS.n74 VSS.t51 67.0429
R477 VSS.n70 VSS.t23 67.0429
R478 VSS.n66 VSS.t25 67.0429
R479 VSS.n64 VSS.t71 67.0429
R480 VSS.n60 VSS.t156 67.0429
R481 VSS.n54 VSS.t168 67.0429
R482 VSS.n88 VSS.t45 67.0426
R483 VSS.n86 VSS.t94 67.0426
R484 VSS.n84 VSS.t58 67.0426
R485 VSS.t56 VSS.n0 67.0426
R486 VSS.n81 VSS.t54 67.0426
R487 VSS.n79 VSS.t40 67.0426
R488 VSS.t63 VSS.n2 67.0426
R489 VSS.t3 VSS.n3 67.0426
R490 VSS.n69 VSS.t31 67.0426
R491 VSS.t172 VSS.n5 67.0426
R492 VSS.t171 VSS.n6 67.0426
R493 VSS.t43 VSS.n8 67.0426
R494 VSS.t154 VSS.n11 67.0426
R495 VSS.n65 VSS.t74 67.0426
R496 VSS.n63 VSS.t66 67.0426
R497 VSS.n62 VSS.t35 67.0426
R498 VSS.t158 VSS.n17 67.0426
R499 VSS.t19 VSS.n18 67.0426
R500 VSS.t37 VSS.n19 67.0426
R501 VSS.t157 VSS.n21 67.0426
R502 VSS.n57 VSS.t153 67.0426
R503 VSS.n90 VSS.n92 0.649706
R504 VSS.n90 VSS.n94 4.80622
R505 VSS.n90 VSS.n96 4.80622
R506 VSS.t13 VSS.n24 29.3548
R507 VSS.t45 VSS.n141 43.0498
R508 VSS.t94 VSS.n144 43.0498
R509 VSS.t58 VSS.n147 43.0498
R510 VSS.n150 VSS.t56 43.0498
R511 VSS.t54 VSS.n153 43.0498
R512 VSS.t40 VSS.n156 43.0498
R513 VSS.t0 VSS.n159 43.0498
R514 VSS.t61 VSS.n162 43.0498
R515 VSS.t51 VSS.n165 43.0498
R516 VSS.n168 VSS.t63 43.0498
R517 VSS.n171 VSS.t3 43.0498
R518 VSS.t23 VSS.n174 43.0498
R519 VSS.t31 VSS.n177 43.0498
R520 VSS.n180 VSS.t172 43.0498
R521 VSS.n183 VSS.t171 43.0498
R522 VSS.n186 VSS.t43 43.0498
R523 VSS.t25 VSS.n189 43.0498
R524 VSS.n192 VSS.t154 43.0498
R525 VSS.t74 VSS.n195 43.0498
R526 VSS.t71 VSS.n198 43.0498
R527 VSS.t66 VSS.n201 43.0498
R528 VSS.t35 VSS.n204 43.0498
R529 VSS.t156 VSS.n207 43.0498
R530 VSS.n210 VSS.t158 43.0498
R531 VSS.n213 VSS.t19 43.0498
R532 VSS.n216 VSS.t37 43.0498
R533 VSS.n219 VSS.t157 43.0498
R534 VSS.t153 VSS.n222 43.0498
R535 VSS.t169 VSS.n94 24.3376
R536 VSS.t29 VSS.n96 24.3376
R537 VSS.n90 VSS.n136 17.0005
R538 VSS.n90 VSS.n97 2.32453
R539 VSS.n90 VSS.n232 17.0005
R540 VSS.t163 VSS.n100 12.6712
R541 VSS.n87 VSS.t82 15.9213
R542 VSS.n85 VSS.t80 15.9213
R543 VSS.n83 VSS.t79 15.9213
R544 VSS.n82 VSS.t78 15.9213
R545 VSS.n80 VSS.t76 15.9213
R546 VSS.n78 VSS.t103 15.9213
R547 VSS.t112 VSS.n1 15.9213
R548 VSS.n73 VSS.t110 15.9213
R549 VSS.n72 VSS.t114 15.9213
R550 VSS.t108 VSS.n4 15.9213
R551 VSS.t92 VSS.n7 15.9213
R552 VSS.t84 VSS.n9 15.9213
R553 VSS.t86 VSS.n10 15.9213
R554 VSS.t90 VSS.n12 15.9213
R555 VSS.t87 VSS.n13 15.9213
R556 VSS.t85 VSS.n14 15.9213
R557 VSS.t83 VSS.n15 15.9213
R558 VSS.n61 VSS.t53 15.9213
R559 VSS.t106 VSS.n16 15.9213
R560 VSS.n58 VSS.t77 15.9213
R561 VSS.t105 VSS.n20 15.9213
R562 VSS.t96 VSS.n22 15.9213
R563 VSS.t68 VSS.n23 15.9213
R564 VSS.n92 VSS.t88 13.1257
R565 VSS.n75 VSS.t111 15.9203
R566 VSS.n71 VSS.t109 15.9203
R567 VSS.n68 VSS.t104 15.9203
R568 VSS.n67 VSS.t115 15.9203
R569 VSS.n59 VSS.t98 15.9203
R570 VSS.n56 VSS.t100 15.9203
R571 VSS.n55 VSS.t117 15.9203
R572 VSS.n89 VSS.t9 13.2307
R573 VSS.t95 VSS.n33 11.8854
R574 VSS.t47 VSS.n34 11.8854
R575 VSS.t50 VSS.n35 11.8854
R576 VSS.t49 VSS.n32 11.8854
R577 VSS.t60 VSS.n31 11.8854
R578 VSS.t2 VSS.n30 11.8854
R579 VSS.n37 VSS.t18 11.8854
R580 VSS.t102 VSS.n38 11.8854
R581 VSS.t33 VSS.n29 11.8854
R582 VSS.n41 VSS.t42 11.8854
R583 VSS.t170 VSS.n28 11.8854
R584 VSS.n43 VSS.t173 11.8854
R585 VSS.n44 VSS.t166 11.8854
R586 VSS.n45 VSS.t151 11.8854
R587 VSS.n27 VSS.t73 11.8854
R588 VSS.n26 VSS.t70 11.8854
R589 VSS.t155 VSS.n48 11.8854
R590 VSS.n49 VSS.t152 11.8854
R591 VSS.n52 VSS.t162 11.8854
R592 VSS.n53 VSS.t167 11.8854
R593 VSS.t39 VSS.n25 11.8854
R594 VSS.t48 VSS.n36 11.8844
R595 VSS.t22 VSS.n39 11.8844
R596 VSS.t65 VSS.n40 11.8844
R597 VSS.t34 VSS.n42 11.8844
R598 VSS.n46 VSS.t113 11.8844
R599 VSS.n47 VSS.t21 11.8844
R600 VSS.t160 VSS.n50 11.8844
R601 VSS.t27 VSS.n51 11.8844
R602 VSS.t133 VSS.n36 9.19536
R603 VSS.n39 VSS.t118 9.19536
R604 VSS.n40 VSS.t128 9.19536
R605 VSS.n42 VSS.t122 9.19536
R606 VSS.t123 VSS.n46 9.19536
R607 VSS.t140 VSS.n47 9.19536
R608 VSS.n50 VSS.t143 9.19536
R609 VSS.n51 VSS.t120 9.19536
R610 VSS.t144 VSS.n95 8.47586
R611 VSS.t125 VSS.n33 9.19506
R612 VSS.t130 VSS.n34 9.19506
R613 VSS.t124 VSS.n35 9.19506
R614 VSS.n32 VSS.t134 9.19506
R615 VSS.t121 VSS.n31 9.19506
R616 VSS.t135 VSS.n30 9.19506
R617 VSS.t136 VSS.n37 9.19506
R618 VSS.t132 VSS.n38 9.19506
R619 VSS.t126 VSS.n29 9.19506
R620 VSS.t129 VSS.n41 9.19506
R621 VSS.n28 VSS.t119 9.19506
R622 VSS.n43 VSS.t137 9.19506
R623 VSS.t131 VSS.n44 9.19506
R624 VSS.n45 VSS.t127 9.19506
R625 VSS.t139 VSS.n27 9.19506
R626 VSS.t138 VSS.n26 9.19506
R627 VSS.t141 VSS.n48 9.19506
R628 VSS.n49 VSS.t142 9.19506
R629 VSS.n52 VSS.t147 9.19506
R630 VSS.t145 VSS.n53 9.19506
R631 VSS.t148 VSS.n91 8.4756
R632 VSS.t146 VSS.n93 8.48466
R633 VSS.t149 VSS.n25 9.19506
R634 VSS.t17 VSS.n24 29.2317
R635 VSS.n90 VSS.n141 8.5005
R636 VSS.n90 VSS.n144 8.5005
R637 VSS.n90 VSS.n147 8.5005
R638 VSS.n90 VSS.n150 8.5005
R639 VSS.n90 VSS.n153 8.5005
R640 VSS.n90 VSS.n156 8.5005
R641 VSS.n90 VSS.n159 8.5005
R642 VSS.n90 VSS.n162 8.5005
R643 VSS.n90 VSS.n165 8.5005
R644 VSS.n90 VSS.n168 8.5005
R645 VSS.n90 VSS.n171 8.5005
R646 VSS.n90 VSS.n174 8.5005
R647 VSS.n90 VSS.n177 8.5005
R648 VSS.n90 VSS.n180 8.5005
R649 VSS.n90 VSS.n183 8.5005
R650 VSS.n90 VSS.n186 8.5005
R651 VSS.n90 VSS.n189 8.5005
R652 VSS.n90 VSS.n192 8.5005
R653 VSS.n90 VSS.n195 8.5005
R654 VSS.n90 VSS.n198 8.5005
R655 VSS.n90 VSS.n201 8.5005
R656 VSS.n90 VSS.n204 8.5005
R657 VSS.n90 VSS.n207 8.5005
R658 VSS.n90 VSS.n210 8.5005
R659 VSS.n90 VSS.n213 8.5005
R660 VSS.n90 VSS.n216 8.5005
R661 VSS.n90 VSS.n219 8.5005
R662 VSS.n90 VSS.n222 8.5005
R663 VSS.n90 VSS.n100 1.14463
R664 VSS.n90 VSS.n137 8.47732
R665 VSS.n90 VSS.t12 8.47732
R666 VSS.n90 VSS.n135 8.47732
R667 VSS.n90 VSS.n237 8.47732
R668 VSS.n90 VSS.n230 8.47732
R669 VSS.n99 VSS.t14 0.279481
R670 VSS.n90 VSS.n99 1.49549
R671 VSS.n90 VSS.t6 5.00032
R672 VSS VSS.n98 2.9705
R673 VSS.n90 VSS.n101 2.74446
R674 VSS.n90 VSS.n133 2.74446
R675 VSS.n90 VSS.n138 2.74446
R676 VSS.n90 VSS.t164 2.74394
R677 VSS.n90 VSS.n102 1.55465
R678 VSS.n90 VSS.n103 1.55465
R679 VSS.n90 VSS.n104 1.55465
R680 VSS.n90 VSS.n105 1.55465
R681 VSS.n90 VSS.n106 1.55465
R682 VSS.n90 VSS.n107 1.55465
R683 VSS.n90 VSS.n108 1.55465
R684 VSS.n90 VSS.n109 1.55465
R685 VSS.n90 VSS.n110 1.55465
R686 VSS.n90 VSS.n111 1.55465
R687 VSS.n90 VSS.n112 1.55465
R688 VSS.n90 VSS.n113 1.55465
R689 VSS.n90 VSS.n114 1.55465
R690 VSS.n90 VSS.n115 1.55465
R691 VSS.n90 VSS.n116 1.55465
R692 VSS.n90 VSS.n117 1.55465
R693 VSS.n90 VSS.n118 1.55465
R694 VSS.n90 VSS.n119 1.55465
R695 VSS.n90 VSS.n120 1.55465
R696 VSS.n90 VSS.n121 1.55465
R697 VSS.n90 VSS.n122 1.55465
R698 VSS.n90 VSS.n123 1.55465
R699 VSS.n90 VSS.n124 1.55465
R700 VSS.n90 VSS.n125 1.55465
R701 VSS.n90 VSS.n126 1.55465
R702 VSS.n90 VSS.n127 1.55465
R703 VSS.n90 VSS.n128 1.55465
R704 VSS.n90 VSS.n129 1.55465
R705 VSS.n90 VSS.n130 1.55465
R706 VSS.n90 VSS.n131 1.55465
R707 VSS.n90 VSS.n132 1.55465
R708 VSS.n90 VSS.n139 1.55388
R709 VSS.n90 VSS.n142 1.55388
R710 VSS.n90 VSS.n145 1.55388
R711 VSS.n90 VSS.n148 1.55388
R712 VSS.n90 VSS.n151 1.55388
R713 VSS.n90 VSS.n154 1.55388
R714 VSS.n90 VSS.n157 1.55388
R715 VSS.n90 VSS.n160 1.55388
R716 VSS.n90 VSS.n163 1.55388
R717 VSS.n90 VSS.n166 1.55388
R718 VSS.n90 VSS.n169 1.55388
R719 VSS.n90 VSS.n172 1.55388
R720 VSS.n90 VSS.n175 1.55388
R721 VSS.n90 VSS.n178 1.55388
R722 VSS.n90 VSS.n181 1.55388
R723 VSS.n90 VSS.n184 1.55388
R724 VSS.n90 VSS.n187 1.55388
R725 VSS.n90 VSS.n190 1.55388
R726 VSS.n90 VSS.n193 1.55388
R727 VSS.n90 VSS.n196 1.55388
R728 VSS.n90 VSS.n199 1.55388
R729 VSS.n90 VSS.n202 1.55388
R730 VSS.n90 VSS.n205 1.55388
R731 VSS.n90 VSS.n208 1.55388
R732 VSS.n90 VSS.n211 1.55388
R733 VSS.n90 VSS.n214 1.55388
R734 VSS.n90 VSS.n217 1.55388
R735 VSS.n90 VSS.n220 1.55388
R736 VSS.n90 VSS.n223 1.55388
R737 VSS.n90 VSS.n225 1.55388
R738 VSS.n90 VSS.n227 1.55388
R739 VSS.t5 VSS.t8 0.806856
R740 VSS.t81 VSS.n143 0.802775
R741 VSS.t59 VSS.n146 0.802775
R742 VSS.t57 VSS.n149 0.802775
R743 VSS.t55 VSS.n152 0.802775
R744 VSS.t41 VSS.n155 0.802775
R745 VSS.t1 VSS.n158 0.802775
R746 VSS.t62 VSS.n161 0.802775
R747 VSS.t52 VSS.n164 0.802775
R748 VSS.t64 VSS.n167 0.802775
R749 VSS.t4 VSS.n170 0.802775
R750 VSS.t24 VSS.n173 0.802775
R751 VSS.t32 VSS.n176 0.802775
R752 VSS.t116 VSS.n179 0.802775
R753 VSS.t93 VSS.n182 0.802775
R754 VSS.t44 VSS.n185 0.802775
R755 VSS.t26 VSS.n188 0.802775
R756 VSS.t91 VSS.n191 0.802775
R757 VSS.t75 VSS.n194 0.802775
R758 VSS.t72 VSS.n197 0.802775
R759 VSS.t67 VSS.n200 0.802775
R760 VSS.t36 VSS.n203 0.802775
R761 VSS.t107 VSS.n206 0.802775
R762 VSS.t99 VSS.n209 0.802775
R763 VSS.t20 VSS.n212 0.802775
R764 VSS.t38 VSS.n215 0.802775
R765 VSS.t97 VSS.n218 0.802775
R766 VSS.t69 VSS.n221 0.802775
R767 VSS.t89 VSS.n224 0.802775
R768 VSS.t101 VSS.n226 0.802775
R769 VSS.t30 VSS.n228 0.802775
R770 VSS.t150 VSS.n229 0.802775
R771 VSS.t15 VSS.n134 0.802775
R772 VSS.t46 VSS.n140 0.802775
R773 VSS.n99 VSS.t16 0.234047
R774 VSS.t14 VSS.n231 0.723599
R775 VSS.n90 VSS.n24 0.139321
R776 VSS.n236 VSS.t7 0.595317
R777 VSS.t11 VSS.n235 0.595317
R778 VSS.n227 VSS.t30 0.47671
R779 VSS.n225 VSS.t101 0.47671
R780 VSS.n223 VSS.t89 0.47671
R781 VSS.n220 VSS.t69 0.47671
R782 VSS.n217 VSS.t97 0.47671
R783 VSS.n214 VSS.t38 0.47671
R784 VSS.n211 VSS.t20 0.47671
R785 VSS.n208 VSS.t99 0.47671
R786 VSS.n205 VSS.t107 0.47671
R787 VSS.n202 VSS.t36 0.47671
R788 VSS.n199 VSS.t67 0.47671
R789 VSS.n196 VSS.t72 0.47671
R790 VSS.n193 VSS.t75 0.47671
R791 VSS.n190 VSS.t91 0.47671
R792 VSS.n187 VSS.t26 0.47671
R793 VSS.n184 VSS.t44 0.47671
R794 VSS.n181 VSS.t93 0.47671
R795 VSS.n178 VSS.t116 0.47671
R796 VSS.n175 VSS.t32 0.47671
R797 VSS.n172 VSS.t24 0.47671
R798 VSS.n169 VSS.t4 0.47671
R799 VSS.n166 VSS.t64 0.47671
R800 VSS.n163 VSS.t52 0.47671
R801 VSS.n160 VSS.t62 0.47671
R802 VSS.n157 VSS.t1 0.47671
R803 VSS.n154 VSS.t41 0.47671
R804 VSS.n151 VSS.t55 0.47671
R805 VSS.n148 VSS.t57 0.47671
R806 VSS.n145 VSS.t59 0.47671
R807 VSS.n142 VSS.t81 0.47671
R808 VSS.n139 VSS.t46 0.47671
R809 VSS.n140 VSS.n102 0.46466
R810 VSS.n143 VSS.n103 0.46466
R811 VSS.n146 VSS.n104 0.46466
R812 VSS.n149 VSS.n105 0.46466
R813 VSS.n152 VSS.n106 0.46466
R814 VSS.n155 VSS.n107 0.46466
R815 VSS.n158 VSS.n108 0.46466
R816 VSS.n161 VSS.n109 0.46466
R817 VSS.n164 VSS.n110 0.46466
R818 VSS.n167 VSS.n111 0.46466
R819 VSS.n170 VSS.n112 0.46466
R820 VSS.n173 VSS.n113 0.46466
R821 VSS.n176 VSS.n114 0.46466
R822 VSS.n179 VSS.n115 0.46466
R823 VSS.n182 VSS.n116 0.46466
R824 VSS.n185 VSS.n117 0.46466
R825 VSS.n188 VSS.n118 0.46466
R826 VSS.n191 VSS.n119 0.46466
R827 VSS.n194 VSS.n120 0.46466
R828 VSS.n197 VSS.n121 0.46466
R829 VSS.n200 VSS.n122 0.46466
R830 VSS.n203 VSS.n123 0.46466
R831 VSS.n206 VSS.n124 0.46466
R832 VSS.n209 VSS.n125 0.46466
R833 VSS.n212 VSS.n126 0.46466
R834 VSS.n215 VSS.n127 0.46466
R835 VSS.n218 VSS.n128 0.46466
R836 VSS.n221 VSS.n129 0.46466
R837 VSS.n224 VSS.n130 0.46466
R838 VSS.n226 VSS.n131 0.46466
R839 VSS.n228 VSS.n132 0.46466
R840 VSS.n143 VSS.n102 0.45349
R841 VSS.n146 VSS.n103 0.45349
R842 VSS.n149 VSS.n104 0.45349
R843 VSS.n152 VSS.n105 0.45349
R844 VSS.n155 VSS.n106 0.45349
R845 VSS.n158 VSS.n107 0.45349
R846 VSS.n161 VSS.n108 0.45349
R847 VSS.n164 VSS.n109 0.45349
R848 VSS.n167 VSS.n110 0.45349
R849 VSS.n170 VSS.n111 0.45349
R850 VSS.n173 VSS.n112 0.45349
R851 VSS.n176 VSS.n113 0.45349
R852 VSS.n179 VSS.n114 0.45349
R853 VSS.n182 VSS.n115 0.45349
R854 VSS.n185 VSS.n116 0.45349
R855 VSS.n188 VSS.n117 0.45349
R856 VSS.n191 VSS.n118 0.45349
R857 VSS.n194 VSS.n119 0.45349
R858 VSS.n197 VSS.n120 0.45349
R859 VSS.n200 VSS.n121 0.45349
R860 VSS.n203 VSS.n122 0.45349
R861 VSS.n206 VSS.n123 0.45349
R862 VSS.n209 VSS.n124 0.45349
R863 VSS.n212 VSS.n125 0.45349
R864 VSS.n215 VSS.n126 0.45349
R865 VSS.n218 VSS.n127 0.45349
R866 VSS.n221 VSS.n128 0.45349
R867 VSS.n224 VSS.n129 0.45349
R868 VSS.n226 VSS.n130 0.45349
R869 VSS.n228 VSS.n131 0.45349
R870 VSS.n229 VSS.n132 0.45349
R871 VSS.n139 VSS.t81 0.441374
R872 VSS.n142 VSS.t59 0.441374
R873 VSS.n145 VSS.t57 0.441374
R874 VSS.n148 VSS.t55 0.441374
R875 VSS.n151 VSS.t41 0.441374
R876 VSS.n154 VSS.t1 0.441374
R877 VSS.n157 VSS.t62 0.441374
R878 VSS.n160 VSS.t52 0.441374
R879 VSS.n163 VSS.t64 0.441374
R880 VSS.n166 VSS.t4 0.441374
R881 VSS.n169 VSS.t24 0.441374
R882 VSS.n172 VSS.t32 0.441374
R883 VSS.n175 VSS.t116 0.441374
R884 VSS.n178 VSS.t93 0.441374
R885 VSS.n181 VSS.t44 0.441374
R886 VSS.n184 VSS.t26 0.441374
R887 VSS.n187 VSS.t91 0.441374
R888 VSS.n190 VSS.t75 0.441374
R889 VSS.n193 VSS.t72 0.441374
R890 VSS.n196 VSS.t67 0.441374
R891 VSS.n199 VSS.t36 0.441374
R892 VSS.n202 VSS.t107 0.441374
R893 VSS.n205 VSS.t99 0.441374
R894 VSS.n208 VSS.t20 0.441374
R895 VSS.n211 VSS.t38 0.441374
R896 VSS.n214 VSS.t97 0.441374
R897 VSS.n217 VSS.t69 0.441374
R898 VSS.n220 VSS.t89 0.441374
R899 VSS.n223 VSS.t101 0.441374
R900 VSS.n225 VSS.t30 0.441374
R901 VSS.n227 VSS.t150 0.441374
R902 VSS.n97 VSS.t8 0.380071
R903 VSS.n98 VSS.n97 0.280466
R904 VSS.t164 VSS.t150 0.301976
R905 VSS.n229 VSS.n133 0.290049
R906 VSS.n140 VSS.n101 0.276768
R907 VSS.n234 VSS.n101 0.271299
R908 VSS.n235 VSS.n138 0.271299
R909 VSS.t46 VSS.n138 0.265518
R910 VSS.t164 VSS.t15 0.254814
R911 VSS.n134 VSS.n133 0.244268
R912 VSS.t7 VSS.t11 0.1875
R913 VSS.n134 VSS.t12 0.135868
R914 VSS.t15 VSS.n230 0.124618
R915 VSS.n231 VSS.t12 0.122118
R916 VSS.t14 VSS.n230 0.122118
R917 VSS.t5 VSS.n98 0.0955
R918 VSS.n90 VSS.n1 0.0884098
R919 VSS.t7 VSS.n233 0.0851154
R920 VSS.t11 VSS.n234 0.0851154
R921 VSS.t16 VSS.n135 0.0771176
R922 VSS.n233 VSS.n137 0.0746176
R923 VSS.n237 VSS.n236 0.0746176
R924 VSS.n231 VSS.n135 0.0696176
R925 VSS.n233 VSS.n136 0.06925
R926 VSS.n236 VSS.n232 0.06925
R927 VSS.n234 VSS.n136 0.05925
R928 VSS.n235 VSS.n232 0.05925
R929 VSS.n137 VSS.t8 0.0546176
R930 VSS.n237 VSS.t5 0.0546176
R931 VSS.n90 VSS.n0 0.0485965
R932 VSS.n90 VSS.n36 0.0444724
R933 VSS.n90 VSS.n77 0.0444724
R934 VSS.n90 VSS.n76 0.0444724
R935 VSS.n90 VSS.n75 0.0444724
R936 VSS.n90 VSS.n74 0.0444724
R937 VSS.n90 VSS.n39 0.0444724
R938 VSS.n90 VSS.n40 0.0444724
R939 VSS.n90 VSS.n71 0.0444724
R940 VSS.n90 VSS.n70 0.0444724
R941 VSS.n90 VSS.n68 0.0444724
R942 VSS.n90 VSS.n42 0.0444724
R943 VSS.n90 VSS.n67 0.0444724
R944 VSS.n90 VSS.n66 0.0444724
R945 VSS.n90 VSS.n46 0.0444724
R946 VSS.n90 VSS.n64 0.0444724
R947 VSS.n90 VSS.n47 0.0444724
R948 VSS.n90 VSS.n60 0.0444724
R949 VSS.n90 VSS.n59 0.0444724
R950 VSS.n90 VSS.n50 0.0444724
R951 VSS.n90 VSS.n51 0.0444724
R952 VSS.n90 VSS.n56 0.0444724
R953 VSS.n95 VSS.t165 11.8883
R954 VSS.n90 VSS.n95 0.085484
R955 VSS.n90 VSS.n55 0.0444724
R956 VSS.n90 VSS.n54 0.0444724
R957 VSS.n90 VSS.n32 0.0444549
R958 VSS.n90 VSS.n31 0.0444549
R959 VSS.n90 VSS.n30 0.0444549
R960 VSS.n90 VSS.n3 0.0444549
R961 VSS.n90 VSS.n29 0.0444549
R962 VSS.n90 VSS.n4 0.0444549
R963 VSS.n90 VSS.n5 0.0444549
R964 VSS.n90 VSS.n28 0.0444549
R965 VSS.n90 VSS.n6 0.0444549
R966 VSS.n90 VSS.n7 0.0444549
R967 VSS.n90 VSS.n8 0.0444549
R968 VSS.n90 VSS.n9 0.0444549
R969 VSS.n90 VSS.n10 0.0444549
R970 VSS.n90 VSS.n11 0.0444549
R971 VSS.n90 VSS.n12 0.0444549
R972 VSS.n90 VSS.n13 0.0444549
R973 VSS.n90 VSS.n27 0.0444549
R974 VSS.n90 VSS.n14 0.0444549
R975 VSS.n90 VSS.n26 0.0444549
R976 VSS.n90 VSS.n15 0.0444549
R977 VSS.n90 VSS.n16 0.0444549
R978 VSS.n90 VSS.n17 0.0444549
R979 VSS.n90 VSS.n18 0.0444549
R980 VSS.n90 VSS.n19 0.0444549
R981 VSS.n90 VSS.n20 0.0444549
R982 VSS.n90 VSS.n21 0.0444549
R983 VSS.n90 VSS.n22 0.0444549
R984 VSS.n90 VSS.n23 0.0444549
R985 VSS.n93 VSS.t28 10.6837
R986 VSS.n90 VSS.n2 0.0884098
R987 VSS.n90 VSS.n25 0.0444549
R988 VSS.n90 VSS.n89 0.0444549
R989 VSS.n90 VSS.n33 0.0444549
R990 VSS.n90 VSS.n88 0.0444549
R991 VSS.n90 VSS.n87 0.0444549
R992 VSS.n90 VSS.n34 0.0444549
R993 VSS.n90 VSS.n86 0.0444549
R994 VSS.n90 VSS.n85 0.0444549
R995 VSS.n90 VSS.n35 0.0444549
R996 VSS.n90 VSS.n84 0.0444549
R997 VSS.n90 VSS.n83 0.0444549
R998 VSS.n90 VSS.n82 0.0444549
R999 VSS.n90 VSS.n81 0.0444549
R1000 VSS.n90 VSS.n80 0.0444549
R1001 VSS.n90 VSS.n79 0.0444549
R1002 VSS.n90 VSS.n78 0.0444549
R1003 VSS.n90 VSS.n37 0.0444549
R1004 VSS.n90 VSS.n38 0.0444549
R1005 VSS.n90 VSS.n73 0.0444549
R1006 VSS.n90 VSS.n72 0.0444549
R1007 VSS.n90 VSS.n41 0.0444549
R1008 VSS.n90 VSS.n69 0.0444549
R1009 VSS.n90 VSS.n43 0.0444549
R1010 VSS.n90 VSS.n44 0.0444549
R1011 VSS.n90 VSS.n45 0.0444549
R1012 VSS.n90 VSS.n65 0.0444549
R1013 VSS.n90 VSS.n63 0.0444549
R1014 VSS.n90 VSS.n62 0.0444549
R1015 VSS.n90 VSS.n61 0.0444549
R1016 VSS.n90 VSS.n48 0.0444549
R1017 VSS.n90 VSS.n49 0.0444549
R1018 VSS.n90 VSS.n58 0.0444549
R1019 VSS.n90 VSS.n52 0.0444549
R1020 VSS.n90 VSS.n53 0.0444549
R1021 VSS.n90 VSS.n57 0.0444549
R1022 VSS.n91 VSS.t159 11.8893
C518 DELAY_VBIASN VSS 16.43641f
C519 DELAY_OUT_LAST VSS 0.40486f
C520 DELAY_OUT_TAP31 VSS 0.6437f
C521 DELAY_OUT_TAP30 VSS 0.6437f
C522 DELAY_OUT_TAP29 VSS 0.6437f
C523 DELAY_OUT_TAP28 VSS 0.6437f
C524 DELAY_OUT_TAP27 VSS 0.6437f
C525 DELAY_OUT_TAP26 VSS 0.6437f
C526 DELAY_OUT_TAP25 VSS 0.6437f
C527 DELAY_OUT_TAP24 VSS 0.6437f
C528 DELAY_OUT_TAP23 VSS 0.6437f
C529 DELAY_OUT_TAP22 VSS 0.6437f
C530 DELAY_OUT_TAP21 VSS 0.6437f
C531 DELAY_OUT_TAP20 VSS 0.6437f
C532 DELAY_OUT_TAP19 VSS 0.6437f
C533 DELAY_OUT_TAP18 VSS 0.6437f
C534 DELAY_OUT_TAP17 VSS 0.6437f
C535 DELAY_OUT_TAP16 VSS 0.6437f
C536 DELAY_OUT_TAP15 VSS 0.6437f
C537 DELAY_OUT_TAP14 VSS 0.6437f
C538 DELAY_OUT_TAP13 VSS 0.6437f
C539 DELAY_OUT_TAP12 VSS 0.6437f
C540 DELAY_OUT_TAP11 VSS 0.6437f
C541 DELAY_OUT_TAP10 VSS 0.6437f
C542 DELAY_OUT_TAP9 VSS 0.6437f
C543 DELAY_OUT_TAP8 VSS 0.6437f
C544 DELAY_OUT_TAP7 VSS 0.6437f
C545 DELAY_OUT_TAP6 VSS 0.6437f
C546 DELAY_OUT_TAP5 VSS 0.6437f
C547 DELAY_OUT_TAP4 VSS 0.6437f
C548 DELAY_OUT_TAP3 VSS 0.6437f
C549 DELAY_OUT_TAP2 VSS 0.6437f
C550 DELAY_OUT_TAP1 VSS 0.64371f
C551 DELAY_VBIASP VSS 4.15787f
C552 DELAY_IN VSS 0.57171f
C553 VDD VSS 20.97692f
C554 a_27411_1842# VSS 0.01336f ; **FLOATING
C555 a_26651_1842# VSS 0.01336f ; **FLOATING
C556 a_25891_1842# VSS 0.01336f ; **FLOATING
C557 a_25131_1842# VSS 0.01336f ; **FLOATING
C558 a_24371_1842# VSS 0.01336f ; **FLOATING
C559 a_23611_1842# VSS 0.01336f ; **FLOATING
C560 a_22851_1842# VSS 0.01336f ; **FLOATING
C561 a_22091_1842# VSS 0.01336f ; **FLOATING
C562 a_21331_1842# VSS 0.01336f ; **FLOATING
C563 a_20571_1842# VSS 0.01336f ; **FLOATING
C564 a_19811_1842# VSS 0.01336f ; **FLOATING
C565 a_19051_1842# VSS 0.01336f ; **FLOATING
C566 a_18291_1842# VSS 0.01336f ; **FLOATING
C567 a_17531_1842# VSS 0.01336f ; **FLOATING
C568 a_16771_1842# VSS 0.01336f ; **FLOATING
C569 a_16011_1842# VSS 0.01336f ; **FLOATING
C570 a_15251_1842# VSS 0.01336f ; **FLOATING
C571 a_14491_1842# VSS 0.01336f ; **FLOATING
C572 a_13731_1842# VSS 0.01336f ; **FLOATING
C573 a_12971_1842# VSS 0.01336f ; **FLOATING
C574 a_12211_1842# VSS 0.01336f ; **FLOATING
C575 a_11451_1842# VSS 0.01336f ; **FLOATING
C576 a_10691_1842# VSS 0.01336f ; **FLOATING
C577 a_9931_1842# VSS 0.01336f ; **FLOATING
C578 a_9171_1842# VSS 0.01336f ; **FLOATING
C579 a_8411_1842# VSS 0.01336f ; **FLOATING
C580 a_7651_1842# VSS 0.01336f ; **FLOATING
C581 a_6891_1842# VSS 0.01336f ; **FLOATING
C582 a_6131_1842# VSS 0.01336f ; **FLOATING
C583 a_5371_1842# VSS 0.01336f ; **FLOATING
C584 a_4611_1842# VSS 0.01336f ; **FLOATING
C585 a_3851_1842# VSS 0.0139f ; **FLOATING
C586 a_27303_1842# VSS 0.54306f ; **FLOATING
C587 a_27737_1842# VSS 0.67217f ; **FLOATING
C588 a_27173_1842# VSS 0.48844f ; **FLOATING
C589 a_26543_1842# VSS 0.54063f ; **FLOATING
C590 a_26413_1842# VSS 0.48844f ; **FLOATING
C591 a_25783_1842# VSS 0.54063f ; **FLOATING
C592 a_25653_1842# VSS 0.48844f ; **FLOATING
C593 a_25023_1842# VSS 0.54063f ; **FLOATING
C594 a_24893_1842# VSS 0.48844f ; **FLOATING
C595 a_24263_1842# VSS 0.54063f ; **FLOATING
C596 a_24133_1842# VSS 0.48844f ; **FLOATING
C597 a_23503_1842# VSS 0.54063f ; **FLOATING
C598 a_23373_1842# VSS 0.48844f ; **FLOATING
C599 a_22743_1842# VSS 0.54063f ; **FLOATING
C600 a_22613_1842# VSS 0.48844f ; **FLOATING
C601 a_21983_1842# VSS 0.54063f ; **FLOATING
C602 a_21853_1842# VSS 0.48844f ; **FLOATING
C603 a_21223_1842# VSS 0.54063f ; **FLOATING
C604 a_21093_1842# VSS 0.48844f ; **FLOATING
C605 a_20463_1842# VSS 0.54063f ; **FLOATING
C606 a_20333_1842# VSS 0.48844f ; **FLOATING
C607 a_19703_1842# VSS 0.54063f ; **FLOATING
C608 a_19573_1842# VSS 0.48844f ; **FLOATING
C609 a_18943_1842# VSS 0.54063f ; **FLOATING
C610 a_18813_1842# VSS 0.48844f ; **FLOATING
C611 a_18183_1842# VSS 0.54063f ; **FLOATING
C612 a_18053_1842# VSS 0.48844f ; **FLOATING
C613 a_17423_1842# VSS 0.54063f ; **FLOATING
C614 a_17293_1842# VSS 0.48844f ; **FLOATING
C615 a_16663_1842# VSS 0.54063f ; **FLOATING
C616 a_16533_1842# VSS 0.48844f ; **FLOATING
C617 a_15903_1842# VSS 0.54063f ; **FLOATING
C618 a_15773_1842# VSS 0.48844f ; **FLOATING
C619 a_15143_1842# VSS 0.54063f ; **FLOATING
C620 a_15013_1842# VSS 0.48844f ; **FLOATING
C621 a_14383_1842# VSS 0.54063f ; **FLOATING
C622 a_14253_1842# VSS 0.48844f ; **FLOATING
C623 a_13623_1842# VSS 0.54063f ; **FLOATING
C624 a_13493_1842# VSS 0.48844f ; **FLOATING
C625 a_12863_1842# VSS 0.54063f ; **FLOATING
C626 a_12733_1842# VSS 0.48844f ; **FLOATING
C627 a_12103_1842# VSS 0.54063f ; **FLOATING
C628 a_11973_1842# VSS 0.48844f ; **FLOATING
C629 a_11343_1842# VSS 0.54063f ; **FLOATING
C630 a_11213_1842# VSS 0.48844f ; **FLOATING
C631 a_10583_1842# VSS 0.54063f ; **FLOATING
C632 a_10453_1842# VSS 0.48844f ; **FLOATING
C633 a_9823_1842# VSS 0.54063f ; **FLOATING
C634 a_9693_1842# VSS 0.48844f ; **FLOATING
C635 a_9063_1842# VSS 0.54063f ; **FLOATING
C636 a_8933_1842# VSS 0.48844f ; **FLOATING
C637 a_8303_1842# VSS 0.54063f ; **FLOATING
C638 a_8173_1842# VSS 0.48844f ; **FLOATING
C639 a_7543_1842# VSS 0.54063f ; **FLOATING
C640 a_7413_1842# VSS 0.48844f ; **FLOATING
C641 a_6783_1842# VSS 0.54063f ; **FLOATING
C642 a_6653_1842# VSS 0.48844f ; **FLOATING
C643 a_6023_1842# VSS 0.54063f ; **FLOATING
C644 a_5893_1842# VSS 0.48844f ; **FLOATING
C645 a_5263_1842# VSS 0.54063f ; **FLOATING
C646 a_5133_1842# VSS 0.48844f ; **FLOATING
C647 a_4503_1842# VSS 0.54063f ; **FLOATING
C648 a_4373_1842# VSS 0.48844f ; **FLOATING
C649 a_3743_1842# VSS 0.61828f ; **FLOATING
C650 VDD.n0 VSS 0.02735f ; **FLOATING
C651 VDD.n1 VSS 0.02735f ; **FLOATING
C652 VDD.n2 VSS 0.02735f ; **FLOATING
C653 VDD.n3 VSS 0.02735f ; **FLOATING
C654 VDD.n4 VSS 0.02735f ; **FLOATING
C655 VDD.n5 VSS 0.02735f ; **FLOATING
C656 VDD.n6 VSS 0.02735f ; **FLOATING
C657 VDD.n7 VSS 0.02735f ; **FLOATING
C658 VDD.n8 VSS 0.02735f ; **FLOATING
C659 VDD.n9 VSS 0.02735f ; **FLOATING
C660 VDD.n10 VSS 0.02735f ; **FLOATING
C661 VDD.n11 VSS 0.02735f ; **FLOATING
C662 VDD.n12 VSS 0.02735f ; **FLOATING
C663 VDD.n13 VSS 0.02735f ; **FLOATING
C664 VDD.n14 VSS 0.02735f ; **FLOATING
C665 VDD.t0 VSS 54.4354f ; **FLOATING
C666 VDD.n15 VSS 0.02735f ; **FLOATING
C667 VDD.n16 VSS 0.02735f ; **FLOATING
C668 VDD.n17 VSS 0.42821f ; **FLOATING
C669 VDD.t81 VSS 0.03749f ; **FLOATING
C670 VDD.n20 VSS 0.038f ; **FLOATING
C671 VDD.n21 VSS 0.42408f ; **FLOATING
C672 VDD.n23 VSS 0.02735f ; **FLOATING
C673 VDD.n24 VSS 0.02735f ; **FLOATING
C674 VDD.n25 VSS 0.4283f ; **FLOATING
C675 VDD.n26 VSS 0.02735f ; **FLOATING
C676 VDD.n27 VSS 0.21408f ; **FLOATING
C677 VDD.t9 VSS 0.03951f ; **FLOATING
C678 VDD.n28 VSS 1.05796f ; **FLOATING
C679 VDD.t5 VSS 0.04253f ; **FLOATING
C680 VDD.n30 VSS 0.02735f ; **FLOATING
C681 VDD.n31 VSS 0.2141f ; **FLOATING
C682 VDD.n32 VSS 0.02735f ; **FLOATING
C683 VDD.n33 VSS 0.2141f ; **FLOATING
C684 VDD.n34 VSS 0.02735f ; **FLOATING
C685 VDD.n35 VSS 0.21414f ; **FLOATING
C686 VDD.n36 VSS 0.02735f ; **FLOATING
C687 VDD.n37 VSS 0.21409f ; **FLOATING
C688 VDD.n38 VSS 0.02735f ; **FLOATING
C689 VDD.n39 VSS 0.21419f ; **FLOATING
C690 VDD.n40 VSS 0.02735f ; **FLOATING
C691 VDD.n41 VSS 0.21414f ; **FLOATING
C692 VDD.n42 VSS 0.02735f ; **FLOATING
C693 VDD.n43 VSS 0.21417f ; **FLOATING
C694 VDD.n44 VSS 0.02735f ; **FLOATING
C695 VDD.n45 VSS 0.21414f ; **FLOATING
C696 VDD.n46 VSS 0.02735f ; **FLOATING
C697 VDD.n47 VSS 0.2142f ; **FLOATING
C698 VDD.n48 VSS 0.02735f ; **FLOATING
C699 VDD.n49 VSS 0.21417f ; **FLOATING
C700 VDD.n50 VSS 0.02735f ; **FLOATING
C701 VDD.n51 VSS 0.21421f ; **FLOATING
C702 VDD.t6 VSS 0.02172f ; **FLOATING
C703 VDD.n52 VSS 0.05597f ; **FLOATING
C704 VDD.n53 VSS 0.05603f ; **FLOATING
C705 VDD.n54 VSS 0.05607f ; **FLOATING
C706 VDD.n55 VSS 0.05603f ; **FLOATING
C707 VDD.n56 VSS 0.05614f ; **FLOATING
C708 VDD.n57 VSS 0.05611f ; **FLOATING
C709 VDD.n58 VSS 0.05594f ; **FLOATING
C710 VDD.n59 VSS 0.05615f ; **FLOATING
C711 VDD.n60 VSS 0.05602f ; **FLOATING
C712 VDD.n61 VSS 0.05614f ; **FLOATING
C713 VDD.n62 VSS 0.05612f ; **FLOATING
C714 VDD.n63 VSS 0.05614f ; **FLOATING
C715 VDD.n64 VSS 0.05609f ; **FLOATING
C716 VDD.n65 VSS 0.05611f ; **FLOATING
C717 VDD.n66 VSS 0.05603f ; **FLOATING
C718 VDD.n67 VSS 0.05614f ; **FLOATING
C719 VDD.n68 VSS 0.05614f ; **FLOATING
C720 VDD.n69 VSS 0.05598f ; **FLOATING
C721 VDD.n70 VSS 0.05601f ; **FLOATING
C722 VDD.n71 VSS 0.05602f ; **FLOATING
C723 VDD.n72 VSS 0.05607f ; **FLOATING
C724 VDD.n73 VSS 0.05606f ; **FLOATING
C725 VDD.n74 VSS 0.05606f ; **FLOATING
C726 VDD.n75 VSS 0.05608f ; **FLOATING
C727 VDD.n76 VSS 0.05599f ; **FLOATING
C728 VDD.n77 VSS 0.05605f ; **FLOATING
C729 VDD.n78 VSS 0.05612f ; **FLOATING
C730 VDD.n79 VSS 0.05612f ; **FLOATING
C731 VDD.n80 VSS 0.05608f ; **FLOATING
C732 VDD.n81 VSS 0.05614f ; **FLOATING
C733 VDD.t8 VSS 0.07737f ; **FLOATING
C734 VDD.t13 VSS 0.03688f ; **FLOATING
C735 VDD.t11 VSS 0.03564f ; **FLOATING
C736 VDD.t10 VSS 0.04238f ; **FLOATING
C737 VDD.t103 VSS 0.04326f ; **FLOATING
C738 VDD.t17 VSS 0.04326f ; **FLOATING
C739 VDD.t93 VSS 0.03688f ; **FLOATING
C740 VDD.n82 VSS 0.13925f ; **FLOATING
C741 VDD.t52 VSS 0.04326f ; **FLOATING
C742 VDD.t83 VSS 0.03688f ; **FLOATING
C743 VDD.n83 VSS 0.12111f ; **FLOATING
C744 VDD.t46 VSS 0.04326f ; **FLOATING
C745 VDD.t92 VSS 0.03688f ; **FLOATING
C746 VDD.n84 VSS 0.12121f ; **FLOATING
C747 VDD.t32 VSS 0.04326f ; **FLOATING
C748 VDD.t63 VSS 0.03688f ; **FLOATING
C749 VDD.n85 VSS 0.12113f ; **FLOATING
C750 VDD.t50 VSS 0.04326f ; **FLOATING
C751 VDD.t64 VSS 0.03688f ; **FLOATING
C752 VDD.n86 VSS 0.12118f ; **FLOATING
C753 VDD.t20 VSS 0.04326f ; **FLOATING
C754 VDD.t84 VSS 0.03688f ; **FLOATING
C755 VDD.n87 VSS 0.12126f ; **FLOATING
C756 VDD.t14 VSS 0.04326f ; **FLOATING
C757 VDD.t91 VSS 0.03688f ; **FLOATING
C758 VDD.n88 VSS 0.12115f ; **FLOATING
C759 VDD.t51 VSS 0.04326f ; **FLOATING
C760 VDD.t88 VSS 0.03688f ; **FLOATING
C761 VDD.n89 VSS 0.12122f ; **FLOATING
C762 VDD.t56 VSS 0.04326f ; **FLOATING
C763 VDD.t90 VSS 0.03688f ; **FLOATING
C764 VDD.n90 VSS 0.12119f ; **FLOATING
C765 VDD.t19 VSS 0.04326f ; **FLOATING
C766 VDD.t89 VSS 0.03688f ; **FLOATING
C767 VDD.n91 VSS 0.1212f ; **FLOATING
C768 VDD.t31 VSS 0.04326f ; **FLOATING
C769 VDD.t86 VSS 0.03688f ; **FLOATING
C770 VDD.n92 VSS 0.12118f ; **FLOATING
C771 VDD.t33 VSS 0.04326f ; **FLOATING
C772 VDD.t87 VSS 0.03688f ; **FLOATING
C773 VDD.n93 VSS 0.12125f ; **FLOATING
C774 VDD.t34 VSS 0.04326f ; **FLOATING
C775 VDD.t82 VSS 0.03688f ; **FLOATING
C776 VDD.n94 VSS 0.12129f ; **FLOATING
C777 VDD.t47 VSS 0.04326f ; **FLOATING
C778 VDD.t85 VSS 0.03688f ; **FLOATING
C779 VDD.n95 VSS 0.12117f ; **FLOATING
C780 VDD.t16 VSS 0.04326f ; **FLOATING
C781 VDD.t65 VSS 0.03688f ; **FLOATING
C782 VDD.n96 VSS 0.1211f ; **FLOATING
C783 VDD.t22 VSS 0.04326f ; **FLOATING
C784 VDD.t80 VSS 0.03688f ; **FLOATING
C785 VDD.n97 VSS 0.12118f ; **FLOATING
C786 VDD.t48 VSS 0.04326f ; **FLOATING
C787 VDD.t66 VSS 0.03688f ; **FLOATING
C788 VDD.n98 VSS 0.12119f ; **FLOATING
C789 VDD.t95 VSS 0.04326f ; **FLOATING
C790 VDD.t79 VSS 0.03688f ; **FLOATING
C791 VDD.n99 VSS 0.12116f ; **FLOATING
C792 VDD.t18 VSS 0.04326f ; **FLOATING
C793 VDD.t70 VSS 0.03688f ; **FLOATING
C794 VDD.n100 VSS 0.12113f ; **FLOATING
C795 VDD.t15 VSS 0.04326f ; **FLOATING
C796 VDD.t71 VSS 0.03688f ; **FLOATING
C797 VDD.n101 VSS 0.12115f ; **FLOATING
C798 VDD.t2 VSS 0.04326f ; **FLOATING
C799 VDD.t77 VSS 0.03688f ; **FLOATING
C800 VDD.n102 VSS 0.12112f ; **FLOATING
C801 VDD.t30 VSS 0.04326f ; **FLOATING
C802 VDD.t78 VSS 0.03688f ; **FLOATING
C803 VDD.n103 VSS 0.1212f ; **FLOATING
C804 VDD.t24 VSS 0.04326f ; **FLOATING
C805 VDD.t76 VSS 0.03688f ; **FLOATING
C806 VDD.n104 VSS 0.12114f ; **FLOATING
C807 VDD.t29 VSS 0.04326f ; **FLOATING
C808 VDD.t75 VSS 0.03688f ; **FLOATING
C809 VDD.n105 VSS 0.12124f ; **FLOATING
C810 VDD.t1 VSS 0.04326f ; **FLOATING
C811 VDD.t74 VSS 0.03688f ; **FLOATING
C812 VDD.n106 VSS 0.12124f ; **FLOATING
C813 VDD.t21 VSS 0.04326f ; **FLOATING
C814 VDD.t62 VSS 0.03688f ; **FLOATING
C815 VDD.n107 VSS 0.1211f ; **FLOATING
C816 VDD.t26 VSS 0.04326f ; **FLOATING
C817 VDD.t67 VSS 0.03688f ; **FLOATING
C818 VDD.n108 VSS 0.1212f ; **FLOATING
C819 VDD.t27 VSS 0.04326f ; **FLOATING
C820 VDD.t68 VSS 0.03688f ; **FLOATING
C821 VDD.n109 VSS 0.12118f ; **FLOATING
C822 VDD.t28 VSS 0.04326f ; **FLOATING
C823 VDD.t69 VSS 0.03688f ; **FLOATING
C824 VDD.n110 VSS 0.12119f ; **FLOATING
C825 VDD.t39 VSS 0.04326f ; **FLOATING
C826 VDD.t72 VSS 0.03688f ; **FLOATING
C827 VDD.n111 VSS 0.12128f ; **FLOATING
C828 VDD.t23 VSS 0.04326f ; **FLOATING
C829 VDD.t73 VSS 0.03688f ; **FLOATING
C830 VDD.n112 VSS 0.10403f ; **FLOATING
C831 VDD.t7 VSS 0.0373f ; **FLOATING
C832 VDD.t4 VSS 0.03688f ; **FLOATING
C833 VDD.t3 VSS 0.02663f ; **FLOATING
C834 DELAY_VBIASP.n0 VSS 0.14347f ; **FLOATING
C835 DELAY_VBIASP.t31 VSS 0.36739f ; **FLOATING
C836 DELAY_VBIASP.t30 VSS 0.35917f ; **FLOATING
C837 DELAY_VBIASP.n1 VSS 0.64365f ; **FLOATING
C838 DELAY_VBIASP.t29 VSS 0.35917f ; **FLOATING
C839 DELAY_VBIASP.n2 VSS 0.44541f ; **FLOATING
C840 DELAY_VBIASP.t28 VSS 0.35917f ; **FLOATING
C841 DELAY_VBIASP.n3 VSS 0.44541f ; **FLOATING
C842 DELAY_VBIASP.t27 VSS 0.35917f ; **FLOATING
C843 DELAY_VBIASP.n4 VSS 0.44541f ; **FLOATING
C844 DELAY_VBIASP.t26 VSS 0.35917f ; **FLOATING
C845 DELAY_VBIASP.n5 VSS 0.44541f ; **FLOATING
C846 DELAY_VBIASP.t25 VSS 0.35917f ; **FLOATING
C847 DELAY_VBIASP.n6 VSS 0.44541f ; **FLOATING
C848 DELAY_VBIASP.t24 VSS 0.35917f ; **FLOATING
C849 DELAY_VBIASP.n7 VSS 0.44541f ; **FLOATING
C850 DELAY_VBIASP.t23 VSS 0.35917f ; **FLOATING
C851 DELAY_VBIASP.n8 VSS 0.44541f ; **FLOATING
C852 DELAY_VBIASP.t22 VSS 0.35917f ; **FLOATING
C853 DELAY_VBIASP.n9 VSS 0.44541f ; **FLOATING
C854 DELAY_VBIASP.t21 VSS 0.35917f ; **FLOATING
C855 DELAY_VBIASP.n10 VSS 0.44541f ; **FLOATING
C856 DELAY_VBIASP.t20 VSS 0.35917f ; **FLOATING
C857 DELAY_VBIASP.n11 VSS 0.44541f ; **FLOATING
C858 DELAY_VBIASP.t19 VSS 0.35917f ; **FLOATING
C859 DELAY_VBIASP.n12 VSS 0.44541f ; **FLOATING
C860 DELAY_VBIASP.t18 VSS 0.35917f ; **FLOATING
C861 DELAY_VBIASP.n13 VSS 0.44541f ; **FLOATING
C862 DELAY_VBIASP.t17 VSS 0.35917f ; **FLOATING
C863 DELAY_VBIASP.n14 VSS 0.44541f ; **FLOATING
C864 DELAY_VBIASP.t16 VSS 0.35917f ; **FLOATING
C865 DELAY_VBIASP.n15 VSS 0.44541f ; **FLOATING
C866 DELAY_VBIASP.t15 VSS 0.35917f ; **FLOATING
C867 DELAY_VBIASP.n16 VSS 0.44541f ; **FLOATING
C868 DELAY_VBIASP.t14 VSS 0.35917f ; **FLOATING
C869 DELAY_VBIASP.n17 VSS 0.44541f ; **FLOATING
C870 DELAY_VBIASP.t13 VSS 0.35917f ; **FLOATING
C871 DELAY_VBIASP.n18 VSS 0.44541f ; **FLOATING
C872 DELAY_VBIASP.t12 VSS 0.35917f ; **FLOATING
C873 DELAY_VBIASP.n19 VSS 0.44541f ; **FLOATING
C874 DELAY_VBIASP.t11 VSS 0.35917f ; **FLOATING
C875 DELAY_VBIASP.n20 VSS 0.44541f ; **FLOATING
C876 DELAY_VBIASP.t10 VSS 0.35917f ; **FLOATING
C877 DELAY_VBIASP.n21 VSS 0.44541f ; **FLOATING
C878 DELAY_VBIASP.t9 VSS 0.35917f ; **FLOATING
C879 DELAY_VBIASP.n22 VSS 0.44541f ; **FLOATING
C880 DELAY_VBIASP.t8 VSS 0.35917f ; **FLOATING
C881 DELAY_VBIASP.n23 VSS 0.44541f ; **FLOATING
C882 DELAY_VBIASP.t7 VSS 0.35917f ; **FLOATING
C883 DELAY_VBIASP.n24 VSS 0.44541f ; **FLOATING
C884 DELAY_VBIASP.t6 VSS 0.35917f ; **FLOATING
C885 DELAY_VBIASP.n25 VSS 0.44541f ; **FLOATING
C886 DELAY_VBIASP.t5 VSS 0.35917f ; **FLOATING
C887 DELAY_VBIASP.n26 VSS 0.44541f ; **FLOATING
C888 DELAY_VBIASP.t4 VSS 0.35917f ; **FLOATING
C889 DELAY_VBIASP.n27 VSS 0.44541f ; **FLOATING
C890 DELAY_VBIASP.t3 VSS 0.35917f ; **FLOATING
C891 DELAY_VBIASP.n28 VSS 0.44541f ; **FLOATING
C892 DELAY_VBIASP.t2 VSS 0.35917f ; **FLOATING
C893 DELAY_VBIASP.n29 VSS 0.44541f ; **FLOATING
C894 DELAY_VBIASP.t1 VSS 0.35917f ; **FLOATING
C895 DELAY_VBIASP.n30 VSS 0.44541f ; **FLOATING
C896 DELAY_VBIASP.t0 VSS 0.35917f ; **FLOATING
C897 DELAY_VBIASN.n0 VSS 0.25441f ; **FLOATING
C898 DELAY_VBIASN.t31 VSS 0.15177f ; **FLOATING
C899 DELAY_VBIASN.t30 VSS 0.14732f ; **FLOATING
C900 DELAY_VBIASN.n1 VSS 0.34864f ; **FLOATING
C901 DELAY_VBIASN.t29 VSS 0.14732f ; **FLOATING
C902 DELAY_VBIASN.n2 VSS 0.24183f ; **FLOATING
C903 DELAY_VBIASN.t28 VSS 0.14732f ; **FLOATING
C904 DELAY_VBIASN.n3 VSS 0.24183f ; **FLOATING
C905 DELAY_VBIASN.t27 VSS 0.14732f ; **FLOATING
C906 DELAY_VBIASN.n4 VSS 0.24183f ; **FLOATING
C907 DELAY_VBIASN.t26 VSS 0.14732f ; **FLOATING
C908 DELAY_VBIASN.n5 VSS 0.24183f ; **FLOATING
C909 DELAY_VBIASN.t25 VSS 0.14732f ; **FLOATING
C910 DELAY_VBIASN.n6 VSS 0.24183f ; **FLOATING
C911 DELAY_VBIASN.t24 VSS 0.14732f ; **FLOATING
C912 DELAY_VBIASN.n7 VSS 0.24183f ; **FLOATING
C913 DELAY_VBIASN.t23 VSS 0.14732f ; **FLOATING
C914 DELAY_VBIASN.n8 VSS 0.24183f ; **FLOATING
C915 DELAY_VBIASN.t22 VSS 0.14732f ; **FLOATING
C916 DELAY_VBIASN.n9 VSS 0.24183f ; **FLOATING
C917 DELAY_VBIASN.t21 VSS 0.14732f ; **FLOATING
C918 DELAY_VBIASN.n10 VSS 0.24183f ; **FLOATING
C919 DELAY_VBIASN.t20 VSS 0.14732f ; **FLOATING
C920 DELAY_VBIASN.n11 VSS 0.24183f ; **FLOATING
C921 DELAY_VBIASN.t19 VSS 0.14732f ; **FLOATING
C922 DELAY_VBIASN.n12 VSS 0.24183f ; **FLOATING
C923 DELAY_VBIASN.t18 VSS 0.14732f ; **FLOATING
C924 DELAY_VBIASN.n13 VSS 0.24183f ; **FLOATING
C925 DELAY_VBIASN.t17 VSS 0.14732f ; **FLOATING
C926 DELAY_VBIASN.n14 VSS 0.24183f ; **FLOATING
C927 DELAY_VBIASN.t16 VSS 0.14732f ; **FLOATING
C928 DELAY_VBIASN.n15 VSS 0.24183f ; **FLOATING
C929 DELAY_VBIASN.t15 VSS 0.14732f ; **FLOATING
C930 DELAY_VBIASN.n16 VSS 0.24183f ; **FLOATING
C931 DELAY_VBIASN.t14 VSS 0.14732f ; **FLOATING
C932 DELAY_VBIASN.n17 VSS 0.24183f ; **FLOATING
C933 DELAY_VBIASN.t13 VSS 0.14732f ; **FLOATING
C934 DELAY_VBIASN.n18 VSS 0.24183f ; **FLOATING
C935 DELAY_VBIASN.t12 VSS 0.14732f ; **FLOATING
C936 DELAY_VBIASN.n19 VSS 0.24183f ; **FLOATING
C937 DELAY_VBIASN.t11 VSS 0.14732f ; **FLOATING
C938 DELAY_VBIASN.n20 VSS 0.24183f ; **FLOATING
C939 DELAY_VBIASN.t10 VSS 0.14732f ; **FLOATING
C940 DELAY_VBIASN.n21 VSS 0.24183f ; **FLOATING
C941 DELAY_VBIASN.t9 VSS 0.14732f ; **FLOATING
C942 DELAY_VBIASN.n22 VSS 0.24183f ; **FLOATING
C943 DELAY_VBIASN.t8 VSS 0.14732f ; **FLOATING
C944 DELAY_VBIASN.n23 VSS 0.24183f ; **FLOATING
C945 DELAY_VBIASN.t7 VSS 0.14732f ; **FLOATING
C946 DELAY_VBIASN.n24 VSS 0.24183f ; **FLOATING
C947 DELAY_VBIASN.t6 VSS 0.14732f ; **FLOATING
C948 DELAY_VBIASN.n25 VSS 0.24183f ; **FLOATING
C949 DELAY_VBIASN.t5 VSS 0.14732f ; **FLOATING
C950 DELAY_VBIASN.n26 VSS 0.24183f ; **FLOATING
C951 DELAY_VBIASN.t4 VSS 0.14732f ; **FLOATING
C952 DELAY_VBIASN.n27 VSS 0.24183f ; **FLOATING
C953 DELAY_VBIASN.t3 VSS 0.14732f ; **FLOATING
C954 DELAY_VBIASN.n28 VSS 0.24183f ; **FLOATING
C955 DELAY_VBIASN.t2 VSS 0.14732f ; **FLOATING
C956 DELAY_VBIASN.n29 VSS 0.24183f ; **FLOATING
C957 DELAY_VBIASN.t1 VSS 0.14732f ; **FLOATING
C958 DELAY_VBIASN.n30 VSS 0.24183f ; **FLOATING
C959 DELAY_VBIASN.t0 VSS 0.14732f ; **FLOATING
.ends
