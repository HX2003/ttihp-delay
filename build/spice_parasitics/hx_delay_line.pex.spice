* NGSPICE file created from hx_delay_line.ext - technology: ihp-sg13g2

.subckt hx_delay_line VSS VDD DELAY_OUT_LAST DELAY_OUT_TAP1 DELAY_OUT_TAP2 DELAY_OUT_TAP3
+ DELAY_OUT_TAP4 DELAY_OUT_TAP5 DELAY_OUT_TAP6 DELAY_OUT_TAP7 DELAY_OUT_TAP8 DELAY_OUT_TAP9
+ DELAY_OUT_TAP10 DELAY_OUT_TAP11 DELAY_OUT_TAP12 DELAY_OUT_TAP13 DELAY_OUT_TAP14
+ DELAY_OUT_TAP15 DELAY_OUT_TAP16 DELAY_OUT_TAP17 DELAY_OUT_TAP18 DELAY_OUT_TAP19
+ DELAY_OUT_TAP20 DELAY_OUT_TAP21 DELAY_OUT_TAP22 DELAY_OUT_TAP23 DELAY_OUT_TAP24
+ DELAY_OUT_TAP25 DELAY_OUT_TAP26 DELAY_OUT_TAP27 DELAY_OUT_TAP28 DELAY_OUT_TAP29
+ DELAY_OUT_TAP30 DELAY_OUT_TAP31 DELAY_IN DELAY_VBIASN DELAY_VBIASP
X0 VDD.t30 DELAY_VBIASP.t3 a_25131_2470# VDD.t0 sg13_lv_pmos ad=0.3808p pd=2.92u as=0.2128p ps=1.5u w=1.12u l=0.6u
X1 VSS.t38 a_5263_1842# DELAY_OUT_TAP3 VSS.t56 sg13_lv_nmos ad=0.1406p pd=1.12u as=0.2516p ps=2.16u w=0.74u l=0.13u
X2 VDD.t11 DELAY_VBIASP.t31 a_3851_2470# VDD.t0 sg13_lv_pmos ad=0.3808p pd=2.92u as=0.2128p ps=1.5u w=1.12u l=0.6u
X3 a_27411_2470# a_27173_1842# a_27303_1842# VDD.t0 sg13_lv_pmos ad=0.2128p pd=1.5u as=0.3808p ps=2.92u w=1.12u l=0.2u
X4 a_9171_1842# a_8933_1842# a_9063_1842# VSS.t60 sg13_lv_nmos ad=0.1406p pd=1.12u as=0.2516p ps=2.16u w=0.74u l=0.2u
X5 a_18053_1842# DELAY_OUT_TAP19 VSS.t112 VSS.t111 sg13_lv_nmos ad=0.2516p pd=2.16u as=0.1406p ps=1.12u w=0.74u l=0.13u
X6 a_15013_1842# DELAY_OUT_TAP15 VDD.t69 VDD.t0 sg13_lv_pmos ad=0.3808p pd=2.92u as=0.2128p ps=1.5u w=1.12u l=0.13u
X7 VDD.t7 DELAY_VBIASP.t15 a_16011_2470# VDD.t0 sg13_lv_pmos ad=0.3808p pd=2.92u as=0.2128p ps=1.5u w=1.12u l=0.6u
X8 VSS.t62 a_7543_1842# DELAY_OUT_TAP6 VSS.t61 sg13_lv_nmos ad=0.1406p pd=1.12u as=0.2516p ps=2.16u w=0.74u l=0.13u
X9 VDD.t13 DELAY_VBIASP.t28 a_6131_2470# VDD.t0 sg13_lv_pmos ad=0.3808p pd=2.92u as=0.2128p ps=1.5u w=1.12u l=0.6u
X10 VDD.t71 a_25783_1842# DELAY_OUT_TAP30 VDD.t0 sg13_lv_pmos ad=0.2128p pd=1.5u as=0.3808p ps=2.92u w=1.12u l=0.13u
X11 a_14491_1842# a_14253_1842# a_14383_1842# VSS.t26 sg13_lv_nmos ad=0.1406p pd=1.12u as=0.2516p ps=2.16u w=0.74u l=0.2u
X12 a_8411_2470# a_8173_1842# a_8303_1842# VDD.t0 sg13_lv_pmos ad=0.2128p pd=1.5u as=0.3808p ps=2.92u w=1.12u l=0.2u
X13 a_17293_1842# DELAY_OUT_TAP18 VDD.t70 VDD.t0 sg13_lv_pmos ad=0.3808p pd=2.92u as=0.2128p ps=1.5u w=1.12u l=0.13u
X14 VSS.t48 VSS.t44 VSS.t44 VSS.t46 sg13_lv_nmos ad=0.1406p pd=1.12u as=0 ps=0 w=0.74u l=0.13u
X15 VDD.t92 a_17423_1842# DELAY_OUT_TAP19 VDD.t0 sg13_lv_pmos ad=0.2128p pd=1.5u as=0.3808p ps=2.92u w=1.12u l=0.13u
X16 a_21093_1842# DELAY_OUT_TAP23 VDD.t83 VDD.t0 sg13_lv_pmos ad=0.3808p pd=2.92u as=0.2128p ps=1.5u w=1.12u l=0.13u
X17 a_22851_2470# a_22613_1842# a_22743_1842# VDD.t0 sg13_lv_pmos ad=0.2128p pd=1.5u as=0.3808p ps=2.92u w=1.12u l=0.2u
X18 VSS.t73 a_12863_1842# DELAY_OUT_TAP13 VSS.t72 sg13_lv_nmos ad=0.1406p pd=1.12u as=0.2516p ps=2.16u w=0.74u l=0.13u
X19 VDD.t38 a_6783_1842# DELAY_OUT_TAP5 VDD.t0 sg13_lv_pmos ad=0.2128p pd=1.5u as=0.3808p ps=2.92u w=1.12u l=0.13u
X20 VDD.t5 DELAY_VBIASP.t21 a_11451_2470# VDD.t0 sg13_lv_pmos ad=0.3808p pd=2.92u as=0.2128p ps=1.5u w=1.12u l=0.6u
X21 VDD.t64 a_21223_1842# DELAY_OUT_TAP24 VDD.t0 sg13_lv_pmos ad=0.2128p pd=1.5u as=0.3808p ps=2.92u w=1.12u l=0.13u
X22 a_12733_1842# DELAY_OUT_TAP12 VDD.t1 VDD.t0 sg13_lv_pmos ad=0.3808p pd=2.92u as=0.2128p ps=1.5u w=1.12u l=0.13u
X23 a_13731_2470# a_13493_1842# a_13623_1842# VDD.t0 sg13_lv_pmos ad=0.2128p pd=1.5u as=0.3808p ps=2.92u w=1.12u l=0.2u
X24 a_3851_2470# DELAY_IN a_3743_1842# VDD.t0 sg13_lv_pmos ad=0.2128p pd=1.5u as=0.3808p ps=2.92u w=1.12u l=0.2u
X25 VSS.t118 DELAY_VBIASN.t12 a_18291_1842# VSS.t131 sg13_lv_nmos ad=0.2516p pd=2.16u as=0.1406p ps=1.12u w=0.74u l=0.6u
X26 VDD.t42 a_23503_1842# DELAY_OUT_TAP27 VDD.t0 sg13_lv_pmos ad=0.2128p pd=1.5u as=0.3808p ps=2.92u w=1.12u l=0.13u
X27 VDD.t33 DELAY_VBIASP.t1 a_26651_2470# VDD.t0 sg13_lv_pmos ad=0.3808p pd=2.92u as=0.2128p ps=1.5u w=1.12u l=0.6u
X28 VSS.t83 DELAY_VBIASN.t7 a_22091_1842# VSS.t148 sg13_lv_nmos ad=0.2516p pd=2.16u as=0.1406p ps=1.12u w=0.74u l=0.6u
X29 a_19573_1842# DELAY_OUT_TAP21 VSS.t41 VSS.t110 sg13_lv_nmos ad=0.2516p pd=2.16u as=0.1406p ps=1.12u w=0.74u l=0.13u
X30 VDD.t39 a_4503_1842# DELAY_OUT_TAP2 VDD.t0 sg13_lv_pmos ad=0.2128p pd=1.5u as=0.3808p ps=2.92u w=1.12u l=0.13u
X31 DELAY_OUT_LAST a_27737_1842# VDD.t101 VDD.t0 sg13_lv_pmos ad=0.3808p pd=2.92u as=0.2128p ps=1.5u w=1.12u l=0.13u
X32 VSS.t70 a_9063_1842# DELAY_OUT_TAP8 VSS.t69 sg13_lv_nmos ad=0.1406p pd=1.12u as=0.2516p ps=2.16u w=0.74u l=0.13u
X33 a_23373_1842# DELAY_OUT_TAP26 VSS.t93 VSS.t92 sg13_lv_nmos ad=0.2516p pd=2.16u as=0.1406p ps=1.12u w=0.74u l=0.13u
X34 VDD.t16 DELAY_VBIASP.t26 a_7651_2470# VDD.t0 sg13_lv_pmos ad=0.3808p pd=2.92u as=0.2128p ps=1.5u w=1.12u l=0.6u
X35 VSS.t20 DELAY_VBIASN.t18 a_13731_1842# VSS.t146 sg13_lv_nmos ad=0.2516p pd=2.16u as=0.1406p ps=1.12u w=0.74u l=0.6u
X36 a_9931_2470# a_9693_1842# a_9823_1842# VDD.t0 sg13_lv_pmos ad=0.2128p pd=1.5u as=0.3808p ps=2.92u w=1.12u l=0.2u
X37 a_11451_2470# a_11213_1842# a_11343_1842# VDD.t0 sg13_lv_pmos ad=0.2128p pd=1.5u as=0.3808p ps=2.92u w=1.12u l=0.2u
X38 a_18813_1842# DELAY_OUT_TAP20 VDD.t96 VDD.t0 sg13_lv_pmos ad=0.3808p pd=2.92u as=0.2128p ps=1.5u w=1.12u l=0.13u
X39 a_16011_1842# a_15773_1842# a_15903_1842# VSS.t25 sg13_lv_nmos ad=0.1406p pd=1.12u as=0.2516p ps=2.16u w=0.74u l=0.2u
X40 a_8933_1842# DELAY_OUT_TAP7 VDD.t86 VDD.t0 sg13_lv_pmos ad=0.3808p pd=2.92u as=0.2128p ps=1.5u w=1.12u l=0.13u
X41 VDD.t66 a_9823_1842# DELAY_OUT_TAP9 VDD.t0 sg13_lv_pmos ad=0.2128p pd=1.5u as=0.3808p ps=2.92u w=1.12u l=0.13u
X42 a_22613_1842# DELAY_OUT_TAP25 VDD.t72 VDD.t0 sg13_lv_pmos ad=0.3808p pd=2.92u as=0.2128p ps=1.5u w=1.12u l=0.13u
X43 a_4373_1842# DELAY_OUT_TAP1 VSS.t7 VSS.t33 sg13_lv_nmos ad=0.2516p pd=2.16u as=0.1406p ps=1.12u w=0.74u l=0.13u
X44 VSS.t75 a_14383_1842# DELAY_OUT_TAP15 VSS.t74 sg13_lv_nmos ad=0.1406p pd=1.12u as=0.2516p ps=2.16u w=0.74u l=0.13u
X45 a_18291_1842# a_18053_1842# a_18183_1842# VSS.t170 sg13_lv_nmos ad=0.1406p pd=1.12u as=0.2516p ps=2.16u w=0.74u l=0.2u
X46 a_26651_2470# a_26413_1842# a_26543_1842# VDD.t0 sg13_lv_pmos ad=0.2128p pd=1.5u as=0.3808p ps=2.92u w=1.12u l=0.2u
X47 a_22091_1842# a_21853_1842# a_21983_1842# VSS.t84 sg13_lv_nmos ad=0.1406p pd=1.12u as=0.2516p ps=2.16u w=0.74u l=0.2u
X48 VSS.t78 a_16663_1842# DELAY_OUT_TAP18 VSS.t77 sg13_lv_nmos ad=0.1406p pd=1.12u as=0.2516p ps=2.16u w=0.74u l=0.13u
X49 VDD.t3 DELAY_VBIASP.t16 a_15251_2470# VDD.t0 sg13_lv_pmos ad=0.3808p pd=2.92u as=0.2128p ps=1.5u w=1.12u l=0.6u
X50 VSS.t10 DELAY_VBIASN.t10 a_19811_1842# VSS.t150 sg13_lv_nmos ad=0.2516p pd=2.16u as=0.1406p ps=1.12u w=0.74u l=0.6u
X51 VDD.t82 a_25023_1842# DELAY_OUT_TAP29 VDD.t0 sg13_lv_pmos ad=0.2128p pd=1.5u as=0.3808p ps=2.92u w=1.12u l=0.13u
X52 VSS.t28 DELAY_VBIASN.t5 a_23611_1842# VSS.t127 sg13_lv_nmos ad=0.2516p pd=2.16u as=0.1406p ps=1.12u w=0.74u l=0.6u
X53 a_17531_2470# a_17293_1842# a_17423_1842# VDD.t0 sg13_lv_pmos ad=0.2128p pd=1.5u as=0.3808p ps=2.92u w=1.12u l=0.2u
X54 a_7651_2470# a_7413_1842# a_7543_1842# VDD.t0 sg13_lv_pmos ad=0.2128p pd=1.5u as=0.3808p ps=2.92u w=1.12u l=0.2u
X55 a_16533_1842# DELAY_OUT_TAP17 VDD.t37 VDD.t0 sg13_lv_pmos ad=0.3808p pd=2.92u as=0.2128p ps=1.5u w=1.12u l=0.13u
X56 a_20333_1842# DELAY_OUT_TAP22 VDD.t36 VDD.t0 sg13_lv_pmos ad=0.3808p pd=2.92u as=0.2128p ps=1.5u w=1.12u l=0.13u
X57 a_21331_2470# a_21093_1842# a_21223_1842# VDD.t0 sg13_lv_pmos ad=0.2128p pd=1.5u as=0.3808p ps=2.92u w=1.12u l=0.2u
X58 a_24893_1842# DELAY_OUT_TAP28 VSS.t101 VSS.t100 sg13_lv_nmos ad=0.2516p pd=2.16u as=0.1406p ps=1.12u w=0.74u l=0.13u
X59 VSS.t2 a_12103_1842# DELAY_OUT_TAP12 VSS.t1 sg13_lv_nmos ad=0.1406p pd=1.12u as=0.2516p ps=2.16u w=0.74u l=0.13u
X60 VDD.t44 a_6023_1842# DELAY_OUT_TAP4 VDD.t0 sg13_lv_pmos ad=0.2128p pd=1.5u as=0.3808p ps=2.92u w=1.12u l=0.13u
X61 VSS.t18 DELAY_VBIASN.t30 a_4611_1842# VSS.t125 sg13_lv_nmos ad=0.2516p pd=2.16u as=0.1406p ps=1.12u w=0.74u l=0.6u
X62 a_11213_1842# DELAY_OUT_TAP10 VDD.t41 VDD.t0 sg13_lv_pmos ad=0.3808p pd=2.92u as=0.2128p ps=1.5u w=1.12u l=0.13u
X63 a_12971_2470# a_12733_1842# a_12863_1842# VDD.t0 sg13_lv_pmos ad=0.2128p pd=1.5u as=0.3808p ps=2.92u w=1.12u l=0.2u
X64 VDD.t46 a_11343_1842# DELAY_OUT_TAP11 VDD.t0 sg13_lv_pmos ad=0.2128p pd=1.5u as=0.3808p ps=2.92u w=1.12u l=0.13u
X65 a_5893_1842# DELAY_OUT_TAP3 VSS.t38 VSS.t37 sg13_lv_nmos ad=0.2516p pd=2.16u as=0.1406p ps=1.12u w=0.74u l=0.13u
X66 a_27173_1842# DELAY_OUT_TAP31 VSS.t30 VSS.t120 sg13_lv_nmos ad=0.2516p pd=2.16u as=0.1406p ps=1.12u w=0.74u l=0.13u
X67 VSS.t112 DELAY_VBIASN.t13 a_17531_1842# VSS.t136 sg13_lv_nmos ad=0.2516p pd=2.16u as=0.1406p ps=1.12u w=0.74u l=0.6u
X68 VSS.t160 a_27303_1842# a_27737_1842# VSS.t169 sg13_lv_nmos ad=0.1406p pd=1.12u as=0.2516p ps=2.16u w=0.74u l=0.13u
X69 VSS.t64 DELAY_VBIASN.t8 a_21331_1842# VSS.t149 sg13_lv_nmos ad=0.2516p pd=2.16u as=0.1406p ps=1.12u w=0.74u l=0.6u
X70 a_15251_2470# a_15013_1842# a_15143_1842# VDD.t0 sg13_lv_pmos ad=0.2128p pd=1.5u as=0.3808p ps=2.92u w=1.12u l=0.2u
X71 VSS.t51 VSS.t53 VSS.t53 VSS.t54 sg13_lv_nmos ad=0.1406p pd=1.12u as=0 ps=0 w=0.74u l=0.2u
X72 a_19811_1842# a_19573_1842# a_19703_1842# VSS.t81 sg13_lv_nmos ad=0.1406p pd=1.12u as=0.2516p ps=2.16u w=0.74u l=0.2u
X73 a_8173_1842# DELAY_OUT_TAP6 VSS.t62 VSS.t87 sg13_lv_nmos ad=0.2516p pd=2.16u as=0.1406p ps=1.12u w=0.74u l=0.13u
X74 a_23611_1842# a_23373_1842# a_23503_1842# VSS.t21 sg13_lv_nmos ad=0.1406p pd=1.12u as=0.2516p ps=2.16u w=0.74u l=0.2u
X75 VDD.t40 a_13623_1842# DELAY_OUT_TAP14 VDD.t0 sg13_lv_pmos ad=0.2128p pd=1.5u as=0.3808p ps=2.92u w=1.12u l=0.13u
X76 a_26413_1842# DELAY_OUT_TAP30 VDD.t71 VDD.t0 sg13_lv_pmos ad=0.3808p pd=2.92u as=0.2128p ps=1.5u w=1.12u l=0.13u
X77 VSS.t104 a_8303_1842# DELAY_OUT_TAP7 VSS.t103 sg13_lv_nmos ad=0.1406p pd=1.12u as=0.2516p ps=2.16u w=0.74u l=0.13u
X78 VSS.t118 a_18183_1842# DELAY_OUT_TAP20 VSS.t171 sg13_lv_nmos ad=0.1406p pd=1.12u as=0.2516p ps=2.16u w=0.74u l=0.13u
X79 VSS.t2 DELAY_VBIASN.t20 a_12211_1842# VSS.t123 sg13_lv_nmos ad=0.2516p pd=2.16u as=0.1406p ps=1.12u w=0.74u l=0.6u
X80 VDD.t22 DELAY_VBIASP.t14 a_16771_2470# VDD.t0 sg13_lv_pmos ad=0.3808p pd=2.92u as=0.2128p ps=1.5u w=1.12u l=0.6u
X81 VSS.t83 a_21983_1842# DELAY_OUT_TAP25 VSS.t82 sg13_lv_nmos ad=0.1406p pd=1.12u as=0.2516p ps=2.16u w=0.74u l=0.13u
X82 VDD.t27 DELAY_VBIASP.t9 a_20571_2470# VDD.t0 sg13_lv_pmos ad=0.3808p pd=2.92u as=0.2128p ps=1.5u w=1.12u l=0.6u
X83 a_4611_1842# a_4373_1842# a_4503_1842# VSS.t65 sg13_lv_nmos ad=0.1406p pd=1.12u as=0.2516p ps=2.16u w=0.74u l=0.2u
X84 a_13493_1842# DELAY_OUT_TAP13 VSS.t73 VSS.t88 sg13_lv_nmos ad=0.2516p pd=2.16u as=0.1406p ps=1.12u w=0.74u l=0.13u
X85 a_7413_1842# DELAY_OUT_TAP5 VDD.t38 VDD.t0 sg13_lv_pmos ad=0.3808p pd=2.92u as=0.2128p ps=1.5u w=1.12u l=0.13u
X86 VDD.t23 DELAY_VBIASP.t11 a_19051_2470# VDD.t0 sg13_lv_pmos ad=0.3808p pd=2.92u as=0.2128p ps=1.5u w=1.12u l=0.6u
X87 a_21853_1842# DELAY_OUT_TAP24 VDD.t64 VDD.t0 sg13_lv_pmos ad=0.3808p pd=2.92u as=0.2128p ps=1.5u w=1.12u l=0.13u
X88 VSS.t134 DELAY_VBIASN.t0 a_27411_1842# VSS.t133 sg13_lv_nmos ad=0.2516p pd=2.16u as=0.1406p ps=1.12u w=0.74u l=0.6u
X89 a_25131_2470# a_24893_1842# a_25023_1842# VDD.t0 sg13_lv_pmos ad=0.2128p pd=1.5u as=0.3808p ps=2.92u w=1.12u l=0.2u
X90 VSS.t14 a_15903_1842# DELAY_OUT_TAP17 VSS.t13 sg13_lv_nmos ad=0.1406p pd=1.12u as=0.2516p ps=2.16u w=0.74u l=0.13u
X91 a_24133_1842# DELAY_OUT_TAP27 VDD.t42 VDD.t0 sg13_lv_pmos ad=0.3808p pd=2.92u as=0.2128p ps=1.5u w=1.12u l=0.13u
X92 VSS.t68 DELAY_VBIASN.t23 a_9931_1842# VSS.t129 sg13_lv_nmos ad=0.2516p pd=2.16u as=0.1406p ps=1.12u w=0.74u l=0.6u
X93 VSS.t104 DELAY_VBIASN.t25 a_8411_1842# VSS.t140 sg13_lv_nmos ad=0.2516p pd=2.16u as=0.1406p ps=1.12u w=0.74u l=0.6u
X94 VSS.t10 a_19703_1842# DELAY_OUT_TAP22 VSS.t9 sg13_lv_nmos ad=0.1406p pd=1.12u as=0.2516p ps=2.16u w=0.74u l=0.13u
X95 a_16771_2470# a_16533_1842# a_16663_1842# VDD.t0 sg13_lv_pmos ad=0.2128p pd=1.5u as=0.3808p ps=2.92u w=1.12u l=0.2u
X96 VSS.t93 DELAY_VBIASN.t6 a_22851_1842# VSS.t135 sg13_lv_nmos ad=0.2516p pd=2.16u as=0.1406p ps=1.12u w=0.74u l=0.6u
X97 a_12211_1842# a_11973_1842# a_12103_1842# VSS.t3 sg13_lv_nmos ad=0.1406p pd=1.12u as=0.2516p ps=2.16u w=0.74u l=0.2u
X98 a_6131_2470# a_5893_1842# a_6023_1842# VDD.t0 sg13_lv_pmos ad=0.2128p pd=1.5u as=0.3808p ps=2.92u w=1.12u l=0.2u
X99 a_5133_1842# DELAY_OUT_TAP2 VDD.t39 VDD.t0 sg13_lv_pmos ad=0.3808p pd=2.92u as=0.2128p ps=1.5u w=1.12u l=0.13u
X100 VDD.t2 a_15143_1842# DELAY_OUT_TAP16 VDD.t0 sg13_lv_pmos ad=0.2128p pd=1.5u as=0.3808p ps=2.92u w=1.12u l=0.13u
X101 a_20571_2470# a_20333_1842# a_20463_1842# VDD.t0 sg13_lv_pmos ad=0.2128p pd=1.5u as=0.3808p ps=2.92u w=1.12u l=0.2u
X102 a_9693_1842# DELAY_OUT_TAP8 VSS.t70 VSS.t107 sg13_lv_nmos ad=0.2516p pd=2.16u as=0.1406p ps=1.12u w=0.74u l=0.13u
X103 VSS.t24 a_10583_1842# DELAY_OUT_TAP10 VSS.t23 sg13_lv_nmos ad=0.1406p pd=1.12u as=0.2516p ps=2.16u w=0.74u l=0.13u
X104 VSS.t7 DELAY_VBIASN.t31 a_3851_1842# VSS.t138 sg13_lv_nmos ad=0.2516p pd=2.16u as=0.1406p ps=1.12u w=0.74u l=0.6u
X105 VSS.t97 DELAY_VBIASN.t3 a_25131_1842# VSS.t152 sg13_lv_nmos ad=0.2516p pd=2.16u as=0.1406p ps=1.12u w=0.74u l=0.6u
X106 a_19051_2470# a_18813_1842# a_18943_1842# VDD.t0 sg13_lv_pmos ad=0.2128p pd=1.5u as=0.3808p ps=2.92u w=1.12u l=0.2u
X107 a_10453_1842# DELAY_OUT_TAP9 VDD.t66 VDD.t0 sg13_lv_pmos ad=0.3808p pd=2.92u as=0.2128p ps=1.5u w=1.12u l=0.13u
X108 a_27411_1842# a_27173_1842# a_27303_1842# VSS.t165 sg13_lv_nmos ad=0.1406p pd=1.12u as=0.2516p ps=2.16u w=0.74u l=0.2u
X109 a_15013_1842# DELAY_OUT_TAP15 VSS.t75 VSS.t91 sg13_lv_nmos ad=0.2516p pd=2.16u as=0.1406p ps=1.12u w=0.74u l=0.13u
X110 VSS.t80 a_25783_1842# DELAY_OUT_TAP30 VSS.t167 sg13_lv_nmos ad=0.1406p pd=1.12u as=0.2516p ps=2.16u w=0.74u l=0.13u
X111 VSS.t14 DELAY_VBIASN.t15 a_16011_1842# VSS.t144 sg13_lv_nmos ad=0.2516p pd=2.16u as=0.1406p ps=1.12u w=0.74u l=0.6u
X112 VDD.t32 DELAY_VBIASP.t4 a_24371_2470# VDD.t0 sg13_lv_pmos ad=0.3808p pd=2.92u as=0.2128p ps=1.5u w=1.12u l=0.6u
X113 VSS.t32 DELAY_VBIASN.t28 a_6131_1842# VSS.t137 sg13_lv_nmos ad=0.2516p pd=2.16u as=0.1406p ps=1.12u w=0.74u l=0.6u
X114 VDD.t49 VDD.t47 VDD.t48 VDD.t0 sg13_lv_pmos ad=0.3808p pd=2.92u as=0 ps=0 w=1.12u l=0.13u
X115 a_8411_1842# a_8173_1842# a_8303_1842# VSS.t71 sg13_lv_nmos ad=0.1406p pd=1.12u as=0.2516p ps=2.16u w=0.74u l=0.2u
X116 a_22851_1842# a_22613_1842# a_22743_1842# VSS.t163 sg13_lv_nmos ad=0.1406p pd=1.12u as=0.2516p ps=2.16u w=0.74u l=0.2u
X117 a_17293_1842# DELAY_OUT_TAP18 VSS.t78 VSS.t113 sg13_lv_nmos ad=0.2516p pd=2.16u as=0.1406p ps=1.12u w=0.74u l=0.13u
X118 a_25653_1842# DELAY_OUT_TAP29 VDD.t82 VDD.t0 sg13_lv_pmos ad=0.3808p pd=2.92u as=0.2128p ps=1.5u w=1.12u l=0.13u
X119 VSS.t16 a_6783_1842# DELAY_OUT_TAP5 VSS.t55 sg13_lv_nmos ad=0.1406p pd=1.12u as=0.2516p ps=2.16u w=0.74u l=0.13u
X120 a_21093_1842# DELAY_OUT_TAP23 VSS.t99 VSS.t98 sg13_lv_nmos ad=0.2516p pd=2.16u as=0.1406p ps=1.12u w=0.74u l=0.13u
X121 VSS.t112 a_17423_1842# DELAY_OUT_TAP19 VSS.t172 sg13_lv_nmos ad=0.1406p pd=1.12u as=0.2516p ps=2.16u w=0.74u l=0.13u
X122 VDD.t14 DELAY_VBIASP.t29 a_5371_2470# VDD.t0 sg13_lv_pmos ad=0.3808p pd=2.92u as=0.2128p ps=1.5u w=1.12u l=0.6u
X123 VSS.t64 a_21223_1842# DELAY_OUT_TAP24 VSS.t85 sg13_lv_nmos ad=0.1406p pd=1.12u as=0.2516p ps=2.16u w=0.74u l=0.13u
X124 VSS.t35 DELAY_VBIASN.t21 a_11451_1842# VSS.t143 sg13_lv_nmos ad=0.2516p pd=2.16u as=0.1406p ps=1.12u w=0.74u l=0.6u
X125 a_3851_1842# DELAY_IN a_3743_1842# VSS.t86 sg13_lv_nmos ad=0.1406p pd=1.12u as=0.2516p ps=2.16u w=0.74u l=0.2u
X126 a_13731_1842# a_13493_1842# a_13623_1842# VSS.t36 sg13_lv_nmos ad=0.1406p pd=1.12u as=0.2516p ps=2.16u w=0.74u l=0.2u
X127 a_12733_1842# DELAY_OUT_TAP12 VSS.t2 VSS.t89 sg13_lv_nmos ad=0.2516p pd=2.16u as=0.1406p ps=1.12u w=0.74u l=0.13u
X128 a_6653_1842# DELAY_OUT_TAP4 VDD.t44 VDD.t0 sg13_lv_pmos ad=0.3808p pd=2.92u as=0.2128p ps=1.5u w=1.12u l=0.13u
X129 VSS.t28 a_23503_1842# DELAY_OUT_TAP27 VSS.t27 sg13_lv_nmos ad=0.1406p pd=1.12u as=0.2516p ps=2.16u w=0.74u l=0.13u
X130 VDD.t10 DELAY_VBIASP.t22 a_10691_2470# VDD.t0 sg13_lv_pmos ad=0.3808p pd=2.92u as=0.2128p ps=1.5u w=1.12u l=0.6u
X131 VDD.t83 a_20463_1842# DELAY_OUT_TAP23 VDD.t0 sg13_lv_pmos ad=0.2128p pd=1.5u as=0.3808p ps=2.92u w=1.12u l=0.13u
X132 VSS.t30 DELAY_VBIASN.t1 a_26651_1842# VSS.t132 sg13_lv_nmos ad=0.2516p pd=2.16u as=0.1406p ps=1.12u w=0.74u l=0.6u
X133 a_24371_2470# a_24133_1842# a_24263_1842# VDD.t0 sg13_lv_pmos ad=0.2128p pd=1.5u as=0.3808p ps=2.92u w=1.12u l=0.2u
X134 a_11973_1842# DELAY_OUT_TAP11 VDD.t46 VDD.t0 sg13_lv_pmos ad=0.3808p pd=2.92u as=0.2128p ps=1.5u w=1.12u l=0.13u
X135 VDD.t9 DELAY_VBIASP.t19 a_12971_2470# VDD.t0 sg13_lv_pmos ad=0.3808p pd=2.92u as=0.2128p ps=1.5u w=1.12u l=0.6u
X136 VDD.t60 a_18943_1842# DELAY_OUT_TAP21 VDD.t0 sg13_lv_pmos ad=0.2128p pd=1.5u as=0.3808p ps=2.92u w=1.12u l=0.13u
X137 VSS.t18 a_4503_1842# DELAY_OUT_TAP2 VSS.t66 sg13_lv_nmos ad=0.1406p pd=1.12u as=0.2516p ps=2.16u w=0.74u l=0.13u
X138 DELAY_OUT_LAST a_27737_1842# VSS.t160 VSS.t159 sg13_lv_nmos ad=0.2516p pd=2.16u as=0.1406p ps=1.12u w=0.74u l=0.13u
X139 VDD.t79 a_22743_1842# DELAY_OUT_TAP26 VDD.t0 sg13_lv_pmos ad=0.2128p pd=1.5u as=0.3808p ps=2.92u w=1.12u l=0.13u
X140 VSS.t62 DELAY_VBIASN.t26 a_7651_1842# VSS.t121 sg13_lv_nmos ad=0.2516p pd=2.16u as=0.1406p ps=1.12u w=0.74u l=0.6u
X141 VDD.t34 DELAY_VBIASP.t2 a_25891_2470# VDD.t0 sg13_lv_pmos ad=0.3808p pd=2.92u as=0.2128p ps=1.5u w=1.12u l=0.6u
X142 a_11451_1842# a_11213_1842# a_11343_1842# VSS.t12 sg13_lv_nmos ad=0.1406p pd=1.12u as=0.2516p ps=2.16u w=0.74u l=0.2u
X143 a_5371_2470# a_5133_1842# a_5263_1842# VDD.t0 sg13_lv_pmos ad=0.2128p pd=1.5u as=0.3808p ps=2.92u w=1.12u l=0.2u
X144 a_14253_1842# DELAY_OUT_TAP14 VDD.t40 VDD.t0 sg13_lv_pmos ad=0.3808p pd=2.92u as=0.2128p ps=1.5u w=1.12u l=0.13u
X145 a_9931_1842# a_9693_1842# a_9823_1842# VSS.t59 sg13_lv_nmos ad=0.1406p pd=1.12u as=0.2516p ps=2.16u w=0.74u l=0.2u
X146 a_18813_1842# DELAY_OUT_TAP20 VSS.t118 VSS.t117 sg13_lv_nmos ad=0.2516p pd=2.16u as=0.1406p ps=1.12u w=0.74u l=0.13u
X147 a_8933_1842# DELAY_OUT_TAP7 VSS.t104 VSS.t108 sg13_lv_nmos ad=0.2516p pd=2.16u as=0.1406p ps=1.12u w=0.74u l=0.13u
X148 a_22613_1842# DELAY_OUT_TAP25 VSS.t83 VSS.t102 sg13_lv_nmos ad=0.2516p pd=2.16u as=0.1406p ps=1.12u w=0.74u l=0.13u
X149 VSS.t68 a_9823_1842# DELAY_OUT_TAP9 VSS.t67 sg13_lv_nmos ad=0.1406p pd=1.12u as=0.2516p ps=2.16u w=0.74u l=0.13u
X150 VDD.t35 a_3743_1842# DELAY_OUT_TAP1 VDD.t0 sg13_lv_pmos ad=0.2128p pd=1.5u as=0.3808p ps=2.92u w=1.12u l=0.13u
X151 VDD.t17 DELAY_VBIASP.t27 a_6891_2470# VDD.t0 sg13_lv_pmos ad=0.3808p pd=2.92u as=0.2128p ps=1.5u w=1.12u l=0.6u
X152 a_10691_2470# a_10453_1842# a_10583_1842# VDD.t0 sg13_lv_pmos ad=0.2128p pd=1.5u as=0.3808p ps=2.92u w=1.12u l=0.2u
X153 a_26651_1842# a_26413_1842# a_26543_1842# VSS.t22 sg13_lv_nmos ad=0.1406p pd=1.12u as=0.2516p ps=2.16u w=0.74u l=0.2u
X154 VSS.t5 DELAY_VBIASN.t16 a_15251_1842# VSS.t126 sg13_lv_nmos ad=0.2516p pd=2.16u as=0.1406p ps=1.12u w=0.74u l=0.6u
X155 VDD.t19 DELAY_VBIASP.t24 a_9171_2470# VDD.t0 sg13_lv_pmos ad=0.3808p pd=2.92u as=0.2128p ps=1.5u w=1.12u l=0.6u
X156 VSS.t97 a_25023_1842# DELAY_OUT_TAP29 VSS.t161 sg13_lv_nmos ad=0.1406p pd=1.12u as=0.2516p ps=2.16u w=0.74u l=0.13u
X157 a_17531_1842# a_17293_1842# a_17423_1842# VSS.t154 sg13_lv_nmos ad=0.1406p pd=1.12u as=0.2516p ps=2.16u w=0.74u l=0.2u
X158 a_7651_1842# a_7413_1842# a_7543_1842# VSS.t58 sg13_lv_nmos ad=0.1406p pd=1.12u as=0.2516p ps=2.16u w=0.74u l=0.2u
X159 a_21331_1842# a_21093_1842# a_21223_1842# VSS.t115 sg13_lv_nmos ad=0.1406p pd=1.12u as=0.2516p ps=2.16u w=0.74u l=0.2u
X160 a_16533_1842# DELAY_OUT_TAP17 VSS.t14 VSS.t114 sg13_lv_nmos ad=0.2516p pd=2.16u as=0.1406p ps=1.12u w=0.74u l=0.13u
X161 a_25891_2470# a_25653_1842# a_25783_1842# VDD.t0 sg13_lv_pmos ad=0.2128p pd=1.5u as=0.3808p ps=2.92u w=1.12u l=0.2u
X162 VSS.t32 a_6023_1842# DELAY_OUT_TAP4 VSS.t39 sg13_lv_nmos ad=0.1406p pd=1.12u as=0.2516p ps=2.16u w=0.74u l=0.13u
X163 a_20333_1842# DELAY_OUT_TAP22 VSS.t10 VSS.t94 sg13_lv_nmos ad=0.2516p pd=2.16u as=0.1406p ps=1.12u w=0.74u l=0.13u
X164 VDD.t6 DELAY_VBIASP.t17 a_14491_2470# VDD.t0 sg13_lv_pmos ad=0.3808p pd=2.92u as=0.2128p ps=1.5u w=1.12u l=0.6u
X165 VDD.t84 a_24263_1842# DELAY_OUT_TAP28 VDD.t0 sg13_lv_pmos ad=0.2128p pd=1.5u as=0.3808p ps=2.92u w=1.12u l=0.13u
X166 a_6891_2470# a_6653_1842# a_6783_1842# VDD.t0 sg13_lv_pmos ad=0.2128p pd=1.5u as=0.3808p ps=2.92u w=1.12u l=0.2u
X167 a_15773_1842# DELAY_OUT_TAP16 VDD.t2 VDD.t0 sg13_lv_pmos ad=0.3808p pd=2.92u as=0.2128p ps=1.5u w=1.12u l=0.13u
X168 VDD.t54 VDD.t52 VDD.t53 VDD.t0 sg13_lv_pmos ad=0.3808p pd=2.92u as=0 ps=0 w=1.12u l=0.6u
X169 a_12971_1842# a_12733_1842# a_12863_1842# VSS.t8 sg13_lv_nmos ad=0.1406p pd=1.12u as=0.2516p ps=2.16u w=0.74u l=0.2u
X170 a_11213_1842# DELAY_OUT_TAP10 VSS.t24 VSS.t116 sg13_lv_nmos ad=0.2516p pd=2.16u as=0.1406p ps=1.12u w=0.74u l=0.13u
X171 VDD.t43 a_26543_1842# DELAY_OUT_TAP31 VDD.t0 sg13_lv_pmos ad=0.2128p pd=1.5u as=0.3808p ps=2.92u w=1.12u l=0.13u
X172 VSS.t35 a_11343_1842# DELAY_OUT_TAP11 VSS.t34 sg13_lv_nmos ad=0.1406p pd=1.12u as=0.2516p ps=2.16u w=0.74u l=0.13u
X173 VDD.t58 a_5263_1842# DELAY_OUT_TAP3 VDD.t0 sg13_lv_pmos ad=0.2128p pd=1.5u as=0.3808p ps=2.92u w=1.12u l=0.13u
X174 a_15251_1842# a_15013_1842# a_15143_1842# VSS.t76 sg13_lv_nmos ad=0.1406p pd=1.12u as=0.2516p ps=2.16u w=0.74u l=0.2u
X175 a_9171_2470# a_8933_1842# a_9063_1842# VDD.t0 sg13_lv_pmos ad=0.2128p pd=1.5u as=0.3808p ps=2.92u w=1.12u l=0.2u
X176 a_18053_1842# DELAY_OUT_TAP19 VDD.t92 VDD.t0 sg13_lv_pmos ad=0.3808p pd=2.92u as=0.2128p ps=1.5u w=1.12u l=0.13u
X177 VSS.t20 a_13623_1842# DELAY_OUT_TAP14 VSS.t19 sg13_lv_nmos ad=0.1406p pd=1.12u as=0.2516p ps=2.16u w=0.74u l=0.13u
X178 VDD.t63 a_7543_1842# DELAY_OUT_TAP6 VDD.t0 sg13_lv_pmos ad=0.2128p pd=1.5u as=0.3808p ps=2.92u w=1.12u l=0.13u
X179 a_26413_1842# DELAY_OUT_TAP30 VSS.t80 VSS.t79 sg13_lv_nmos ad=0.2516p pd=2.16u as=0.1406p ps=1.12u w=0.74u l=0.13u
X180 VSS.t78 DELAY_VBIASN.t14 a_16771_1842# VSS.t130 sg13_lv_nmos ad=0.2516p pd=2.16u as=0.1406p ps=1.12u w=0.74u l=0.6u
X181 a_14491_2470# a_14253_1842# a_14383_1842# VDD.t0 sg13_lv_pmos ad=0.2128p pd=1.5u as=0.3808p ps=2.92u w=1.12u l=0.2u
X182 VSS.t99 DELAY_VBIASN.t9 a_20571_1842# VSS.t151 sg13_lv_nmos ad=0.2516p pd=2.16u as=0.1406p ps=1.12u w=0.74u l=0.6u
X183 VDD.t49 VDD.t50 VDD.t51 VDD.t0 sg13_lv_pmos ad=0.2128p pd=1.5u as=0 ps=0 w=1.12u l=0.13u
X184 VDD.t68 a_12863_1842# DELAY_OUT_TAP13 VDD.t0 sg13_lv_pmos ad=0.2128p pd=1.5u as=0.3808p ps=2.92u w=1.12u l=0.13u
X185 a_7413_1842# DELAY_OUT_TAP5 VSS.t16 VSS.t15 sg13_lv_nmos ad=0.2516p pd=2.16u as=0.1406p ps=1.12u w=0.74u l=0.13u
X186 a_21853_1842# DELAY_OUT_TAP24 VSS.t64 VSS.t63 sg13_lv_nmos ad=0.2516p pd=2.16u as=0.1406p ps=1.12u w=0.74u l=0.13u
X187 VSS.t41 DELAY_VBIASN.t11 a_19051_1842# VSS.t147 sg13_lv_nmos ad=0.2516p pd=2.16u as=0.1406p ps=1.12u w=0.74u l=0.6u
X188 a_25131_1842# a_24893_1842# a_25023_1842# VSS.t155 sg13_lv_nmos ad=0.1406p pd=1.12u as=0.2516p ps=2.16u w=0.74u l=0.2u
X189 VDD.t24 DELAY_VBIASP.t12 a_18291_2470# VDD.t0 sg13_lv_pmos ad=0.3808p pd=2.92u as=0.2128p ps=1.5u w=1.12u l=0.6u
X190 a_24133_1842# DELAY_OUT_TAP27 VSS.t28 VSS.t95 sg13_lv_nmos ad=0.2516p pd=2.16u as=0.1406p ps=1.12u w=0.74u l=0.13u
X191 VDD.t25 DELAY_VBIASP.t7 a_22091_2470# VDD.t0 sg13_lv_pmos ad=0.3808p pd=2.92u as=0.2128p ps=1.5u w=1.12u l=0.6u
X192 a_16771_1842# a_16533_1842# a_16663_1842# VSS.t168 sg13_lv_nmos ad=0.1406p pd=1.12u as=0.2516p ps=2.16u w=0.74u l=0.2u
X193 a_19573_1842# DELAY_OUT_TAP21 VDD.t60 VDD.t0 sg13_lv_pmos ad=0.3808p pd=2.92u as=0.2128p ps=1.5u w=1.12u l=0.13u
X194 a_6131_1842# a_5893_1842# a_6023_1842# VSS.t0 sg13_lv_nmos ad=0.1406p pd=1.12u as=0.2516p ps=2.16u w=0.74u l=0.2u
X195 a_20571_1842# a_20333_1842# a_20463_1842# VSS.t11 sg13_lv_nmos ad=0.1406p pd=1.12u as=0.2516p ps=2.16u w=0.74u l=0.2u
X196 a_23373_1842# DELAY_OUT_TAP26 VDD.t79 VDD.t0 sg13_lv_pmos ad=0.3808p pd=2.92u as=0.2128p ps=1.5u w=1.12u l=0.13u
X197 a_5133_1842# DELAY_OUT_TAP2 VSS.t18 VSS.t17 sg13_lv_nmos ad=0.2516p pd=2.16u as=0.1406p ps=1.12u w=0.74u l=0.13u
X198 VSS.t5 a_15143_1842# DELAY_OUT_TAP16 VSS.t4 sg13_lv_nmos ad=0.1406p pd=1.12u as=0.2516p ps=2.16u w=0.74u l=0.13u
X199 VDD.t67 a_9063_1842# DELAY_OUT_TAP8 VDD.t0 sg13_lv_pmos ad=0.2128p pd=1.5u as=0.3808p ps=2.92u w=1.12u l=0.13u
X200 VDD.t8 DELAY_VBIASP.t18 a_13731_2470# VDD.t0 sg13_lv_pmos ad=0.3808p pd=2.92u as=0.2128p ps=1.5u w=1.12u l=0.6u
X201 a_19051_1842# a_18813_1842# a_18943_1842# VSS.t173 sg13_lv_nmos ad=0.1406p pd=1.12u as=0.2516p ps=2.16u w=0.74u l=0.2u
X202 a_16011_2470# a_15773_1842# a_15903_1842# VDD.t0 sg13_lv_pmos ad=0.2128p pd=1.5u as=0.3808p ps=2.92u w=1.12u l=0.2u
X203 a_10453_1842# DELAY_OUT_TAP9 VSS.t68 VSS.t105 sg13_lv_nmos ad=0.2516p pd=2.16u as=0.1406p ps=1.12u w=0.74u l=0.13u
X204 a_4373_1842# DELAY_OUT_TAP1 VDD.t35 VDD.t0 sg13_lv_pmos ad=0.3808p pd=2.92u as=0.2128p ps=1.5u w=1.12u l=0.13u
X205 VDD.t69 a_14383_1842# DELAY_OUT_TAP15 VDD.t0 sg13_lv_pmos ad=0.2128p pd=1.5u as=0.3808p ps=2.92u w=1.12u l=0.13u
X206 VSS.t101 DELAY_VBIASN.t4 a_24371_1842# VSS.t124 sg13_lv_nmos ad=0.2516p pd=2.16u as=0.1406p ps=1.12u w=0.74u l=0.6u
X207 a_18291_2470# a_18053_1842# a_18183_1842# VDD.t0 sg13_lv_pmos ad=0.2128p pd=1.5u as=0.3808p ps=2.92u w=1.12u l=0.2u
X208 a_22091_2470# a_21853_1842# a_21983_1842# VDD.t0 sg13_lv_pmos ad=0.2128p pd=1.5u as=0.3808p ps=2.92u w=1.12u l=0.2u
X209 VSS.t45 VSS.t42 VSS.t44 VSS.t43 sg13_lv_nmos ad=0.2516p pd=2.16u as=0 ps=0 w=0.74u l=0.13u
X210 VDD.t70 a_16663_1842# DELAY_OUT_TAP18 VDD.t0 sg13_lv_pmos ad=0.2128p pd=1.5u as=0.3808p ps=2.92u w=1.12u l=0.13u
X211 VDD.t26 DELAY_VBIASP.t10 a_19811_2470# VDD.t0 sg13_lv_pmos ad=0.3808p pd=2.92u as=0.2128p ps=1.5u w=1.12u l=0.6u
X212 a_25653_1842# DELAY_OUT_TAP29 VSS.t97 VSS.t96 sg13_lv_nmos ad=0.2516p pd=2.16u as=0.1406p ps=1.12u w=0.74u l=0.13u
X213 VSS.t38 DELAY_VBIASN.t29 a_5371_1842# VSS.t139 sg13_lv_nmos ad=0.2516p pd=2.16u as=0.1406p ps=1.12u w=0.74u l=0.6u
X214 VDD.t31 DELAY_VBIASP.t5 a_23611_2470# VDD.t0 sg13_lv_pmos ad=0.3808p pd=2.92u as=0.2128p ps=1.5u w=1.12u l=0.6u
X215 VDD.t1 a_12103_1842# DELAY_OUT_TAP12 VDD.t0 sg13_lv_pmos ad=0.2128p pd=1.5u as=0.3808p ps=2.92u w=1.12u l=0.13u
X216 a_24893_1842# DELAY_OUT_TAP28 VDD.t84 VDD.t0 sg13_lv_pmos ad=0.3808p pd=2.92u as=0.2128p ps=1.5u w=1.12u l=0.13u
X217 a_6653_1842# DELAY_OUT_TAP4 VSS.t32 VSS.t31 sg13_lv_nmos ad=0.2516p pd=2.16u as=0.1406p ps=1.12u w=0.74u l=0.13u
X218 VSS.t99 a_20463_1842# DELAY_OUT_TAP23 VSS.t156 sg13_lv_nmos ad=0.1406p pd=1.12u as=0.2516p ps=2.16u w=0.74u l=0.13u
X219 VSS.t24 DELAY_VBIASN.t22 a_10691_1842# VSS.t142 sg13_lv_nmos ad=0.2516p pd=2.16u as=0.1406p ps=1.12u w=0.74u l=0.6u
X220 VDD.t15 DELAY_VBIASP.t30 a_4611_2470# VDD.t0 sg13_lv_pmos ad=0.3808p pd=2.92u as=0.2128p ps=1.5u w=1.12u l=0.6u
X221 a_24371_1842# a_24133_1842# a_24263_1842# VSS.t157 sg13_lv_nmos ad=0.1406p pd=1.12u as=0.2516p ps=2.16u w=0.74u l=0.2u
X222 VSS.t41 a_18943_1842# DELAY_OUT_TAP21 VSS.t40 sg13_lv_nmos ad=0.1406p pd=1.12u as=0.2516p ps=2.16u w=0.74u l=0.13u
X223 a_11973_1842# DELAY_OUT_TAP11 VSS.t35 VSS.t90 sg13_lv_nmos ad=0.2516p pd=2.16u as=0.1406p ps=1.12u w=0.74u l=0.13u
X224 a_5893_1842# DELAY_OUT_TAP3 VDD.t58 VDD.t0 sg13_lv_pmos ad=0.3808p pd=2.92u as=0.2128p ps=1.5u w=1.12u l=0.13u
X225 VDD.t21 DELAY_VBIASP.t13 a_17531_2470# VDD.t0 sg13_lv_pmos ad=0.3808p pd=2.92u as=0.2128p ps=1.5u w=1.12u l=0.6u
X226 a_27173_1842# DELAY_OUT_TAP31 VDD.t43 VDD.t0 sg13_lv_pmos ad=0.3808p pd=2.92u as=0.2128p ps=1.5u w=1.12u l=0.13u
X227 VSS.t73 DELAY_VBIASN.t19 a_12971_1842# VSS.t128 sg13_lv_nmos ad=0.2516p pd=2.16u as=0.1406p ps=1.12u w=0.74u l=0.6u
X228 VDD.t101 a_27303_1842# a_27737_1842# VDD.t0 sg13_lv_pmos ad=0.2128p pd=1.5u as=0.3808p ps=2.92u w=1.12u l=0.13u
X229 VSS.t80 DELAY_VBIASN.t2 a_25891_1842# VSS.t153 sg13_lv_nmos ad=0.2516p pd=2.16u as=0.1406p ps=1.12u w=0.74u l=0.6u
X230 VSS.t93 a_22743_1842# DELAY_OUT_TAP26 VSS.t164 sg13_lv_nmos ad=0.1406p pd=1.12u as=0.2516p ps=2.16u w=0.74u l=0.13u
X231 a_19811_2470# a_19573_1842# a_19703_1842# VDD.t0 sg13_lv_pmos ad=0.2128p pd=1.5u as=0.3808p ps=2.92u w=1.12u l=0.2u
X232 VDD.t28 DELAY_VBIASP.t8 a_21331_2470# VDD.t0 sg13_lv_pmos ad=0.3808p pd=2.92u as=0.2128p ps=1.5u w=1.12u l=0.6u
X233 VDD.t57 VDD.t55 VDD.t54 VDD.t0 sg13_lv_pmos ad=0.2128p pd=1.5u as=0 ps=0 w=1.12u l=0.2u
X234 a_5371_1842# a_5133_1842# a_5263_1842# VSS.t57 sg13_lv_nmos ad=0.1406p pd=1.12u as=0.2516p ps=2.16u w=0.74u l=0.2u
X235 a_14253_1842# DELAY_OUT_TAP14 VSS.t20 VSS.t109 sg13_lv_nmos ad=0.2516p pd=2.16u as=0.1406p ps=1.12u w=0.74u l=0.13u
X236 a_8173_1842# DELAY_OUT_TAP6 VDD.t63 VDD.t0 sg13_lv_pmos ad=0.3808p pd=2.92u as=0.2128p ps=1.5u w=1.12u l=0.13u
X237 VDD.t96 a_18183_1842# DELAY_OUT_TAP20 VDD.t0 sg13_lv_pmos ad=0.2128p pd=1.5u as=0.3808p ps=2.92u w=1.12u l=0.13u
X238 a_23611_2470# a_23373_1842# a_23503_1842# VDD.t0 sg13_lv_pmos ad=0.2128p pd=1.5u as=0.3808p ps=2.92u w=1.12u l=0.2u
X239 VSS.t7 a_3743_1842# DELAY_OUT_TAP1 VSS.t6 sg13_lv_nmos ad=0.1406p pd=1.12u as=0.2516p ps=2.16u w=0.74u l=0.13u
X240 VDD.t86 a_8303_1842# DELAY_OUT_TAP7 VDD.t0 sg13_lv_pmos ad=0.2128p pd=1.5u as=0.3808p ps=2.92u w=1.12u l=0.13u
X241 VDD.t20 DELAY_VBIASP.t20 a_12211_2470# VDD.t0 sg13_lv_pmos ad=0.3808p pd=2.92u as=0.2128p ps=1.5u w=1.12u l=0.6u
X242 VDD.t72 a_21983_1842# DELAY_OUT_TAP25 VDD.t0 sg13_lv_pmos ad=0.2128p pd=1.5u as=0.3808p ps=2.92u w=1.12u l=0.13u
X243 VSS.t16 DELAY_VBIASN.t27 a_6891_1842# VSS.t122 sg13_lv_nmos ad=0.2516p pd=2.16u as=0.1406p ps=1.12u w=0.74u l=0.6u
X244 a_4611_2470# a_4373_1842# a_4503_1842# VDD.t0 sg13_lv_pmos ad=0.2128p pd=1.5u as=0.3808p ps=2.92u w=1.12u l=0.2u
X245 a_13493_1842# DELAY_OUT_TAP13 VDD.t68 VDD.t0 sg13_lv_pmos ad=0.3808p pd=2.92u as=0.2128p ps=1.5u w=1.12u l=0.13u
X246 a_10691_1842# a_10453_1842# a_10583_1842# VSS.t106 sg13_lv_nmos ad=0.1406p pd=1.12u as=0.2516p ps=2.16u w=0.74u l=0.2u
X247 VDD.t29 DELAY_VBIASP.t0 a_27411_2470# VDD.t0 sg13_lv_pmos ad=0.3808p pd=2.92u as=0.2128p ps=1.5u w=1.12u l=0.6u
X248 VSS.t70 DELAY_VBIASN.t24 a_9171_1842# VSS.t141 sg13_lv_nmos ad=0.2516p pd=2.16u as=0.1406p ps=1.12u w=0.74u l=0.6u
X249 a_25891_1842# a_25653_1842# a_25783_1842# VSS.t162 sg13_lv_nmos ad=0.1406p pd=1.12u as=0.2516p ps=2.16u w=0.74u l=0.2u
X250 VDD.t12 DELAY_VBIASP.t23 a_9931_2470# VDD.t0 sg13_lv_pmos ad=0.3808p pd=2.92u as=0.2128p ps=1.5u w=1.12u l=0.6u
X251 VDD.t37 a_15903_1842# DELAY_OUT_TAP17 VDD.t0 sg13_lv_pmos ad=0.2128p pd=1.5u as=0.3808p ps=2.92u w=1.12u l=0.13u
X252 VSS.t75 DELAY_VBIASN.t17 a_14491_1842# VSS.t145 sg13_lv_nmos ad=0.2516p pd=2.16u as=0.1406p ps=1.12u w=0.74u l=0.6u
X253 VDD.t18 DELAY_VBIASP.t25 a_8411_2470# VDD.t0 sg13_lv_pmos ad=0.3808p pd=2.92u as=0.2128p ps=1.5u w=1.12u l=0.6u
X254 VDD.t36 a_19703_1842# DELAY_OUT_TAP22 VDD.t0 sg13_lv_pmos ad=0.2128p pd=1.5u as=0.3808p ps=2.92u w=1.12u l=0.13u
X255 VSS.t101 a_24263_1842# DELAY_OUT_TAP28 VSS.t158 sg13_lv_nmos ad=0.1406p pd=1.12u as=0.2516p ps=2.16u w=0.74u l=0.13u
X256 a_12211_2470# a_11973_1842# a_12103_1842# VDD.t0 sg13_lv_pmos ad=0.2128p pd=1.5u as=0.3808p ps=2.92u w=1.12u l=0.2u
X257 VDD.t4 DELAY_VBIASP.t6 a_22851_2470# VDD.t0 sg13_lv_pmos ad=0.3808p pd=2.92u as=0.2128p ps=1.5u w=1.12u l=0.6u
X258 a_6891_1842# a_6653_1842# a_6783_1842# VSS.t166 sg13_lv_nmos ad=0.1406p pd=1.12u as=0.2516p ps=2.16u w=0.74u l=0.2u
X259 VSS.t52 VSS.t49 VSS.t51 VSS.t50 sg13_lv_nmos ad=0.2516p pd=2.16u as=0 ps=0 w=0.74u l=0.6u
X260 a_15773_1842# DELAY_OUT_TAP16 VSS.t5 VSS.t119 sg13_lv_nmos ad=0.2516p pd=2.16u as=0.1406p ps=1.12u w=0.74u l=0.13u
X261 a_9693_1842# DELAY_OUT_TAP8 VDD.t67 VDD.t0 sg13_lv_pmos ad=0.3808p pd=2.92u as=0.2128p ps=1.5u w=1.12u l=0.13u
X262 VDD.t41 a_10583_1842# DELAY_OUT_TAP10 VDD.t0 sg13_lv_pmos ad=0.2128p pd=1.5u as=0.3808p ps=2.92u w=1.12u l=0.13u
X263 VSS.t30 a_26543_1842# DELAY_OUT_TAP31 VSS.t29 sg13_lv_nmos ad=0.1406p pd=1.12u as=0.2516p ps=2.16u w=0.74u l=0.13u
C0 a_21331_1842# a_21223_1842# 0.01163f
C1 VDD a_15903_1842# 0.49633f
C2 VDD a_27173_1842# 0.4916f
C3 a_18291_1842# a_18183_1842# 0.01163f
C4 a_3743_1842# DELAY_VBIASN 0.0649f
C5 DELAY_VBIASP DELAY_OUT_TAP15 0.04137f
C6 DELAY_OUT_TAP13 a_12733_1842# 0.0114f
C7 a_26413_1842# a_26543_1842# 0.70845f
C8 DELAY_VBIASN a_15773_1842# 0.10601f
C9 VDD a_23373_1842# 0.4916f
C10 a_15251_2470# a_15143_1842# 0.01697f
C11 a_27303_1842# DELAY_VBIASP 0.06629f
C12 VDD a_12733_1842# 0.4916f
C13 a_8933_1842# DELAY_VBIASP 0.11222f
C14 a_19811_1842# a_19703_1842# 0.01163f
C15 a_16011_2470# VDD 0.01806f
C16 VDD a_27411_2470# 0.01806f
C17 DELAY_OUT_TAP3 DELAY_VBIASP 0.04137f
C18 a_15143_1842# DELAY_VBIASN 0.07258f
C19 DELAY_OUT_TAP12 a_12103_1842# 0.69646f
C20 VDD a_18291_2470# 0.01806f
C21 DELAY_VBIASN DELAY_OUT_TAP20 0.04353f
C22 a_6023_1842# VDD 0.49633f
C23 VDD DELAY_OUT_TAP26 0.72899f
C24 a_19703_1842# a_19811_2470# 0.01697f
C25 a_8933_1842# a_9063_1842# 0.70845f
C26 DELAY_IN DELAY_VBIASN 0.06969f
C27 DELAY_OUT_TAP14 a_13623_1842# 0.69646f
C28 a_10583_1842# DELAY_VBIASN 0.07258f
C29 a_24263_1842# a_24371_2470# 0.01697f
C30 VDD a_7651_2470# 0.01806f
C31 DELAY_OUT_TAP10 DELAY_VBIASP 0.04137f
C32 a_20463_1842# VDD 0.49633f
C33 a_21853_1842# DELAY_VBIASP 0.11222f
C34 a_25653_1842# DELAY_VBIASP 0.11222f
C35 VDD a_4611_2470# 0.01806f
C36 DELAY_OUT_TAP4 DELAY_VBIASP 0.04137f
C37 a_20463_1842# a_20571_2470# 0.01697f
C38 a_6783_1842# VDD 0.49633f
C39 a_21223_1842# DELAY_VBIASN 0.07258f
C40 a_20333_1842# DELAY_VBIASN 0.10601f
C41 a_18943_1842# DELAY_OUT_TAP21 0.69646f
C42 VDD a_9171_2470# 0.01806f
C43 a_16011_2470# a_15903_1842# 0.01697f
C44 a_11213_1842# VDD 0.4916f
C45 VDD a_22851_2470# 0.01806f
C46 DELAY_VBIASP a_24263_1842# 0.06627f
C47 a_22743_1842# a_22851_1842# 0.01163f
C48 DELAY_VBIASP a_16533_1842# 0.11222f
C49 a_6653_1842# DELAY_VBIASN 0.10601f
C50 VDD a_3851_2470# 0.01866f
C51 DELAY_OUT_TAP28 DELAY_VBIASP 0.04137f
C52 a_17423_1842# DELAY_VBIASN 0.07258f
C53 a_8933_1842# DELAY_OUT_TAP8 0.0114f
C54 DELAY_VBIASN a_27737_1842# 0.04176f
C55 a_19051_1842# a_18943_1842# 0.01163f
C56 a_26413_1842# DELAY_VBIASN 0.10601f
C57 a_12971_1842# a_12863_1842# 0.01163f
C58 a_23373_1842# DELAY_OUT_TAP26 0.70708f
C59 a_18053_1842# DELAY_OUT_TAP20 0.0114f
C60 a_19573_1842# DELAY_OUT_TAP21 0.70708f
C61 DELAY_OUT_TAP13 a_13493_1842# 0.70708f
C62 VDD a_18183_1842# 0.49633f
C63 a_5133_1842# VDD 0.4916f
C64 a_13731_1842# a_13623_1842# 0.01163f
C65 DELAY_OUT_TAP14 a_14253_1842# 0.70708f
C66 a_8173_1842# DELAY_OUT_TAP7 0.0114f
C67 DELAY_OUT_TAP11 VDD 0.72899f
C68 a_18053_1842# DELAY_VBIASN 0.10601f
C69 a_15013_1842# a_15143_1842# 0.70845f
C70 a_19703_1842# DELAY_VBIASN 0.07258f
C71 DELAY_VBIASP DELAY_OUT_TAP14 0.04137f
C72 VDD a_13493_1842# 0.4916f
C73 a_4503_1842# DELAY_VBIASP 0.06627f
C74 a_25023_1842# DELAY_OUT_TAP29 0.69646f
C75 a_21983_1842# VDD 0.49633f
C76 VDD DELAY_OUT_TAP24 0.72899f
C77 VDD a_25783_1842# 0.49633f
C78 VDD DELAY_OUT_TAP7 0.72899f
C79 VDD DELAY_OUT_TAP5 0.72899f
C80 a_12103_1842# DELAY_VBIASN 0.07258f
C81 a_17423_1842# a_17531_2470# 0.01697f
C82 DELAY_OUT_TAP23 DELAY_VBIASN 0.04353f
C83 DELAY_OUT_TAP30 DELAY_VBIASP 0.04137f
C84 VDD a_16663_1842# 0.49633f
C85 DELAY_OUT_TAP6 DELAY_VBIASN 0.04353f
C86 a_15013_1842# DELAY_VBIASN 0.10601f
C87 VDD DELAY_OUT_TAP19 0.72899f
C88 VDD DELAY_OUT_TAP29 0.72899f
C89 DELAY_OUT_TAP2 DELAY_VBIASP 0.04137f
C90 DELAY_OUT_TAP12 a_11973_1842# 0.0114f
C91 DELAY_VBIASP DELAY_OUT_TAP21 0.04137f
C92 a_5133_1842# a_5263_1842# 0.70845f
C93 a_20333_1842# DELAY_OUT_TAP23 0.0114f
C94 a_7413_1842# DELAY_OUT_TAP5 0.70708f
C95 a_16011_1842# a_15903_1842# 0.01163f
C96 a_5893_1842# VDD 0.4916f
C97 a_4373_1842# a_4503_1842# 0.70845f
C98 a_22743_1842# VDD 0.49633f
C99 a_10453_1842# a_10583_1842# 0.70845f
C100 DELAY_VBIASN DELAY_OUT_TAP18 0.04353f
C101 a_11343_1842# DELAY_VBIASN 0.07258f
C102 DELAY_VBIASN a_14383_1842# 0.07258f
C103 a_10453_1842# DELAY_VBIASN 0.10601f
C104 a_22613_1842# DELAY_VBIASN 0.10601f
C105 DELAY_OUT_TAP17 a_16533_1842# 0.70708f
C106 a_24893_1842# DELAY_VBIASP 0.11222f
C107 DELAY_OUT_LAST DELAY_VBIASN 0.04786f
C108 a_4373_1842# DELAY_OUT_TAP2 0.0114f
C109 DELAY_OUT_TAP12 DELAY_VBIASP 0.04137f
C110 a_18183_1842# a_18291_2470# 0.01697f
C111 a_21093_1842# DELAY_VBIASN 0.10601f
C112 VDD DELAY_OUT_TAP15 0.72899f
C113 a_21223_1842# a_21331_2470# 0.01697f
C114 a_18813_1842# DELAY_OUT_TAP21 0.0114f
C115 a_11343_1842# a_11451_1842# 0.01163f
C116 DELAY_VBIASP a_24133_1842# 0.11222f
C117 a_10583_1842# a_10691_1842# 0.01163f
C118 VDD a_27303_1842# 0.49714f
C119 a_21093_1842# a_21223_1842# 0.70845f
C120 a_17293_1842# DELAY_VBIASN 0.10601f
C121 DELAY_VBIASP a_26543_1842# 0.06627f
C122 VDD a_11451_2470# 0.01806f
C123 DELAY_OUT_LAST a_27737_1842# 0.70955f
C124 a_18943_1842# DELAY_VBIASN 0.07258f
C125 a_10583_1842# a_10691_2470# 0.01697f
C126 VDD a_8933_1842# 0.4916f
C127 a_13623_1842# DELAY_VBIASN 0.07258f
C128 VDD DELAY_OUT_TAP3 0.72899f
C129 a_6783_1842# a_6891_1842# 0.01163f
C130 VDD a_26651_2470# 0.01806f
C131 a_25131_1842# a_25023_1842# 0.01163f
C132 a_3743_1842# DELAY_OUT_TAP1 0.69646f
C133 DELAY_VBIASN DELAY_OUT_TAP25 0.04353f
C134 a_25023_1842# a_25131_2470# 0.01697f
C135 DELAY_OUT_TAP9 DELAY_VBIASN 0.04353f
C136 a_17293_1842# a_17423_1842# 0.70845f
C137 a_4503_1842# a_4611_1842# 0.01163f
C138 a_3743_1842# DELAY_VBIASP 0.05992f
C139 a_5893_1842# a_6023_1842# 0.70845f
C140 DELAY_OUT_TAP10 VDD 0.72899f
C141 DELAY_OUT_TAP11 a_11213_1842# 0.0114f
C142 a_19573_1842# DELAY_VBIASN 0.10601f
C143 DELAY_VBIASP a_15773_1842# 0.11222f
C144 a_22743_1842# DELAY_OUT_TAP26 0.69646f
C145 a_27303_1842# a_27173_1842# 0.70845f
C146 a_21853_1842# VDD 0.4916f
C147 a_6783_1842# DELAY_OUT_TAP5 0.69646f
C148 VDD a_25131_2470# 0.01806f
C149 VDD a_25653_1842# 0.4916f
C150 VDD DELAY_OUT_TAP4 0.72899f
C151 a_5263_1842# DELAY_OUT_TAP3 0.69646f
C152 a_9823_1842# DELAY_VBIASN 0.07258f
C153 a_11973_1842# DELAY_VBIASN 0.10601f
C154 DELAY_OUT_TAP22 DELAY_VBIASN 0.04353f
C155 a_14491_2470# a_14383_1842# 0.01697f
C156 a_15143_1842# DELAY_VBIASP 0.06627f
C157 VDD a_16533_1842# 0.4916f
C158 VDD a_24263_1842# 0.49633f
C159 DELAY_IN DELAY_OUT_TAP1 0.01139f
C160 VDD DELAY_OUT_TAP28 0.72899f
C161 DELAY_VBIASP DELAY_OUT_TAP20 0.04137f
C162 DELAY_OUT_TAP23 a_21093_1842# 0.70708f
C163 a_20333_1842# DELAY_OUT_TAP22 0.70708f
C164 a_27411_2470# a_27303_1842# 0.01697f
C165 DELAY_OUT_TAP1 DELAY_VBIASN 0.04353f
C166 a_22743_1842# a_22851_2470# 0.01697f
C167 DELAY_IN DELAY_VBIASP 0.0738f
C168 a_10583_1842# DELAY_VBIASP 0.06627f
C169 DELAY_VBIASN a_14253_1842# 0.10601f
C170 DELAY_VBIASP DELAY_VBIASN 3.50557f
C171 a_9823_1842# a_9931_1842# 0.01163f
C172 a_6023_1842# a_6131_1842# 0.01163f
C173 DELAY_VBIASP a_21223_1842# 0.06627f
C174 a_9063_1842# DELAY_VBIASN 0.07258f
C175 a_20333_1842# DELAY_VBIASP 0.11222f
C176 VDD DELAY_OUT_TAP14 0.72899f
C177 a_17293_1842# DELAY_OUT_TAP18 0.70708f
C178 a_19573_1842# a_19703_1842# 0.70845f
C179 VDD a_4503_1842# 0.49633f
C180 a_18813_1842# DELAY_OUT_TAP20 0.70708f
C181 a_6653_1842# DELAY_VBIASP 0.11222f
C182 a_17423_1842# DELAY_VBIASP 0.06627f
C183 a_4373_1842# DELAY_VBIASN 0.10601f
C184 a_23611_1842# a_23503_1842# 0.01163f
C185 DELAY_OUT_TAP22 a_19703_1842# 0.69646f
C186 DELAY_VBIASP a_27737_1842# 0.04001f
C187 VDD DELAY_OUT_TAP30 0.72899f
C188 DELAY_VBIASP a_26413_1842# 0.11222f
C189 a_18813_1842# DELAY_VBIASN 0.10601f
C190 DELAY_OUT_TAP31 a_26543_1842# 0.69646f
C191 a_11973_1842# a_12103_1842# 0.70845f
C192 VDD DELAY_OUT_TAP2 0.72899f
C193 VDD DELAY_OUT_TAP21 0.72899f
C194 a_24893_1842# a_25023_1842# 0.70845f
C195 DELAY_OUT_TAP17 a_15773_1842# 0.0114f
C196 a_6023_1842# DELAY_OUT_TAP4 0.69646f
C197 a_8303_1842# DELAY_VBIASN 0.07258f
C198 a_22613_1842# DELAY_OUT_TAP25 0.70708f
C199 VDD a_25891_2470# 0.01806f
C200 a_10453_1842# DELAY_OUT_TAP9 0.70708f
C201 a_24133_1842# DELAY_OUT_TAP27 0.70708f
C202 DELAY_OUT_TAP8 DELAY_VBIASN 0.04353f
C203 DELAY_VBIASP a_18053_1842# 0.11222f
C204 a_19703_1842# DELAY_VBIASP 0.06627f
C205 DELAY_OUT_TAP10 a_11213_1842# 0.70708f
C206 VDD a_24893_1842# 0.4916f
C207 a_20463_1842# a_20571_1842# 0.01163f
C208 a_12103_1842# DELAY_VBIASP 0.06627f
C209 DELAY_OUT_TAP12 VDD 0.72899f
C210 DELAY_OUT_TAP23 DELAY_VBIASP 0.04137f
C211 a_9693_1842# DELAY_VBIASN 0.10601f
C212 a_7543_1842# DELAY_VBIASN 0.07258f
C213 a_5133_1842# DELAY_OUT_TAP3 0.0114f
C214 a_3743_1842# a_3851_1842# 0.01163f
C215 DELAY_OUT_TAP6 DELAY_VBIASP 0.04137f
C216 VDD a_24133_1842# 0.4916f
C217 a_15013_1842# DELAY_VBIASP 0.11222f
C218 DELAY_OUT_TAP17 DELAY_VBIASN 0.04353f
C219 a_14253_1842# a_14383_1842# 0.70845f
C220 VDD a_26543_1842# 0.49633f
C221 DELAY_VBIASP DELAY_OUT_TAP18 0.04137f
C222 VDD a_19811_2470# 0.01806f
C223 a_8933_1842# DELAY_OUT_TAP7 0.70708f
C224 a_11343_1842# DELAY_VBIASP 0.06627f
C225 DELAY_VBIASP a_14383_1842# 0.06627f
C226 a_10453_1842# DELAY_VBIASP 0.11222f
C227 a_22613_1842# DELAY_VBIASP 0.11222f
C228 DELAY_VBIASP DELAY_OUT_LAST 0.21225f
C229 VDD a_6891_2470# 0.01806f
C230 a_23503_1842# DELAY_VBIASN 0.07258f
C231 DELAY_OUT_TAP31 DELAY_VBIASN 0.04353f
C232 a_5893_1842# DELAY_OUT_TAP3 0.70708f
C233 a_16663_1842# a_16771_1842# 0.01163f
C234 a_21853_1842# a_21983_1842# 0.70845f
C235 DELAY_VBIASP a_21093_1842# 0.11222f
C236 VDD a_3743_1842# 0.61241f
C237 a_4503_1842# a_4611_2470# 0.01697f
C238 a_12863_1842# DELAY_VBIASN 0.07258f
C239 a_5263_1842# a_5371_1842# 0.01163f
C240 a_21853_1842# DELAY_OUT_TAP24 0.70708f
C241 a_9823_1842# DELAY_OUT_TAP9 0.69646f
C242 VDD a_15773_1842# 0.4916f
C243 a_13731_2470# a_13623_1842# 0.01697f
C244 a_25653_1842# a_25783_1842# 0.70845f
C245 DELAY_OUT_TAP12 a_12733_1842# 0.70708f
C246 a_17293_1842# DELAY_VBIASP 0.11222f
C247 DELAY_OUT_TAP27 DELAY_VBIASN 0.04353f
C248 DELAY_OUT_TAP22 a_19573_1842# 0.0114f
C249 a_18943_1842# DELAY_VBIASP 0.06627f
C250 a_25653_1842# DELAY_OUT_TAP29 0.70708f
C251 DELAY_VBIASP a_13623_1842# 0.06627f
C252 VDD a_15143_1842# 0.49633f
C253 a_25023_1842# DELAY_VBIASN 0.07258f
C254 DELAY_OUT_TAP31 a_26413_1842# 0.0114f
C255 a_16533_1842# a_16663_1842# 0.70845f
C256 VDD DELAY_OUT_TAP20 0.72899f
C257 DELAY_OUT_TAP16 a_15773_1842# 0.70708f
C258 a_5893_1842# DELAY_OUT_TAP4 0.0114f
C259 a_8173_1842# DELAY_VBIASN 0.10601f
C260 DELAY_VBIASP DELAY_OUT_TAP25 0.04137f
C261 a_21983_1842# a_22091_1842# 0.01163f
C262 a_15251_2470# VDD 0.01806f
C263 DELAY_OUT_TAP13 DELAY_VBIASN 0.04353f
C264 a_7543_1842# DELAY_OUT_TAP6 0.69646f
C265 DELAY_OUT_TAP9 DELAY_VBIASP 0.04137f
C266 VDD DELAY_IN 0.45518f
C267 a_10583_1842# VDD 0.49633f
C268 a_15773_1842# a_15903_1842# 0.70845f
C269 a_19573_1842# DELAY_VBIASP 0.11222f
C270 VDD DELAY_VBIASN 0.85759f
C271 VDD a_22091_2470# 0.01806f
C272 DELAY_OUT_TAP16 a_15143_1842# 0.69646f
C273 DELAY_OUT_TAP14 a_13493_1842# 0.0114f
C274 a_18813_1842# a_18943_1842# 0.70845f
C275 a_9823_1842# DELAY_VBIASP 0.06627f
C276 a_11973_1842# DELAY_VBIASP 0.11222f
C277 VDD a_21223_1842# 0.49633f
C278 DELAY_OUT_TAP22 DELAY_VBIASP 0.04137f
C279 a_20333_1842# VDD 0.4916f
C280 a_5133_1842# DELAY_OUT_TAP2 0.70708f
C281 a_7413_1842# DELAY_VBIASN 0.10601f
C282 a_6653_1842# VDD 0.4916f
C283 DELAY_OUT_TAP30 a_25783_1842# 0.69646f
C284 DELAY_OUT_TAP16 DELAY_VBIASN 0.04353f
C285 VDD a_17423_1842# 0.49633f
C286 VDD a_27737_1842# 0.75775f
C287 DELAY_VBIASP DELAY_OUT_TAP1 0.04137f
C288 VDD a_26413_1842# 0.4916f
C289 a_5263_1842# DELAY_VBIASN 0.07258f
C290 DELAY_VBIASP a_14253_1842# 0.11222f
C291 a_25783_1842# a_25891_2470# 0.01697f
C292 DELAY_VBIASN a_15903_1842# 0.07258f
C293 DELAY_VBIASN a_27173_1842# 0.10602f
C294 VDD a_17531_2470# 0.01806f
C295 a_6783_1842# a_6891_2470# 0.01697f
C296 a_23373_1842# DELAY_VBIASN 0.10601f
C297 a_12103_1842# a_12211_2470# 0.01697f
C298 a_9063_1842# DELAY_VBIASP 0.06627f
C299 VDD a_18053_1842# 0.4916f
C300 a_4373_1842# DELAY_OUT_TAP1 0.70708f
C301 a_19703_1842# VDD 0.49633f
C302 a_12733_1842# DELAY_VBIASN 0.10601f
C303 a_8173_1842# DELAY_OUT_TAP6 0.70708f
C304 a_9693_1842# DELAY_OUT_TAP9 0.0114f
C305 a_3743_1842# a_3851_2470# 0.01697f
C306 a_12103_1842# VDD 0.49633f
C307 a_4373_1842# DELAY_VBIASP 0.11222f
C308 a_27173_1842# a_27737_1842# 0.0114f
C309 a_24893_1842# DELAY_OUT_TAP29 0.0114f
C310 DELAY_OUT_TAP23 VDD 0.72899f
C311 a_6023_1842# DELAY_VBIASN 0.07258f
C312 DELAY_OUT_TAP26 DELAY_VBIASN 0.04353f
C313 a_18813_1842# DELAY_VBIASP 0.11222f
C314 VDD DELAY_OUT_TAP6 0.72899f
C315 VDD a_15013_1842# 0.4916f
C316 a_8303_1842# DELAY_VBIASP 0.06627f
C317 VDD a_14491_2470# 0.01806f
C318 a_9693_1842# a_9823_1842# 0.70845f
C319 a_14491_1842# a_14383_1842# 0.01163f
C320 DELAY_OUT_TAP28 a_24263_1842# 0.69646f
C321 VDD DELAY_OUT_TAP18 0.72899f
C322 a_20463_1842# DELAY_VBIASN 0.07258f
C323 a_11343_1842# VDD 0.49633f
C324 a_7413_1842# DELAY_OUT_TAP6 0.0114f
C325 VDD a_14383_1842# 0.49633f
C326 DELAY_OUT_TAP8 DELAY_VBIASP 0.04137f
C327 a_10453_1842# VDD 0.4916f
C328 a_22613_1842# VDD 0.4916f
C329 a_18943_1842# a_19051_2470# 0.01697f
C330 a_6783_1842# DELAY_VBIASN 0.07258f
C331 a_11213_1842# DELAY_VBIASN 0.10601f
C332 VDD DELAY_OUT_LAST 0.45735f
C333 DELAY_OUT_TAP16 a_15013_1842# 0.0114f
C334 VDD a_21331_2470# 0.01806f
C335 a_20333_1842# a_20463_1842# 0.70845f
C336 a_9063_1842# DELAY_OUT_TAP8 0.69646f
C337 a_9693_1842# DELAY_VBIASP 0.11222f
C338 a_7543_1842# DELAY_VBIASP 0.06627f
C339 VDD a_21093_1842# 0.4916f
C340 a_18183_1842# DELAY_OUT_TAP20 0.69646f
C341 a_6653_1842# a_6783_1842# 0.70845f
C342 DELAY_OUT_TAP17 DELAY_VBIASP 0.04137f
C343 DELAY_OUT_TAP30 a_25653_1842# 0.0114f
C344 VDD a_17293_1842# 0.4916f
C345 a_18183_1842# DELAY_VBIASN 0.07258f
C346 VDD a_18943_1842# 0.49633f
C347 VDD a_13623_1842# 0.49633f
C348 a_5133_1842# DELAY_VBIASN 0.10601f
C349 VDD a_10691_2470# 0.01806f
C350 a_27303_1842# a_27411_1842# 0.01163f
C351 DELAY_OUT_TAP11 DELAY_VBIASN 0.04353f
C352 VDD DELAY_OUT_TAP25 0.72899f
C353 a_13493_1842# DELAY_VBIASN 0.10601f
C354 VDD a_16771_2470# 0.01806f
C355 DELAY_VBIASP a_23503_1842# 0.06627f
C356 a_21983_1842# a_22091_2470# 0.01697f
C357 DELAY_OUT_TAP31 DELAY_VBIASP 0.04137f
C358 a_21983_1842# DELAY_VBIASN 0.07258f
C359 VDD DELAY_OUT_TAP9 0.72899f
C360 a_25783_1842# DELAY_VBIASN 0.07258f
C361 DELAY_VBIASN DELAY_OUT_TAP24 0.04353f
C362 DELAY_OUT_TAP7 DELAY_VBIASN 0.04353f
C363 DELAY_OUT_TAP5 DELAY_VBIASN 0.04353f
C364 a_12863_1842# DELAY_VBIASP 0.06627f
C365 a_17423_1842# a_17531_1842# 0.01163f
C366 a_26651_2470# a_26543_1842# 0.01697f
C367 a_19573_1842# VDD 0.4916f
C368 a_20463_1842# DELAY_OUT_TAP23 0.69646f
C369 a_16663_1842# DELAY_VBIASN 0.07258f
C370 a_9693_1842# DELAY_OUT_TAP8 0.70708f
C371 a_21223_1842# DELAY_OUT_TAP24 0.69646f
C372 DELAY_VBIASN DELAY_OUT_TAP19 0.04353f
C373 DELAY_OUT_TAP29 DELAY_VBIASN 0.04353f
C374 a_9823_1842# a_9931_2470# 0.01697f
C375 a_22613_1842# DELAY_OUT_TAP26 0.0114f
C376 a_9823_1842# VDD 0.49633f
C377 a_11973_1842# VDD 0.4916f
C378 DELAY_VBIASP DELAY_OUT_TAP27 0.04137f
C379 a_24371_1842# a_24263_1842# 0.01163f
C380 a_24893_1842# DELAY_OUT_TAP28 0.70708f
C381 DELAY_OUT_TAP22 VDD 0.72899f
C382 a_5893_1842# DELAY_VBIASN 0.10601f
C383 a_8303_1842# a_8411_1842# 0.01163f
C384 a_22743_1842# DELAY_VBIASN 0.07258f
C385 a_6653_1842# DELAY_OUT_TAP5 0.0114f
C386 VDD a_24371_2470# 0.01806f
C387 a_25023_1842# DELAY_VBIASP 0.06627f
C388 a_25891_1842# a_25783_1842# 0.01163f
C389 a_8173_1842# DELAY_VBIASP 0.11222f
C390 VDD a_13731_2470# 0.01806f
C391 a_4503_1842# DELAY_OUT_TAP2 0.69646f
C392 a_24133_1842# a_24263_1842# 0.70845f
C393 DELAY_OUT_TAP13 DELAY_VBIASP 0.04137f
C394 VDD DELAY_OUT_TAP1 0.72899f
C395 a_18053_1842# a_18183_1842# 0.70845f
C396 DELAY_OUT_TAP28 a_24133_1842# 0.0114f
C397 a_17423_1842# DELAY_OUT_TAP19 0.69646f
C398 a_11213_1842# a_11343_1842# 0.70845f
C399 a_12863_1842# a_12971_2470# 0.01697f
C400 VDD a_14253_1842# 0.4916f
C401 VDD DELAY_VBIASP 13.2523f
C402 DELAY_OUT_TAP15 DELAY_VBIASN 0.04353f
C403 a_27303_1842# DELAY_VBIASN 0.07259f
C404 VDD a_9063_1842# 0.49633f
C405 a_15143_1842# a_15251_1842# 0.01163f
C406 a_7413_1842# DELAY_VBIASP 0.11222f
C407 a_8303_1842# a_8411_2470# 0.01697f
C408 a_8933_1842# DELAY_VBIASN 0.10601f
C409 a_18053_1842# DELAY_OUT_TAP19 0.70708f
C410 DELAY_OUT_TAP16 DELAY_VBIASP 0.04137f
C411 a_8173_1842# a_8303_1842# 0.70845f
C412 DELAY_OUT_TAP3 DELAY_VBIASN 0.04353f
C413 VDD a_4373_1842# 0.4916f
C414 a_5263_1842# DELAY_VBIASP 0.06627f
C415 DELAY_OUT_TAP11 a_11343_1842# 0.69646f
C416 VDD a_18813_1842# 0.4916f
C417 DELAY_VBIASP a_15903_1842# 0.06627f
C418 VDD a_12971_2470# 0.01806f
C419 a_10583_1842# DELAY_OUT_TAP10 0.69646f
C420 DELAY_VBIASP a_27173_1842# 0.11222f
C421 a_27303_1842# a_27737_1842# 0.69646f
C422 a_8303_1842# VDD 0.49633f
C423 DELAY_OUT_TAP10 DELAY_VBIASN 0.04353f
C424 DELAY_VBIASP a_23373_1842# 0.11222f
C425 a_21853_1842# DELAY_VBIASN 0.10601f
C426 VDD DELAY_OUT_TAP8 0.72899f
C427 a_16663_1842# DELAY_OUT_TAP18 0.69646f
C428 a_9171_1842# a_9063_1842# 0.01163f
C429 a_25653_1842# DELAY_VBIASN 0.10601f
C430 a_12733_1842# DELAY_VBIASP 0.11222f
C431 DELAY_OUT_TAP4 DELAY_VBIASN 0.04353f
C432 a_16533_1842# DELAY_VBIASN 0.10601f
C433 a_24263_1842# DELAY_VBIASN 0.07258f
C434 a_21093_1842# DELAY_OUT_TAP24 0.0114f
C435 DELAY_OUT_TAP28 DELAY_VBIASN 0.04353f
C436 a_6023_1842# DELAY_VBIASP 0.06627f
C437 a_9693_1842# VDD 0.4916f
C438 a_22613_1842# a_22743_1842# 0.70845f
C439 a_7543_1842# VDD 0.49633f
C440 DELAY_VBIASP DELAY_OUT_TAP26 0.04137f
C441 a_6653_1842# DELAY_OUT_TAP4 0.70708f
C442 a_23503_1842# DELAY_OUT_TAP27 0.69646f
C443 a_15013_1842# DELAY_OUT_TAP15 0.70708f
C444 DELAY_OUT_TAP17 VDD 0.72899f
C445 a_13493_1842# a_13623_1842# 0.70845f
C446 a_7413_1842# a_7543_1842# 0.70845f
C447 a_20463_1842# DELAY_VBIASP 0.06627f
C448 a_21983_1842# DELAY_OUT_TAP25 0.69646f
C449 DELAY_OUT_TAP15 a_14383_1842# 0.69646f
C450 a_17293_1842# DELAY_OUT_TAP19 0.0114f
C451 a_6783_1842# DELAY_VBIASP 0.06627f
C452 a_11213_1842# DELAY_VBIASP 0.11222f
C453 a_26651_1842# a_26543_1842# 0.01163f
C454 DELAY_OUT_TAP13 a_12863_1842# 0.69646f
C455 DELAY_OUT_TAP14 DELAY_VBIASN 0.04353f
C456 a_4503_1842# DELAY_VBIASN 0.07258f
C457 VDD a_23503_1842# 0.49633f
C458 VDD DELAY_OUT_TAP31 0.72899f
C459 a_23503_1842# a_23611_2470# 0.01697f
C460 a_7543_1842# a_7651_1842# 0.01163f
C461 a_16663_1842# a_16771_2470# 0.01697f
C462 a_11343_1842# a_11451_2470# 0.01697f
C463 a_9063_1842# a_9171_2470# 0.01697f
C464 DELAY_OUT_TAP11 a_11973_1842# 0.70708f
C465 VDD a_12863_1842# 0.49633f
C466 VDD a_6131_2470# 0.01806f
C467 DELAY_OUT_TAP30 DELAY_VBIASN 0.04353f
C468 DELAY_OUT_TAP17 a_15903_1842# 0.69646f
C469 VDD a_19051_2470# 0.01806f
C470 DELAY_OUT_TAP2 DELAY_VBIASN 0.04353f
C471 DELAY_VBIASN DELAY_OUT_TAP21 0.04353f
C472 VDD DELAY_OUT_TAP27 0.72899f
C473 DELAY_VBIASP a_18183_1842# 0.06627f
C474 a_5133_1842# DELAY_VBIASP 0.11222f
C475 a_12211_1842# a_12103_1842# 0.01163f
C476 VDD a_25023_1842# 0.49633f
C477 a_10453_1842# DELAY_OUT_TAP10 0.0114f
C478 VDD a_8411_2470# 0.01806f
C479 VDD a_12211_2470# 0.01806f
C480 a_8173_1842# VDD 0.4916f
C481 DELAY_OUT_TAP11 DELAY_VBIASP 0.04137f
C482 DELAY_VBIASP a_13493_1842# 0.11222f
C483 DELAY_OUT_TAP31 a_27173_1842# 0.70708f
C484 DELAY_OUT_TAP13 VDD 0.72899f
C485 a_21983_1842# DELAY_VBIASP 0.06627f
C486 a_24893_1842# DELAY_VBIASN 0.10601f
C487 DELAY_OUT_TAP30 a_26413_1842# 0.70708f
C488 a_25783_1842# DELAY_VBIASP 0.06627f
C489 DELAY_VBIASP DELAY_OUT_TAP24 0.04137f
C490 DELAY_OUT_TAP7 DELAY_VBIASP 0.04137f
C491 VDD a_5371_2470# 0.01806f
C492 a_16533_1842# DELAY_OUT_TAP18 0.0114f
C493 DELAY_OUT_TAP5 DELAY_VBIASP 0.04137f
C494 DELAY_OUT_TAP12 DELAY_VBIASN 0.04353f
C495 a_23373_1842# a_23503_1842# 0.70845f
C496 a_7543_1842# a_7651_2470# 0.01697f
C497 VDD a_9931_2470# 0.01806f
C498 VDD a_23611_2470# 0.01806f
C499 DELAY_VBIASP a_16663_1842# 0.06627f
C500 DELAY_VBIASP DELAY_OUT_TAP19 0.04137f
C501 VDD a_20571_2470# 0.01806f
C502 DELAY_OUT_TAP29 DELAY_VBIASP 0.04137f
C503 a_24133_1842# DELAY_VBIASN 0.10601f
C504 a_12733_1842# a_12863_1842# 0.70845f
C505 a_5893_1842# DELAY_VBIASP 0.11222f
C506 a_7413_1842# VDD 0.4916f
C507 a_22743_1842# DELAY_VBIASP 0.06627f
C508 a_26543_1842# DELAY_VBIASN 0.07258f
C509 a_23373_1842# DELAY_OUT_TAP27 0.0114f
C510 DELAY_OUT_TAP16 VDD 0.72899f
C511 a_6023_1842# a_6131_2470# 0.01697f
C512 a_5263_1842# a_5371_2470# 0.01697f
C513 DELAY_IN a_3743_1842# 0.53924f
C514 a_5263_1842# VDD 0.49633f
C515 a_21853_1842# DELAY_OUT_TAP25 0.0114f
C516 DELAY_OUT_TAP15 a_14253_1842# 0.0114f
C517 a_8303_1842# DELAY_OUT_TAP7 0.69646f
R0 DELAY_VBIASN.n1 DELAY_VBIASN.t31 34.3755
R1 DELAY_VBIASN.n1 DELAY_VBIASN.t30 33.0005
R2 DELAY_VBIASN.n2 DELAY_VBIASN.t29 33.0005
R3 DELAY_VBIASN.n3 DELAY_VBIASN.t28 33.0005
R4 DELAY_VBIASN.n4 DELAY_VBIASN.t27 33.0005
R5 DELAY_VBIASN.n5 DELAY_VBIASN.t26 33.0005
R6 DELAY_VBIASN.n6 DELAY_VBIASN.t25 33.0005
R7 DELAY_VBIASN.n7 DELAY_VBIASN.t24 33.0005
R8 DELAY_VBIASN.n8 DELAY_VBIASN.t23 33.0005
R9 DELAY_VBIASN.n9 DELAY_VBIASN.t22 33.0005
R10 DELAY_VBIASN.n10 DELAY_VBIASN.t21 33.0005
R11 DELAY_VBIASN.n11 DELAY_VBIASN.t20 33.0005
R12 DELAY_VBIASN.n12 DELAY_VBIASN.t19 33.0005
R13 DELAY_VBIASN.n13 DELAY_VBIASN.t18 33.0005
R14 DELAY_VBIASN.n14 DELAY_VBIASN.t17 33.0005
R15 DELAY_VBIASN.n15 DELAY_VBIASN.t16 33.0005
R16 DELAY_VBIASN.n16 DELAY_VBIASN.t15 33.0005
R17 DELAY_VBIASN.n17 DELAY_VBIASN.t14 33.0005
R18 DELAY_VBIASN.n18 DELAY_VBIASN.t13 33.0005
R19 DELAY_VBIASN.n19 DELAY_VBIASN.t12 33.0005
R20 DELAY_VBIASN.n20 DELAY_VBIASN.t11 33.0005
R21 DELAY_VBIASN.n21 DELAY_VBIASN.t10 33.0005
R22 DELAY_VBIASN.n22 DELAY_VBIASN.t9 33.0005
R23 DELAY_VBIASN.n23 DELAY_VBIASN.t8 33.0005
R24 DELAY_VBIASN.n24 DELAY_VBIASN.t7 33.0005
R25 DELAY_VBIASN.n25 DELAY_VBIASN.t6 33.0005
R26 DELAY_VBIASN.n26 DELAY_VBIASN.t5 33.0005
R27 DELAY_VBIASN.n27 DELAY_VBIASN.t4 33.0005
R28 DELAY_VBIASN.n28 DELAY_VBIASN.t3 33.0005
R29 DELAY_VBIASN.n29 DELAY_VBIASN.t2 33.0005
R30 DELAY_VBIASN.n30 DELAY_VBIASN.t1 33.0005
R31 DELAY_VBIASN.n0 DELAY_VBIASN.t0 33.0005
R32 DELAY_VBIASN DELAY_VBIASN.n0 1.55517
R33 DELAY_VBIASN.n0 DELAY_VBIASN.n30 1.3755
R34 DELAY_VBIASN.n30 DELAY_VBIASN.n29 1.3755
R35 DELAY_VBIASN.n29 DELAY_VBIASN.n28 1.3755
R36 DELAY_VBIASN.n28 DELAY_VBIASN.n27 1.3755
R37 DELAY_VBIASN.n27 DELAY_VBIASN.n26 1.3755
R38 DELAY_VBIASN.n26 DELAY_VBIASN.n25 1.3755
R39 DELAY_VBIASN.n25 DELAY_VBIASN.n24 1.3755
R40 DELAY_VBIASN.n24 DELAY_VBIASN.n23 1.3755
R41 DELAY_VBIASN.n23 DELAY_VBIASN.n22 1.3755
R42 DELAY_VBIASN.n22 DELAY_VBIASN.n21 1.3755
R43 DELAY_VBIASN.n21 DELAY_VBIASN.n20 1.3755
R44 DELAY_VBIASN.n20 DELAY_VBIASN.n19 1.3755
R45 DELAY_VBIASN.n19 DELAY_VBIASN.n18 1.3755
R46 DELAY_VBIASN.n18 DELAY_VBIASN.n17 1.3755
R47 DELAY_VBIASN.n17 DELAY_VBIASN.n16 1.3755
R48 DELAY_VBIASN.n16 DELAY_VBIASN.n15 1.3755
R49 DELAY_VBIASN.n15 DELAY_VBIASN.n14 1.3755
R50 DELAY_VBIASN.n14 DELAY_VBIASN.n13 1.3755
R51 DELAY_VBIASN.n13 DELAY_VBIASN.n12 1.3755
R52 DELAY_VBIASN.n12 DELAY_VBIASN.n11 1.3755
R53 DELAY_VBIASN.n11 DELAY_VBIASN.n10 1.3755
R54 DELAY_VBIASN.n10 DELAY_VBIASN.n9 1.3755
R55 DELAY_VBIASN.n9 DELAY_VBIASN.n8 1.3755
R56 DELAY_VBIASN.n8 DELAY_VBIASN.n7 1.3755
R57 DELAY_VBIASN.n7 DELAY_VBIASN.n6 1.3755
R58 DELAY_VBIASN.n6 DELAY_VBIASN.n5 1.3755
R59 DELAY_VBIASN.n5 DELAY_VBIASN.n4 1.3755
R60 DELAY_VBIASN.n4 DELAY_VBIASN.n3 1.3755
R61 DELAY_VBIASN.n3 DELAY_VBIASN.n2 1.3755
R62 DELAY_VBIASN.n2 DELAY_VBIASN.n1 1.3755
R63 DELAY_VBIASP.n1 DELAY_VBIASP.t31 34.3685
R64 DELAY_VBIASP.n1 DELAY_VBIASP.t30 33.0005
R65 DELAY_VBIASP.n2 DELAY_VBIASP.t29 33.0005
R66 DELAY_VBIASP.n3 DELAY_VBIASP.t28 33.0005
R67 DELAY_VBIASP.n4 DELAY_VBIASP.t27 33.0005
R68 DELAY_VBIASP.n5 DELAY_VBIASP.t26 33.0005
R69 DELAY_VBIASP.n6 DELAY_VBIASP.t25 33.0005
R70 DELAY_VBIASP.n7 DELAY_VBIASP.t24 33.0005
R71 DELAY_VBIASP.n8 DELAY_VBIASP.t23 33.0005
R72 DELAY_VBIASP.n9 DELAY_VBIASP.t22 33.0005
R73 DELAY_VBIASP.n10 DELAY_VBIASP.t21 33.0005
R74 DELAY_VBIASP.n11 DELAY_VBIASP.t20 33.0005
R75 DELAY_VBIASP.n12 DELAY_VBIASP.t19 33.0005
R76 DELAY_VBIASP.n13 DELAY_VBIASP.t18 33.0005
R77 DELAY_VBIASP.n14 DELAY_VBIASP.t17 33.0005
R78 DELAY_VBIASP.n15 DELAY_VBIASP.t16 33.0005
R79 DELAY_VBIASP.n16 DELAY_VBIASP.t15 33.0005
R80 DELAY_VBIASP.n17 DELAY_VBIASP.t14 33.0005
R81 DELAY_VBIASP.n18 DELAY_VBIASP.t13 33.0005
R82 DELAY_VBIASP.n19 DELAY_VBIASP.t12 33.0005
R83 DELAY_VBIASP.n20 DELAY_VBIASP.t11 33.0005
R84 DELAY_VBIASP.n21 DELAY_VBIASP.t10 33.0005
R85 DELAY_VBIASP.n22 DELAY_VBIASP.t9 33.0005
R86 DELAY_VBIASP.n23 DELAY_VBIASP.t8 33.0005
R87 DELAY_VBIASP.n24 DELAY_VBIASP.t7 33.0005
R88 DELAY_VBIASP.n25 DELAY_VBIASP.t6 33.0005
R89 DELAY_VBIASP.n26 DELAY_VBIASP.t5 33.0005
R90 DELAY_VBIASP.n27 DELAY_VBIASP.t4 33.0005
R91 DELAY_VBIASP.n28 DELAY_VBIASP.t3 33.0005
R92 DELAY_VBIASP.n29 DELAY_VBIASP.t2 33.0005
R93 DELAY_VBIASP.n30 DELAY_VBIASP.t1 33.0005
R94 DELAY_VBIASP.n0 DELAY_VBIASP.t0 33.0005
R95 DELAY_VBIASP DELAY_VBIASP.n0 1.70586
R96 DELAY_VBIASP.n0 DELAY_VBIASP.n30 1.36852
R97 DELAY_VBIASP.n30 DELAY_VBIASP.n29 1.36852
R98 DELAY_VBIASP.n29 DELAY_VBIASP.n28 1.36852
R99 DELAY_VBIASP.n28 DELAY_VBIASP.n27 1.36852
R100 DELAY_VBIASP.n27 DELAY_VBIASP.n26 1.36852
R101 DELAY_VBIASP.n26 DELAY_VBIASP.n25 1.36852
R102 DELAY_VBIASP.n25 DELAY_VBIASP.n24 1.36852
R103 DELAY_VBIASP.n24 DELAY_VBIASP.n23 1.36852
R104 DELAY_VBIASP.n23 DELAY_VBIASP.n22 1.36852
R105 DELAY_VBIASP.n22 DELAY_VBIASP.n21 1.36852
R106 DELAY_VBIASP.n21 DELAY_VBIASP.n20 1.36852
R107 DELAY_VBIASP.n20 DELAY_VBIASP.n19 1.36852
R108 DELAY_VBIASP.n19 DELAY_VBIASP.n18 1.36852
R109 DELAY_VBIASP.n18 DELAY_VBIASP.n17 1.36852
R110 DELAY_VBIASP.n17 DELAY_VBIASP.n16 1.36852
R111 DELAY_VBIASP.n16 DELAY_VBIASP.n15 1.36852
R112 DELAY_VBIASP.n15 DELAY_VBIASP.n14 1.36852
R113 DELAY_VBIASP.n14 DELAY_VBIASP.n13 1.36852
R114 DELAY_VBIASP.n13 DELAY_VBIASP.n12 1.36852
R115 DELAY_VBIASP.n12 DELAY_VBIASP.n11 1.36852
R116 DELAY_VBIASP.n11 DELAY_VBIASP.n10 1.36852
R117 DELAY_VBIASP.n10 DELAY_VBIASP.n9 1.36852
R118 DELAY_VBIASP.n9 DELAY_VBIASP.n8 1.36852
R119 DELAY_VBIASP.n8 DELAY_VBIASP.n7 1.36852
R120 DELAY_VBIASP.n7 DELAY_VBIASP.n6 1.36852
R121 DELAY_VBIASP.n6 DELAY_VBIASP.n5 1.36852
R122 DELAY_VBIASP.n5 DELAY_VBIASP.n4 1.36852
R123 DELAY_VBIASP.n4 DELAY_VBIASP.n3 1.36852
R124 DELAY_VBIASP.n3 DELAY_VBIASP.n2 1.36852
R125 DELAY_VBIASP.n2 DELAY_VBIASP.n1 1.36852
R126 VDD.t0 VDD.t52 15.1333
R127 VDD.t0 VDD.t55 15.0005
R128 VDD.t0 VDD.t47 15.0005
R129 VDD.n9 VDD 1.59504
R130 VDD.t0 VDD.t35 6.09923
R131 VDD.n34 VDD.t39 6.09923
R132 VDD.n28 VDD.t58 6.09923
R133 VDD.n56 VDD.t44 6.09923
R134 VDD.n18 VDD.t38 6.09923
R135 VDD.n42 VDD.t63 6.09923
R136 VDD.n24 VDD.t86 6.09923
R137 VDD.n50 VDD.t67 6.09923
R138 VDD.n22 VDD.t66 6.09923
R139 VDD.n48 VDD.t41 6.09923
R140 VDD.n38 VDD.t46 6.09923
R141 VDD.t0 VDD.t1 6.09923
R142 VDD.n52 VDD.t68 6.09923
R143 VDD.n20 VDD.t40 6.09923
R144 VDD.n44 VDD.t69 6.09923
R145 VDD.n30 VDD.t2 6.09923
R146 VDD.t0 VDD.t37 6.09923
R147 VDD.n40 VDD.t70 6.09923
R148 VDD.n16 VDD.t92 6.09923
R149 VDD.n36 VDD.t96 6.09923
R150 VDD.n32 VDD.t60 6.09923
R151 VDD.n14 VDD.t36 6.09923
R152 VDD.n14 VDD.t83 6.09923
R153 VDD.n46 VDD.t64 6.09923
R154 VDD.n26 VDD.t72 6.09923
R155 VDD.n54 VDD.t79 6.09923
R156 VDD.n8 VDD.t42 6.09923
R157 VDD.n8 VDD.t84 6.09923
R158 VDD.t0 VDD.t82 6.09923
R159 VDD.t0 VDD.t71 6.09923
R160 VDD.t0 VDD.t43 6.09923
R161 VDD.t0 VDD.t101 6.09923
R162 VDD.t0 VDD.n4 0.159689
R163 VDD.n4 VDD.n28 0.181828
R164 VDD.t0 VDD.n18 0.609174
R165 VDD.t0 VDD.n24 0.609124
R166 VDD.t0 VDD.n22 0.609194
R167 VDD.t0 VDD.n38 0.470719
R168 VDD.n11 VDD.n20 0.111462
R169 VDD.t0 VDD.n30 0.470726
R170 VDD.n10 VDD.n16 0.111406
R171 VDD.t0 VDD.n32 0.67273
R172 VDD.t0 VDD.n14 0.313806
R173 VDD.t0 VDD.n26 0.609184
R174 VDD.t0 VDD.t48 5.60969
R175 VDD.t0 VDD.t51 5.78888
R176 VDD.t0 VDD.t57 5.60347
R177 VDD.t0 VDD.t11 5.80553
R178 VDD.n33 VDD.t15 5.59675
R179 VDD.n27 VDD.t14 5.59675
R180 VDD.n55 VDD.t13 5.59675
R181 VDD.n17 VDD.t17 5.59675
R182 VDD.n41 VDD.t16 5.59675
R183 VDD.n23 VDD.t18 5.59675
R184 VDD.n49 VDD.t19 5.59675
R185 VDD.n21 VDD.t12 5.59675
R186 VDD.n47 VDD.t10 5.59675
R187 VDD.n37 VDD.t5 5.59675
R188 VDD.n2 VDD.t20 5.59675
R189 VDD.n51 VDD.t9 5.59675
R190 VDD.n19 VDD.t8 5.59675
R191 VDD.n43 VDD.t6 5.59675
R192 VDD.n29 VDD.t3 5.59675
R193 VDD.n3 VDD.t7 5.59675
R194 VDD.n39 VDD.t22 5.59675
R195 VDD.n15 VDD.t21 5.59675
R196 VDD.n35 VDD.t24 5.59675
R197 VDD.n31 VDD.t23 5.59675
R198 VDD.n13 VDD.t26 5.59675
R199 VDD.n12 VDD.t27 5.59675
R200 VDD.n45 VDD.t28 5.59675
R201 VDD.n25 VDD.t25 5.59675
R202 VDD.n53 VDD.t4 5.59675
R203 VDD.n7 VDD.t31 5.59675
R204 VDD.n6 VDD.t32 5.59675
R205 VDD.n0 VDD.t30 5.59675
R206 VDD.t0 VDD.t34 5.59675
R207 VDD.t0 VDD.t29 5.75534
R208 VDD.n9 VDD.t0 0.71648
R209 VDD VDD.n9 1.59504
R210 VDD.n34 VDD.n4 0.107617
R211 VDD.n36 VDD.n32 0.409438
R212 VDD.n56 VDD.n18 0.409773
R213 VDD.n42 VDD.n24 0.409614
R214 VDD.n44 VDD.n30 0.409614
R215 VDD.n48 VDD.n38 0.409651
R216 VDD.n46 VDD.n26 0.409651
R217 VDD.n50 VDD.n22 0.40971
R218 VDD.n52 VDD.n11 0.225479
R219 VDD.n40 VDD.n10 0.225397
R220 VDD.t0 VDD.n82 1.55397
R221 VDD.n5 VDD.n109 0.714073
R222 VDD.t0 VDD.n59 1.55376
R223 VDD.t0 VDD.n64 1.55376
R224 VDD.t0 VDD.n75 1.55373
R225 VDD.t0 VDD.n68 1.55371
R226 VDD.t0 VDD.n60 1.55361
R227 VDD.t0 VDD.n78 1.55361
R228 VDD.t0 VDD.n57 1.55358
R229 VDD.t0 VDD.n66 1.55354
R230 VDD.t0 VDD.n67 1.55352
R231 VDD.t0 VDD.n69 1.5535
R232 VDD.t0 VDD.n70 1.5535
R233 VDD.t0 VDD.n77 1.5535
R234 VDD.t0 VDD.n79 1.5535
R235 VDD.t0 VDD.n80 1.5535
R236 VDD.t0 VDD.n61 1.55344
R237 VDD.t0 VDD.n65 1.55343
R238 VDD.t0 VDD.n71 1.55334
R239 VDD.t0 VDD.n72 1.55334
R240 VDD.t0 VDD.n73 1.55334
R241 VDD.t0 VDD.n74 1.55334
R242 VDD.t0 VDD.n5 0.416589
R243 VDD.t0 VDD.n76 1.55331
R244 VDD.t0 VDD.n63 1.55328
R245 VDD.t0 VDD.n81 1.55328
R246 VDD.t0 VDD.n58 1.55327
R247 VDD.t0 VDD.n62 1.55325
R248 VDD.t0 VDD.t49 5.71343
R249 VDD.n33 VDD.n5 0.620795
R250 VDD.n27 VDD.n109 0.495398
R251 VDD.n55 VDD.n108 0.495398
R252 VDD.n17 VDD.n107 0.495398
R253 VDD.n41 VDD.n106 0.495398
R254 VDD.n23 VDD.n105 0.495398
R255 VDD.n49 VDD.n104 0.495398
R256 VDD.n21 VDD.n103 0.495398
R257 VDD.n47 VDD.n102 0.495398
R258 VDD.n37 VDD.n101 0.495398
R259 VDD.n2 VDD.n100 0.495398
R260 VDD.n51 VDD.n99 0.495398
R261 VDD.n19 VDD.n98 0.495398
R262 VDD.n43 VDD.n97 0.495398
R263 VDD.n29 VDD.n96 0.495398
R264 VDD.n3 VDD.n95 0.495398
R265 VDD.n39 VDD.n94 0.495398
R266 VDD.n15 VDD.n93 0.495398
R267 VDD.n35 VDD.n92 0.495398
R268 VDD.n31 VDD.n91 0.495398
R269 VDD.n13 VDD.n90 0.495398
R270 VDD.n12 VDD.n89 0.495398
R271 VDD.n45 VDD.n88 0.495398
R272 VDD.n25 VDD.n87 0.495398
R273 VDD.n53 VDD.n86 0.495398
R274 VDD.n7 VDD.n85 0.495398
R275 VDD.n6 VDD.n84 0.495398
R276 VDD.n0 VDD.n83 0.495398
R277 VDD.n34 VDD.n33 0.478641
R278 VDD.n28 VDD.n27 0.478641
R279 VDD.n56 VDD.n55 0.478641
R280 VDD.n18 VDD.n17 0.478641
R281 VDD.n42 VDD.n41 0.478641
R282 VDD.n24 VDD.n23 0.478641
R283 VDD.n50 VDD.n49 0.478641
R284 VDD.n22 VDD.n21 0.478641
R285 VDD.n48 VDD.n47 0.478641
R286 VDD.n38 VDD.n37 0.478641
R287 VDD.t0 VDD.n2 0.478641
R288 VDD.n52 VDD.n51 0.478641
R289 VDD.n20 VDD.n19 0.478641
R290 VDD.n44 VDD.n43 0.478641
R291 VDD.n30 VDD.n29 0.478641
R292 VDD.t0 VDD.n3 0.478641
R293 VDD.n40 VDD.n39 0.478641
R294 VDD.n16 VDD.n15 0.478641
R295 VDD.n36 VDD.n35 0.478641
R296 VDD.n32 VDD.n31 0.478641
R297 VDD.n14 VDD.n13 0.478641
R298 VDD.n14 VDD.n12 0.478641
R299 VDD.n46 VDD.n45 0.478641
R300 VDD.n26 VDD.n25 0.478641
R301 VDD.n54 VDD.n53 0.478641
R302 VDD.n8 VDD.n7 0.478641
R303 VDD.n8 VDD.n6 0.478641
R304 VDD.t0 VDD.n0 0.478641
R305 VDD.t0 VDD.t53 6.19118
R306 VDD.n84 VDD.n82 0.467573
R307 VDD.n102 VDD.n64 0.467303
R308 VDD.n107 VDD.n59 0.467303
R309 VDD.n98 VDD.n68 0.467258
R310 VDD.n1 VDD.t33 6.23958
R311 VDD.n88 VDD.n78 0.467143
R312 VDD.n106 VDD.n60 0.467143
R313 VDD.n99 VDD.n67 0.467091
R314 VDD.n100 VDD.n66 0.467012
R315 VDD.n109 VDD.n57 0.467003
R316 VDD.n91 VDD.n75 0.467002
R317 VDD.n101 VDD.n65 0.466718
R318 VDD.n90 VDD.n76 0.466717
R319 VDD.n95 VDD.n71 0.466699
R320 VDD.n93 VDD.n73 0.466699
R321 VDD.n92 VDD.n74 0.466699
R322 VDD.n83 VDD.n1 0.875206
R323 VDD.n97 VDD.n69 0.466677
R324 VDD.n104 VDD.n62 0.466552
R325 VDD.n108 VDD.n58 0.466439
R326 VDD.n96 VDD.n70 0.466426
R327 VDD.n89 VDD.n77 0.466426
R328 VDD.n87 VDD.n79 0.466426
R329 VDD.n86 VDD.n80 0.466426
R330 VDD.n105 VDD.n61 0.466376
R331 VDD.n103 VDD.n63 0.466265
R332 VDD.n85 VDD.n81 0.466265
R333 VDD.n94 VDD.n72 0.466253
R334 VDD.n93 VDD.n72 0.451699
R335 VDD.n102 VDD.n63 0.451619
R336 VDD.n84 VDD.n81 0.451619
R337 VDD.n104 VDD.n61 0.451531
R338 VDD.n95 VDD.n70 0.451477
R339 VDD.n86 VDD.n79 0.451477
R340 VDD.n85 VDD.n80 0.451477
R341 VDD.n88 VDD.n77 0.451477
R342 VDD.n107 VDD.n58 0.451469
R343 VDD.n103 VDD.n62 0.451353
R344 VDD.n94 VDD.n71 0.451252
R345 VDD.n92 VDD.n73 0.451252
R346 VDD.n91 VDD.n74 0.451252
R347 VDD.n96 VDD.n69 0.451226
R348 VDD.n89 VDD.n76 0.451206
R349 VDD.n100 VDD.n65 0.451178
R350 VDD.n108 VDD.n57 0.451009
R351 VDD.n99 VDD.n66 0.450921
R352 VDD.n90 VDD.n75 0.450907
R353 VDD.n98 VDD.n67 0.450884
R354 VDD.n105 VDD.n60 0.450828
R355 VDD.n87 VDD.n78 0.450828
R356 VDD.n97 VDD.n68 0.450729
R357 VDD.n106 VDD.n59 0.450676
R358 VDD.n101 VDD.n64 0.450676
R359 VDD.n83 VDD.n82 0.450429
R360 VDD.t0 VDD.t50 15.0661
R361 VDD.n16 VDD.n36 1.23764
R362 VDD.t0 VDD.n10 0.334948
R363 VDD.n18 VDD.n42 1.23755
R364 VDD.n22 VDD.n48 1.23752
R365 VDD.n20 VDD.n44 1.23747
R366 VDD.n14 VDD.n46 1.23745
R367 VDD.n26 VDD.n54 1.2374
R368 VDD.n28 VDD.n56 1.23736
R369 VDD.t0 VDD.n11 0.334873
R370 VDD.n24 VDD.n50 1.23734
R371 VDD.t0 VDD.t54 5.87988
R372 VDD.n54 VDD.n8 1.11854
R373 VDD.t0 VDD.n1 1.07258
R374 VDD.t0 VDD.n8 1.06448
R375 VSS.n91 VSS.t138 108.746
R376 VSS.t125 VSS.n1 108.746
R377 VSS.t139 VSS.n3 108.746
R378 VSS.n87 VSS.t122 108.746
R379 VSS.n86 VSS.t121 108.746
R380 VSS.n85 VSS.t140 108.746
R381 VSS.t141 VSS.n7 108.746
R382 VSS.t142 VSS.n9 108.746
R383 VSS.t143 VSS.n11 108.746
R384 VSS.t123 VSS.n12 108.746
R385 VSS.n81 VSS.t128 108.746
R386 VSS.n79 VSS.t146 108.746
R387 VSS.n78 VSS.t145 108.746
R388 VSS.t126 VSS.n15 108.746
R389 VSS.t144 VSS.n17 108.746
R390 VSS.t130 VSS.n19 108.746
R391 VSS.t131 VSS.n21 108.746
R392 VSS.n74 VSS.t147 108.746
R393 VSS.t150 VSS.n23 108.746
R394 VSS.n71 VSS.t151 108.746
R395 VSS.n70 VSS.t149 108.746
R396 VSS.t135 VSS.n25 108.746
R397 VSS.t124 VSS.n28 108.746
R398 VSS.n65 VSS.t152 108.746
R399 VSS.n32 VSS.t132 8.4756
R400 VSS.n89 VSS.t137 108.746
R401 VSS.n83 VSS.t129 108.746
R402 VSS.n75 VSS.t136 108.746
R403 VSS.n68 VSS.t148 108.746
R404 VSS.n66 VSS.t127 108.746
R405 VSS.t167 VSS.n64 67.0839
R406 VSS.n62 VSS.t133 108.746
R407 VSS.n76 VSS.t154 106.056
R408 VSS.n73 VSS.t81 106.056
R409 VSS.n72 VSS.t11 106.056
R410 VSS.n69 VSS.t84 106.056
R411 VSS.n63 VSS.t22 106.056
R412 VSS.n92 VSS.t86 106.056
R413 VSS.t65 VSS.n0 106.056
R414 VSS.t57 VSS.n2 106.056
R415 VSS.n90 VSS.t0 106.056
R416 VSS.n88 VSS.t166 106.056
R417 VSS.t58 VSS.n4 106.056
R418 VSS.t71 VSS.n5 106.056
R419 VSS.t60 VSS.n6 106.056
R420 VSS.n84 VSS.t59 106.056
R421 VSS.t106 VSS.n8 106.056
R422 VSS.t12 VSS.n10 106.056
R423 VSS.n82 VSS.t3 106.056
R424 VSS.t8 VSS.n13 106.056
R425 VSS.n80 VSS.t36 106.056
R426 VSS.t26 VSS.n14 106.056
R427 VSS.n77 VSS.t76 106.056
R428 VSS.t25 VSS.n16 106.056
R429 VSS.t168 VSS.n18 106.056
R430 VSS.t170 VSS.n20 106.056
R431 VSS.t173 VSS.n22 106.056
R432 VSS.t115 VSS.n24 106.056
R433 VSS.n67 VSS.t163 106.056
R434 VSS.t21 VSS.n26 106.056
R435 VSS.t157 VSS.n27 106.056
R436 VSS.t155 VSS.n29 106.056
R437 VSS.n94 VSS.t162 10.6843
R438 VSS.t165 VSS.n30 106.056
R439 VSS.t43 VSS.t46 99.7537
R440 VSS.n141 VSS.t33 94.1709
R441 VSS.n144 VSS.t17 94.1709
R442 VSS.t37 VSS.n147 94.1709
R443 VSS.t31 VSS.n150 94.1709
R444 VSS.n153 VSS.t15 94.1709
R445 VSS.n156 VSS.t87 94.1709
R446 VSS.n159 VSS.t108 94.1709
R447 VSS.t107 VSS.n162 94.1709
R448 VSS.n165 VSS.t105 94.1709
R449 VSS.n168 VSS.t116 94.1709
R450 VSS.t90 VSS.n171 94.1709
R451 VSS.n174 VSS.t89 94.1709
R452 VSS.t88 VSS.n177 94.1709
R453 VSS.n180 VSS.t109 94.1709
R454 VSS.t91 VSS.n183 94.1709
R455 VSS.n186 VSS.t119 94.1709
R456 VSS.n189 VSS.t114 94.1709
R457 VSS.t113 VSS.n192 94.1709
R458 VSS.n195 VSS.t111 94.1709
R459 VSS.n198 VSS.t117 94.1709
R460 VSS.t110 VSS.n201 94.1709
R461 VSS.t94 VSS.n204 94.1709
R462 VSS.n207 VSS.t98 94.1709
R463 VSS.t63 VSS.n210 94.1709
R464 VSS.t102 VSS.n213 94.1709
R465 VSS.n216 VSS.t92 94.1709
R466 VSS.n219 VSS.t95 94.1709
R467 VSS.n222 VSS.t100 94.1709
R468 VSS.t96 VSS.n225 94.1709
R469 VSS.t79 VSS.n228 94.1709
R470 VSS.n95 VSS.t120 97.257
R471 VSS.t169 VSS.n100 49.7977
R472 VSS.n89 VSS.t39 67.0429
R473 VSS.n83 VSS.t67 67.0429
R474 VSS.n75 VSS.t172 67.0429
R475 VSS.n68 VSS.t82 67.0429
R476 VSS.n66 VSS.t27 67.0429
R477 VSS.n62 VSS.t169 67.0429
R478 VSS.n91 VSS.t6 67.0426
R479 VSS.t66 VSS.n1 67.0426
R480 VSS.t56 VSS.n3 67.0426
R481 VSS.n87 VSS.t55 67.0426
R482 VSS.n86 VSS.t61 67.0426
R483 VSS.n85 VSS.t103 67.0426
R484 VSS.t69 VSS.n7 67.0426
R485 VSS.t23 VSS.n9 67.0426
R486 VSS.t34 VSS.n11 67.0426
R487 VSS.t1 VSS.n12 67.0426
R488 VSS.n81 VSS.t72 67.0426
R489 VSS.n79 VSS.t19 67.0426
R490 VSS.n78 VSS.t74 67.0426
R491 VSS.t4 VSS.n15 67.0426
R492 VSS.t13 VSS.n17 67.0426
R493 VSS.t77 VSS.n19 67.0426
R494 VSS.t171 VSS.n21 67.0426
R495 VSS.n74 VSS.t40 67.0426
R496 VSS.t9 VSS.n23 67.0426
R497 VSS.n71 VSS.t156 67.0426
R498 VSS.n70 VSS.t85 67.0426
R499 VSS.t164 VSS.n25 67.0426
R500 VSS.t158 VSS.n28 67.0426
R501 VSS.n65 VSS.t161 67.0426
R502 VSS.n93 VSS.n95 4.80622
R503 VSS.t50 VSS.n99 29.3549
R504 VSS.n93 VSS.n99 0.139322
R505 VSS.t6 VSS.n141 43.0498
R506 VSS.n144 VSS.t66 43.0498
R507 VSS.n147 VSS.t56 43.0498
R508 VSS.t39 VSS.n150 43.0498
R509 VSS.t55 VSS.n153 43.0498
R510 VSS.t61 VSS.n156 43.0498
R511 VSS.t103 VSS.n159 43.0498
R512 VSS.n162 VSS.t69 43.0498
R513 VSS.t67 VSS.n165 43.0498
R514 VSS.n168 VSS.t23 43.0498
R515 VSS.n171 VSS.t34 43.0498
R516 VSS.n174 VSS.t1 43.0498
R517 VSS.t72 VSS.n177 43.0498
R518 VSS.t19 VSS.n180 43.0498
R519 VSS.t74 VSS.n183 43.0498
R520 VSS.n186 VSS.t4 43.0498
R521 VSS.n189 VSS.t13 43.0498
R522 VSS.n192 VSS.t77 43.0498
R523 VSS.t172 VSS.n195 43.0498
R524 VSS.n198 VSS.t171 43.0498
R525 VSS.t40 VSS.n201 43.0498
R526 VSS.n204 VSS.t9 43.0498
R527 VSS.t156 VSS.n207 43.0498
R528 VSS.t85 VSS.n210 43.0498
R529 VSS.t82 VSS.n213 43.0498
R530 VSS.n216 VSS.t164 43.0498
R531 VSS.t27 VSS.n219 43.0498
R532 VSS.n222 VSS.t158 43.0498
R533 VSS.t161 VSS.n225 43.0498
R534 VSS.t167 VSS.n228 43.0498
R535 VSS.t29 VSS.n95 24.3376
R536 VSS.n93 VSS.n136 17.0005
R537 VSS.n93 VSS.n96 2.32453
R538 VSS.n93 VSS.n234 17.0005
R539 VSS.t159 VSS.n100 12.6712
R540 VSS.t33 VSS.n0 15.9213
R541 VSS.t17 VSS.n2 15.9213
R542 VSS.n90 VSS.t37 15.9213
R543 VSS.n88 VSS.t31 15.9213
R544 VSS.t15 VSS.n4 15.9213
R545 VSS.t87 VSS.n5 15.9213
R546 VSS.t108 VSS.n6 15.9213
R547 VSS.n84 VSS.t107 15.9213
R548 VSS.t105 VSS.n8 15.9213
R549 VSS.t116 VSS.n10 15.9213
R550 VSS.n82 VSS.t90 15.9213
R551 VSS.t89 VSS.n13 15.9213
R552 VSS.n80 VSS.t88 15.9213
R553 VSS.t109 VSS.n14 15.9213
R554 VSS.n77 VSS.t91 15.9213
R555 VSS.t119 VSS.n16 15.9213
R556 VSS.t114 VSS.n18 15.9213
R557 VSS.t111 VSS.n20 15.9213
R558 VSS.t117 VSS.n22 15.9213
R559 VSS.t98 VSS.n24 15.9213
R560 VSS.n67 VSS.t102 15.9213
R561 VSS.t92 VSS.n26 15.9213
R562 VSS.t95 VSS.n27 15.9213
R563 VSS.t100 VSS.n29 15.9213
R564 VSS.t120 VSS.n30 15.9213
R565 VSS.n76 VSS.t113 15.9203
R566 VSS.n73 VSS.t110 15.9203
R567 VSS.n72 VSS.t94 15.9203
R568 VSS.n69 VSS.t63 15.9203
R569 VSS.n63 VSS.t79 15.9203
R570 VSS.t46 VSS.n92 13.2307
R571 VSS.t86 VSS.n43 11.8854
R572 VSS.n42 VSS.t65 11.8854
R573 VSS.n41 VSS.t57 11.8854
R574 VSS.t0 VSS.n40 11.8854
R575 VSS.n45 VSS.t58 11.8854
R576 VSS.n39 VSS.t60 11.8854
R577 VSS.n48 VSS.t106 11.8854
R578 VSS.n49 VSS.t12 11.8854
R579 VSS.t3 VSS.n38 11.8854
R580 VSS.n50 VSS.t8 11.8854
R581 VSS.t36 VSS.n51 11.8854
R582 VSS.n52 VSS.t26 11.8854
R583 VSS.t76 VSS.n53 11.8854
R584 VSS.n37 VSS.t25 11.8854
R585 VSS.n54 VSS.t168 11.8854
R586 VSS.t154 VSS.n55 11.8854
R587 VSS.n56 VSS.t170 11.8854
R588 VSS.n57 VSS.t173 11.8854
R589 VSS.t81 VSS.n36 11.8854
R590 VSS.t11 VSS.n58 11.8854
R591 VSS.n59 VSS.t115 11.8854
R592 VSS.n35 VSS.t21 11.8854
R593 VSS.n34 VSS.t157 11.8854
R594 VSS.n33 VSS.t155 11.8854
R595 VSS.n94 VSS.n93 0.00542769
R596 VSS.n31 VSS.t165 11.8854
R597 VSS.t166 VSS.n44 11.8844
R598 VSS.n46 VSS.t71 11.8844
R599 VSS.t59 VSS.n47 11.8844
R600 VSS.t84 VSS.n60 11.8844
R601 VSS.t163 VSS.n61 11.8844
R602 VSS.t122 VSS.n44 9.19536
R603 VSS.t140 VSS.n46 9.19536
R604 VSS.t129 VSS.n47 9.19536
R605 VSS.t148 VSS.n60 9.19536
R606 VSS.n61 VSS.t135 9.19536
R607 VSS.t138 VSS.n43 9.19506
R608 VSS.n42 VSS.t125 9.19506
R609 VSS.n41 VSS.t139 9.19506
R610 VSS.t137 VSS.n40 9.19506
R611 VSS.t121 VSS.n45 9.19506
R612 VSS.n39 VSS.t141 9.19506
R613 VSS.n48 VSS.t142 9.19506
R614 VSS.n49 VSS.t143 9.19506
R615 VSS.n38 VSS.t123 9.19506
R616 VSS.t128 VSS.n50 9.19506
R617 VSS.t146 VSS.n51 9.19506
R618 VSS.t145 VSS.n52 9.19506
R619 VSS.n53 VSS.t126 9.19506
R620 VSS.n37 VSS.t144 9.19506
R621 VSS.n54 VSS.t130 9.19506
R622 VSS.t136 VSS.n55 9.19506
R623 VSS.n56 VSS.t131 9.19506
R624 VSS.t147 VSS.n57 9.19506
R625 VSS.n36 VSS.t150 9.19506
R626 VSS.t151 VSS.n58 9.19506
R627 VSS.t149 VSS.n59 9.19506
R628 VSS.t127 VSS.n35 9.19506
R629 VSS.n34 VSS.t124 9.19506
R630 VSS.t152 VSS.n33 9.19506
R631 VSS.t153 VSS.n64 8.4756
R632 VSS.n32 VSS.t22 11.8893
R633 VSS.t133 VSS.n31 9.19506
R634 VSS.t54 VSS.n99 29.2319
R635 VSS.n93 VSS.n141 8.5005
R636 VSS.n93 VSS.n144 8.5005
R637 VSS.n93 VSS.n147 8.5005
R638 VSS.n93 VSS.n150 8.5005
R639 VSS.n93 VSS.n153 8.5005
R640 VSS.n93 VSS.n156 8.5005
R641 VSS.n93 VSS.n159 8.5005
R642 VSS.n93 VSS.n162 8.5005
R643 VSS.n93 VSS.n165 8.5005
R644 VSS.n93 VSS.n168 8.5005
R645 VSS.n93 VSS.n171 8.5005
R646 VSS.n93 VSS.n174 8.5005
R647 VSS.n93 VSS.n177 8.5005
R648 VSS.n93 VSS.n180 8.5005
R649 VSS.n93 VSS.n183 8.5005
R650 VSS.n93 VSS.n186 8.5005
R651 VSS.n93 VSS.n189 8.5005
R652 VSS.n93 VSS.n192 8.5005
R653 VSS.n93 VSS.n195 8.5005
R654 VSS.n93 VSS.n198 8.5005
R655 VSS.n93 VSS.n201 8.5005
R656 VSS.n93 VSS.n204 8.5005
R657 VSS.n93 VSS.n207 8.5005
R658 VSS.n93 VSS.n210 8.5005
R659 VSS.n93 VSS.n213 8.5005
R660 VSS.n93 VSS.n216 8.5005
R661 VSS.n93 VSS.n219 8.5005
R662 VSS.n93 VSS.n222 8.5005
R663 VSS.n93 VSS.n225 8.5005
R664 VSS.n93 VSS.n228 8.5005
R665 VSS.n93 VSS.n100 1.14463
R666 VSS.n93 VSS.n137 8.47732
R667 VSS.n93 VSS.t49 8.47732
R668 VSS.n93 VSS.n135 8.47732
R669 VSS.n93 VSS.n239 8.47732
R670 VSS.n93 VSS.n232 8.47732
R671 VSS.n98 VSS.t51 0.279481
R672 VSS.n93 VSS.n98 1.49549
R673 VSS.n93 VSS.t43 5.00032
R674 VSS VSS.n97 2.9705
R675 VSS.n93 VSS.n101 2.74446
R676 VSS.n93 VSS.n133 2.74446
R677 VSS.n93 VSS.n138 2.74446
R678 VSS.n93 VSS.t160 2.74394
R679 VSS.n93 VSS.n102 1.55465
R680 VSS.n93 VSS.n103 1.55465
R681 VSS.n93 VSS.n104 1.55465
R682 VSS.n93 VSS.n105 1.55465
R683 VSS.n93 VSS.n106 1.55465
R684 VSS.n93 VSS.n107 1.55465
R685 VSS.n93 VSS.n108 1.55465
R686 VSS.n93 VSS.n109 1.55465
R687 VSS.n93 VSS.n110 1.55465
R688 VSS.n93 VSS.n111 1.55465
R689 VSS.n93 VSS.n112 1.55465
R690 VSS.n93 VSS.n113 1.55465
R691 VSS.n93 VSS.n114 1.55465
R692 VSS.n93 VSS.n115 1.55465
R693 VSS.n93 VSS.n116 1.55465
R694 VSS.n93 VSS.n117 1.55465
R695 VSS.n93 VSS.n118 1.55465
R696 VSS.n93 VSS.n119 1.55465
R697 VSS.n93 VSS.n120 1.55465
R698 VSS.n93 VSS.n121 1.55465
R699 VSS.n93 VSS.n122 1.55465
R700 VSS.n93 VSS.n123 1.55465
R701 VSS.n93 VSS.n124 1.55465
R702 VSS.n93 VSS.n125 1.55465
R703 VSS.n93 VSS.n126 1.55465
R704 VSS.n93 VSS.n127 1.55465
R705 VSS.n93 VSS.n128 1.55465
R706 VSS.n93 VSS.n129 1.55465
R707 VSS.n93 VSS.n130 1.55465
R708 VSS.n93 VSS.n131 1.55465
R709 VSS.n93 VSS.n132 1.55465
R710 VSS.n93 VSS.n139 1.55388
R711 VSS.n93 VSS.n142 1.55388
R712 VSS.n93 VSS.n145 1.55388
R713 VSS.n93 VSS.n148 1.55388
R714 VSS.n93 VSS.n151 1.55388
R715 VSS.n93 VSS.n154 1.55388
R716 VSS.n93 VSS.n157 1.55388
R717 VSS.n93 VSS.n160 1.55388
R718 VSS.n93 VSS.n163 1.55388
R719 VSS.n93 VSS.n166 1.55388
R720 VSS.n93 VSS.n169 1.55388
R721 VSS.n93 VSS.n172 1.55388
R722 VSS.n93 VSS.n175 1.55388
R723 VSS.n93 VSS.n178 1.55388
R724 VSS.n93 VSS.n181 1.55388
R725 VSS.n93 VSS.n184 1.55388
R726 VSS.n93 VSS.n187 1.55388
R727 VSS.n93 VSS.n190 1.55388
R728 VSS.n93 VSS.n193 1.55388
R729 VSS.n93 VSS.n196 1.55388
R730 VSS.n93 VSS.n199 1.55388
R731 VSS.n93 VSS.n202 1.55388
R732 VSS.n93 VSS.n205 1.55388
R733 VSS.n93 VSS.n208 1.55388
R734 VSS.n93 VSS.n211 1.55388
R735 VSS.n93 VSS.n214 1.55388
R736 VSS.n93 VSS.n217 1.55388
R737 VSS.n93 VSS.n220 1.55388
R738 VSS.n93 VSS.n223 1.55388
R739 VSS.n93 VSS.n226 1.55388
R740 VSS.n93 VSS.n229 1.55388
R741 VSS.t42 VSS.t45 0.806856
R742 VSS.t18 VSS.n143 0.802775
R743 VSS.t38 VSS.n146 0.802775
R744 VSS.t32 VSS.n149 0.802775
R745 VSS.t16 VSS.n152 0.802775
R746 VSS.t62 VSS.n155 0.802775
R747 VSS.t104 VSS.n158 0.802775
R748 VSS.t70 VSS.n161 0.802775
R749 VSS.t68 VSS.n164 0.802775
R750 VSS.t24 VSS.n167 0.802775
R751 VSS.t35 VSS.n170 0.802775
R752 VSS.t2 VSS.n173 0.802775
R753 VSS.t73 VSS.n176 0.802775
R754 VSS.t20 VSS.n179 0.802775
R755 VSS.t75 VSS.n182 0.802775
R756 VSS.t5 VSS.n185 0.802775
R757 VSS.t14 VSS.n188 0.802775
R758 VSS.t78 VSS.n191 0.802775
R759 VSS.t112 VSS.n194 0.802775
R760 VSS.t118 VSS.n197 0.802775
R761 VSS.t41 VSS.n200 0.802775
R762 VSS.t10 VSS.n203 0.802775
R763 VSS.t99 VSS.n206 0.802775
R764 VSS.t64 VSS.n209 0.802775
R765 VSS.t83 VSS.n212 0.802775
R766 VSS.t93 VSS.n215 0.802775
R767 VSS.t28 VSS.n218 0.802775
R768 VSS.t101 VSS.n221 0.802775
R769 VSS.t97 VSS.n224 0.802775
R770 VSS.t80 VSS.n227 0.802775
R771 VSS.t30 VSS.n230 0.802775
R772 VSS.t134 VSS.n231 0.802775
R773 VSS.t52 VSS.n134 0.802775
R774 VSS.t7 VSS.n140 0.802775
R775 VSS.n98 VSS.t53 0.234047
R776 VSS.t51 VSS.n233 0.723599
R777 VSS.n238 VSS.t44 0.595317
R778 VSS.t48 VSS.n237 0.595317
R779 VSS.n229 VSS.t30 0.47671
R780 VSS.n226 VSS.t80 0.47671
R781 VSS.n223 VSS.t97 0.47671
R782 VSS.n220 VSS.t101 0.47671
R783 VSS.n217 VSS.t28 0.47671
R784 VSS.n214 VSS.t93 0.47671
R785 VSS.n211 VSS.t83 0.47671
R786 VSS.n208 VSS.t64 0.47671
R787 VSS.n205 VSS.t99 0.47671
R788 VSS.n202 VSS.t10 0.47671
R789 VSS.n199 VSS.t41 0.47671
R790 VSS.n196 VSS.t118 0.47671
R791 VSS.n193 VSS.t112 0.47671
R792 VSS.n190 VSS.t78 0.47671
R793 VSS.n187 VSS.t14 0.47671
R794 VSS.n184 VSS.t5 0.47671
R795 VSS.n181 VSS.t75 0.47671
R796 VSS.n178 VSS.t20 0.47671
R797 VSS.n175 VSS.t73 0.47671
R798 VSS.n172 VSS.t2 0.47671
R799 VSS.n169 VSS.t35 0.47671
R800 VSS.n166 VSS.t24 0.47671
R801 VSS.n163 VSS.t68 0.47671
R802 VSS.n160 VSS.t70 0.47671
R803 VSS.n157 VSS.t104 0.47671
R804 VSS.n154 VSS.t62 0.47671
R805 VSS.n151 VSS.t16 0.47671
R806 VSS.n148 VSS.t32 0.47671
R807 VSS.n145 VSS.t38 0.47671
R808 VSS.n142 VSS.t18 0.47671
R809 VSS.n139 VSS.t7 0.47671
R810 VSS.n140 VSS.n102 0.46466
R811 VSS.n143 VSS.n103 0.46466
R812 VSS.n146 VSS.n104 0.46466
R813 VSS.n149 VSS.n105 0.46466
R814 VSS.n152 VSS.n106 0.46466
R815 VSS.n155 VSS.n107 0.46466
R816 VSS.n158 VSS.n108 0.46466
R817 VSS.n161 VSS.n109 0.46466
R818 VSS.n164 VSS.n110 0.46466
R819 VSS.n167 VSS.n111 0.46466
R820 VSS.n170 VSS.n112 0.46466
R821 VSS.n173 VSS.n113 0.46466
R822 VSS.n176 VSS.n114 0.46466
R823 VSS.n179 VSS.n115 0.46466
R824 VSS.n182 VSS.n116 0.46466
R825 VSS.n185 VSS.n117 0.46466
R826 VSS.n188 VSS.n118 0.46466
R827 VSS.n191 VSS.n119 0.46466
R828 VSS.n194 VSS.n120 0.46466
R829 VSS.n197 VSS.n121 0.46466
R830 VSS.n200 VSS.n122 0.46466
R831 VSS.n203 VSS.n123 0.46466
R832 VSS.n206 VSS.n124 0.46466
R833 VSS.n209 VSS.n125 0.46466
R834 VSS.n212 VSS.n126 0.46466
R835 VSS.n215 VSS.n127 0.46466
R836 VSS.n218 VSS.n128 0.46466
R837 VSS.n221 VSS.n129 0.46466
R838 VSS.n224 VSS.n130 0.46466
R839 VSS.n227 VSS.n131 0.46466
R840 VSS.n230 VSS.n132 0.46466
R841 VSS.n143 VSS.n102 0.45349
R842 VSS.n146 VSS.n103 0.45349
R843 VSS.n149 VSS.n104 0.45349
R844 VSS.n152 VSS.n105 0.45349
R845 VSS.n155 VSS.n106 0.45349
R846 VSS.n158 VSS.n107 0.45349
R847 VSS.n161 VSS.n108 0.45349
R848 VSS.n164 VSS.n109 0.45349
R849 VSS.n167 VSS.n110 0.45349
R850 VSS.n170 VSS.n111 0.45349
R851 VSS.n173 VSS.n112 0.45349
R852 VSS.n176 VSS.n113 0.45349
R853 VSS.n179 VSS.n114 0.45349
R854 VSS.n182 VSS.n115 0.45349
R855 VSS.n185 VSS.n116 0.45349
R856 VSS.n188 VSS.n117 0.45349
R857 VSS.n191 VSS.n118 0.45349
R858 VSS.n194 VSS.n119 0.45349
R859 VSS.n197 VSS.n120 0.45349
R860 VSS.n200 VSS.n121 0.45349
R861 VSS.n203 VSS.n122 0.45349
R862 VSS.n206 VSS.n123 0.45349
R863 VSS.n209 VSS.n124 0.45349
R864 VSS.n212 VSS.n125 0.45349
R865 VSS.n215 VSS.n126 0.45349
R866 VSS.n218 VSS.n127 0.45349
R867 VSS.n221 VSS.n128 0.45349
R868 VSS.n224 VSS.n129 0.45349
R869 VSS.n227 VSS.n130 0.45349
R870 VSS.n230 VSS.n131 0.45349
R871 VSS.n231 VSS.n132 0.45349
R872 VSS.n139 VSS.t18 0.441374
R873 VSS.n142 VSS.t38 0.441374
R874 VSS.n145 VSS.t32 0.441374
R875 VSS.n148 VSS.t16 0.441374
R876 VSS.n151 VSS.t62 0.441374
R877 VSS.n154 VSS.t104 0.441374
R878 VSS.n157 VSS.t70 0.441374
R879 VSS.n160 VSS.t68 0.441374
R880 VSS.n163 VSS.t24 0.441374
R881 VSS.n166 VSS.t35 0.441374
R882 VSS.n169 VSS.t2 0.441374
R883 VSS.n172 VSS.t73 0.441374
R884 VSS.n175 VSS.t20 0.441374
R885 VSS.n178 VSS.t75 0.441374
R886 VSS.n181 VSS.t5 0.441374
R887 VSS.n184 VSS.t14 0.441374
R888 VSS.n187 VSS.t78 0.441374
R889 VSS.n190 VSS.t112 0.441374
R890 VSS.n193 VSS.t118 0.441374
R891 VSS.n196 VSS.t41 0.441374
R892 VSS.n199 VSS.t10 0.441374
R893 VSS.n202 VSS.t99 0.441374
R894 VSS.n205 VSS.t64 0.441374
R895 VSS.n208 VSS.t83 0.441374
R896 VSS.n211 VSS.t93 0.441374
R897 VSS.n214 VSS.t28 0.441374
R898 VSS.n217 VSS.t101 0.441374
R899 VSS.n220 VSS.t97 0.441374
R900 VSS.n223 VSS.t80 0.441374
R901 VSS.n226 VSS.t30 0.441374
R902 VSS.n229 VSS.t134 0.441374
R903 VSS.n96 VSS.t45 0.380071
R904 VSS.n97 VSS.n96 0.280466
R905 VSS.t160 VSS.t134 0.301976
R906 VSS.n231 VSS.n133 0.290049
R907 VSS.n140 VSS.n101 0.276768
R908 VSS.n236 VSS.n101 0.271299
R909 VSS.n237 VSS.n138 0.271299
R910 VSS.t7 VSS.n138 0.265518
R911 VSS.t160 VSS.t52 0.254814
R912 VSS.n134 VSS.n133 0.244268
R913 VSS.t44 VSS.t48 0.1875
R914 VSS.n134 VSS.t49 0.135868
R915 VSS.t52 VSS.n232 0.124618
R916 VSS.n233 VSS.t49 0.122118
R917 VSS.t51 VSS.n232 0.122118
R918 VSS.t42 VSS.n97 0.0955
R919 VSS.n93 VSS.n1 0.0884098
R920 VSS.n93 VSS.n32 0.085468
R921 VSS.t44 VSS.n235 0.0851154
R922 VSS.t48 VSS.n236 0.0851154
R923 VSS.t53 VSS.n135 0.0771176
R924 VSS.n235 VSS.n137 0.0746176
R925 VSS.n239 VSS.n238 0.0746176
R926 VSS.n233 VSS.n135 0.0696176
R927 VSS.n235 VSS.n136 0.06925
R928 VSS.n238 VSS.n234 0.06925
R929 VSS.n236 VSS.n136 0.05925
R930 VSS.n237 VSS.n234 0.05925
R931 VSS.n137 VSS.t45 0.0546176
R932 VSS.n239 VSS.t42 0.0546176
R933 VSS.n93 VSS.n0 0.0485985
R934 VSS.n93 VSS.n89 0.0444724
R935 VSS.n93 VSS.n44 0.0444724
R936 VSS.n93 VSS.n46 0.0444724
R937 VSS.n93 VSS.n47 0.0444724
R938 VSS.n93 VSS.n83 0.0444724
R939 VSS.n93 VSS.n76 0.0444724
R940 VSS.n93 VSS.n75 0.0444724
R941 VSS.n93 VSS.n73 0.0444724
R942 VSS.n93 VSS.n72 0.0444724
R943 VSS.n93 VSS.n69 0.0444724
R944 VSS.n93 VSS.n60 0.0444724
R945 VSS.n93 VSS.n68 0.0444724
R946 VSS.n93 VSS.n61 0.0444724
R947 VSS.n93 VSS.n66 0.0444724
R948 VSS.n93 VSS.n64 0.00442681
R949 VSS.n93 VSS.n63 0.0444724
R950 VSS.n93 VSS.n62 0.0444724
R951 VSS.n93 VSS.n42 0.0444549
R952 VSS.n93 VSS.n2 0.0444549
R953 VSS.n93 VSS.n41 0.0444549
R954 VSS.n93 VSS.n3 0.0444549
R955 VSS.n93 VSS.n40 0.0444549
R956 VSS.n93 VSS.n4 0.0444549
R957 VSS.n93 VSS.n5 0.0444549
R958 VSS.n93 VSS.n6 0.0444549
R959 VSS.n93 VSS.n39 0.0444549
R960 VSS.n93 VSS.n7 0.0444549
R961 VSS.n93 VSS.n8 0.0444549
R962 VSS.n93 VSS.n9 0.0444549
R963 VSS.n93 VSS.n10 0.0444549
R964 VSS.n93 VSS.n11 0.0444549
R965 VSS.n93 VSS.n38 0.0444549
R966 VSS.n93 VSS.n12 0.0444549
R967 VSS.n93 VSS.n13 0.0444549
R968 VSS.n93 VSS.n14 0.0444549
R969 VSS.n93 VSS.n15 0.0444549
R970 VSS.n93 VSS.n16 0.0444549
R971 VSS.n93 VSS.n37 0.0444549
R972 VSS.n93 VSS.n17 0.0444549
R973 VSS.n93 VSS.n18 0.0444549
R974 VSS.n93 VSS.n19 0.0444549
R975 VSS.n93 VSS.n20 0.0444549
R976 VSS.n93 VSS.n21 0.0444549
R977 VSS.n93 VSS.n22 0.0444549
R978 VSS.n93 VSS.n36 0.0444549
R979 VSS.n93 VSS.n23 0.0444549
R980 VSS.n93 VSS.n24 0.0444549
R981 VSS.n93 VSS.n25 0.0444549
R982 VSS.n93 VSS.n26 0.0444549
R983 VSS.n93 VSS.n35 0.0444549
R984 VSS.n93 VSS.n27 0.0444549
R985 VSS.n93 VSS.n34 0.0444549
R986 VSS.n93 VSS.n28 0.0444549
R987 VSS.n93 VSS.n29 0.0444549
R988 VSS.n93 VSS.n33 0.0444549
R989 VSS.n93 VSS.n30 0.0444549
R990 VSS.n93 VSS.n31 0.0444549
R991 VSS.n93 VSS.n92 0.0444549
R992 VSS.n93 VSS.n43 0.0444549
R993 VSS.n93 VSS.n91 0.0444549
R994 VSS.n93 VSS.n90 0.0444549
R995 VSS.n93 VSS.n88 0.0444549
R996 VSS.n93 VSS.n87 0.0444549
R997 VSS.n93 VSS.n45 0.0444549
R998 VSS.n93 VSS.n86 0.0444549
R999 VSS.n93 VSS.n85 0.0444549
R1000 VSS.n93 VSS.n84 0.0444549
R1001 VSS.n93 VSS.n48 0.0444549
R1002 VSS.n93 VSS.n49 0.0444549
R1003 VSS.n93 VSS.n82 0.0444549
R1004 VSS.n93 VSS.n50 0.0444549
R1005 VSS.n93 VSS.n81 0.0444549
R1006 VSS.n93 VSS.n80 0.0444549
R1007 VSS.n93 VSS.n51 0.0444549
R1008 VSS.n93 VSS.n79 0.0444549
R1009 VSS.n93 VSS.n52 0.0444549
R1010 VSS.n93 VSS.n78 0.0444549
R1011 VSS.n93 VSS.n77 0.0444549
R1012 VSS.n93 VSS.n53 0.0444549
R1013 VSS.n93 VSS.n54 0.0444549
R1014 VSS.n93 VSS.n55 0.0444549
R1015 VSS.n93 VSS.n56 0.0444549
R1016 VSS.n93 VSS.n57 0.0444549
R1017 VSS.n93 VSS.n74 0.0444549
R1018 VSS.n93 VSS.n58 0.0444549
R1019 VSS.n93 VSS.n71 0.0444549
R1020 VSS.n93 VSS.n59 0.0444549
R1021 VSS.n93 VSS.n70 0.0444549
R1022 VSS.n93 VSS.n67 0.0444549
R1023 VSS.n93 VSS.n65 0.0444549
R1024 VSS.n94 VSS.t96 15.9613
C518 DELAY_VBIASN VSS 16.43641f
C519 DELAY_OUT_LAST VSS 0.40486f
C520 DELAY_OUT_TAP31 VSS 0.6437f
C521 DELAY_OUT_TAP30 VSS 0.6437f
C522 DELAY_OUT_TAP29 VSS 0.6437f
C523 DELAY_OUT_TAP28 VSS 0.6437f
C524 DELAY_OUT_TAP27 VSS 0.6437f
C525 DELAY_OUT_TAP26 VSS 0.6437f
C526 DELAY_OUT_TAP25 VSS 0.6437f
C527 DELAY_OUT_TAP24 VSS 0.6437f
C528 DELAY_OUT_TAP23 VSS 0.6437f
C529 DELAY_OUT_TAP22 VSS 0.6437f
C530 DELAY_OUT_TAP21 VSS 0.6437f
C531 DELAY_OUT_TAP20 VSS 0.6437f
C532 DELAY_OUT_TAP19 VSS 0.6437f
C533 DELAY_OUT_TAP18 VSS 0.6437f
C534 DELAY_OUT_TAP17 VSS 0.6437f
C535 DELAY_OUT_TAP16 VSS 0.6437f
C536 DELAY_OUT_TAP15 VSS 0.6437f
C537 DELAY_OUT_TAP14 VSS 0.6437f
C538 DELAY_OUT_TAP13 VSS 0.6437f
C539 DELAY_OUT_TAP12 VSS 0.6437f
C540 DELAY_OUT_TAP11 VSS 0.6437f
C541 DELAY_OUT_TAP10 VSS 0.6437f
C542 DELAY_OUT_TAP9 VSS 0.6437f
C543 DELAY_OUT_TAP8 VSS 0.6437f
C544 DELAY_OUT_TAP7 VSS 0.6437f
C545 DELAY_OUT_TAP6 VSS 0.6437f
C546 DELAY_OUT_TAP5 VSS 0.6437f
C547 DELAY_OUT_TAP4 VSS 0.6437f
C548 DELAY_OUT_TAP3 VSS 0.6437f
C549 DELAY_OUT_TAP2 VSS 0.6437f
C550 DELAY_OUT_TAP1 VSS 0.64371f
C551 DELAY_VBIASP VSS 4.15787f
C552 DELAY_IN VSS 0.57171f
C553 VDD VSS 20.97692f
C554 a_27411_1842# VSS 0.01336f ; **FLOATING
C555 a_26651_1842# VSS 0.01336f ; **FLOATING
C556 a_25891_1842# VSS 0.01336f ; **FLOATING
C557 a_25131_1842# VSS 0.01336f ; **FLOATING
C558 a_24371_1842# VSS 0.01336f ; **FLOATING
C559 a_23611_1842# VSS 0.01336f ; **FLOATING
C560 a_22851_1842# VSS 0.01336f ; **FLOATING
C561 a_22091_1842# VSS 0.01336f ; **FLOATING
C562 a_21331_1842# VSS 0.01336f ; **FLOATING
C563 a_20571_1842# VSS 0.01336f ; **FLOATING
C564 a_19811_1842# VSS 0.01336f ; **FLOATING
C565 a_19051_1842# VSS 0.01336f ; **FLOATING
C566 a_18291_1842# VSS 0.01336f ; **FLOATING
C567 a_17531_1842# VSS 0.01336f ; **FLOATING
C568 a_16771_1842# VSS 0.01336f ; **FLOATING
C569 a_16011_1842# VSS 0.01336f ; **FLOATING
C570 a_15251_1842# VSS 0.01336f ; **FLOATING
C571 a_14491_1842# VSS 0.01336f ; **FLOATING
C572 a_13731_1842# VSS 0.01336f ; **FLOATING
C573 a_12971_1842# VSS 0.01336f ; **FLOATING
C574 a_12211_1842# VSS 0.01336f ; **FLOATING
C575 a_11451_1842# VSS 0.01336f ; **FLOATING
C576 a_10691_1842# VSS 0.01336f ; **FLOATING
C577 a_9931_1842# VSS 0.01336f ; **FLOATING
C578 a_9171_1842# VSS 0.01336f ; **FLOATING
C579 a_8411_1842# VSS 0.01336f ; **FLOATING
C580 a_7651_1842# VSS 0.01336f ; **FLOATING
C581 a_6891_1842# VSS 0.01336f ; **FLOATING
C582 a_6131_1842# VSS 0.01336f ; **FLOATING
C583 a_5371_1842# VSS 0.01336f ; **FLOATING
C584 a_4611_1842# VSS 0.01336f ; **FLOATING
C585 a_3851_1842# VSS 0.0139f ; **FLOATING
C586 a_27303_1842# VSS 0.54306f ; **FLOATING
C587 a_27737_1842# VSS 0.67217f ; **FLOATING
C588 a_27173_1842# VSS 0.48844f ; **FLOATING
C589 a_26543_1842# VSS 0.54063f ; **FLOATING
C590 a_26413_1842# VSS 0.48844f ; **FLOATING
C591 a_25783_1842# VSS 0.54063f ; **FLOATING
C592 a_25653_1842# VSS 0.48844f ; **FLOATING
C593 a_25023_1842# VSS 0.54063f ; **FLOATING
C594 a_24893_1842# VSS 0.48844f ; **FLOATING
C595 a_24263_1842# VSS 0.54063f ; **FLOATING
C596 a_24133_1842# VSS 0.48844f ; **FLOATING
C597 a_23503_1842# VSS 0.54063f ; **FLOATING
C598 a_23373_1842# VSS 0.48844f ; **FLOATING
C599 a_22743_1842# VSS 0.54063f ; **FLOATING
C600 a_22613_1842# VSS 0.48844f ; **FLOATING
C601 a_21983_1842# VSS 0.54063f ; **FLOATING
C602 a_21853_1842# VSS 0.48844f ; **FLOATING
C603 a_21223_1842# VSS 0.54063f ; **FLOATING
C604 a_21093_1842# VSS 0.48844f ; **FLOATING
C605 a_20463_1842# VSS 0.54063f ; **FLOATING
C606 a_20333_1842# VSS 0.48844f ; **FLOATING
C607 a_19703_1842# VSS 0.54063f ; **FLOATING
C608 a_19573_1842# VSS 0.48844f ; **FLOATING
C609 a_18943_1842# VSS 0.54063f ; **FLOATING
C610 a_18813_1842# VSS 0.48844f ; **FLOATING
C611 a_18183_1842# VSS 0.54063f ; **FLOATING
C612 a_18053_1842# VSS 0.48844f ; **FLOATING
C613 a_17423_1842# VSS 0.54063f ; **FLOATING
C614 a_17293_1842# VSS 0.48844f ; **FLOATING
C615 a_16663_1842# VSS 0.54063f ; **FLOATING
C616 a_16533_1842# VSS 0.48844f ; **FLOATING
C617 a_15903_1842# VSS 0.54063f ; **FLOATING
C618 a_15773_1842# VSS 0.48844f ; **FLOATING
C619 a_15143_1842# VSS 0.54063f ; **FLOATING
C620 a_15013_1842# VSS 0.48844f ; **FLOATING
C621 a_14383_1842# VSS 0.54063f ; **FLOATING
C622 a_14253_1842# VSS 0.48844f ; **FLOATING
C623 a_13623_1842# VSS 0.54063f ; **FLOATING
C624 a_13493_1842# VSS 0.48844f ; **FLOATING
C625 a_12863_1842# VSS 0.54063f ; **FLOATING
C626 a_12733_1842# VSS 0.48844f ; **FLOATING
C627 a_12103_1842# VSS 0.54063f ; **FLOATING
C628 a_11973_1842# VSS 0.48844f ; **FLOATING
C629 a_11343_1842# VSS 0.54063f ; **FLOATING
C630 a_11213_1842# VSS 0.48844f ; **FLOATING
C631 a_10583_1842# VSS 0.54063f ; **FLOATING
C632 a_10453_1842# VSS 0.48844f ; **FLOATING
C633 a_9823_1842# VSS 0.54063f ; **FLOATING
C634 a_9693_1842# VSS 0.48844f ; **FLOATING
C635 a_9063_1842# VSS 0.54063f ; **FLOATING
C636 a_8933_1842# VSS 0.48844f ; **FLOATING
C637 a_8303_1842# VSS 0.54063f ; **FLOATING
C638 a_8173_1842# VSS 0.48844f ; **FLOATING
C639 a_7543_1842# VSS 0.54063f ; **FLOATING
C640 a_7413_1842# VSS 0.48844f ; **FLOATING
C641 a_6783_1842# VSS 0.54063f ; **FLOATING
C642 a_6653_1842# VSS 0.48844f ; **FLOATING
C643 a_6023_1842# VSS 0.54063f ; **FLOATING
C644 a_5893_1842# VSS 0.48844f ; **FLOATING
C645 a_5263_1842# VSS 0.54063f ; **FLOATING
C646 a_5133_1842# VSS 0.48844f ; **FLOATING
C647 a_4503_1842# VSS 0.54063f ; **FLOATING
C648 a_4373_1842# VSS 0.48844f ; **FLOATING
C649 a_3743_1842# VSS 0.61828f ; **FLOATING
C650 VDD.n0 VSS 0.02735f ; **FLOATING
C651 VDD.n1 VSS 0.31861f ; **FLOATING
C652 VDD.n2 VSS 0.02735f ; **FLOATING
C653 VDD.n3 VSS 0.02735f ; **FLOATING
C654 VDD.t0 VSS 54.2383f ; **FLOATING
C655 VDD.n5 VSS 0.14944f ; **FLOATING
C656 VDD.n6 VSS 0.02735f ; **FLOATING
C657 VDD.n7 VSS 0.02735f ; **FLOATING
C658 VDD.n8 VSS 0.42826f ; **FLOATING
C659 VDD.t33 VSS 0.05112f ; **FLOATING
C660 VDD.n12 VSS 0.02735f ; **FLOATING
C661 VDD.n13 VSS 0.02735f ; **FLOATING
C662 VDD.n14 VSS 0.42829f ; **FLOATING
C663 VDD.n15 VSS 0.02735f ; **FLOATING
C664 VDD.n16 VSS 0.21409f ; **FLOATING
C665 VDD.n17 VSS 0.02735f ; **FLOATING
C666 VDD.n18 VSS 0.21408f ; **FLOATING
C667 VDD.n19 VSS 0.02735f ; **FLOATING
C668 VDD.n20 VSS 0.21411f ; **FLOATING
C669 VDD.n21 VSS 0.02735f ; **FLOATING
C670 VDD.n22 VSS 0.21406f ; **FLOATING
C671 VDD.n23 VSS 0.02735f ; **FLOATING
C672 VDD.n24 VSS 0.21414f ; **FLOATING
C673 VDD.n25 VSS 0.02735f ; **FLOATING
C674 VDD.n26 VSS 0.21412f ; **FLOATING
C675 VDD.n27 VSS 0.02735f ; **FLOATING
C676 VDD.n28 VSS 0.21418f ; **FLOATING
C677 VDD.t53 VSS 0.03951f ; **FLOATING
C678 VDD.t49 VSS 0.04162f ; **FLOATING
C679 VDD.n29 VSS 0.02735f ; **FLOATING
C680 VDD.n30 VSS 0.2141f ; **FLOATING
C681 VDD.n31 VSS 0.02735f ; **FLOATING
C682 VDD.n32 VSS 0.21414f ; **FLOATING
C683 VDD.n33 VSS 0.05626f ; **FLOATING
C684 VDD.n34 VSS 0.21418f ; **FLOATING
C685 VDD.n35 VSS 0.02735f ; **FLOATING
C686 VDD.n36 VSS 0.21418f ; **FLOATING
C687 VDD.n37 VSS 0.02735f ; **FLOATING
C688 VDD.n38 VSS 0.21413f ; **FLOATING
C689 VDD.n39 VSS 0.02735f ; **FLOATING
C690 VDD.n40 VSS 0.21416f ; **FLOATING
C691 VDD.n41 VSS 0.02735f ; **FLOATING
C692 VDD.n42 VSS 0.2142f ; **FLOATING
C693 VDD.n43 VSS 0.02735f ; **FLOATING
C694 VDD.n44 VSS 0.21417f ; **FLOATING
C695 VDD.n45 VSS 0.02735f ; **FLOATING
C696 VDD.n46 VSS 0.21416f ; **FLOATING
C697 VDD.n47 VSS 0.02735f ; **FLOATING
C698 VDD.n48 VSS 0.21421f ; **FLOATING
C699 VDD.n49 VSS 0.02735f ; **FLOATING
C700 VDD.n50 VSS 0.21414f ; **FLOATING
C701 VDD.n51 VSS 0.02735f ; **FLOATING
C702 VDD.n52 VSS 0.21414f ; **FLOATING
C703 VDD.n53 VSS 0.02735f ; **FLOATING
C704 VDD.n54 VSS 0.21418f ; **FLOATING
C705 VDD.n55 VSS 0.02735f ; **FLOATING
C706 VDD.n56 VSS 0.21414f ; **FLOATING
C707 VDD.t50 VSS 0.02172f ; **FLOATING
C708 VDD.n57 VSS 0.05615f ; **FLOATING
C709 VDD.n58 VSS 0.05609f ; **FLOATING
C710 VDD.n59 VSS 0.05603f ; **FLOATING
C711 VDD.n60 VSS 0.05607f ; **FLOATING
C712 VDD.n61 VSS 0.05603f ; **FLOATING
C713 VDD.n62 VSS 0.0561f ; **FLOATING
C714 VDD.n63 VSS 0.05605f ; **FLOATING
C715 VDD.n64 VSS 0.05603f ; **FLOATING
C716 VDD.n65 VSS 0.05602f ; **FLOATING
C717 VDD.n66 VSS 0.05604f ; **FLOATING
C718 VDD.n67 VSS 0.05611f ; **FLOATING
C719 VDD.n68 VSS 0.05606f ; **FLOATING
C720 VDD.n69 VSS 0.05601f ; **FLOATING
C721 VDD.n70 VSS 0.05601f ; **FLOATING
C722 VDD.n71 VSS 0.05614f ; **FLOATING
C723 VDD.n72 VSS 0.05614f ; **FLOATING
C724 VDD.n73 VSS 0.05614f ; **FLOATING
C725 VDD.n74 VSS 0.05614f ; **FLOATING
C726 VDD.n75 VSS 0.05593f ; **FLOATING
C727 VDD.n76 VSS 0.0561f ; **FLOATING
C728 VDD.n77 VSS 0.05601f ; **FLOATING
C729 VDD.n78 VSS 0.05607f ; **FLOATING
C730 VDD.n79 VSS 0.05601f ; **FLOATING
C731 VDD.n80 VSS 0.05601f ; **FLOATING
C732 VDD.n81 VSS 0.05605f ; **FLOATING
C733 VDD.n82 VSS 0.05599f ; **FLOATING
C734 VDD.t52 VSS 0.07737f ; **FLOATING
C735 VDD.t57 VSS 0.03688f ; **FLOATING
C736 VDD.t55 VSS 0.03564f ; **FLOATING
C737 VDD.t54 VSS 0.04263f ; **FLOATING
C738 VDD.t101 VSS 0.04326f ; **FLOATING
C739 VDD.t29 VSS 0.03764f ; **FLOATING
C740 VDD.t43 VSS 0.04326f ; **FLOATING
C741 VDD.t71 VSS 0.04326f ; **FLOATING
C742 VDD.t34 VSS 0.03688f ; **FLOATING
C743 VDD.t82 VSS 0.04326f ; **FLOATING
C744 VDD.t30 VSS 0.03688f ; **FLOATING
C745 VDD.n83 VSS 0.17029f ; **FLOATING
C746 VDD.t84 VSS 0.04326f ; **FLOATING
C747 VDD.t32 VSS 0.03688f ; **FLOATING
C748 VDD.n84 VSS 0.12118f ; **FLOATING
C749 VDD.t42 VSS 0.04326f ; **FLOATING
C750 VDD.t31 VSS 0.03688f ; **FLOATING
C751 VDD.n85 VSS 0.12124f ; **FLOATING
C752 VDD.t79 VSS 0.04326f ; **FLOATING
C753 VDD.t4 VSS 0.03688f ; **FLOATING
C754 VDD.n86 VSS 0.12125f ; **FLOATING
C755 VDD.t72 VSS 0.04326f ; **FLOATING
C756 VDD.t25 VSS 0.03688f ; **FLOATING
C757 VDD.n87 VSS 0.12124f ; **FLOATING
C758 VDD.t64 VSS 0.04326f ; **FLOATING
C759 VDD.t28 VSS 0.03688f ; **FLOATING
C760 VDD.n88 VSS 0.12119f ; **FLOATING
C761 VDD.t83 VSS 0.04326f ; **FLOATING
C762 VDD.t27 VSS 0.03688f ; **FLOATING
C763 VDD.n89 VSS 0.12122f ; **FLOATING
C764 VDD.t36 VSS 0.04326f ; **FLOATING
C765 VDD.t26 VSS 0.03688f ; **FLOATING
C766 VDD.n90 VSS 0.12125f ; **FLOATING
C767 VDD.t60 VSS 0.04326f ; **FLOATING
C768 VDD.t23 VSS 0.03688f ; **FLOATING
C769 VDD.n91 VSS 0.12121f ; **FLOATING
C770 VDD.t96 VSS 0.04326f ; **FLOATING
C771 VDD.t24 VSS 0.03688f ; **FLOATING
C772 VDD.n92 VSS 0.12112f ; **FLOATING
C773 VDD.t92 VSS 0.04326f ; **FLOATING
C774 VDD.t21 VSS 0.03688f ; **FLOATING
C775 VDD.n93 VSS 0.1211f ; **FLOATING
C776 VDD.t70 VSS 0.04326f ; **FLOATING
C777 VDD.t22 VSS 0.03688f ; **FLOATING
C778 VDD.n94 VSS 0.12114f ; **FLOATING
C779 VDD.t37 VSS 0.04326f ; **FLOATING
C780 VDD.t7 VSS 0.03688f ; **FLOATING
C781 VDD.n95 VSS 0.12118f ; **FLOATING
C782 VDD.t2 VSS 0.04326f ; **FLOATING
C783 VDD.t3 VSS 0.03688f ; **FLOATING
C784 VDD.n96 VSS 0.12126f ; **FLOATING
C785 VDD.t69 VSS 0.04326f ; **FLOATING
C786 VDD.t6 VSS 0.03688f ; **FLOATING
C787 VDD.n97 VSS 0.12124f ; **FLOATING
C788 VDD.t40 VSS 0.04326f ; **FLOATING
C789 VDD.t8 VSS 0.03688f ; **FLOATING
C790 VDD.n98 VSS 0.12116f ; **FLOATING
C791 VDD.t68 VSS 0.04326f ; **FLOATING
C792 VDD.t9 VSS 0.03688f ; **FLOATING
C793 VDD.n99 VSS 0.12118f ; **FLOATING
C794 VDD.t1 VSS 0.04326f ; **FLOATING
C795 VDD.t20 VSS 0.03688f ; **FLOATING
C796 VDD.n100 VSS 0.12122f ; **FLOATING
C797 VDD.t46 VSS 0.04326f ; **FLOATING
C798 VDD.t5 VSS 0.03688f ; **FLOATING
C799 VDD.n101 VSS 0.12125f ; **FLOATING
C800 VDD.t41 VSS 0.04326f ; **FLOATING
C801 VDD.t10 VSS 0.03688f ; **FLOATING
C802 VDD.n102 VSS 0.12118f ; **FLOATING
C803 VDD.t66 VSS 0.04326f ; **FLOATING
C804 VDD.t12 VSS 0.03688f ; **FLOATING
C805 VDD.n103 VSS 0.12119f ; **FLOATING
C806 VDD.t67 VSS 0.04326f ; **FLOATING
C807 VDD.t19 VSS 0.03688f ; **FLOATING
C808 VDD.n104 VSS 0.12119f ; **FLOATING
C809 VDD.t86 VSS 0.04326f ; **FLOATING
C810 VDD.t18 VSS 0.03688f ; **FLOATING
C811 VDD.n105 VSS 0.12123f ; **FLOATING
C812 VDD.t63 VSS 0.04326f ; **FLOATING
C813 VDD.t16 VSS 0.03688f ; **FLOATING
C814 VDD.n106 VSS 0.12121f ; **FLOATING
C815 VDD.t38 VSS 0.04326f ; **FLOATING
C816 VDD.t17 VSS 0.03688f ; **FLOATING
C817 VDD.n107 VSS 0.12116f ; **FLOATING
C818 VDD.t44 VSS 0.04326f ; **FLOATING
C819 VDD.t13 VSS 0.03688f ; **FLOATING
C820 VDD.n108 VSS 0.12115f ; **FLOATING
C821 VDD.t58 VSS 0.04326f ; **FLOATING
C822 VDD.t14 VSS 0.03688f ; **FLOATING
C823 VDD.n109 VSS 0.14186f ; **FLOATING
C824 VDD.t39 VSS 0.04326f ; **FLOATING
C825 VDD.t15 VSS 0.03688f ; **FLOATING
C826 VDD.t35 VSS 0.04326f ; **FLOATING
C827 VDD.t11 VSS 0.03787f ; **FLOATING
C828 VDD.t51 VSS 0.03759f ; **FLOATING
C829 VDD.t48 VSS 0.03688f ; **FLOATING
C830 VDD.t47 VSS 0.02663f ; **FLOATING
C831 DELAY_VBIASP.n0 VSS 0.14347f ; **FLOATING
C832 DELAY_VBIASP.t31 VSS 0.36739f ; **FLOATING
C833 DELAY_VBIASP.t30 VSS 0.35917f ; **FLOATING
C834 DELAY_VBIASP.n1 VSS 0.64365f ; **FLOATING
C835 DELAY_VBIASP.t29 VSS 0.35917f ; **FLOATING
C836 DELAY_VBIASP.n2 VSS 0.44541f ; **FLOATING
C837 DELAY_VBIASP.t28 VSS 0.35917f ; **FLOATING
C838 DELAY_VBIASP.n3 VSS 0.44541f ; **FLOATING
C839 DELAY_VBIASP.t27 VSS 0.35917f ; **FLOATING
C840 DELAY_VBIASP.n4 VSS 0.44541f ; **FLOATING
C841 DELAY_VBIASP.t26 VSS 0.35917f ; **FLOATING
C842 DELAY_VBIASP.n5 VSS 0.44541f ; **FLOATING
C843 DELAY_VBIASP.t25 VSS 0.35917f ; **FLOATING
C844 DELAY_VBIASP.n6 VSS 0.44541f ; **FLOATING
C845 DELAY_VBIASP.t24 VSS 0.35917f ; **FLOATING
C846 DELAY_VBIASP.n7 VSS 0.44541f ; **FLOATING
C847 DELAY_VBIASP.t23 VSS 0.35917f ; **FLOATING
C848 DELAY_VBIASP.n8 VSS 0.44541f ; **FLOATING
C849 DELAY_VBIASP.t22 VSS 0.35917f ; **FLOATING
C850 DELAY_VBIASP.n9 VSS 0.44541f ; **FLOATING
C851 DELAY_VBIASP.t21 VSS 0.35917f ; **FLOATING
C852 DELAY_VBIASP.n10 VSS 0.44541f ; **FLOATING
C853 DELAY_VBIASP.t20 VSS 0.35917f ; **FLOATING
C854 DELAY_VBIASP.n11 VSS 0.44541f ; **FLOATING
C855 DELAY_VBIASP.t19 VSS 0.35917f ; **FLOATING
C856 DELAY_VBIASP.n12 VSS 0.44541f ; **FLOATING
C857 DELAY_VBIASP.t18 VSS 0.35917f ; **FLOATING
C858 DELAY_VBIASP.n13 VSS 0.44541f ; **FLOATING
C859 DELAY_VBIASP.t17 VSS 0.35917f ; **FLOATING
C860 DELAY_VBIASP.n14 VSS 0.44541f ; **FLOATING
C861 DELAY_VBIASP.t16 VSS 0.35917f ; **FLOATING
C862 DELAY_VBIASP.n15 VSS 0.44541f ; **FLOATING
C863 DELAY_VBIASP.t15 VSS 0.35917f ; **FLOATING
C864 DELAY_VBIASP.n16 VSS 0.44541f ; **FLOATING
C865 DELAY_VBIASP.t14 VSS 0.35917f ; **FLOATING
C866 DELAY_VBIASP.n17 VSS 0.44541f ; **FLOATING
C867 DELAY_VBIASP.t13 VSS 0.35917f ; **FLOATING
C868 DELAY_VBIASP.n18 VSS 0.44541f ; **FLOATING
C869 DELAY_VBIASP.t12 VSS 0.35917f ; **FLOATING
C870 DELAY_VBIASP.n19 VSS 0.44541f ; **FLOATING
C871 DELAY_VBIASP.t11 VSS 0.35917f ; **FLOATING
C872 DELAY_VBIASP.n20 VSS 0.44541f ; **FLOATING
C873 DELAY_VBIASP.t10 VSS 0.35917f ; **FLOATING
C874 DELAY_VBIASP.n21 VSS 0.44541f ; **FLOATING
C875 DELAY_VBIASP.t9 VSS 0.35917f ; **FLOATING
C876 DELAY_VBIASP.n22 VSS 0.44541f ; **FLOATING
C877 DELAY_VBIASP.t8 VSS 0.35917f ; **FLOATING
C878 DELAY_VBIASP.n23 VSS 0.44541f ; **FLOATING
C879 DELAY_VBIASP.t7 VSS 0.35917f ; **FLOATING
C880 DELAY_VBIASP.n24 VSS 0.44541f ; **FLOATING
C881 DELAY_VBIASP.t6 VSS 0.35917f ; **FLOATING
C882 DELAY_VBIASP.n25 VSS 0.44541f ; **FLOATING
C883 DELAY_VBIASP.t5 VSS 0.35917f ; **FLOATING
C884 DELAY_VBIASP.n26 VSS 0.44541f ; **FLOATING
C885 DELAY_VBIASP.t4 VSS 0.35917f ; **FLOATING
C886 DELAY_VBIASP.n27 VSS 0.44541f ; **FLOATING
C887 DELAY_VBIASP.t3 VSS 0.35917f ; **FLOATING
C888 DELAY_VBIASP.n28 VSS 0.44541f ; **FLOATING
C889 DELAY_VBIASP.t2 VSS 0.35917f ; **FLOATING
C890 DELAY_VBIASP.n29 VSS 0.44541f ; **FLOATING
C891 DELAY_VBIASP.t1 VSS 0.35917f ; **FLOATING
C892 DELAY_VBIASP.n30 VSS 0.44541f ; **FLOATING
C893 DELAY_VBIASP.t0 VSS 0.35917f ; **FLOATING
C894 DELAY_VBIASN.n0 VSS 0.25441f ; **FLOATING
C895 DELAY_VBIASN.t31 VSS 0.15177f ; **FLOATING
C896 DELAY_VBIASN.t30 VSS 0.14732f ; **FLOATING
C897 DELAY_VBIASN.n1 VSS 0.34864f ; **FLOATING
C898 DELAY_VBIASN.t29 VSS 0.14732f ; **FLOATING
C899 DELAY_VBIASN.n2 VSS 0.24183f ; **FLOATING
C900 DELAY_VBIASN.t28 VSS 0.14732f ; **FLOATING
C901 DELAY_VBIASN.n3 VSS 0.24183f ; **FLOATING
C902 DELAY_VBIASN.t27 VSS 0.14732f ; **FLOATING
C903 DELAY_VBIASN.n4 VSS 0.24183f ; **FLOATING
C904 DELAY_VBIASN.t26 VSS 0.14732f ; **FLOATING
C905 DELAY_VBIASN.n5 VSS 0.24183f ; **FLOATING
C906 DELAY_VBIASN.t25 VSS 0.14732f ; **FLOATING
C907 DELAY_VBIASN.n6 VSS 0.24183f ; **FLOATING
C908 DELAY_VBIASN.t24 VSS 0.14732f ; **FLOATING
C909 DELAY_VBIASN.n7 VSS 0.24183f ; **FLOATING
C910 DELAY_VBIASN.t23 VSS 0.14732f ; **FLOATING
C911 DELAY_VBIASN.n8 VSS 0.24183f ; **FLOATING
C912 DELAY_VBIASN.t22 VSS 0.14732f ; **FLOATING
C913 DELAY_VBIASN.n9 VSS 0.24183f ; **FLOATING
C914 DELAY_VBIASN.t21 VSS 0.14732f ; **FLOATING
C915 DELAY_VBIASN.n10 VSS 0.24183f ; **FLOATING
C916 DELAY_VBIASN.t20 VSS 0.14732f ; **FLOATING
C917 DELAY_VBIASN.n11 VSS 0.24183f ; **FLOATING
C918 DELAY_VBIASN.t19 VSS 0.14732f ; **FLOATING
C919 DELAY_VBIASN.n12 VSS 0.24183f ; **FLOATING
C920 DELAY_VBIASN.t18 VSS 0.14732f ; **FLOATING
C921 DELAY_VBIASN.n13 VSS 0.24183f ; **FLOATING
C922 DELAY_VBIASN.t17 VSS 0.14732f ; **FLOATING
C923 DELAY_VBIASN.n14 VSS 0.24183f ; **FLOATING
C924 DELAY_VBIASN.t16 VSS 0.14732f ; **FLOATING
C925 DELAY_VBIASN.n15 VSS 0.24183f ; **FLOATING
C926 DELAY_VBIASN.t15 VSS 0.14732f ; **FLOATING
C927 DELAY_VBIASN.n16 VSS 0.24183f ; **FLOATING
C928 DELAY_VBIASN.t14 VSS 0.14732f ; **FLOATING
C929 DELAY_VBIASN.n17 VSS 0.24183f ; **FLOATING
C930 DELAY_VBIASN.t13 VSS 0.14732f ; **FLOATING
C931 DELAY_VBIASN.n18 VSS 0.24183f ; **FLOATING
C932 DELAY_VBIASN.t12 VSS 0.14732f ; **FLOATING
C933 DELAY_VBIASN.n19 VSS 0.24183f ; **FLOATING
C934 DELAY_VBIASN.t11 VSS 0.14732f ; **FLOATING
C935 DELAY_VBIASN.n20 VSS 0.24183f ; **FLOATING
C936 DELAY_VBIASN.t10 VSS 0.14732f ; **FLOATING
C937 DELAY_VBIASN.n21 VSS 0.24183f ; **FLOATING
C938 DELAY_VBIASN.t9 VSS 0.14732f ; **FLOATING
C939 DELAY_VBIASN.n22 VSS 0.24183f ; **FLOATING
C940 DELAY_VBIASN.t8 VSS 0.14732f ; **FLOATING
C941 DELAY_VBIASN.n23 VSS 0.24183f ; **FLOATING
C942 DELAY_VBIASN.t7 VSS 0.14732f ; **FLOATING
C943 DELAY_VBIASN.n24 VSS 0.24183f ; **FLOATING
C944 DELAY_VBIASN.t6 VSS 0.14732f ; **FLOATING
C945 DELAY_VBIASN.n25 VSS 0.24183f ; **FLOATING
C946 DELAY_VBIASN.t5 VSS 0.14732f ; **FLOATING
C947 DELAY_VBIASN.n26 VSS 0.24183f ; **FLOATING
C948 DELAY_VBIASN.t4 VSS 0.14732f ; **FLOATING
C949 DELAY_VBIASN.n27 VSS 0.24183f ; **FLOATING
C950 DELAY_VBIASN.t3 VSS 0.14732f ; **FLOATING
C951 DELAY_VBIASN.n28 VSS 0.24183f ; **FLOATING
C952 DELAY_VBIASN.t2 VSS 0.14732f ; **FLOATING
C953 DELAY_VBIASN.n29 VSS 0.24183f ; **FLOATING
C954 DELAY_VBIASN.t1 VSS 0.14732f ; **FLOATING
C955 DELAY_VBIASN.n30 VSS 0.24183f ; **FLOATING
C956 DELAY_VBIASN.t0 VSS 0.14732f ; **FLOATING
.ends
