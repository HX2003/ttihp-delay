* NGSPICE file created from hx_delay_line.ext - technology: ihp-sg13g2

.subckt hx_delay_line VSS VDD DELAY_OUT_LAST DELAY_OUT_TAP1 DELAY_OUT_TAP2 DELAY_OUT_TAP3
+ DELAY_OUT_TAP4 DELAY_OUT_TAP5 DELAY_OUT_TAP6 DELAY_OUT_TAP7 DELAY_OUT_TAP8 DELAY_OUT_TAP9
+ DELAY_OUT_TAP10 DELAY_OUT_TAP11 DELAY_OUT_TAP12 DELAY_OUT_TAP13 DELAY_OUT_TAP14
+ DELAY_OUT_TAP15 DELAY_OUT_TAP16 DELAY_OUT_TAP17 DELAY_OUT_TAP18 DELAY_OUT_TAP19
+ DELAY_OUT_TAP20 DELAY_OUT_TAP21 DELAY_OUT_TAP22 DELAY_OUT_TAP23 DELAY_OUT_TAP24
+ DELAY_OUT_TAP25 DELAY_OUT_TAP26 DELAY_OUT_TAP27 DELAY_OUT_TAP28 DELAY_OUT_TAP29
+ DELAY_OUT_TAP30 DELAY_OUT_TAP31 DELAY_IN DELAY_VBIASN DELAY_VBIASP
X0 VDD.t48 DELAY_VBIASP.t3 a_25131_2470# VDD.t0 sg13_lv_pmos ad=0.3808p pd=2.92u as=0.2128p ps=1.5u w=1.12u l=0.6u
X1 VSS.t18 a_5263_1842# DELAY_OUT_TAP3 VSS.t40 sg13_lv_nmos ad=0.1406p pd=1.12u as=0.2516p ps=2.16u w=0.74u l=0.13u
X2 VDD.t30 DELAY_VBIASP.t31 a_3851_2470# VDD.t0 sg13_lv_pmos ad=0.3808p pd=2.92u as=0.2128p ps=1.5u w=1.12u l=0.6u
X3 a_27411_2470# a_27173_1842# a_27303_1842# VDD.t0 sg13_lv_pmos ad=0.2128p pd=1.5u as=0.3808p ps=2.92u w=1.12u l=0.2u
X4 a_9171_1842# a_8933_1842# a_9063_1842# VSS.t48 sg13_lv_nmos ad=0.1406p pd=1.12u as=0.2516p ps=2.16u w=0.74u l=0.2u
X5 a_18053_1842# DELAY_OUT_TAP19 VSS.t110 VSS.t109 sg13_lv_nmos ad=0.2516p pd=2.16u as=0.1406p ps=1.12u w=0.74u l=0.13u
X6 a_15013_1842# DELAY_OUT_TAP15 VDD.t13 VDD.t0 sg13_lv_pmos ad=0.3808p pd=2.92u as=0.2128p ps=1.5u w=1.12u l=0.13u
X7 VDD.t34 DELAY_VBIASP.t15 a_16011_2470# VDD.t0 sg13_lv_pmos ad=0.3808p pd=2.92u as=0.2128p ps=1.5u w=1.12u l=0.6u
X8 VSS.t9 a_7543_1842# DELAY_OUT_TAP6 VSS.t90 sg13_lv_nmos ad=0.1406p pd=1.12u as=0.2516p ps=2.16u w=0.74u l=0.13u
X9 VDD.t33 DELAY_VBIASP.t28 a_6131_2470# VDD.t0 sg13_lv_pmos ad=0.3808p pd=2.92u as=0.2128p ps=1.5u w=1.12u l=0.6u
X10 VDD.t54 a_25783_1842# DELAY_OUT_TAP30 VDD.t0 sg13_lv_pmos ad=0.2128p pd=1.5u as=0.3808p ps=2.92u w=1.12u l=0.13u
X11 a_14491_1842# a_14253_1842# a_14383_1842# VSS.t67 sg13_lv_nmos ad=0.1406p pd=1.12u as=0.2516p ps=2.16u w=0.74u l=0.2u
X12 a_8411_2470# a_8173_1842# a_8303_1842# VDD.t0 sg13_lv_pmos ad=0.2128p pd=1.5u as=0.3808p ps=2.92u w=1.12u l=0.2u
X13 a_17293_1842# DELAY_OUT_TAP18 VDD.t97 VDD.t0 sg13_lv_pmos ad=0.3808p pd=2.92u as=0.2128p ps=1.5u w=1.12u l=0.13u
X14 VSS.t99 VSS.t95 VSS.t95 VSS.t97 sg13_lv_nmos ad=0.1406p pd=1.12u as=0 ps=0 w=0.74u l=0.13u
X15 VDD.t92 a_17423_1842# DELAY_OUT_TAP19 VDD.t0 sg13_lv_pmos ad=0.2128p pd=1.5u as=0.3808p ps=2.92u w=1.12u l=0.13u
X16 a_21093_1842# DELAY_OUT_TAP23 VDD.t74 VDD.t0 sg13_lv_pmos ad=0.3808p pd=2.92u as=0.2128p ps=1.5u w=1.12u l=0.13u
X17 a_22851_2470# a_22613_1842# a_22743_1842# VDD.t0 sg13_lv_pmos ad=0.2128p pd=1.5u as=0.3808p ps=2.92u w=1.12u l=0.2u
X18 VSS.t51 a_12863_1842# DELAY_OUT_TAP13 VSS.t50 sg13_lv_nmos ad=0.1406p pd=1.12u as=0.2516p ps=2.16u w=0.74u l=0.13u
X19 VDD.t14 a_6783_1842# DELAY_OUT_TAP5 VDD.t0 sg13_lv_pmos ad=0.2128p pd=1.5u as=0.3808p ps=2.92u w=1.12u l=0.13u
X20 VDD.t25 DELAY_VBIASP.t21 a_11451_2470# VDD.t0 sg13_lv_pmos ad=0.3808p pd=2.92u as=0.2128p ps=1.5u w=1.12u l=0.6u
X21 VDD.t73 a_21223_1842# DELAY_OUT_TAP24 VDD.t0 sg13_lv_pmos ad=0.2128p pd=1.5u as=0.3808p ps=2.92u w=1.12u l=0.13u
X22 a_12733_1842# DELAY_OUT_TAP12 VDD.t69 VDD.t0 sg13_lv_pmos ad=0.3808p pd=2.92u as=0.2128p ps=1.5u w=1.12u l=0.13u
X23 a_13731_2470# a_13493_1842# a_13623_1842# VDD.t0 sg13_lv_pmos ad=0.2128p pd=1.5u as=0.3808p ps=2.92u w=1.12u l=0.2u
X24 a_3851_2470# DELAY_IN a_3743_1842# VDD.t0 sg13_lv_pmos ad=0.2128p pd=1.5u as=0.3808p ps=2.92u w=1.12u l=0.2u
X25 VSS.t42 DELAY_VBIASN.t12 a_18291_1842# VSS.t131 sg13_lv_nmos ad=0.2516p pd=2.16u as=0.1406p ps=1.12u w=0.74u l=0.6u
X26 VDD.t84 a_23503_1842# DELAY_OUT_TAP27 VDD.t0 sg13_lv_pmos ad=0.2128p pd=1.5u as=0.3808p ps=2.92u w=1.12u l=0.13u
X27 VDD.t50 DELAY_VBIASP.t1 a_26651_2470# VDD.t0 sg13_lv_pmos ad=0.3808p pd=2.92u as=0.2128p ps=1.5u w=1.12u l=0.6u
X28 VSS.t69 DELAY_VBIASN.t7 a_22091_1842# VSS.t149 sg13_lv_nmos ad=0.2516p pd=2.16u as=0.1406p ps=1.12u w=0.74u l=0.6u
X29 a_19573_1842# DELAY_OUT_TAP21 VSS.t20 VSS.t107 sg13_lv_nmos ad=0.2516p pd=2.16u as=0.1406p ps=1.12u w=0.74u l=0.13u
X30 VDD.t55 a_4503_1842# DELAY_OUT_TAP2 VDD.t0 sg13_lv_pmos ad=0.2128p pd=1.5u as=0.3808p ps=2.92u w=1.12u l=0.13u
X31 DELAY_OUT_LAST a_27737_1842# VDD.t100 VDD.t0 sg13_lv_pmos ad=0.3808p pd=2.92u as=0.2128p ps=1.5u w=1.12u l=0.13u
X32 VSS.t58 a_9063_1842# DELAY_OUT_TAP8 VSS.t57 sg13_lv_nmos ad=0.1406p pd=1.12u as=0.2516p ps=2.16u w=0.74u l=0.13u
X33 a_23373_1842# DELAY_OUT_TAP26 VSS.t27 VSS.t88 sg13_lv_nmos ad=0.2516p pd=2.16u as=0.1406p ps=1.12u w=0.74u l=0.13u
X34 VDD.t36 DELAY_VBIASP.t26 a_7651_2470# VDD.t0 sg13_lv_pmos ad=0.3808p pd=2.92u as=0.2128p ps=1.5u w=1.12u l=0.6u
X35 VSS.t66 DELAY_VBIASN.t18 a_13731_1842# VSS.t125 sg13_lv_nmos ad=0.2516p pd=2.16u as=0.1406p ps=1.12u w=0.74u l=0.6u
X36 a_9931_2470# a_9693_1842# a_9823_1842# VDD.t0 sg13_lv_pmos ad=0.2128p pd=1.5u as=0.3808p ps=2.92u w=1.12u l=0.2u
X37 a_11451_2470# a_11213_1842# a_11343_1842# VDD.t0 sg13_lv_pmos ad=0.2128p pd=1.5u as=0.3808p ps=2.92u w=1.12u l=0.2u
X38 a_18813_1842# DELAY_OUT_TAP20 VDD.t60 VDD.t0 sg13_lv_pmos ad=0.3808p pd=2.92u as=0.2128p ps=1.5u w=1.12u l=0.13u
X39 a_16011_1842# a_15773_1842# a_15903_1842# VSS.t35 sg13_lv_nmos ad=0.1406p pd=1.12u as=0.2516p ps=2.16u w=0.74u l=0.2u
X40 a_8933_1842# DELAY_OUT_TAP7 VDD.t68 VDD.t0 sg13_lv_pmos ad=0.3808p pd=2.92u as=0.2128p ps=1.5u w=1.12u l=0.13u
X41 VDD.t66 a_9823_1842# DELAY_OUT_TAP9 VDD.t0 sg13_lv_pmos ad=0.2128p pd=1.5u as=0.3808p ps=2.92u w=1.12u l=0.13u
X42 a_22613_1842# DELAY_OUT_TAP25 VDD.t72 VDD.t0 sg13_lv_pmos ad=0.3808p pd=2.92u as=0.2128p ps=1.5u w=1.12u l=0.13u
X43 a_4373_1842# DELAY_OUT_TAP1 VSS.t39 VSS.t38 sg13_lv_nmos ad=0.2516p pd=2.16u as=0.1406p ps=1.12u w=0.74u l=0.13u
X44 VSS.t5 a_14383_1842# DELAY_OUT_TAP15 VSS.t4 sg13_lv_nmos ad=0.1406p pd=1.12u as=0.2516p ps=2.16u w=0.74u l=0.13u
X45 a_18291_1842# a_18053_1842# a_18183_1842# VSS.t173 sg13_lv_nmos ad=0.1406p pd=1.12u as=0.2516p ps=2.16u w=0.74u l=0.2u
X46 a_26651_2470# a_26413_1842# a_26543_1842# VDD.t0 sg13_lv_pmos ad=0.2128p pd=1.5u as=0.3808p ps=2.92u w=1.12u l=0.2u
X47 a_22091_1842# a_21853_1842# a_21983_1842# VSS.t70 sg13_lv_nmos ad=0.1406p pd=1.12u as=0.2516p ps=2.16u w=0.74u l=0.2u
X48 VSS.t117 a_16663_1842# DELAY_OUT_TAP18 VSS.t172 sg13_lv_nmos ad=0.1406p pd=1.12u as=0.2516p ps=2.16u w=0.74u l=0.13u
X49 VDD.t40 DELAY_VBIASP.t16 a_15251_2470# VDD.t0 sg13_lv_pmos ad=0.3808p pd=2.92u as=0.2128p ps=1.5u w=1.12u l=0.6u
X50 VSS.t119 DELAY_VBIASN.t10 a_19811_1842# VSS.t146 sg13_lv_nmos ad=0.2516p pd=2.16u as=0.1406p ps=1.12u w=0.74u l=0.6u
X51 VDD.t16 a_25023_1842# DELAY_OUT_TAP29 VDD.t0 sg13_lv_pmos ad=0.2128p pd=1.5u as=0.3808p ps=2.92u w=1.12u l=0.13u
X52 VSS.t87 DELAY_VBIASN.t5 a_23611_1842# VSS.t126 sg13_lv_nmos ad=0.2516p pd=2.16u as=0.1406p ps=1.12u w=0.74u l=0.6u
X53 a_17531_2470# a_17293_1842# a_17423_1842# VDD.t0 sg13_lv_pmos ad=0.2128p pd=1.5u as=0.3808p ps=2.92u w=1.12u l=0.2u
X54 a_7651_2470# a_7413_1842# a_7543_1842# VDD.t0 sg13_lv_pmos ad=0.2128p pd=1.5u as=0.3808p ps=2.92u w=1.12u l=0.2u
X55 a_16533_1842# DELAY_OUT_TAP17 VDD.t52 VDD.t0 sg13_lv_pmos ad=0.3808p pd=2.92u as=0.2128p ps=1.5u w=1.12u l=0.13u
X56 a_20333_1842# DELAY_OUT_TAP22 VDD.t98 VDD.t0 sg13_lv_pmos ad=0.3808p pd=2.92u as=0.2128p ps=1.5u w=1.12u l=0.13u
X57 a_21331_2470# a_21093_1842# a_21223_1842# VDD.t0 sg13_lv_pmos ad=0.2128p pd=1.5u as=0.3808p ps=2.92u w=1.12u l=0.2u
X58 a_24893_1842# DELAY_OUT_TAP28 VSS.t84 VSS.t83 sg13_lv_nmos ad=0.2516p pd=2.16u as=0.1406p ps=1.12u w=0.74u l=0.13u
X59 VSS.t63 a_12103_1842# DELAY_OUT_TAP12 VSS.t62 sg13_lv_nmos ad=0.1406p pd=1.12u as=0.2516p ps=2.16u w=0.74u l=0.13u
X60 VDD.t57 a_6023_1842# DELAY_OUT_TAP4 VDD.t0 sg13_lv_pmos ad=0.2128p pd=1.5u as=0.3808p ps=2.92u w=1.12u l=0.13u
X61 VSS.t31 DELAY_VBIASN.t30 a_4611_1842# VSS.t134 sg13_lv_nmos ad=0.2516p pd=2.16u as=0.1406p ps=1.12u w=0.74u l=0.6u
X62 a_11213_1842# DELAY_OUT_TAP10 VDD.t56 VDD.t0 sg13_lv_pmos ad=0.3808p pd=2.92u as=0.2128p ps=1.5u w=1.12u l=0.13u
X63 a_12971_2470# a_12733_1842# a_12863_1842# VDD.t0 sg13_lv_pmos ad=0.2128p pd=1.5u as=0.3808p ps=2.92u w=1.12u l=0.2u
X64 VDD.t1 a_11343_1842# DELAY_OUT_TAP11 VDD.t0 sg13_lv_pmos ad=0.2128p pd=1.5u as=0.3808p ps=2.92u w=1.12u l=0.13u
X65 a_5893_1842# DELAY_OUT_TAP3 VSS.t18 VSS.t17 sg13_lv_nmos ad=0.2516p pd=2.16u as=0.1406p ps=1.12u w=0.74u l=0.13u
X66 a_27173_1842# DELAY_OUT_TAP31 VSS.t121 VSS.t120 sg13_lv_nmos ad=0.2516p pd=2.16u as=0.1406p ps=1.12u w=0.74u l=0.13u
X67 VSS.t110 DELAY_VBIASN.t13 a_17531_1842# VSS.t133 sg13_lv_nmos ad=0.2516p pd=2.16u as=0.1406p ps=1.12u w=0.74u l=0.6u
X68 VSS.t158 a_27303_1842# a_27737_1842# VSS.t164 sg13_lv_nmos ad=0.1406p pd=1.12u as=0.2516p ps=2.16u w=0.74u l=0.13u
X69 VSS.t72 DELAY_VBIASN.t8 a_21331_1842# VSS.t148 sg13_lv_nmos ad=0.2516p pd=2.16u as=0.1406p ps=1.12u w=0.74u l=0.6u
X70 a_15251_2470# a_15013_1842# a_15143_1842# VDD.t0 sg13_lv_pmos ad=0.2128p pd=1.5u as=0.3808p ps=2.92u w=1.12u l=0.2u
X71 VSS.t102 VSS.t104 VSS.t104 VSS.t105 sg13_lv_nmos ad=0.1406p pd=1.12u as=0 ps=0 w=0.74u l=0.2u
X72 a_19811_1842# a_19573_1842# a_19703_1842# VSS.t155 sg13_lv_nmos ad=0.1406p pd=1.12u as=0.2516p ps=2.16u w=0.74u l=0.2u
X73 a_8173_1842# DELAY_OUT_TAP6 VSS.t9 VSS.t8 sg13_lv_nmos ad=0.2516p pd=2.16u as=0.1406p ps=1.12u w=0.74u l=0.13u
X74 a_23611_1842# a_23373_1842# a_23503_1842# VSS.t160 sg13_lv_nmos ad=0.1406p pd=1.12u as=0.2516p ps=2.16u w=0.74u l=0.2u
X75 VDD.t71 a_13623_1842# DELAY_OUT_TAP14 VDD.t0 sg13_lv_pmos ad=0.2128p pd=1.5u as=0.3808p ps=2.92u w=1.12u l=0.13u
X76 a_26413_1842# DELAY_OUT_TAP30 VDD.t54 VDD.t0 sg13_lv_pmos ad=0.3808p pd=2.92u as=0.2128p ps=1.5u w=1.12u l=0.13u
X77 VSS.t60 a_8303_1842# DELAY_OUT_TAP7 VSS.t59 sg13_lv_nmos ad=0.1406p pd=1.12u as=0.2516p ps=2.16u w=0.74u l=0.13u
X78 VSS.t42 a_18183_1842# DELAY_OUT_TAP20 VSS.t41 sg13_lv_nmos ad=0.1406p pd=1.12u as=0.2516p ps=2.16u w=0.74u l=0.13u
X79 VSS.t63 DELAY_VBIASN.t20 a_12211_1842# VSS.t144 sg13_lv_nmos ad=0.2516p pd=2.16u as=0.1406p ps=1.12u w=0.74u l=0.6u
X80 VDD.t42 DELAY_VBIASP.t14 a_16771_2470# VDD.t0 sg13_lv_pmos ad=0.3808p pd=2.92u as=0.2128p ps=1.5u w=1.12u l=0.6u
X81 VSS.t69 a_21983_1842# DELAY_OUT_TAP25 VSS.t68 sg13_lv_nmos ad=0.1406p pd=1.12u as=0.2516p ps=2.16u w=0.74u l=0.13u
X82 VDD.t45 DELAY_VBIASP.t9 a_20571_2470# VDD.t0 sg13_lv_pmos ad=0.3808p pd=2.92u as=0.2128p ps=1.5u w=1.12u l=0.6u
X83 a_4611_1842# a_4373_1842# a_4503_1842# VSS.t53 sg13_lv_nmos ad=0.1406p pd=1.12u as=0.2516p ps=2.16u w=0.74u l=0.2u
X84 a_13493_1842# DELAY_OUT_TAP13 VSS.t51 VSS.t76 sg13_lv_nmos ad=0.2516p pd=2.16u as=0.1406p ps=1.12u w=0.74u l=0.13u
X85 a_7413_1842# DELAY_OUT_TAP5 VDD.t14 VDD.t0 sg13_lv_pmos ad=0.3808p pd=2.92u as=0.2128p ps=1.5u w=1.12u l=0.13u
X86 VDD.t26 DELAY_VBIASP.t11 a_19051_2470# VDD.t0 sg13_lv_pmos ad=0.3808p pd=2.92u as=0.2128p ps=1.5u w=1.12u l=0.6u
X87 a_21853_1842# DELAY_OUT_TAP24 VDD.t73 VDD.t0 sg13_lv_pmos ad=0.3808p pd=2.92u as=0.2128p ps=1.5u w=1.12u l=0.13u
X88 VSS.t154 DELAY_VBIASN.t0 a_27411_1842# VSS.t153 sg13_lv_nmos ad=0.2516p pd=2.16u as=0.1406p ps=1.12u w=0.74u l=0.6u
X89 a_25131_2470# a_24893_1842# a_25023_1842# VDD.t0 sg13_lv_pmos ad=0.2128p pd=1.5u as=0.3808p ps=2.92u w=1.12u l=0.2u
X90 VSS.t23 a_15903_1842# DELAY_OUT_TAP17 VSS.t22 sg13_lv_nmos ad=0.1406p pd=1.12u as=0.2516p ps=2.16u w=0.74u l=0.13u
X91 a_24133_1842# DELAY_OUT_TAP27 VDD.t84 VDD.t0 sg13_lv_pmos ad=0.3808p pd=2.92u as=0.2128p ps=1.5u w=1.12u l=0.13u
X92 VSS.t56 DELAY_VBIASN.t23 a_9931_1842# VSS.t129 sg13_lv_nmos ad=0.2516p pd=2.16u as=0.1406p ps=1.12u w=0.74u l=0.6u
X93 VSS.t60 DELAY_VBIASN.t25 a_8411_1842# VSS.t137 sg13_lv_nmos ad=0.2516p pd=2.16u as=0.1406p ps=1.12u w=0.74u l=0.6u
X94 VSS.t119 a_19703_1842# DELAY_OUT_TAP22 VSS.t159 sg13_lv_nmos ad=0.1406p pd=1.12u as=0.2516p ps=2.16u w=0.74u l=0.13u
X95 a_16771_2470# a_16533_1842# a_16663_1842# VDD.t0 sg13_lv_pmos ad=0.2128p pd=1.5u as=0.3808p ps=2.92u w=1.12u l=0.2u
X96 VSS.t27 DELAY_VBIASN.t6 a_22851_1842# VSS.t132 sg13_lv_nmos ad=0.2516p pd=2.16u as=0.1406p ps=1.12u w=0.74u l=0.6u
X97 a_12211_1842# a_11973_1842# a_12103_1842# VSS.t10 sg13_lv_nmos ad=0.1406p pd=1.12u as=0.2516p ps=2.16u w=0.74u l=0.2u
X98 a_6131_2470# a_5893_1842# a_6023_1842# VDD.t0 sg13_lv_pmos ad=0.2128p pd=1.5u as=0.3808p ps=2.92u w=1.12u l=0.2u
X99 a_5133_1842# DELAY_OUT_TAP2 VDD.t55 VDD.t0 sg13_lv_pmos ad=0.3808p pd=2.92u as=0.2128p ps=1.5u w=1.12u l=0.13u
X100 VDD.t17 a_15143_1842# DELAY_OUT_TAP16 VDD.t0 sg13_lv_pmos ad=0.2128p pd=1.5u as=0.3808p ps=2.92u w=1.12u l=0.13u
X101 a_20571_2470# a_20333_1842# a_20463_1842# VDD.t0 sg13_lv_pmos ad=0.2128p pd=1.5u as=0.3808p ps=2.92u w=1.12u l=0.2u
X102 a_9693_1842# DELAY_OUT_TAP8 VSS.t58 VSS.t115 sg13_lv_nmos ad=0.2516p pd=2.16u as=0.1406p ps=1.12u w=0.74u l=0.13u
X103 VSS.t34 a_10583_1842# DELAY_OUT_TAP10 VSS.t33 sg13_lv_nmos ad=0.1406p pd=1.12u as=0.2516p ps=2.16u w=0.74u l=0.13u
X104 VSS.t39 DELAY_VBIASN.t31 a_3851_1842# VSS.t128 sg13_lv_nmos ad=0.2516p pd=2.16u as=0.1406p ps=1.12u w=0.74u l=0.6u
X105 VSS.t12 DELAY_VBIASN.t3 a_25131_1842# VSS.t150 sg13_lv_nmos ad=0.2516p pd=2.16u as=0.1406p ps=1.12u w=0.74u l=0.6u
X106 a_19051_2470# a_18813_1842# a_18943_1842# VDD.t0 sg13_lv_pmos ad=0.2128p pd=1.5u as=0.3808p ps=2.92u w=1.12u l=0.2u
X107 a_10453_1842# DELAY_OUT_TAP9 VDD.t66 VDD.t0 sg13_lv_pmos ad=0.3808p pd=2.92u as=0.2128p ps=1.5u w=1.12u l=0.13u
X108 a_27411_1842# a_27173_1842# a_27303_1842# VSS.t169 sg13_lv_nmos ad=0.1406p pd=1.12u as=0.2516p ps=2.16u w=0.74u l=0.2u
X109 a_15013_1842# DELAY_OUT_TAP15 VSS.t5 VSS.t113 sg13_lv_nmos ad=0.2516p pd=2.16u as=0.1406p ps=1.12u w=0.74u l=0.13u
X110 VSS.t29 a_25783_1842# DELAY_OUT_TAP30 VSS.t28 sg13_lv_nmos ad=0.1406p pd=1.12u as=0.2516p ps=2.16u w=0.74u l=0.13u
X111 VSS.t23 DELAY_VBIASN.t15 a_16011_1842# VSS.t141 sg13_lv_nmos ad=0.2516p pd=2.16u as=0.1406p ps=1.12u w=0.74u l=0.6u
X112 VDD.t49 DELAY_VBIASP.t4 a_24371_2470# VDD.t0 sg13_lv_pmos ad=0.3808p pd=2.92u as=0.2128p ps=1.5u w=1.12u l=0.6u
X113 VSS.t37 DELAY_VBIASN.t28 a_6131_1842# VSS.t122 sg13_lv_nmos ad=0.2516p pd=2.16u as=0.1406p ps=1.12u w=0.74u l=0.6u
X114 VDD.t4 VDD.t2 VDD.t3 VDD.t0 sg13_lv_pmos ad=0.3808p pd=2.92u as=0 ps=0 w=1.12u l=0.13u
X115 a_8411_1842# a_8173_1842# a_8303_1842# VSS.t49 sg13_lv_nmos ad=0.1406p pd=1.12u as=0.2516p ps=2.16u w=0.74u l=0.2u
X116 a_22851_1842# a_22613_1842# a_22743_1842# VSS.t13 sg13_lv_nmos ad=0.1406p pd=1.12u as=0.2516p ps=2.16u w=0.74u l=0.2u
X117 a_17293_1842# DELAY_OUT_TAP18 VSS.t117 VSS.t116 sg13_lv_nmos ad=0.2516p pd=2.16u as=0.1406p ps=1.12u w=0.74u l=0.13u
X118 a_25653_1842# DELAY_OUT_TAP29 VDD.t16 VDD.t0 sg13_lv_pmos ad=0.3808p pd=2.92u as=0.2128p ps=1.5u w=1.12u l=0.13u
X119 VSS.t7 a_6783_1842# DELAY_OUT_TAP5 VSS.t43 sg13_lv_nmos ad=0.1406p pd=1.12u as=0.2516p ps=2.16u w=0.74u l=0.13u
X120 a_21093_1842# DELAY_OUT_TAP23 VSS.t75 VSS.t89 sg13_lv_nmos ad=0.2516p pd=2.16u as=0.1406p ps=1.12u w=0.74u l=0.13u
X121 VSS.t110 a_17423_1842# DELAY_OUT_TAP19 VSS.t171 sg13_lv_nmos ad=0.1406p pd=1.12u as=0.2516p ps=2.16u w=0.74u l=0.13u
X122 VDD.t35 DELAY_VBIASP.t29 a_5371_2470# VDD.t0 sg13_lv_pmos ad=0.3808p pd=2.92u as=0.2128p ps=1.5u w=1.12u l=0.6u
X123 VSS.t72 a_21223_1842# DELAY_OUT_TAP24 VSS.t71 sg13_lv_nmos ad=0.1406p pd=1.12u as=0.2516p ps=2.16u w=0.74u l=0.13u
X124 VSS.t2 DELAY_VBIASN.t21 a_11451_1842# VSS.t127 sg13_lv_nmos ad=0.2516p pd=2.16u as=0.1406p ps=1.12u w=0.74u l=0.6u
X125 a_3851_1842# DELAY_IN a_3743_1842# VSS.t32 sg13_lv_nmos ad=0.1406p pd=1.12u as=0.2516p ps=2.16u w=0.74u l=0.2u
X126 a_13731_1842# a_13493_1842# a_13623_1842# VSS.t14 sg13_lv_nmos ad=0.1406p pd=1.12u as=0.2516p ps=2.16u w=0.74u l=0.2u
X127 a_12733_1842# DELAY_OUT_TAP12 VSS.t63 VSS.t77 sg13_lv_nmos ad=0.2516p pd=2.16u as=0.1406p ps=1.12u w=0.74u l=0.13u
X128 a_6653_1842# DELAY_OUT_TAP4 VDD.t57 VDD.t0 sg13_lv_pmos ad=0.3808p pd=2.92u as=0.2128p ps=1.5u w=1.12u l=0.13u
X129 VSS.t87 a_23503_1842# DELAY_OUT_TAP27 VSS.t161 sg13_lv_nmos ad=0.1406p pd=1.12u as=0.2516p ps=2.16u w=0.74u l=0.13u
X130 VDD.t31 DELAY_VBIASP.t22 a_10691_2470# VDD.t0 sg13_lv_pmos ad=0.3808p pd=2.92u as=0.2128p ps=1.5u w=1.12u l=0.6u
X131 VDD.t74 a_20463_1842# DELAY_OUT_TAP23 VDD.t0 sg13_lv_pmos ad=0.2128p pd=1.5u as=0.3808p ps=2.92u w=1.12u l=0.13u
X132 VSS.t121 DELAY_VBIASN.t1 a_26651_1842# VSS.t130 sg13_lv_nmos ad=0.2516p pd=2.16u as=0.1406p ps=1.12u w=0.74u l=0.6u
X133 a_24371_2470# a_24133_1842# a_24263_1842# VDD.t0 sg13_lv_pmos ad=0.2128p pd=1.5u as=0.3808p ps=2.92u w=1.12u l=0.2u
X134 a_11973_1842# DELAY_OUT_TAP11 VDD.t1 VDD.t0 sg13_lv_pmos ad=0.3808p pd=2.92u as=0.2128p ps=1.5u w=1.12u l=0.13u
X135 VDD.t23 DELAY_VBIASP.t19 a_12971_2470# VDD.t0 sg13_lv_pmos ad=0.3808p pd=2.92u as=0.2128p ps=1.5u w=1.12u l=0.6u
X136 VDD.t51 a_18943_1842# DELAY_OUT_TAP21 VDD.t0 sg13_lv_pmos ad=0.2128p pd=1.5u as=0.3808p ps=2.92u w=1.12u l=0.13u
X137 VSS.t31 a_4503_1842# DELAY_OUT_TAP2 VSS.t45 sg13_lv_nmos ad=0.1406p pd=1.12u as=0.2516p ps=2.16u w=0.74u l=0.13u
X138 DELAY_OUT_LAST a_27737_1842# VSS.t158 VSS.t157 sg13_lv_nmos ad=0.2516p pd=2.16u as=0.1406p ps=1.12u w=0.74u l=0.13u
X139 VDD.t53 a_22743_1842# DELAY_OUT_TAP26 VDD.t0 sg13_lv_pmos ad=0.2128p pd=1.5u as=0.3808p ps=2.92u w=1.12u l=0.13u
X140 VSS.t9 DELAY_VBIASN.t26 a_7651_1842# VSS.t135 sg13_lv_nmos ad=0.2516p pd=2.16u as=0.1406p ps=1.12u w=0.74u l=0.6u
X141 VDD.t21 DELAY_VBIASP.t2 a_25891_2470# VDD.t0 sg13_lv_pmos ad=0.3808p pd=2.92u as=0.2128p ps=1.5u w=1.12u l=0.6u
X142 a_11451_1842# a_11213_1842# a_11343_1842# VSS.t3 sg13_lv_nmos ad=0.1406p pd=1.12u as=0.2516p ps=2.16u w=0.74u l=0.2u
X143 a_5371_2470# a_5133_1842# a_5263_1842# VDD.t0 sg13_lv_pmos ad=0.2128p pd=1.5u as=0.3808p ps=2.92u w=1.12u l=0.2u
X144 a_14253_1842# DELAY_OUT_TAP14 VDD.t71 VDD.t0 sg13_lv_pmos ad=0.3808p pd=2.92u as=0.2128p ps=1.5u w=1.12u l=0.13u
X145 a_9931_1842# a_9693_1842# a_9823_1842# VSS.t47 sg13_lv_nmos ad=0.1406p pd=1.12u as=0.2516p ps=2.16u w=0.74u l=0.2u
X146 a_18813_1842# DELAY_OUT_TAP20 VSS.t42 VSS.t108 sg13_lv_nmos ad=0.2516p pd=2.16u as=0.1406p ps=1.12u w=0.74u l=0.13u
X147 a_8933_1842# DELAY_OUT_TAP7 VSS.t60 VSS.t91 sg13_lv_nmos ad=0.2516p pd=2.16u as=0.1406p ps=1.12u w=0.74u l=0.13u
X148 a_22613_1842# DELAY_OUT_TAP25 VSS.t69 VSS.t85 sg13_lv_nmos ad=0.2516p pd=2.16u as=0.1406p ps=1.12u w=0.74u l=0.13u
X149 VSS.t56 a_9823_1842# DELAY_OUT_TAP9 VSS.t55 sg13_lv_nmos ad=0.1406p pd=1.12u as=0.2516p ps=2.16u w=0.74u l=0.13u
X150 VDD.t58 a_3743_1842# DELAY_OUT_TAP1 VDD.t0 sg13_lv_pmos ad=0.2128p pd=1.5u as=0.3808p ps=2.92u w=1.12u l=0.13u
X151 VDD.t28 DELAY_VBIASP.t27 a_6891_2470# VDD.t0 sg13_lv_pmos ad=0.3808p pd=2.92u as=0.2128p ps=1.5u w=1.12u l=0.6u
X152 a_10691_2470# a_10453_1842# a_10583_1842# VDD.t0 sg13_lv_pmos ad=0.2128p pd=1.5u as=0.3808p ps=2.92u w=1.12u l=0.2u
X153 a_26651_1842# a_26413_1842# a_26543_1842# VSS.t166 sg13_lv_nmos ad=0.1406p pd=1.12u as=0.2516p ps=2.16u w=0.74u l=0.2u
X154 VSS.t16 DELAY_VBIASN.t16 a_15251_1842# VSS.t139 sg13_lv_nmos ad=0.2516p pd=2.16u as=0.1406p ps=1.12u w=0.74u l=0.6u
X155 VDD.t38 DELAY_VBIASP.t24 a_9171_2470# VDD.t0 sg13_lv_pmos ad=0.3808p pd=2.92u as=0.2128p ps=1.5u w=1.12u l=0.6u
X156 VSS.t12 a_25023_1842# DELAY_OUT_TAP29 VSS.t11 sg13_lv_nmos ad=0.1406p pd=1.12u as=0.2516p ps=2.16u w=0.74u l=0.13u
X157 a_17531_1842# a_17293_1842# a_17423_1842# VSS.t170 sg13_lv_nmos ad=0.1406p pd=1.12u as=0.2516p ps=2.16u w=0.74u l=0.2u
X158 a_7651_1842# a_7413_1842# a_7543_1842# VSS.t46 sg13_lv_nmos ad=0.1406p pd=1.12u as=0.2516p ps=2.16u w=0.74u l=0.2u
X159 a_21331_1842# a_21093_1842# a_21223_1842# VSS.t73 sg13_lv_nmos ad=0.1406p pd=1.12u as=0.2516p ps=2.16u w=0.74u l=0.2u
X160 a_16533_1842# DELAY_OUT_TAP17 VSS.t23 VSS.t111 sg13_lv_nmos ad=0.2516p pd=2.16u as=0.1406p ps=1.12u w=0.74u l=0.13u
X161 a_25891_2470# a_25653_1842# a_25783_1842# VDD.t0 sg13_lv_pmos ad=0.2128p pd=1.5u as=0.3808p ps=2.92u w=1.12u l=0.2u
X162 VSS.t37 a_6023_1842# DELAY_OUT_TAP4 VSS.t44 sg13_lv_nmos ad=0.1406p pd=1.12u as=0.2516p ps=2.16u w=0.74u l=0.13u
X163 a_20333_1842# DELAY_OUT_TAP22 VSS.t119 VSS.t118 sg13_lv_nmos ad=0.2516p pd=2.16u as=0.1406p ps=1.12u w=0.74u l=0.13u
X164 VDD.t39 DELAY_VBIASP.t17 a_14491_2470# VDD.t0 sg13_lv_pmos ad=0.3808p pd=2.92u as=0.2128p ps=1.5u w=1.12u l=0.6u
X165 VDD.t82 a_24263_1842# DELAY_OUT_TAP28 VDD.t0 sg13_lv_pmos ad=0.2128p pd=1.5u as=0.3808p ps=2.92u w=1.12u l=0.13u
X166 a_6891_2470# a_6653_1842# a_6783_1842# VDD.t0 sg13_lv_pmos ad=0.2128p pd=1.5u as=0.3808p ps=2.92u w=1.12u l=0.2u
X167 a_15773_1842# DELAY_OUT_TAP16 VDD.t17 VDD.t0 sg13_lv_pmos ad=0.3808p pd=2.92u as=0.2128p ps=1.5u w=1.12u l=0.13u
X168 VDD.t9 VDD.t7 VDD.t8 VDD.t0 sg13_lv_pmos ad=0.3808p pd=2.92u as=0 ps=0 w=1.12u l=0.6u
X169 a_12971_1842# a_12733_1842# a_12863_1842# VSS.t92 sg13_lv_nmos ad=0.1406p pd=1.12u as=0.2516p ps=2.16u w=0.74u l=0.2u
X170 a_11213_1842# DELAY_OUT_TAP10 VSS.t34 VSS.t79 sg13_lv_nmos ad=0.2516p pd=2.16u as=0.1406p ps=1.12u w=0.74u l=0.13u
X171 VDD.t99 a_26543_1842# DELAY_OUT_TAP31 VDD.t0 sg13_lv_pmos ad=0.2128p pd=1.5u as=0.3808p ps=2.92u w=1.12u l=0.13u
X172 VSS.t2 a_11343_1842# DELAY_OUT_TAP11 VSS.t1 sg13_lv_nmos ad=0.1406p pd=1.12u as=0.2516p ps=2.16u w=0.74u l=0.13u
X173 VDD.t18 a_5263_1842# DELAY_OUT_TAP3 VDD.t0 sg13_lv_pmos ad=0.2128p pd=1.5u as=0.3808p ps=2.92u w=1.12u l=0.13u
X174 a_15251_1842# a_15013_1842# a_15143_1842# VSS.t24 sg13_lv_nmos ad=0.1406p pd=1.12u as=0.2516p ps=2.16u w=0.74u l=0.2u
X175 a_9171_2470# a_8933_1842# a_9063_1842# VDD.t0 sg13_lv_pmos ad=0.2128p pd=1.5u as=0.3808p ps=2.92u w=1.12u l=0.2u
X176 a_18053_1842# DELAY_OUT_TAP19 VDD.t92 VDD.t0 sg13_lv_pmos ad=0.3808p pd=2.92u as=0.2128p ps=1.5u w=1.12u l=0.13u
X177 VSS.t66 a_13623_1842# DELAY_OUT_TAP14 VSS.t65 sg13_lv_nmos ad=0.1406p pd=1.12u as=0.2516p ps=2.16u w=0.74u l=0.13u
X178 VDD.t15 a_7543_1842# DELAY_OUT_TAP6 VDD.t0 sg13_lv_pmos ad=0.2128p pd=1.5u as=0.3808p ps=2.92u w=1.12u l=0.13u
X179 a_26413_1842# DELAY_OUT_TAP30 VSS.t29 VSS.t52 sg13_lv_nmos ad=0.2516p pd=2.16u as=0.1406p ps=1.12u w=0.74u l=0.13u
X180 VSS.t117 DELAY_VBIASN.t14 a_16771_1842# VSS.t124 sg13_lv_nmos ad=0.2516p pd=2.16u as=0.1406p ps=1.12u w=0.74u l=0.6u
X181 a_14491_2470# a_14253_1842# a_14383_1842# VDD.t0 sg13_lv_pmos ad=0.2128p pd=1.5u as=0.3808p ps=2.92u w=1.12u l=0.2u
X182 VSS.t75 DELAY_VBIASN.t9 a_20571_1842# VSS.t147 sg13_lv_nmos ad=0.2516p pd=2.16u as=0.1406p ps=1.12u w=0.74u l=0.6u
X183 VDD.t4 VDD.t5 VDD.t6 VDD.t0 sg13_lv_pmos ad=0.2128p pd=1.5u as=0 ps=0 w=1.12u l=0.13u
X184 VDD.t64 a_12863_1842# DELAY_OUT_TAP13 VDD.t0 sg13_lv_pmos ad=0.2128p pd=1.5u as=0.3808p ps=2.92u w=1.12u l=0.13u
X185 a_7413_1842# DELAY_OUT_TAP5 VSS.t7 VSS.t6 sg13_lv_nmos ad=0.2516p pd=2.16u as=0.1406p ps=1.12u w=0.74u l=0.13u
X186 a_21853_1842# DELAY_OUT_TAP24 VSS.t72 VSS.t82 sg13_lv_nmos ad=0.2516p pd=2.16u as=0.1406p ps=1.12u w=0.74u l=0.13u
X187 VSS.t20 DELAY_VBIASN.t11 a_19051_1842# VSS.t145 sg13_lv_nmos ad=0.2516p pd=2.16u as=0.1406p ps=1.12u w=0.74u l=0.6u
X188 a_25131_1842# a_24893_1842# a_25023_1842# VSS.t165 sg13_lv_nmos ad=0.1406p pd=1.12u as=0.2516p ps=2.16u w=0.74u l=0.2u
X189 VDD.t29 DELAY_VBIASP.t12 a_18291_2470# VDD.t0 sg13_lv_pmos ad=0.3808p pd=2.92u as=0.2128p ps=1.5u w=1.12u l=0.6u
X190 a_24133_1842# DELAY_OUT_TAP27 VSS.t87 VSS.t86 sg13_lv_nmos ad=0.2516p pd=2.16u as=0.1406p ps=1.12u w=0.74u l=0.13u
X191 VDD.t43 DELAY_VBIASP.t7 a_22091_2470# VDD.t0 sg13_lv_pmos ad=0.3808p pd=2.92u as=0.2128p ps=1.5u w=1.12u l=0.6u
X192 a_16771_1842# a_16533_1842# a_16663_1842# VSS.t25 sg13_lv_nmos ad=0.1406p pd=1.12u as=0.2516p ps=2.16u w=0.74u l=0.2u
X193 a_19573_1842# DELAY_OUT_TAP21 VDD.t51 VDD.t0 sg13_lv_pmos ad=0.3808p pd=2.92u as=0.2128p ps=1.5u w=1.12u l=0.13u
X194 a_6131_1842# a_5893_1842# a_6023_1842# VSS.t167 sg13_lv_nmos ad=0.1406p pd=1.12u as=0.2516p ps=2.16u w=0.74u l=0.2u
X195 a_20571_1842# a_20333_1842# a_20463_1842# VSS.t114 sg13_lv_nmos ad=0.1406p pd=1.12u as=0.2516p ps=2.16u w=0.74u l=0.2u
X196 a_23373_1842# DELAY_OUT_TAP26 VDD.t53 VDD.t0 sg13_lv_pmos ad=0.3808p pd=2.92u as=0.2128p ps=1.5u w=1.12u l=0.13u
X197 a_5133_1842# DELAY_OUT_TAP2 VSS.t31 VSS.t30 sg13_lv_nmos ad=0.2516p pd=2.16u as=0.1406p ps=1.12u w=0.74u l=0.13u
X198 VSS.t16 a_15143_1842# DELAY_OUT_TAP16 VSS.t15 sg13_lv_nmos ad=0.1406p pd=1.12u as=0.2516p ps=2.16u w=0.74u l=0.13u
X199 VDD.t67 a_9063_1842# DELAY_OUT_TAP8 VDD.t0 sg13_lv_pmos ad=0.2128p pd=1.5u as=0.3808p ps=2.92u w=1.12u l=0.13u
X200 VDD.t19 DELAY_VBIASP.t18 a_13731_2470# VDD.t0 sg13_lv_pmos ad=0.3808p pd=2.92u as=0.2128p ps=1.5u w=1.12u l=0.6u
X201 a_19051_1842# a_18813_1842# a_18943_1842# VSS.t168 sg13_lv_nmos ad=0.1406p pd=1.12u as=0.2516p ps=2.16u w=0.74u l=0.2u
X202 a_16011_2470# a_15773_1842# a_15903_1842# VDD.t0 sg13_lv_pmos ad=0.2128p pd=1.5u as=0.3808p ps=2.92u w=1.12u l=0.2u
X203 a_10453_1842# DELAY_OUT_TAP9 VSS.t56 VSS.t80 sg13_lv_nmos ad=0.2516p pd=2.16u as=0.1406p ps=1.12u w=0.74u l=0.13u
X204 a_4373_1842# DELAY_OUT_TAP1 VDD.t58 VDD.t0 sg13_lv_pmos ad=0.3808p pd=2.92u as=0.2128p ps=1.5u w=1.12u l=0.13u
X205 VDD.t13 a_14383_1842# DELAY_OUT_TAP15 VDD.t0 sg13_lv_pmos ad=0.2128p pd=1.5u as=0.3808p ps=2.92u w=1.12u l=0.13u
X206 VSS.t84 DELAY_VBIASN.t4 a_24371_1842# VSS.t152 sg13_lv_nmos ad=0.2516p pd=2.16u as=0.1406p ps=1.12u w=0.74u l=0.6u
X207 a_18291_2470# a_18053_1842# a_18183_1842# VDD.t0 sg13_lv_pmos ad=0.2128p pd=1.5u as=0.3808p ps=2.92u w=1.12u l=0.2u
X208 a_22091_2470# a_21853_1842# a_21983_1842# VDD.t0 sg13_lv_pmos ad=0.2128p pd=1.5u as=0.3808p ps=2.92u w=1.12u l=0.2u
X209 VSS.t96 VSS.t93 VSS.t95 VSS.t94 sg13_lv_nmos ad=0.2516p pd=2.16u as=0 ps=0 w=0.74u l=0.13u
X210 VDD.t97 a_16663_1842# DELAY_OUT_TAP18 VDD.t0 sg13_lv_pmos ad=0.2128p pd=1.5u as=0.3808p ps=2.92u w=1.12u l=0.13u
X211 VDD.t44 DELAY_VBIASP.t10 a_19811_2470# VDD.t0 sg13_lv_pmos ad=0.3808p pd=2.92u as=0.2128p ps=1.5u w=1.12u l=0.6u
X212 a_25653_1842# DELAY_OUT_TAP29 VSS.t12 VSS.t81 sg13_lv_nmos ad=0.2516p pd=2.16u as=0.1406p ps=1.12u w=0.74u l=0.13u
X213 VSS.t18 DELAY_VBIASN.t29 a_5371_1842# VSS.t123 sg13_lv_nmos ad=0.2516p pd=2.16u as=0.1406p ps=1.12u w=0.74u l=0.6u
X214 VDD.t22 DELAY_VBIASP.t5 a_23611_2470# VDD.t0 sg13_lv_pmos ad=0.3808p pd=2.92u as=0.2128p ps=1.5u w=1.12u l=0.6u
X215 VDD.t69 a_12103_1842# DELAY_OUT_TAP12 VDD.t0 sg13_lv_pmos ad=0.2128p pd=1.5u as=0.3808p ps=2.92u w=1.12u l=0.13u
X216 a_24893_1842# DELAY_OUT_TAP28 VDD.t82 VDD.t0 sg13_lv_pmos ad=0.3808p pd=2.92u as=0.2128p ps=1.5u w=1.12u l=0.13u
X217 a_6653_1842# DELAY_OUT_TAP4 VSS.t37 VSS.t36 sg13_lv_nmos ad=0.2516p pd=2.16u as=0.1406p ps=1.12u w=0.74u l=0.13u
X218 VSS.t75 a_20463_1842# DELAY_OUT_TAP23 VSS.t74 sg13_lv_nmos ad=0.1406p pd=1.12u as=0.2516p ps=2.16u w=0.74u l=0.13u
X219 VSS.t34 DELAY_VBIASN.t22 a_10691_1842# VSS.t140 sg13_lv_nmos ad=0.2516p pd=2.16u as=0.1406p ps=1.12u w=0.74u l=0.6u
X220 VDD.t27 DELAY_VBIASP.t30 a_4611_2470# VDD.t0 sg13_lv_pmos ad=0.3808p pd=2.92u as=0.2128p ps=1.5u w=1.12u l=0.6u
X221 a_24371_1842# a_24133_1842# a_24263_1842# VSS.t156 sg13_lv_nmos ad=0.1406p pd=1.12u as=0.2516p ps=2.16u w=0.74u l=0.2u
X222 VSS.t20 a_18943_1842# DELAY_OUT_TAP21 VSS.t19 sg13_lv_nmos ad=0.1406p pd=1.12u as=0.2516p ps=2.16u w=0.74u l=0.13u
X223 a_11973_1842# DELAY_OUT_TAP11 VSS.t2 VSS.t78 sg13_lv_nmos ad=0.2516p pd=2.16u as=0.1406p ps=1.12u w=0.74u l=0.13u
X224 a_5893_1842# DELAY_OUT_TAP3 VDD.t18 VDD.t0 sg13_lv_pmos ad=0.3808p pd=2.92u as=0.2128p ps=1.5u w=1.12u l=0.13u
X225 VDD.t41 DELAY_VBIASP.t13 a_17531_2470# VDD.t0 sg13_lv_pmos ad=0.3808p pd=2.92u as=0.2128p ps=1.5u w=1.12u l=0.6u
X226 a_27173_1842# DELAY_OUT_TAP31 VDD.t99 VDD.t0 sg13_lv_pmos ad=0.3808p pd=2.92u as=0.2128p ps=1.5u w=1.12u l=0.13u
X227 VSS.t51 DELAY_VBIASN.t19 a_12971_1842# VSS.t143 sg13_lv_nmos ad=0.2516p pd=2.16u as=0.1406p ps=1.12u w=0.74u l=0.6u
X228 VDD.t100 a_27303_1842# a_27737_1842# VDD.t0 sg13_lv_pmos ad=0.2128p pd=1.5u as=0.3808p ps=2.92u w=1.12u l=0.13u
X229 VSS.t29 DELAY_VBIASN.t2 a_25891_1842# VSS.t151 sg13_lv_nmos ad=0.2516p pd=2.16u as=0.1406p ps=1.12u w=0.74u l=0.6u
X230 VSS.t27 a_22743_1842# DELAY_OUT_TAP26 VSS.t26 sg13_lv_nmos ad=0.1406p pd=1.12u as=0.2516p ps=2.16u w=0.74u l=0.13u
X231 a_19811_2470# a_19573_1842# a_19703_1842# VDD.t0 sg13_lv_pmos ad=0.2128p pd=1.5u as=0.3808p ps=2.92u w=1.12u l=0.2u
X232 VDD.t46 DELAY_VBIASP.t8 a_21331_2470# VDD.t0 sg13_lv_pmos ad=0.3808p pd=2.92u as=0.2128p ps=1.5u w=1.12u l=0.6u
X233 VDD.t12 VDD.t10 VDD.t9 VDD.t0 sg13_lv_pmos ad=0.2128p pd=1.5u as=0 ps=0 w=1.12u l=0.2u
X234 a_5371_1842# a_5133_1842# a_5263_1842# VSS.t0 sg13_lv_nmos ad=0.1406p pd=1.12u as=0.2516p ps=2.16u w=0.74u l=0.2u
X235 a_14253_1842# DELAY_OUT_TAP14 VSS.t66 VSS.t106 sg13_lv_nmos ad=0.2516p pd=2.16u as=0.1406p ps=1.12u w=0.74u l=0.13u
X236 a_8173_1842# DELAY_OUT_TAP6 VDD.t15 VDD.t0 sg13_lv_pmos ad=0.3808p pd=2.92u as=0.2128p ps=1.5u w=1.12u l=0.13u
X237 VDD.t60 a_18183_1842# DELAY_OUT_TAP20 VDD.t0 sg13_lv_pmos ad=0.2128p pd=1.5u as=0.3808p ps=2.92u w=1.12u l=0.13u
X238 a_23611_2470# a_23373_1842# a_23503_1842# VDD.t0 sg13_lv_pmos ad=0.2128p pd=1.5u as=0.3808p ps=2.92u w=1.12u l=0.2u
X239 VSS.t39 a_3743_1842# DELAY_OUT_TAP1 VSS.t64 sg13_lv_nmos ad=0.1406p pd=1.12u as=0.2516p ps=2.16u w=0.74u l=0.13u
X240 VDD.t68 a_8303_1842# DELAY_OUT_TAP7 VDD.t0 sg13_lv_pmos ad=0.2128p pd=1.5u as=0.3808p ps=2.92u w=1.12u l=0.13u
X241 VDD.t24 DELAY_VBIASP.t20 a_12211_2470# VDD.t0 sg13_lv_pmos ad=0.3808p pd=2.92u as=0.2128p ps=1.5u w=1.12u l=0.6u
X242 VDD.t72 a_21983_1842# DELAY_OUT_TAP25 VDD.t0 sg13_lv_pmos ad=0.2128p pd=1.5u as=0.3808p ps=2.92u w=1.12u l=0.13u
X243 VSS.t7 DELAY_VBIASN.t27 a_6891_1842# VSS.t136 sg13_lv_nmos ad=0.2516p pd=2.16u as=0.1406p ps=1.12u w=0.74u l=0.6u
X244 a_4611_2470# a_4373_1842# a_4503_1842# VDD.t0 sg13_lv_pmos ad=0.2128p pd=1.5u as=0.3808p ps=2.92u w=1.12u l=0.2u
X245 a_13493_1842# DELAY_OUT_TAP13 VDD.t64 VDD.t0 sg13_lv_pmos ad=0.3808p pd=2.92u as=0.2128p ps=1.5u w=1.12u l=0.13u
X246 a_10691_1842# a_10453_1842# a_10583_1842# VSS.t61 sg13_lv_nmos ad=0.1406p pd=1.12u as=0.2516p ps=2.16u w=0.74u l=0.2u
X247 VDD.t20 DELAY_VBIASP.t0 a_27411_2470# VDD.t0 sg13_lv_pmos ad=0.3808p pd=2.92u as=0.2128p ps=1.5u w=1.12u l=0.6u
X248 VSS.t58 DELAY_VBIASN.t24 a_9171_1842# VSS.t138 sg13_lv_nmos ad=0.2516p pd=2.16u as=0.1406p ps=1.12u w=0.74u l=0.6u
X249 a_25891_1842# a_25653_1842# a_25783_1842# VSS.t21 sg13_lv_nmos ad=0.1406p pd=1.12u as=0.2516p ps=2.16u w=0.74u l=0.2u
X250 VDD.t32 DELAY_VBIASP.t23 a_9931_2470# VDD.t0 sg13_lv_pmos ad=0.3808p pd=2.92u as=0.2128p ps=1.5u w=1.12u l=0.6u
X251 VDD.t52 a_15903_1842# DELAY_OUT_TAP17 VDD.t0 sg13_lv_pmos ad=0.2128p pd=1.5u as=0.3808p ps=2.92u w=1.12u l=0.13u
X252 VSS.t5 DELAY_VBIASN.t17 a_14491_1842# VSS.t142 sg13_lv_nmos ad=0.2516p pd=2.16u as=0.1406p ps=1.12u w=0.74u l=0.6u
X253 VDD.t37 DELAY_VBIASP.t25 a_8411_2470# VDD.t0 sg13_lv_pmos ad=0.3808p pd=2.92u as=0.2128p ps=1.5u w=1.12u l=0.6u
X254 VDD.t98 a_19703_1842# DELAY_OUT_TAP22 VDD.t0 sg13_lv_pmos ad=0.2128p pd=1.5u as=0.3808p ps=2.92u w=1.12u l=0.13u
X255 VSS.t84 a_24263_1842# DELAY_OUT_TAP28 VSS.t163 sg13_lv_nmos ad=0.1406p pd=1.12u as=0.2516p ps=2.16u w=0.74u l=0.13u
X256 a_12211_2470# a_11973_1842# a_12103_1842# VDD.t0 sg13_lv_pmos ad=0.2128p pd=1.5u as=0.3808p ps=2.92u w=1.12u l=0.2u
X257 VDD.t47 DELAY_VBIASP.t6 a_22851_2470# VDD.t0 sg13_lv_pmos ad=0.3808p pd=2.92u as=0.2128p ps=1.5u w=1.12u l=0.6u
X258 a_6891_1842# a_6653_1842# a_6783_1842# VSS.t54 sg13_lv_nmos ad=0.1406p pd=1.12u as=0.2516p ps=2.16u w=0.74u l=0.2u
X259 VSS.t103 VSS.t100 VSS.t102 VSS.t101 sg13_lv_nmos ad=0.2516p pd=2.16u as=0 ps=0 w=0.74u l=0.6u
X260 a_15773_1842# DELAY_OUT_TAP16 VSS.t16 VSS.t112 sg13_lv_nmos ad=0.2516p pd=2.16u as=0.1406p ps=1.12u w=0.74u l=0.13u
X261 a_9693_1842# DELAY_OUT_TAP8 VDD.t67 VDD.t0 sg13_lv_pmos ad=0.3808p pd=2.92u as=0.2128p ps=1.5u w=1.12u l=0.13u
X262 VDD.t56 a_10583_1842# DELAY_OUT_TAP10 VDD.t0 sg13_lv_pmos ad=0.2128p pd=1.5u as=0.3808p ps=2.92u w=1.12u l=0.13u
X263 VSS.t121 a_26543_1842# DELAY_OUT_TAP31 VSS.t162 sg13_lv_nmos ad=0.1406p pd=1.12u as=0.2516p ps=2.16u w=0.74u l=0.13u
C0 a_14383_1842# a_14491_1842# 0.01163f
C1 DELAY_VBIASN DELAY_OUT_TAP11 0.04353f
C2 a_14383_1842# a_14253_1842# 0.70845f
C3 a_10583_1842# VDD 0.49633f
C4 DELAY_OUT_TAP29 a_25653_1842# 0.70708f
C5 DELAY_OUT_TAP4 a_5893_1842# 0.0114f
C6 a_21093_1842# VDD 0.4916f
C7 a_12211_1842# a_12103_1842# 0.01163f
C8 a_27737_1842# a_27303_1842# 0.69646f
C9 a_4373_1842# DELAY_VBIASN 0.10601f
C10 a_9063_1842# VDD 0.49633f
C11 DELAY_OUT_TAP12 DELAY_VBIASP 0.04137f
C12 DELAY_OUT_TAP21 DELAY_VBIASN 0.04353f
C13 VDD DELAY_OUT_LAST 0.45735f
C14 a_16533_1842# DELAY_VBIASN 0.10601f
C15 a_3743_1842# DELAY_VBIASN 0.0649f
C16 a_8303_1842# DELAY_VBIASN 0.07258f
C17 a_24893_1842# DELAY_VBIASN 0.10601f
C18 a_14383_1842# VDD 0.49633f
C19 VDD DELAY_OUT_TAP16 0.72899f
C20 a_12733_1842# DELAY_OUT_TAP12 0.70708f
C21 a_9823_1842# VDD 0.49633f
C22 a_17423_1842# DELAY_VBIASP 0.06627f
C23 DELAY_OUT_TAP26 VDD 0.72899f
C24 a_26413_1842# DELAY_OUT_TAP31 0.0114f
C25 a_15013_1842# DELAY_VBIASN 0.10601f
C26 a_10453_1842# DELAY_VBIASN 0.10601f
C27 a_8303_1842# a_8411_1842# 0.01163f
C28 a_21223_1842# VDD 0.49633f
C29 DELAY_VBIASN a_14253_1842# 0.10601f
C30 DELAY_OUT_TAP13 DELAY_VBIASP 0.04137f
C31 a_25891_1842# a_25783_1842# 0.01163f
C32 a_8933_1842# DELAY_VBIASP 0.11222f
C33 a_19703_1842# DELAY_VBIASN 0.07258f
C34 a_9931_2470# VDD 0.01806f
C35 DELAY_VBIASN DELAY_OUT_TAP18 0.04353f
C36 a_21853_1842# DELAY_VBIASN 0.10601f
C37 a_17293_1842# a_17423_1842# 0.70845f
C38 a_19573_1842# DELAY_VBIASP 0.11222f
C39 VDD a_21331_2470# 0.01806f
C40 a_12733_1842# DELAY_OUT_TAP13 0.0114f
C41 DELAY_OUT_TAP10 DELAY_VBIASP 0.04137f
C42 a_25783_1842# a_25653_1842# 0.70845f
C43 DELAY_OUT_TAP22 a_19703_1842# 0.69646f
C44 a_11973_1842# VDD 0.4916f
C45 a_20333_1842# DELAY_VBIASP 0.11222f
C46 DELAY_VBIASP a_5893_1842# 0.11222f
C47 a_6783_1842# DELAY_VBIASP 0.06627f
C48 DELAY_VBIASN VDD 0.85759f
C49 DELAY_VBIASN DELAY_OUT_TAP3 0.04353f
C50 a_14383_1842# a_14491_2470# 0.01697f
C51 a_25891_2470# VDD 0.01806f
C52 a_6023_1842# VDD 0.49633f
C53 DELAY_VBIASN DELAY_OUT_TAP20 0.04353f
C54 DELAY_OUT_TAP23 DELAY_VBIASP 0.04137f
C55 DELAY_VBIASP a_5263_1842# 0.06627f
C56 DELAY_OUT_TAP22 VDD 0.72899f
C57 VDD a_27173_1842# 0.4916f
C58 a_16771_2470# VDD 0.01806f
C59 a_27411_2470# a_27303_1842# 0.01697f
C60 DELAY_OUT_TAP15 DELAY_VBIASP 0.04137f
C61 DELAY_VBIASN DELAY_OUT_TAP1 0.04353f
C62 a_5371_2470# a_5263_1842# 0.01697f
C63 a_11343_1842# DELAY_OUT_TAP11 0.69646f
C64 a_26413_1842# DELAY_VBIASP 0.11222f
C65 a_26413_1842# a_26543_1842# 0.70845f
C66 a_6131_2470# VDD 0.01806f
C67 DELAY_OUT_TAP30 a_25783_1842# 0.69646f
C68 a_23373_1842# VDD 0.4916f
C69 a_9693_1842# DELAY_OUT_TAP8 0.70708f
C70 DELAY_OUT_TAP21 a_18813_1842# 0.0114f
C71 DELAY_OUT_TAP2 DELAY_VBIASP 0.04137f
C72 DELAY_OUT_TAP29 a_25023_1842# 0.69646f
C73 a_15773_1842# DELAY_OUT_TAP16 0.70708f
C74 a_20463_1842# VDD 0.49633f
C75 a_6131_1842# a_6023_1842# 0.01163f
C76 a_17531_2470# a_17423_1842# 0.01697f
C77 a_21853_1842# DELAY_OUT_TAP25 0.0114f
C78 DELAY_OUT_TAP11 DELAY_VBIASP 0.04137f
C79 VDD DELAY_OUT_TAP31 0.72899f
C80 a_15903_1842# DELAY_VBIASN 0.07258f
C81 a_12103_1842# a_11973_1842# 0.70845f
C82 VDD DELAY_OUT_TAP4 0.72899f
C83 a_24263_1842# DELAY_VBIASN 0.07258f
C84 a_16663_1842# a_16771_1842# 0.01163f
C85 a_4373_1842# DELAY_VBIASP 0.11222f
C86 a_23503_1842# VDD 0.49633f
C87 a_12103_1842# DELAY_VBIASN 0.07258f
C88 DELAY_OUT_TAP25 VDD 0.72899f
C89 DELAY_OUT_TAP21 DELAY_VBIASP 0.04137f
C90 a_13493_1842# DELAY_VBIASN 0.10601f
C91 a_16663_1842# DELAY_VBIASN 0.07258f
C92 DELAY_VBIASN a_13623_1842# 0.07258f
C93 DELAY_VBIASN a_24133_1842# 0.10601f
C94 a_16533_1842# DELAY_VBIASP 0.11222f
C95 a_3743_1842# DELAY_VBIASP 0.05992f
C96 a_8303_1842# DELAY_VBIASP 0.06627f
C97 a_19703_1842# a_19811_1842# 0.01163f
C98 DELAY_VBIASN DELAY_OUT_TAP17 0.04353f
C99 a_24893_1842# DELAY_VBIASP 0.11222f
C100 a_15773_1842# DELAY_VBIASN 0.10601f
C101 DELAY_OUT_TAP9 a_9693_1842# 0.0114f
C102 a_18813_1842# VDD 0.4916f
C103 a_7543_1842# DELAY_VBIASN 0.07258f
C104 VDD a_20571_2470# 0.01806f
C105 DELAY_VBIASN a_25653_1842# 0.10601f
C106 a_15013_1842# DELAY_VBIASP 0.11222f
C107 a_22613_1842# VDD 0.4916f
C108 a_10453_1842# DELAY_VBIASP 0.11222f
C109 a_18813_1842# DELAY_OUT_TAP20 0.70708f
C110 a_14253_1842# DELAY_VBIASP 0.11222f
C111 a_16771_2470# a_16663_1842# 0.01697f
C112 a_11343_1842# VDD 0.49633f
C113 a_24371_2470# VDD 0.01806f
C114 a_19703_1842# DELAY_VBIASP 0.06627f
C115 DELAY_VBIASP DELAY_OUT_TAP18 0.04137f
C116 a_21853_1842# DELAY_VBIASP 0.11222f
C117 DELAY_VBIASN DELAY_OUT_TAP6 0.04353f
C118 a_6653_1842# DELAY_OUT_TAP5 0.0114f
C119 a_8173_1842# a_8303_1842# 0.70845f
C120 a_25131_2470# VDD 0.01806f
C121 DELAY_VBIASN DELAY_OUT_TAP19 0.04353f
C122 a_7543_1842# a_7651_1842# 0.01163f
C123 a_17293_1842# DELAY_OUT_TAP18 0.70708f
C124 VDD DELAY_VBIASP 13.2523f
C125 VDD a_26543_1842# 0.49633f
C126 DELAY_OUT_TAP3 DELAY_VBIASP 0.04137f
C127 a_16011_2470# VDD 0.01806f
C128 DELAY_OUT_TAP20 DELAY_VBIASP 0.04137f
C129 DELAY_VBIASN DELAY_OUT_TAP30 0.04353f
C130 a_12733_1842# VDD 0.4916f
C131 a_5371_2470# VDD 0.01806f
C132 a_17293_1842# VDD 0.4916f
C133 a_27303_1842# VDD 0.49714f
C134 a_22743_1842# VDD 0.49633f
C135 a_22851_2470# VDD 0.01806f
C136 a_9063_1842# DELAY_OUT_TAP8 0.69646f
C137 DELAY_OUT_TAP1 DELAY_VBIASP 0.04137f
C138 a_8173_1842# VDD 0.4916f
C139 a_15143_1842# DELAY_OUT_TAP16 0.69646f
C140 a_14253_1842# DELAY_OUT_TAP14 0.70708f
C141 a_5133_1842# DELAY_VBIASN 0.10601f
C142 a_24371_2470# a_24263_1842# 0.01697f
C143 DELAY_OUT_TAP27 VDD 0.72899f
C144 a_4503_1842# DELAY_VBIASN 0.07258f
C145 DELAY_VBIASN DELAY_OUT_TAP28 0.04353f
C146 a_21853_1842# a_21983_1842# 0.70845f
C147 a_18053_1842# VDD 0.4916f
C148 a_27303_1842# a_27411_1842# 0.01163f
C149 a_12863_1842# DELAY_VBIASN 0.07258f
C150 a_15903_1842# DELAY_VBIASP 0.06627f
C151 a_3743_1842# DELAY_IN 0.53924f
C152 a_18053_1842# DELAY_OUT_TAP20 0.0114f
C153 a_21223_1842# a_21331_1842# 0.01163f
C154 a_15903_1842# a_16011_2470# 0.01697f
C155 VDD DELAY_OUT_TAP14 0.72899f
C156 a_15143_1842# DELAY_VBIASN 0.07258f
C157 a_24263_1842# DELAY_VBIASP 0.06627f
C158 a_18183_1842# VDD 0.49633f
C159 a_9823_1842# a_9693_1842# 0.70845f
C160 a_12103_1842# DELAY_VBIASP 0.06627f
C161 DELAY_VBIASN a_25023_1842# 0.07258f
C162 a_10583_1842# a_10691_2470# 0.01697f
C163 DELAY_VBIASN DELAY_OUT_TAP8 0.04353f
C164 a_21983_1842# VDD 0.49633f
C165 a_13493_1842# DELAY_VBIASP 0.11222f
C166 a_18183_1842# DELAY_OUT_TAP20 0.69646f
C167 a_16663_1842# DELAY_VBIASP 0.06627f
C168 a_12971_2470# VDD 0.01806f
C169 a_13623_1842# DELAY_VBIASP 0.06627f
C170 a_20333_1842# DELAY_OUT_TAP23 0.0114f
C171 a_24133_1842# DELAY_VBIASP 0.11222f
C172 a_23611_1842# a_23503_1842# 0.01163f
C173 a_21853_1842# DELAY_OUT_TAP24 0.70708f
C174 a_23611_2470# VDD 0.01806f
C175 a_17531_2470# VDD 0.01806f
C176 DELAY_VBIASP DELAY_OUT_TAP17 0.04137f
C177 a_15773_1842# DELAY_VBIASP 0.11222f
C178 a_9823_1842# DELAY_OUT_TAP9 0.69646f
C179 DELAY_VBIASN DELAY_OUT_TAP5 0.04353f
C180 a_7543_1842# DELAY_VBIASP 0.06627f
C181 a_25653_1842# DELAY_VBIASP 0.11222f
C182 a_7413_1842# VDD 0.4916f
C183 a_11213_1842# DELAY_VBIASN 0.10601f
C184 DELAY_OUT_TAP6 DELAY_VBIASP 0.04137f
C185 VDD DELAY_OUT_TAP24 0.72899f
C186 VDD DELAY_IN 0.45518f
C187 a_9693_1842# DELAY_VBIASN 0.10601f
C188 DELAY_OUT_TAP19 DELAY_VBIASP 0.04137f
C189 a_9171_2470# a_9063_1842# 0.01697f
C190 DELAY_VBIASN DELAY_OUT_TAP29 0.04353f
C191 a_8411_2470# a_8303_1842# 0.01697f
C192 DELAY_VBIASN a_18943_1842# 0.07258f
C193 DELAY_OUT_TAP9 DELAY_VBIASN 0.04353f
C194 a_9063_1842# a_9171_1842# 0.01163f
C195 a_24133_1842# DELAY_OUT_TAP27 0.70708f
C196 a_27737_1842# VDD 0.75775f
C197 a_17293_1842# DELAY_OUT_TAP19 0.0114f
C198 a_8173_1842# DELAY_OUT_TAP6 0.70708f
C199 DELAY_OUT_TAP1 DELAY_IN 0.01139f
C200 DELAY_OUT_TAP21 a_19573_1842# 0.70708f
C201 DELAY_OUT_TAP30 DELAY_VBIASP 0.04137f
C202 a_25131_1842# a_25023_1842# 0.01163f
C203 a_13493_1842# DELAY_OUT_TAP14 0.0114f
C204 a_13623_1842# DELAY_OUT_TAP14 0.69646f
C205 a_26651_1842# a_26543_1842# 0.01163f
C206 VDD DELAY_OUT_TAP12 0.72899f
C207 a_10453_1842# DELAY_OUT_TAP10 0.0114f
C208 a_22091_2470# a_21983_1842# 0.01697f
C209 a_19703_1842# a_19573_1842# 0.70845f
C210 a_8411_2470# VDD 0.01806f
C211 a_5133_1842# DELAY_VBIASP 0.11222f
C212 a_6783_1842# a_6891_1842# 0.01163f
C213 a_17423_1842# VDD 0.49633f
C214 a_18183_1842# a_18291_1842# 0.01163f
C215 a_6653_1842# DELAY_VBIASN 0.10601f
C216 DELAY_VBIASN a_25783_1842# 0.07258f
C217 a_18053_1842# DELAY_OUT_TAP19 0.70708f
C218 VDD DELAY_OUT_TAP13 0.72899f
C219 a_4503_1842# DELAY_VBIASP 0.06627f
C220 a_25783_1842# a_25891_2470# 0.01697f
C221 a_8933_1842# VDD 0.4916f
C222 DELAY_OUT_TAP28 DELAY_VBIASP 0.04137f
C223 a_21223_1842# a_21093_1842# 0.70845f
C224 a_7543_1842# a_7413_1842# 0.70845f
C225 DELAY_VBIASN DELAY_OUT_TAP7 0.04353f
C226 a_12863_1842# DELAY_VBIASP 0.06627f
C227 a_19573_1842# VDD 0.4916f
C228 a_25131_2470# a_25023_1842# 0.01697f
C229 DELAY_OUT_TAP10 VDD 0.72899f
C230 a_4373_1842# DELAY_OUT_TAP2 0.0114f
C231 a_22743_1842# a_22851_1842# 0.01163f
C232 a_15143_1842# DELAY_VBIASP 0.06627f
C233 a_15013_1842# DELAY_OUT_TAP15 0.70708f
C234 a_4611_2470# VDD 0.01806f
C235 a_20333_1842# VDD 0.4916f
C236 a_14253_1842# DELAY_OUT_TAP15 0.0114f
C237 a_11213_1842# a_11343_1842# 0.70845f
C238 a_12863_1842# a_12733_1842# 0.70845f
C239 a_7413_1842# DELAY_OUT_TAP6 0.0114f
C240 a_25023_1842# DELAY_VBIASP 0.06627f
C241 VDD a_5893_1842# 0.4916f
C242 a_6783_1842# VDD 0.49633f
C243 DELAY_OUT_TAP8 DELAY_VBIASP 0.04137f
C244 DELAY_OUT_TAP3 a_5893_1842# 0.70708f
C245 a_27411_2470# VDD 0.01806f
C246 a_10583_1842# DELAY_VBIASN 0.07258f
C247 a_18943_1842# a_18813_1842# 0.70845f
C248 a_9823_1842# a_9931_2470# 0.01697f
C249 a_21093_1842# DELAY_VBIASN 0.10601f
C250 DELAY_OUT_TAP5 DELAY_VBIASP 0.04137f
C251 VDD DELAY_OUT_TAP23 0.72899f
C252 VDD a_5263_1842# 0.49633f
C253 DELAY_OUT_TAP3 a_5263_1842# 0.69646f
C254 a_9063_1842# DELAY_VBIASN 0.07258f
C255 a_11213_1842# DELAY_VBIASP 0.11222f
C256 DELAY_VBIASN DELAY_OUT_LAST 0.04786f
C257 VDD DELAY_OUT_TAP15 0.72899f
C258 a_12103_1842# DELAY_OUT_TAP12 0.69646f
C259 a_21223_1842# a_21331_2470# 0.01697f
C260 a_11343_1842# a_11451_2470# 0.01697f
C261 a_19811_2470# a_19703_1842# 0.01697f
C262 a_14383_1842# DELAY_VBIASN 0.07258f
C263 DELAY_VBIASN DELAY_OUT_TAP16 0.04353f
C264 a_9823_1842# DELAY_VBIASN 0.07258f
C265 a_9693_1842# DELAY_VBIASP 0.11222f
C266 a_26413_1842# VDD 0.4916f
C267 a_6653_1842# DELAY_OUT_TAP4 0.70708f
C268 DELAY_OUT_TAP26 DELAY_VBIASN 0.04353f
C269 a_21223_1842# DELAY_VBIASN 0.07258f
C270 DELAY_OUT_TAP29 DELAY_VBIASP 0.04137f
C271 VDD DELAY_OUT_TAP2 0.72899f
C272 a_18943_1842# DELAY_VBIASP 0.06627f
C273 DELAY_OUT_TAP9 DELAY_VBIASP 0.04137f
C274 a_13493_1842# DELAY_OUT_TAP13 0.70708f
C275 a_19811_2470# VDD 0.01806f
C276 VDD DELAY_OUT_TAP11 0.72899f
C277 a_16533_1842# DELAY_OUT_TAP18 0.0114f
C278 VDD a_15251_2470# 0.01806f
C279 DELAY_VBIASN a_11973_1842# 0.10601f
C280 a_12863_1842# a_12971_2470# 0.01697f
C281 a_26651_2470# a_26543_1842# 0.01697f
C282 a_4373_1842# VDD 0.4916f
C283 DELAY_OUT_TAP26 a_23373_1842# 0.70708f
C284 a_6023_1842# DELAY_VBIASN 0.07258f
C285 DELAY_OUT_TAP21 VDD 0.72899f
C286 a_17423_1842# DELAY_OUT_TAP19 0.69646f
C287 a_8303_1842# VDD 0.49633f
C288 a_16533_1842# VDD 0.4916f
C289 a_3743_1842# VDD 0.61241f
C290 a_13731_1842# a_13623_1842# 0.01163f
C291 DELAY_OUT_TAP22 DELAY_VBIASN 0.04353f
C292 a_24893_1842# VDD 0.4916f
C293 a_18291_2470# a_18183_1842# 0.01697f
C294 DELAY_VBIASN a_27173_1842# 0.10602f
C295 a_6783_1842# a_6891_2470# 0.01697f
C296 a_6653_1842# DELAY_VBIASP 0.11222f
C297 a_25783_1842# DELAY_VBIASP 0.06627f
C298 a_15013_1842# VDD 0.4916f
C299 a_4373_1842# DELAY_OUT_TAP1 0.70708f
C300 a_10453_1842# VDD 0.4916f
C301 a_14253_1842# VDD 0.4916f
C302 a_19703_1842# VDD 0.49633f
C303 VDD DELAY_OUT_TAP18 0.72899f
C304 a_21853_1842# VDD 0.4916f
C305 a_7413_1842# DELAY_OUT_TAP5 0.70708f
C306 a_23373_1842# DELAY_VBIASN 0.10601f
C307 a_3743_1842# DELAY_OUT_TAP1 0.69646f
C308 DELAY_OUT_TAP7 DELAY_VBIASP 0.04137f
C309 a_6131_2470# a_6023_1842# 0.01697f
C310 a_7651_2470# VDD 0.01806f
C311 a_15903_1842# a_16011_1842# 0.01163f
C312 a_20463_1842# DELAY_VBIASN 0.07258f
C313 VDD DELAY_OUT_TAP3 0.72899f
C314 a_10583_1842# DELAY_VBIASP 0.06627f
C315 DELAY_VBIASN DELAY_OUT_TAP31 0.04353f
C316 DELAY_OUT_TAP26 a_22613_1842# 0.0114f
C317 DELAY_OUT_TAP20 VDD 0.72899f
C318 a_21093_1842# DELAY_VBIASP 0.11222f
C319 DELAY_VBIASN DELAY_OUT_TAP4 0.04353f
C320 a_18943_1842# a_19051_1842# 0.01163f
C321 a_8173_1842# DELAY_OUT_TAP7 0.0114f
C322 a_9063_1842# DELAY_VBIASP 0.06627f
C323 a_6023_1842# DELAY_OUT_TAP4 0.69646f
C324 DELAY_VBIASN a_23503_1842# 0.07258f
C325 DELAY_OUT_TAP25 DELAY_VBIASN 0.04353f
C326 DELAY_OUT_LAST DELAY_VBIASP 0.21225f
C327 a_27173_1842# DELAY_OUT_TAP31 0.70708f
C328 VDD DELAY_OUT_TAP1 0.72899f
C329 a_21983_1842# a_22091_1842# 0.01163f
C330 a_14383_1842# DELAY_VBIASP 0.06627f
C331 DELAY_OUT_TAP16 DELAY_VBIASP 0.04137f
C332 a_9823_1842# DELAY_VBIASP 0.06627f
C333 a_12863_1842# DELAY_OUT_TAP13 0.69646f
C334 DELAY_VBIASN a_18813_1842# 0.10601f
C335 a_16533_1842# a_16663_1842# 0.70845f
C336 a_5371_1842# a_5263_1842# 0.01163f
C337 a_19051_2470# VDD 0.01806f
C338 DELAY_OUT_TAP26 DELAY_VBIASP 0.04137f
C339 a_22613_1842# DELAY_VBIASN 0.10601f
C340 a_21223_1842# DELAY_VBIASP 0.06627f
C341 a_16533_1842# DELAY_OUT_TAP17 0.70708f
C342 VDD a_14491_2470# 0.01806f
C343 a_17423_1842# a_17531_1842# 0.01163f
C344 a_4611_2470# a_4503_1842# 0.01697f
C345 DELAY_VBIASN a_11343_1842# 0.07258f
C346 DELAY_OUT_TAP30 a_26413_1842# 0.70708f
C347 a_5133_1842# a_5263_1842# 0.70845f
C348 a_8933_1842# DELAY_OUT_TAP8 0.0114f
C349 a_23373_1842# a_23503_1842# 0.70845f
C350 DELAY_OUT_TAP26 a_22743_1842# 0.69646f
C351 a_3743_1842# a_3851_1842# 0.01163f
C352 a_16663_1842# DELAY_OUT_TAP18 0.69646f
C353 a_15143_1842# a_15251_1842# 0.01163f
C354 a_11973_1842# DELAY_VBIASP 0.11222f
C355 a_15903_1842# VDD 0.49633f
C356 a_24263_1842# VDD 0.49633f
C357 DELAY_VBIASN DELAY_VBIASP 3.50557f
C358 DELAY_VBIASN a_26543_1842# 0.07258f
C359 a_12103_1842# VDD 0.49633f
C360 a_7543_1842# a_7651_2470# 0.01697f
C361 a_6023_1842# DELAY_VBIASP 0.06627f
C362 a_13493_1842# VDD 0.4916f
C363 a_16663_1842# VDD 0.49633f
C364 a_13623_1842# VDD 0.49633f
C365 a_24133_1842# VDD 0.4916f
C366 a_22091_2470# VDD 0.01806f
C367 a_12733_1842# DELAY_VBIASN 0.10601f
C368 a_20463_1842# a_20571_2470# 0.01697f
C369 a_5133_1842# DELAY_OUT_TAP2 0.70708f
C370 DELAY_OUT_TAP10 a_11213_1842# 0.70708f
C371 DELAY_OUT_TAP22 DELAY_VBIASP 0.04137f
C372 VDD DELAY_OUT_TAP17 0.72899f
C373 a_15773_1842# VDD 0.4916f
C374 a_6783_1842# DELAY_OUT_TAP5 0.69646f
C375 a_17293_1842# DELAY_VBIASN 0.10601f
C376 a_27173_1842# DELAY_VBIASP 0.11222f
C377 a_27303_1842# DELAY_VBIASN 0.07259f
C378 a_22743_1842# DELAY_VBIASN 0.07258f
C379 a_7543_1842# VDD 0.49633f
C380 a_25653_1842# VDD 0.4916f
C381 a_6891_2470# VDD 0.01806f
C382 a_24263_1842# a_24371_1842# 0.01163f
C383 a_4503_1842# DELAY_OUT_TAP2 0.69646f
C384 a_8173_1842# DELAY_VBIASN 0.10601f
C385 VDD DELAY_OUT_TAP6 0.72899f
C386 a_27303_1842# a_27173_1842# 0.70845f
C387 a_23373_1842# DELAY_VBIASP 0.11222f
C388 a_21093_1842# DELAY_OUT_TAP24 0.0114f
C389 DELAY_OUT_TAP25 a_22613_1842# 0.70708f
C390 DELAY_VBIASN DELAY_OUT_TAP27 0.04353f
C391 DELAY_OUT_TAP19 VDD 0.72899f
C392 a_20463_1842# DELAY_VBIASP 0.06627f
C393 a_4503_1842# a_4373_1842# 0.70845f
C394 a_15143_1842# a_15251_2470# 0.01697f
C395 a_18053_1842# DELAY_VBIASN 0.10601f
C396 DELAY_OUT_TAP31 DELAY_VBIASP 0.04137f
C397 a_26543_1842# DELAY_OUT_TAP31 0.69646f
C398 DELAY_OUT_TAP4 DELAY_VBIASP 0.04137f
C399 DELAY_VBIASN DELAY_OUT_TAP14 0.04353f
C400 DELAY_OUT_TAP30 VDD 0.72899f
C401 a_24893_1842# DELAY_OUT_TAP28 0.70708f
C402 DELAY_VBIASN a_18183_1842# 0.07258f
C403 a_23503_1842# DELAY_VBIASP 0.06627f
C404 DELAY_OUT_TAP25 DELAY_VBIASP 0.04137f
C405 a_21223_1842# DELAY_OUT_TAP24 0.69646f
C406 a_21983_1842# DELAY_VBIASN 0.07258f
C407 a_27737_1842# DELAY_OUT_LAST 0.70955f
C408 a_24263_1842# a_24133_1842# 0.70845f
C409 a_15903_1842# DELAY_OUT_TAP17 0.69646f
C410 a_15903_1842# a_15773_1842# 0.70845f
C411 VDD a_12211_2470# 0.01806f
C412 a_23373_1842# DELAY_OUT_TAP27 0.0114f
C413 a_11213_1842# DELAY_OUT_TAP11 0.0114f
C414 a_13493_1842# a_13623_1842# 0.70845f
C415 a_18813_1842# DELAY_VBIASP 0.11222f
C416 a_8933_1842# DELAY_OUT_TAP7 0.70708f
C417 a_24893_1842# a_25023_1842# 0.70845f
C418 a_10583_1842# a_10691_1842# 0.01163f
C419 a_15013_1842# a_15143_1842# 0.70845f
C420 a_7413_1842# DELAY_VBIASN 0.10601f
C421 a_22613_1842# DELAY_VBIASP 0.11222f
C422 a_5133_1842# VDD 0.4916f
C423 a_5133_1842# DELAY_OUT_TAP3 0.0114f
C424 a_4503_1842# a_4611_1842# 0.01163f
C425 a_11343_1842# DELAY_VBIASP 0.06627f
C426 a_6783_1842# a_6653_1842# 0.70845f
C427 a_12971_1842# a_12863_1842# 0.01163f
C428 a_15773_1842# DELAY_OUT_TAP17 0.0114f
C429 DELAY_VBIASN DELAY_OUT_TAP24 0.04353f
C430 DELAY_VBIASN DELAY_IN 0.06969f
C431 a_4503_1842# VDD 0.49633f
C432 DELAY_OUT_TAP28 VDD 0.72899f
C433 a_22743_1842# a_22613_1842# 0.70845f
C434 a_12863_1842# VDD 0.49633f
C435 a_23503_1842# DELAY_OUT_TAP27 0.69646f
C436 DELAY_OUT_TAP10 a_10583_1842# 0.69646f
C437 a_8933_1842# a_9063_1842# 0.70845f
C438 a_7543_1842# DELAY_OUT_TAP6 0.69646f
C439 a_15143_1842# VDD 0.49633f
C440 a_26543_1842# DELAY_VBIASP 0.06627f
C441 a_27737_1842# DELAY_VBIASN 0.04176f
C442 DELAY_OUT_TAP21 a_18943_1842# 0.69646f
C443 a_25023_1842# VDD 0.49633f
C444 VDD DELAY_OUT_TAP8 0.72899f
C445 a_24893_1842# DELAY_OUT_TAP29 0.0114f
C446 a_20463_1842# a_20571_1842# 0.01163f
C447 a_12733_1842# DELAY_VBIASP 0.11222f
C448 VDD DELAY_OUT_TAP5 0.72899f
C449 a_17293_1842# DELAY_VBIASP 0.11222f
C450 a_3851_2470# a_3743_1842# 0.01697f
C451 a_11973_1842# DELAY_OUT_TAP12 0.0114f
C452 a_13731_2470# VDD 0.01806f
C453 a_27303_1842# DELAY_VBIASP 0.06629f
C454 a_27737_1842# a_27173_1842# 0.0114f
C455 a_22743_1842# DELAY_VBIASP 0.06627f
C456 a_18291_2470# VDD 0.01806f
C457 a_10453_1842# DELAY_OUT_TAP9 0.70708f
C458 DELAY_OUT_TAP25 a_21983_1842# 0.69646f
C459 a_21093_1842# DELAY_OUT_TAP23 0.70708f
C460 DELAY_VBIASN DELAY_OUT_TAP12 0.04353f
C461 a_12103_1842# a_12211_2470# 0.01697f
C462 a_8173_1842# DELAY_VBIASP 0.11222f
C463 a_11213_1842# VDD 0.4916f
C464 a_23611_2470# a_23503_1842# 0.01697f
C465 DELAY_OUT_TAP30 a_25653_1842# 0.0114f
C466 a_22851_2470# a_22743_1842# 0.01697f
C467 a_9693_1842# VDD 0.4916f
C468 a_17423_1842# DELAY_VBIASN 0.07258f
C469 DELAY_OUT_TAP27 DELAY_VBIASP 0.04137f
C470 DELAY_OUT_TAP29 VDD 0.72899f
C471 DELAY_VBIASN DELAY_OUT_TAP13 0.04353f
C472 a_24263_1842# DELAY_OUT_TAP28 0.69646f
C473 a_8933_1842# DELAY_VBIASN 0.10601f
C474 a_18943_1842# VDD 0.49633f
C475 DELAY_OUT_TAP9 VDD 0.72899f
C476 a_18053_1842# DELAY_VBIASP 0.11222f
C477 DELAY_VBIASN a_19573_1842# 0.10601f
C478 a_14383_1842# DELAY_OUT_TAP15 0.69646f
C479 a_3851_2470# VDD 0.01866f
C480 DELAY_OUT_TAP10 DELAY_VBIASN 0.04353f
C481 VDD a_11451_2470# 0.01806f
C482 a_24133_1842# DELAY_OUT_TAP28 0.0114f
C483 DELAY_OUT_TAP14 DELAY_VBIASP 0.04137f
C484 a_20333_1842# DELAY_VBIASN 0.10601f
C485 a_26651_2470# VDD 0.01806f
C486 a_10691_2470# VDD 0.01806f
C487 a_8303_1842# DELAY_OUT_TAP7 0.69646f
C488 a_18183_1842# DELAY_VBIASP 0.06627f
C489 DELAY_OUT_TAP22 a_19573_1842# 0.0114f
C490 DELAY_VBIASN a_5893_1842# 0.10601f
C491 a_21983_1842# DELAY_VBIASP 0.06627f
C492 a_6783_1842# DELAY_VBIASN 0.07258f
C493 a_6023_1842# a_5893_1842# 0.70845f
C494 DELAY_OUT_TAP22 a_20333_1842# 0.70708f
C495 DELAY_VBIASN DELAY_OUT_TAP23 0.04353f
C496 DELAY_VBIASN a_5263_1842# 0.07258f
C497 a_19051_2470# a_18943_1842# 0.01697f
C498 a_7413_1842# DELAY_VBIASP 0.11222f
C499 a_13731_2470# a_13623_1842# 0.01697f
C500 DELAY_VBIASN DELAY_OUT_TAP15 0.04353f
C501 a_6653_1842# VDD 0.4916f
C502 a_9171_2470# VDD 0.01806f
C503 a_25783_1842# VDD 0.49633f
C504 a_9823_1842# a_9931_1842# 0.01163f
C505 DELAY_OUT_TAP24 DELAY_VBIASP 0.04137f
C506 a_11451_1842# a_11343_1842# 0.01163f
C507 a_10453_1842# a_10583_1842# 0.70845f
C508 DELAY_IN DELAY_VBIASP 0.0738f
C509 DELAY_VBIASN a_26413_1842# 0.10601f
C510 VDD DELAY_OUT_TAP7 0.72899f
C511 a_20463_1842# a_20333_1842# 0.70845f
C512 DELAY_VBIASN DELAY_OUT_TAP2 0.04353f
C513 a_11973_1842# DELAY_OUT_TAP11 0.70708f
C514 a_27737_1842# DELAY_VBIASP 0.04001f
C515 a_18053_1842# a_18183_1842# 0.70845f
C516 a_15013_1842# DELAY_OUT_TAP16 0.0114f
C517 a_20463_1842# DELAY_OUT_TAP23 0.69646f
R0 DELAY_VBIASN.n1 DELAY_VBIASN.t31 34.3755
R1 DELAY_VBIASN.n1 DELAY_VBIASN.t30 33.0005
R2 DELAY_VBIASN.n2 DELAY_VBIASN.t29 33.0005
R3 DELAY_VBIASN.n3 DELAY_VBIASN.t28 33.0005
R4 DELAY_VBIASN.n4 DELAY_VBIASN.t27 33.0005
R5 DELAY_VBIASN.n5 DELAY_VBIASN.t26 33.0005
R6 DELAY_VBIASN.n6 DELAY_VBIASN.t25 33.0005
R7 DELAY_VBIASN.n7 DELAY_VBIASN.t24 33.0005
R8 DELAY_VBIASN.n8 DELAY_VBIASN.t23 33.0005
R9 DELAY_VBIASN.n9 DELAY_VBIASN.t22 33.0005
R10 DELAY_VBIASN.n10 DELAY_VBIASN.t21 33.0005
R11 DELAY_VBIASN.n11 DELAY_VBIASN.t20 33.0005
R12 DELAY_VBIASN.n12 DELAY_VBIASN.t19 33.0005
R13 DELAY_VBIASN.n13 DELAY_VBIASN.t18 33.0005
R14 DELAY_VBIASN.n14 DELAY_VBIASN.t17 33.0005
R15 DELAY_VBIASN.n15 DELAY_VBIASN.t16 33.0005
R16 DELAY_VBIASN.n16 DELAY_VBIASN.t15 33.0005
R17 DELAY_VBIASN.n17 DELAY_VBIASN.t14 33.0005
R18 DELAY_VBIASN.n18 DELAY_VBIASN.t13 33.0005
R19 DELAY_VBIASN.n19 DELAY_VBIASN.t12 33.0005
R20 DELAY_VBIASN.n20 DELAY_VBIASN.t11 33.0005
R21 DELAY_VBIASN.n21 DELAY_VBIASN.t10 33.0005
R22 DELAY_VBIASN.n22 DELAY_VBIASN.t9 33.0005
R23 DELAY_VBIASN.n23 DELAY_VBIASN.t8 33.0005
R24 DELAY_VBIASN.n24 DELAY_VBIASN.t7 33.0005
R25 DELAY_VBIASN.n25 DELAY_VBIASN.t6 33.0005
R26 DELAY_VBIASN.n26 DELAY_VBIASN.t5 33.0005
R27 DELAY_VBIASN.n27 DELAY_VBIASN.t4 33.0005
R28 DELAY_VBIASN.n28 DELAY_VBIASN.t3 33.0005
R29 DELAY_VBIASN.n29 DELAY_VBIASN.t2 33.0005
R30 DELAY_VBIASN.n30 DELAY_VBIASN.t1 33.0005
R31 DELAY_VBIASN.n0 DELAY_VBIASN.t0 33.0005
R32 DELAY_VBIASN DELAY_VBIASN.n0 1.55517
R33 DELAY_VBIASN.n0 DELAY_VBIASN.n30 1.3755
R34 DELAY_VBIASN.n30 DELAY_VBIASN.n29 1.3755
R35 DELAY_VBIASN.n29 DELAY_VBIASN.n28 1.3755
R36 DELAY_VBIASN.n28 DELAY_VBIASN.n27 1.3755
R37 DELAY_VBIASN.n27 DELAY_VBIASN.n26 1.3755
R38 DELAY_VBIASN.n26 DELAY_VBIASN.n25 1.3755
R39 DELAY_VBIASN.n25 DELAY_VBIASN.n24 1.3755
R40 DELAY_VBIASN.n24 DELAY_VBIASN.n23 1.3755
R41 DELAY_VBIASN.n23 DELAY_VBIASN.n22 1.3755
R42 DELAY_VBIASN.n22 DELAY_VBIASN.n21 1.3755
R43 DELAY_VBIASN.n21 DELAY_VBIASN.n20 1.3755
R44 DELAY_VBIASN.n20 DELAY_VBIASN.n19 1.3755
R45 DELAY_VBIASN.n19 DELAY_VBIASN.n18 1.3755
R46 DELAY_VBIASN.n18 DELAY_VBIASN.n17 1.3755
R47 DELAY_VBIASN.n17 DELAY_VBIASN.n16 1.3755
R48 DELAY_VBIASN.n16 DELAY_VBIASN.n15 1.3755
R49 DELAY_VBIASN.n15 DELAY_VBIASN.n14 1.3755
R50 DELAY_VBIASN.n14 DELAY_VBIASN.n13 1.3755
R51 DELAY_VBIASN.n13 DELAY_VBIASN.n12 1.3755
R52 DELAY_VBIASN.n12 DELAY_VBIASN.n11 1.3755
R53 DELAY_VBIASN.n11 DELAY_VBIASN.n10 1.3755
R54 DELAY_VBIASN.n10 DELAY_VBIASN.n9 1.3755
R55 DELAY_VBIASN.n9 DELAY_VBIASN.n8 1.3755
R56 DELAY_VBIASN.n8 DELAY_VBIASN.n7 1.3755
R57 DELAY_VBIASN.n7 DELAY_VBIASN.n6 1.3755
R58 DELAY_VBIASN.n6 DELAY_VBIASN.n5 1.3755
R59 DELAY_VBIASN.n5 DELAY_VBIASN.n4 1.3755
R60 DELAY_VBIASN.n4 DELAY_VBIASN.n3 1.3755
R61 DELAY_VBIASN.n3 DELAY_VBIASN.n2 1.3755
R62 DELAY_VBIASN.n2 DELAY_VBIASN.n1 1.3755
R63 DELAY_VBIASP.n1 DELAY_VBIASP.t31 34.3685
R64 DELAY_VBIASP.n1 DELAY_VBIASP.t30 33.0005
R65 DELAY_VBIASP.n2 DELAY_VBIASP.t29 33.0005
R66 DELAY_VBIASP.n3 DELAY_VBIASP.t28 33.0005
R67 DELAY_VBIASP.n4 DELAY_VBIASP.t27 33.0005
R68 DELAY_VBIASP.n5 DELAY_VBIASP.t26 33.0005
R69 DELAY_VBIASP.n6 DELAY_VBIASP.t25 33.0005
R70 DELAY_VBIASP.n7 DELAY_VBIASP.t24 33.0005
R71 DELAY_VBIASP.n8 DELAY_VBIASP.t23 33.0005
R72 DELAY_VBIASP.n9 DELAY_VBIASP.t22 33.0005
R73 DELAY_VBIASP.n10 DELAY_VBIASP.t21 33.0005
R74 DELAY_VBIASP.n11 DELAY_VBIASP.t20 33.0005
R75 DELAY_VBIASP.n12 DELAY_VBIASP.t19 33.0005
R76 DELAY_VBIASP.n13 DELAY_VBIASP.t18 33.0005
R77 DELAY_VBIASP.n14 DELAY_VBIASP.t17 33.0005
R78 DELAY_VBIASP.n15 DELAY_VBIASP.t16 33.0005
R79 DELAY_VBIASP.n16 DELAY_VBIASP.t15 33.0005
R80 DELAY_VBIASP.n17 DELAY_VBIASP.t14 33.0005
R81 DELAY_VBIASP.n18 DELAY_VBIASP.t13 33.0005
R82 DELAY_VBIASP.n19 DELAY_VBIASP.t12 33.0005
R83 DELAY_VBIASP.n20 DELAY_VBIASP.t11 33.0005
R84 DELAY_VBIASP.n21 DELAY_VBIASP.t10 33.0005
R85 DELAY_VBIASP.n22 DELAY_VBIASP.t9 33.0005
R86 DELAY_VBIASP.n23 DELAY_VBIASP.t8 33.0005
R87 DELAY_VBIASP.n24 DELAY_VBIASP.t7 33.0005
R88 DELAY_VBIASP.n25 DELAY_VBIASP.t6 33.0005
R89 DELAY_VBIASP.n26 DELAY_VBIASP.t5 33.0005
R90 DELAY_VBIASP.n27 DELAY_VBIASP.t4 33.0005
R91 DELAY_VBIASP.n28 DELAY_VBIASP.t3 33.0005
R92 DELAY_VBIASP.n29 DELAY_VBIASP.t2 33.0005
R93 DELAY_VBIASP.n30 DELAY_VBIASP.t1 33.0005
R94 DELAY_VBIASP.n0 DELAY_VBIASP.t0 33.0005
R95 DELAY_VBIASP DELAY_VBIASP.n0 1.70586
R96 DELAY_VBIASP.n0 DELAY_VBIASP.n30 1.36852
R97 DELAY_VBIASP.n30 DELAY_VBIASP.n29 1.36852
R98 DELAY_VBIASP.n29 DELAY_VBIASP.n28 1.36852
R99 DELAY_VBIASP.n28 DELAY_VBIASP.n27 1.36852
R100 DELAY_VBIASP.n27 DELAY_VBIASP.n26 1.36852
R101 DELAY_VBIASP.n26 DELAY_VBIASP.n25 1.36852
R102 DELAY_VBIASP.n25 DELAY_VBIASP.n24 1.36852
R103 DELAY_VBIASP.n24 DELAY_VBIASP.n23 1.36852
R104 DELAY_VBIASP.n23 DELAY_VBIASP.n22 1.36852
R105 DELAY_VBIASP.n22 DELAY_VBIASP.n21 1.36852
R106 DELAY_VBIASP.n21 DELAY_VBIASP.n20 1.36852
R107 DELAY_VBIASP.n20 DELAY_VBIASP.n19 1.36852
R108 DELAY_VBIASP.n19 DELAY_VBIASP.n18 1.36852
R109 DELAY_VBIASP.n18 DELAY_VBIASP.n17 1.36852
R110 DELAY_VBIASP.n17 DELAY_VBIASP.n16 1.36852
R111 DELAY_VBIASP.n16 DELAY_VBIASP.n15 1.36852
R112 DELAY_VBIASP.n15 DELAY_VBIASP.n14 1.36852
R113 DELAY_VBIASP.n14 DELAY_VBIASP.n13 1.36852
R114 DELAY_VBIASP.n13 DELAY_VBIASP.n12 1.36852
R115 DELAY_VBIASP.n12 DELAY_VBIASP.n11 1.36852
R116 DELAY_VBIASP.n11 DELAY_VBIASP.n10 1.36852
R117 DELAY_VBIASP.n10 DELAY_VBIASP.n9 1.36852
R118 DELAY_VBIASP.n9 DELAY_VBIASP.n8 1.36852
R119 DELAY_VBIASP.n8 DELAY_VBIASP.n7 1.36852
R120 DELAY_VBIASP.n7 DELAY_VBIASP.n6 1.36852
R121 DELAY_VBIASP.n6 DELAY_VBIASP.n5 1.36852
R122 DELAY_VBIASP.n5 DELAY_VBIASP.n4 1.36852
R123 DELAY_VBIASP.n4 DELAY_VBIASP.n3 1.36852
R124 DELAY_VBIASP.n3 DELAY_VBIASP.n2 1.36852
R125 DELAY_VBIASP.n2 DELAY_VBIASP.n1 1.36852
R126 VDD.t0 VDD.t7 15.1333
R127 VDD.t0 VDD.t10 15.0005
R128 VDD.n26 VDD.t2 15.0005
R129 VDD VDD.n27 1.59504
R130 VDD.t0 VDD.t58 6.09923
R131 VDD.t0 VDD.t55 6.09923
R132 VDD.t0 VDD.t18 6.09923
R133 VDD.t0 VDD.t57 6.09923
R134 VDD.t0 VDD.t14 6.09923
R135 VDD.t0 VDD.t15 6.09923
R136 VDD.t0 VDD.t68 6.09923
R137 VDD.n25 VDD.t67 6.09923
R138 VDD.n51 VDD.t66 6.09923
R139 VDD.n23 VDD.t56 6.09923
R140 VDD.n43 VDD.t1 6.09923
R141 VDD.n18 VDD.t69 6.09923
R142 VDD.n18 VDD.t64 6.09923
R143 VDD.n47 VDD.t71 6.09923
R144 VDD.n35 VDD.t13 6.09923
R145 VDD.n21 VDD.t17 6.09923
R146 VDD.n21 VDD.t52 6.09923
R147 VDD.t0 VDD.t97 6.09923
R148 VDD.t0 VDD.t92 6.09923
R149 VDD.n45 VDD.t60 6.09923
R150 VDD.n31 VDD.t51 6.09923
R151 VDD.t0 VDD.t98 6.09923
R152 VDD.n37 VDD.t74 6.09923
R153 VDD.n33 VDD.t73 6.09923
R154 VDD.t0 VDD.t72 6.09923
R155 VDD.n49 VDD.t53 6.09923
R156 VDD.t0 VDD.t84 6.09923
R157 VDD.n39 VDD.t82 6.09923
R158 VDD.n29 VDD.t16 6.09923
R159 VDD.t0 VDD.t54 6.09923
R160 VDD.n41 VDD.t99 6.09923
R161 VDD.t0 VDD.t100 6.09923
R162 VDD.t0 VDD.n23 0.609143
R163 VDD.t0 VDD.n35 0.664997
R164 VDD.n13 VDD.n29 0.0919185
R165 VDD.n26 VDD.t3 5.60969
R166 VDD.t0 VDD.t12 5.60347
R167 VDD.n4 VDD.t30 5.59675
R168 VDD.n5 VDD.t27 5.59675
R169 VDD.n3 VDD.t35 5.59675
R170 VDD.n2 VDD.t33 5.59675
R171 VDD.n1 VDD.t28 5.59675
R172 VDD.n0 VDD.t36 5.59675
R173 VDD.n11 VDD.t37 5.59675
R174 VDD.n24 VDD.t38 5.59675
R175 VDD.n50 VDD.t32 5.59675
R176 VDD.n22 VDD.t31 5.59675
R177 VDD.n42 VDD.t25 5.59675
R178 VDD.n17 VDD.t24 5.59675
R179 VDD.n16 VDD.t23 5.59675
R180 VDD.n46 VDD.t19 5.59675
R181 VDD.n34 VDD.t39 5.59675
R182 VDD.n20 VDD.t40 5.59675
R183 VDD.n19 VDD.t34 5.59675
R184 VDD.n10 VDD.t42 5.59675
R185 VDD.n9 VDD.t41 5.59675
R186 VDD.n44 VDD.t29 5.59675
R187 VDD.n30 VDD.t26 5.59675
R188 VDD.n7 VDD.t44 5.59675
R189 VDD.n36 VDD.t45 5.59675
R190 VDD.n32 VDD.t46 5.59675
R191 VDD.n8 VDD.t43 5.59675
R192 VDD.n48 VDD.t47 5.59675
R193 VDD.n12 VDD.t22 5.59675
R194 VDD.n38 VDD.t49 5.59675
R195 VDD.n28 VDD.t48 5.59675
R196 VDD.n6 VDD.t21 5.59675
R197 VDD.n40 VDD.t50 5.59675
R198 VDD.t0 VDD.t20 5.75932
R199 VDD VDD.n27 1.59504
R200 VDD.n27 VDD.n26 0.71648
R201 VDD.n26 VDD.n110 0.313775
R202 VDD.n51 VDD.n23 0.4099
R203 VDD.n47 VDD.n35 0.409773
R204 VDD.n15 VDD.n31 0.0919217
R205 VDD.n39 VDD.n13 0.24017
R206 VDD.t0 VDD.n65 1.55381
R207 VDD.t0 VDD.n70 1.55381
R208 VDD.t0 VDD.n79 1.55381
R209 VDD.t0 VDD.n69 1.55366
R210 VDD.t0 VDD.n80 1.55366
R211 VDD.t0 VDD.n53 1.55361
R212 VDD.t0 VDD.n57 1.55361
R213 VDD.t0 VDD.n64 1.55361
R214 VDD.t0 VDD.n76 1.55351
R215 VDD.t0 VDD.n62 1.55349
R216 VDD.t0 VDD.n52 1.55347
R217 VDD.t0 VDD.n63 1.55347
R218 VDD.t0 VDD.n67 1.55347
R219 VDD.t0 VDD.n60 1.55345
R220 VDD.t0 VDD.n77 1.55344
R221 VDD.t0 VDD.n74 1.5534
R222 VDD.t0 VDD.n66 1.55339
R223 VDD.t0 VDD.n56 1.55338
R224 VDD.t0 VDD.n61 1.55334
R225 VDD.t0 VDD.n59 1.55334
R226 VDD.t0 VDD.n75 1.55333
R227 VDD.t0 VDD.n55 1.55331
R228 VDD.t0 VDD.n58 1.55331
R229 VDD.t0 VDD.n72 1.55329
R230 VDD.t0 VDD.n54 1.55329
R231 VDD.t0 VDD.n71 1.55328
R232 VDD.t0 VDD.n68 1.55327
R233 VDD.t0 VDD.n73 1.55327
R234 VDD.t0 VDD.n78 1.55325
R235 VDD.n26 VDD.t4 6.01449
R236 VDD.n4 VDD.n110 0.495398
R237 VDD.n5 VDD.n109 0.495398
R238 VDD.n3 VDD.n108 0.495398
R239 VDD.n2 VDD.n107 0.495398
R240 VDD.n1 VDD.n106 0.495398
R241 VDD.n0 VDD.n105 0.495398
R242 VDD.n11 VDD.n104 0.495398
R243 VDD.n24 VDD.n103 0.495398
R244 VDD.n50 VDD.n102 0.495398
R245 VDD.n22 VDD.n101 0.495398
R246 VDD.n42 VDD.n100 0.495398
R247 VDD.n17 VDD.n99 0.495398
R248 VDD.n16 VDD.n98 0.495398
R249 VDD.n46 VDD.n97 0.495398
R250 VDD.n34 VDD.n96 0.495398
R251 VDD.n20 VDD.n95 0.495398
R252 VDD.n19 VDD.n94 0.495398
R253 VDD.n10 VDD.n93 0.495398
R254 VDD.n9 VDD.n92 0.495398
R255 VDD.n44 VDD.n91 0.495398
R256 VDD.n30 VDD.n90 0.495398
R257 VDD.n7 VDD.n89 0.495398
R258 VDD.n36 VDD.n88 0.495398
R259 VDD.n32 VDD.n87 0.495398
R260 VDD.n8 VDD.n86 0.495398
R261 VDD.n48 VDD.n85 0.495398
R262 VDD.n12 VDD.n84 0.495398
R263 VDD.n38 VDD.n83 0.495398
R264 VDD.n28 VDD.n82 0.495398
R265 VDD.n6 VDD.n81 0.495398
R266 VDD.n40 VDD.n14 0.580993
R267 VDD.t0 VDD.n4 0.478641
R268 VDD.t0 VDD.n5 0.478641
R269 VDD.t0 VDD.n3 0.478641
R270 VDD.t0 VDD.n2 0.478641
R271 VDD.t0 VDD.n1 0.478641
R272 VDD.t0 VDD.n0 0.478641
R273 VDD.t0 VDD.n11 0.478641
R274 VDD.n25 VDD.n24 0.478641
R275 VDD.n51 VDD.n50 0.478641
R276 VDD.n23 VDD.n22 0.478641
R277 VDD.n43 VDD.n42 0.478641
R278 VDD.n18 VDD.n17 0.478641
R279 VDD.n18 VDD.n16 0.478641
R280 VDD.n47 VDD.n46 0.478641
R281 VDD.n35 VDD.n34 0.478641
R282 VDD.n21 VDD.n20 0.478641
R283 VDD.n21 VDD.n19 0.478641
R284 VDD.t0 VDD.n10 0.478641
R285 VDD.t0 VDD.n9 0.478641
R286 VDD.n45 VDD.n44 0.478641
R287 VDD.n31 VDD.n30 0.478641
R288 VDD.t0 VDD.n7 0.478641
R289 VDD.n37 VDD.n36 0.478641
R290 VDD.n33 VDD.n32 0.478641
R291 VDD.t0 VDD.n8 0.478641
R292 VDD.n49 VDD.n48 0.478641
R293 VDD.t0 VDD.n12 0.478641
R294 VDD.n39 VDD.n38 0.478641
R295 VDD.n29 VDD.n28 0.478641
R296 VDD.t0 VDD.n6 0.478641
R297 VDD.n41 VDD.n40 0.478641
R298 VDD.t0 VDD.t8 6.19118
R299 VDD.n92 VDD.n70 0.467341
R300 VDD.n97 VDD.n65 0.467341
R301 VDD.n83 VDD.n79 0.467341
R302 VDD.n82 VDD.n80 0.467205
R303 VDD.n93 VDD.n69 0.467205
R304 VDD.n109 VDD.n53 0.467143
R305 VDD.n105 VDD.n57 0.467143
R306 VDD.n98 VDD.n64 0.467143
R307 VDD.n110 VDD.n52 0.46682
R308 VDD.n99 VDD.n63 0.46682
R309 VDD.n106 VDD.n56 0.466801
R310 VDD.n85 VDD.n77 0.466798
R311 VDD.n96 VDD.n66 0.466761
R312 VDD.n103 VDD.n59 0.466741
R313 VDD.n107 VDD.n55 0.466717
R314 VDD.n101 VDD.n61 0.466699
R315 VDD.n104 VDD.n58 0.466677
R316 VDD.n108 VDD.n54 0.466614
R317 VDD.n84 VDD.n78 0.466552
R318 VDD.n90 VDD.n72 0.466523
R319 VDD.n91 VDD.n71 0.466483
R320 VDD.n94 VDD.n68 0.466439
R321 VDD.n89 VDD.n73 0.466439
R322 VDD.n81 VDD.n14 0.750406
R323 VDD.n86 VDD.n76 0.466288
R324 VDD.n87 VDD.n75 0.466257
R325 VDD.n100 VDD.n62 0.46623
R326 VDD.n102 VDD.n60 0.466103
R327 VDD.n88 VDD.n74 0.466025
R328 VDD.n95 VDD.n67 0.465933
R329 VDD.n94 VDD.n67 0.452033
R330 VDD.n87 VDD.n74 0.451904
R331 VDD.n101 VDD.n60 0.451788
R332 VDD.n86 VDD.n75 0.451693
R333 VDD.n99 VDD.n62 0.451673
R334 VDD.n85 VDD.n76 0.451656
R335 VDD.n93 VDD.n68 0.451469
R336 VDD.n88 VDD.n73 0.451469
R337 VDD.n90 VDD.n71 0.451417
R338 VDD.n89 VDD.n72 0.451359
R339 VDD.n83 VDD.n78 0.451353
R340 VDD.n103 VDD.n58 0.451265
R341 VDD.n107 VDD.n54 0.451263
R342 VDD.n100 VDD.n61 0.451252
R343 VDD.n106 VDD.n55 0.451206
R344 VDD.n95 VDD.n66 0.451204
R345 VDD.n102 VDD.n59 0.451193
R346 VDD.n109 VDD.n52 0.451146
R347 VDD.n98 VDD.n63 0.451146
R348 VDD.n84 VDD.n77 0.451129
R349 VDD.n105 VDD.n56 0.451113
R350 VDD.n108 VDD.n53 0.450828
R351 VDD.n104 VDD.n57 0.450828
R352 VDD.n97 VDD.n64 0.450828
R353 VDD.n92 VDD.n69 0.450779
R354 VDD.n81 VDD.n80 0.450779
R355 VDD.n96 VDD.n65 0.450618
R356 VDD.n91 VDD.n70 0.450618
R357 VDD.n82 VDD.n79 0.450618
R358 VDD.t6 VDD.n26 5.71158
R359 VDD.t0 VDD.t9 5.77017
R360 VDD.n26 VDD.t5 15.0661
R361 VDD.t0 VDD.n13 0.275831
R362 VDD.t0 VDD.n37 0.24014
R363 VDD.n23 VDD.n43 1.2374
R364 VDD.n15 VDD.n45 0.240164
R365 VDD.t0 VDD.n41 0.457466
R366 VDD.n18 VDD.n47 1.23731
R367 VDD.n25 VDD.n51 1.23729
R368 VDD.t0 VDD.n14 1.19236
R369 VDD.t0 VDD.n21 1.16562
R370 VDD.t0 VDD.n18 1.11852
R371 VDD.t0 VDD.n15 1.08201
R372 VDD.t0 VDD.n25 1.06357
R373 VDD.n43 VDD.n18 1.06199
R374 VDD.t0 VDD.n26 1.03492
R375 VDD.t0 VDD.n49 1.02944
R376 VDD.t0 VDD.n33 1.01764
R377 VSS.n78 VSS.t128 108.746
R378 VSS.n76 VSS.t123 108.746
R379 VSS.t122 VSS.n2 108.746
R380 VSS.t136 VSS.n3 108.746
R381 VSS.t135 VSS.n5 108.746
R382 VSS.t137 VSS.n7 108.746
R383 VSS.t138 VSS.n9 108.746
R384 VSS.n71 VSS.t140 108.746
R385 VSS.t127 VSS.n11 108.746
R386 VSS.t144 VSS.n12 108.746
R387 VSS.t143 VSS.n14 108.746
R388 VSS.n67 VSS.t125 108.746
R389 VSS.t142 VSS.n15 108.746
R390 VSS.t141 VSS.n17 108.746
R391 VSS.n63 VSS.t124 108.746
R392 VSS.t131 VSS.n19 108.746
R393 VSS.n58 VSS.t145 108.746
R394 VSS.n57 VSS.t146 108.746
R395 VSS.n80 VSS.t147 8.4756
R396 VSS.t148 VSS.n22 108.746
R397 VSS.t149 VSS.n84 8.4756
R398 VSS.t130 VSS.n25 108.746
R399 VSS.n77 VSS.t134 108.746
R400 VSS.n72 VSS.t129 108.746
R401 VSS.n64 VSS.t139 108.746
R402 VSS.n61 VSS.t133 108.746
R403 VSS.n56 VSS.t126 108.746
R404 VSS.n90 VSS.t150 8.4756
R405 VSS.n55 VSS.t151 108.746
R406 VSS.n52 VSS.t153 108.746
R407 VSS.n70 VSS.t3 106.056
R408 VSS.n68 VSS.t14 106.056
R409 VSS.n66 VSS.t67 106.056
R410 VSS.n65 VSS.t24 106.056
R411 VSS.n59 VSS.t168 106.056
R412 VSS.n91 VSS.t165 10.6843
R413 VSS.n54 VSS.t166 106.056
R414 VSS.n53 VSS.t169 106.056
R415 VSS.n79 VSS.t32 106.056
R416 VSS.t53 VSS.n0 106.056
R417 VSS.t0 VSS.n1 106.056
R418 VSS.n75 VSS.t167 106.056
R419 VSS.n74 VSS.t54 106.056
R420 VSS.t46 VSS.n4 106.056
R421 VSS.t49 VSS.n6 106.056
R422 VSS.t48 VSS.n8 106.056
R423 VSS.n73 VSS.t47 106.056
R424 VSS.t61 VSS.n10 106.056
R425 VSS.n69 VSS.t10 106.056
R426 VSS.t92 VSS.n13 106.056
R427 VSS.t35 VSS.n16 106.056
R428 VSS.t25 VSS.n18 106.056
R429 VSS.n62 VSS.t170 106.056
R430 VSS.n60 VSS.t173 106.056
R431 VSS.t155 VSS.n20 106.056
R432 VSS.n81 VSS.t114 10.6874
R433 VSS.t73 VSS.n21 106.056
R434 VSS.t70 VSS.n83 10.6843
R435 VSS.n85 VSS.t13 10.6837
R436 VSS.t160 VSS.n23 106.056
R437 VSS.t156 VSS.n24 106.056
R438 VSS.t97 VSS.t94 99.7536
R439 VSS.n139 VSS.t38 94.1709
R440 VSS.n142 VSS.t30 94.1709
R441 VSS.t17 VSS.n145 94.1709
R442 VSS.t36 VSS.n148 94.1709
R443 VSS.n151 VSS.t6 94.1709
R444 VSS.n154 VSS.t8 94.1709
R445 VSS.n157 VSS.t91 94.1709
R446 VSS.t115 VSS.n160 94.1709
R447 VSS.n163 VSS.t80 94.1709
R448 VSS.t79 VSS.n166 94.1709
R449 VSS.t78 VSS.n169 94.1709
R450 VSS.n172 VSS.t77 94.1709
R451 VSS.t76 VSS.n175 94.1709
R452 VSS.t106 VSS.n178 94.1709
R453 VSS.t113 VSS.n181 94.1709
R454 VSS.n184 VSS.t112 94.1709
R455 VSS.n187 VSS.t111 94.1709
R456 VSS.t116 VSS.n190 94.1709
R457 VSS.t109 VSS.n193 94.1709
R458 VSS.t108 VSS.n196 94.1709
R459 VSS.n199 VSS.t107 94.1709
R460 VSS.t118 VSS.n202 94.1709
R461 VSS.n82 VSS.t89 97.257
R462 VSS.n207 VSS.t82 94.1709
R463 VSS.n86 VSS.t68 49.8
R464 VSS.n87 VSS.t88 97.257
R465 VSS.n214 VSS.t86 94.1709
R466 VSS.t83 VSS.n89 97.257
R467 VSS.t81 VSS.n93 12.6433
R468 VSS.t52 VSS.n221 94.1709
R469 VSS.t120 VSS.n224 94.1709
R470 VSS.t157 VSS.n98 12.6712
R471 VSS.n77 VSS.t45 67.0429
R472 VSS.n72 VSS.t55 67.0429
R473 VSS.n64 VSS.t15 67.0429
R474 VSS.n61 VSS.t171 67.0429
R475 VSS.n56 VSS.t161 67.0429
R476 VSS.n55 VSS.t28 67.0429
R477 VSS.n52 VSS.t164 67.0429
R478 VSS.n78 VSS.t64 67.0426
R479 VSS.n76 VSS.t40 67.0426
R480 VSS.t44 VSS.n2 67.0426
R481 VSS.t43 VSS.n3 67.0426
R482 VSS.t90 VSS.n5 67.0426
R483 VSS.t59 VSS.n7 67.0426
R484 VSS.t57 VSS.n9 67.0426
R485 VSS.n71 VSS.t33 67.0426
R486 VSS.t1 VSS.n11 67.0426
R487 VSS.t62 VSS.n12 67.0426
R488 VSS.t50 VSS.n14 67.0426
R489 VSS.n67 VSS.t65 67.0426
R490 VSS.t4 VSS.n15 67.0426
R491 VSS.t22 VSS.n17 67.0426
R492 VSS.n63 VSS.t172 67.0426
R493 VSS.t41 VSS.n19 67.0426
R494 VSS.n58 VSS.t19 67.0426
R495 VSS.n57 VSS.t159 67.0426
R496 VSS.n80 VSS.n82 4.80622
R497 VSS.t71 VSS.n22 67.0426
R498 VSS.t68 VSS.n84 67.0836
R499 VSS.n87 VSS.t26 24.3376
R500 VSS.n89 VSS.t163 24.3376
R501 VSS.t162 VSS.n25 67.0426
R502 VSS.n97 VSS.t105 29.2317
R503 VSS.n97 VSS.t101 29.3548
R504 VSS.t64 VSS.n139 43.0498
R505 VSS.t45 VSS.n142 43.0498
R506 VSS.t40 VSS.n145 43.0498
R507 VSS.n148 VSS.t44 43.0498
R508 VSS.n151 VSS.t43 43.0498
R509 VSS.n154 VSS.t90 43.0498
R510 VSS.n157 VSS.t59 43.0498
R511 VSS.n160 VSS.t57 43.0498
R512 VSS.t55 VSS.n163 43.0498
R513 VSS.t33 VSS.n166 43.0498
R514 VSS.n169 VSS.t1 43.0498
R515 VSS.n172 VSS.t62 43.0498
R516 VSS.n175 VSS.t50 43.0498
R517 VSS.t65 VSS.n178 43.0498
R518 VSS.n181 VSS.t4 43.0498
R519 VSS.t15 VSS.n184 43.0498
R520 VSS.n187 VSS.t22 43.0498
R521 VSS.t172 VSS.n190 43.0498
R522 VSS.t171 VSS.n193 43.0498
R523 VSS.n196 VSS.t41 43.0498
R524 VSS.t19 VSS.n199 43.0498
R525 VSS.t159 VSS.n202 43.0498
R526 VSS.t74 VSS.n82 24.3376
R527 VSS.n207 VSS.t71 43.0498
R528 VSS.t161 VSS.n214 43.0498
R529 VSS.t11 VSS.n93 49.8
R530 VSS.t28 VSS.n221 43.0498
R531 VSS.n224 VSS.t162 43.0498
R532 VSS.t164 VSS.n98 49.7977
R533 VSS.n80 VSS.n134 17.0005
R534 VSS.n80 VSS.n94 2.32453
R535 VSS.n80 VSS.n228 17.0005
R536 VSS.n80 VSS.n98 1.14463
R537 VSS.t38 VSS.n0 15.9213
R538 VSS.t30 VSS.n1 15.9213
R539 VSS.n75 VSS.t17 15.9213
R540 VSS.n74 VSS.t36 15.9213
R541 VSS.t6 VSS.n4 15.9213
R542 VSS.t8 VSS.n6 15.9213
R543 VSS.t91 VSS.n8 15.9213
R544 VSS.n73 VSS.t115 15.9213
R545 VSS.t80 VSS.n10 15.9213
R546 VSS.n69 VSS.t78 15.9213
R547 VSS.t77 VSS.n13 15.9213
R548 VSS.t112 VSS.n16 15.9213
R549 VSS.t111 VSS.n18 15.9213
R550 VSS.n62 VSS.t116 15.9213
R551 VSS.n60 VSS.t109 15.9213
R552 VSS.t107 VSS.n20 15.9213
R553 VSS.t89 VSS.n21 15.9213
R554 VSS.n86 VSS.t85 12.6433
R555 VSS.t88 VSS.n23 15.9213
R556 VSS.t86 VSS.n24 15.9213
R557 VSS.n80 VSS.n93 1.14212
R558 VSS.n70 VSS.t79 15.9203
R559 VSS.n68 VSS.t76 15.9203
R560 VSS.n66 VSS.t106 15.9203
R561 VSS.n65 VSS.t113 15.9203
R562 VSS.n59 VSS.t108 15.9203
R563 VSS.n54 VSS.t52 15.9203
R564 VSS.n53 VSS.t120 15.9203
R565 VSS.n79 VSS.t97 13.2307
R566 VSS.t32 VSS.n34 11.8854
R567 VSS.n35 VSS.t53 11.8854
R568 VSS.n36 VSS.t0 11.8854
R569 VSS.t167 VSS.n37 11.8854
R570 VSS.t54 VSS.n33 11.8854
R571 VSS.n32 VSS.t46 11.8854
R572 VSS.n39 VSS.t48 11.8854
R573 VSS.n31 VSS.t61 11.8854
R574 VSS.t3 VSS.n41 11.8854
R575 VSS.t10 VSS.n30 11.8854
R576 VSS.n42 VSS.t92 11.8854
R577 VSS.t14 VSS.n43 11.8854
R578 VSS.t67 VSS.n29 11.8854
R579 VSS.t24 VSS.n44 11.8854
R580 VSS.n28 VSS.t35 11.8854
R581 VSS.t170 VSS.n27 11.8854
R582 VSS.t173 VSS.n46 11.8854
R583 VSS.t21 VSS.n92 10.6843
R584 VSS.t169 VSS.n26 11.8854
R585 VSS.n38 VSS.t49 11.8844
R586 VSS.t47 VSS.n40 11.8844
R587 VSS.n45 VSS.t25 11.8844
R588 VSS.t168 VSS.n47 11.8844
R589 VSS.n48 VSS.t155 11.8844
R590 VSS.n49 VSS.t73 11.8844
R591 VSS.n50 VSS.t160 11.8844
R592 VSS.t166 VSS.n51 11.8844
R593 VSS.n38 VSS.t137 9.19536
R594 VSS.t129 VSS.n40 9.19536
R595 VSS.t124 VSS.n45 9.19536
R596 VSS.t145 VSS.n47 9.19536
R597 VSS.t146 VSS.n48 9.19536
R598 VSS.n49 VSS.t148 9.19536
R599 VSS.t126 VSS.n50 9.19536
R600 VSS.t152 VSS.n88 8.47586
R601 VSS.n51 VSS.t130 9.19536
R602 VSS.t128 VSS.n34 9.19506
R603 VSS.t134 VSS.n35 9.19506
R604 VSS.t123 VSS.n36 9.19506
R605 VSS.n37 VSS.t122 9.19506
R606 VSS.n33 VSS.t136 9.19506
R607 VSS.n32 VSS.t135 9.19506
R608 VSS.n39 VSS.t138 9.19506
R609 VSS.t140 VSS.n31 9.19506
R610 VSS.n41 VSS.t127 9.19506
R611 VSS.n30 VSS.t144 9.19506
R612 VSS.n42 VSS.t143 9.19506
R613 VSS.t125 VSS.n43 9.19506
R614 VSS.n29 VSS.t142 9.19506
R615 VSS.t139 VSS.n44 9.19506
R616 VSS.n28 VSS.t141 9.19506
R617 VSS.t133 VSS.n27 9.19506
R618 VSS.n46 VSS.t131 9.19506
R619 VSS.n80 VSS.n81 0.00542901
R620 VSS.t132 VSS.n85 8.48466
R621 VSS.t151 VSS.n92 9.19999
R622 VSS.t153 VSS.n26 9.19506
R623 VSS.n97 VSS.n80 0.139321
R624 VSS.n80 VSS.n139 8.5005
R625 VSS.n80 VSS.n142 8.5005
R626 VSS.n80 VSS.n145 8.5005
R627 VSS.n80 VSS.n148 8.5005
R628 VSS.n80 VSS.n151 8.5005
R629 VSS.n80 VSS.n154 8.5005
R630 VSS.n80 VSS.n157 8.5005
R631 VSS.n80 VSS.n160 8.5005
R632 VSS.n80 VSS.n163 8.5005
R633 VSS.n80 VSS.n166 8.5005
R634 VSS.n80 VSS.n169 8.5005
R635 VSS.n80 VSS.n172 8.5005
R636 VSS.n80 VSS.n175 8.5005
R637 VSS.n80 VSS.n178 8.5005
R638 VSS.n80 VSS.n181 8.5005
R639 VSS.n80 VSS.n184 8.5005
R640 VSS.n80 VSS.n187 8.5005
R641 VSS.n80 VSS.n190 8.5005
R642 VSS.n80 VSS.n193 8.5005
R643 VSS.n80 VSS.n196 8.5005
R644 VSS.n80 VSS.n199 8.5005
R645 VSS.n80 VSS.n202 8.5005
R646 VSS.n80 VSS.n207 8.5005
R647 VSS.n80 VSS.n86 1.14212
R648 VSS.n80 VSS.n87 4.80622
R649 VSS.n80 VSS.n214 8.5005
R650 VSS.n80 VSS.n89 4.80622
R651 VSS.n80 VSS.n221 8.5005
R652 VSS.n80 VSS.n224 8.5005
R653 VSS.n80 VSS.n135 8.47732
R654 VSS.n80 VSS.t100 8.47732
R655 VSS.n80 VSS.n133 8.47732
R656 VSS.n80 VSS.n233 8.47732
R657 VSS.n80 VSS.n226 8.47732
R658 VSS.n96 VSS.t102 0.279322
R659 VSS.n80 VSS.t94 5.00033
R660 VSS VSS.n95 2.9705
R661 VSS.n80 VSS.n99 2.74446
R662 VSS.n80 VSS.n131 2.74446
R663 VSS.n80 VSS.n136 2.74446
R664 VSS.n80 VSS.t158 2.74394
R665 VSS.n80 VSS.n100 1.55465
R666 VSS.n80 VSS.n101 1.55465
R667 VSS.n80 VSS.n102 1.55465
R668 VSS.n80 VSS.n103 1.55465
R669 VSS.n80 VSS.n104 1.55465
R670 VSS.n80 VSS.n105 1.55465
R671 VSS.n80 VSS.n106 1.55465
R672 VSS.n80 VSS.n107 1.55465
R673 VSS.n80 VSS.n108 1.55465
R674 VSS.n80 VSS.n109 1.55465
R675 VSS.n80 VSS.n110 1.55465
R676 VSS.n80 VSS.n111 1.55465
R677 VSS.n80 VSS.n112 1.55465
R678 VSS.n80 VSS.n113 1.55465
R679 VSS.n80 VSS.n114 1.55465
R680 VSS.n80 VSS.n115 1.55465
R681 VSS.n80 VSS.n116 1.55465
R682 VSS.n80 VSS.n117 1.55465
R683 VSS.n80 VSS.n118 1.55465
R684 VSS.n80 VSS.n119 1.55465
R685 VSS.n80 VSS.n120 1.55465
R686 VSS.n80 VSS.n121 1.55465
R687 VSS.n80 VSS.n122 1.55465
R688 VSS.n80 VSS.n123 1.55465
R689 VSS.n80 VSS.n124 1.55465
R690 VSS.n80 VSS.n125 1.55465
R691 VSS.n80 VSS.n126 1.55465
R692 VSS.n80 VSS.n127 1.55465
R693 VSS.n80 VSS.n128 1.55465
R694 VSS.n80 VSS.n129 1.55465
R695 VSS.n80 VSS.n130 1.55465
R696 VSS.n80 VSS.n137 1.55388
R697 VSS.n80 VSS.n140 1.55388
R698 VSS.n80 VSS.n143 1.55388
R699 VSS.n80 VSS.n146 1.55388
R700 VSS.n80 VSS.n149 1.55388
R701 VSS.n80 VSS.n152 1.55388
R702 VSS.n80 VSS.n155 1.55388
R703 VSS.n80 VSS.n158 1.55388
R704 VSS.n80 VSS.n161 1.55388
R705 VSS.n80 VSS.n164 1.55388
R706 VSS.n80 VSS.n167 1.55388
R707 VSS.n80 VSS.n170 1.55388
R708 VSS.n80 VSS.n173 1.55388
R709 VSS.n80 VSS.n176 1.55388
R710 VSS.n80 VSS.n179 1.55388
R711 VSS.n80 VSS.n182 1.55388
R712 VSS.n80 VSS.n185 1.55388
R713 VSS.n80 VSS.n188 1.55388
R714 VSS.n80 VSS.n191 1.55388
R715 VSS.n80 VSS.n194 1.55388
R716 VSS.n80 VSS.n197 1.55388
R717 VSS.n80 VSS.n200 1.55388
R718 VSS.n80 VSS.n203 1.55388
R719 VSS.n80 VSS.n205 1.55388
R720 VSS.n80 VSS.n208 1.55388
R721 VSS.n80 VSS.n210 1.55388
R722 VSS.n80 VSS.n212 1.55388
R723 VSS.n80 VSS.n215 1.55388
R724 VSS.n80 VSS.n217 1.55388
R725 VSS.n80 VSS.n219 1.55388
R726 VSS.n80 VSS.n222 1.55388
R727 VSS.t93 VSS.t96 0.806856
R728 VSS.t31 VSS.n141 0.802775
R729 VSS.t18 VSS.n144 0.802775
R730 VSS.t37 VSS.n147 0.802775
R731 VSS.t7 VSS.n150 0.802775
R732 VSS.t9 VSS.n153 0.802775
R733 VSS.t60 VSS.n156 0.802775
R734 VSS.t58 VSS.n159 0.802775
R735 VSS.t56 VSS.n162 0.802775
R736 VSS.t34 VSS.n165 0.802775
R737 VSS.t2 VSS.n168 0.802775
R738 VSS.t63 VSS.n171 0.802775
R739 VSS.t51 VSS.n174 0.802775
R740 VSS.t66 VSS.n177 0.802775
R741 VSS.t5 VSS.n180 0.802775
R742 VSS.t16 VSS.n183 0.802775
R743 VSS.t23 VSS.n186 0.802775
R744 VSS.t117 VSS.n189 0.802775
R745 VSS.t110 VSS.n192 0.802775
R746 VSS.t42 VSS.n195 0.802775
R747 VSS.t20 VSS.n198 0.802775
R748 VSS.t119 VSS.n201 0.802775
R749 VSS.t75 VSS.n204 0.802775
R750 VSS.t72 VSS.n206 0.802775
R751 VSS.t69 VSS.n209 0.802775
R752 VSS.t27 VSS.n211 0.802775
R753 VSS.t87 VSS.n213 0.802775
R754 VSS.t84 VSS.n216 0.802775
R755 VSS.t12 VSS.n218 0.802775
R756 VSS.t29 VSS.n220 0.802775
R757 VSS.t121 VSS.n223 0.802775
R758 VSS.t154 VSS.n225 0.802775
R759 VSS.t103 VSS.n132 0.802775
R760 VSS.t39 VSS.n138 0.802775
R761 VSS.t102 VSS.n227 0.723599
R762 VSS.n232 VSS.t95 0.595317
R763 VSS.t99 VSS.n231 0.595317
R764 VSS.n222 VSS.t121 0.47671
R765 VSS.n219 VSS.t29 0.47671
R766 VSS.n217 VSS.t12 0.47671
R767 VSS.n215 VSS.t84 0.47671
R768 VSS.n212 VSS.t87 0.47671
R769 VSS.n210 VSS.t27 0.47671
R770 VSS.n208 VSS.t69 0.47671
R771 VSS.n205 VSS.t72 0.47671
R772 VSS.n203 VSS.t75 0.47671
R773 VSS.n200 VSS.t119 0.47671
R774 VSS.n197 VSS.t20 0.47671
R775 VSS.n194 VSS.t42 0.47671
R776 VSS.n191 VSS.t110 0.47671
R777 VSS.n188 VSS.t117 0.47671
R778 VSS.n185 VSS.t23 0.47671
R779 VSS.n182 VSS.t16 0.47671
R780 VSS.n179 VSS.t5 0.47671
R781 VSS.n176 VSS.t66 0.47671
R782 VSS.n173 VSS.t51 0.47671
R783 VSS.n170 VSS.t63 0.47671
R784 VSS.n167 VSS.t2 0.47671
R785 VSS.n164 VSS.t34 0.47671
R786 VSS.n161 VSS.t56 0.47671
R787 VSS.n158 VSS.t58 0.47671
R788 VSS.n155 VSS.t60 0.47671
R789 VSS.n152 VSS.t9 0.47671
R790 VSS.n149 VSS.t7 0.47671
R791 VSS.n146 VSS.t37 0.47671
R792 VSS.n143 VSS.t18 0.47671
R793 VSS.n140 VSS.t31 0.47671
R794 VSS.n137 VSS.t39 0.47671
R795 VSS.n138 VSS.n100 0.46466
R796 VSS.n141 VSS.n101 0.46466
R797 VSS.n144 VSS.n102 0.46466
R798 VSS.n147 VSS.n103 0.46466
R799 VSS.n150 VSS.n104 0.46466
R800 VSS.n153 VSS.n105 0.46466
R801 VSS.n156 VSS.n106 0.46466
R802 VSS.n159 VSS.n107 0.46466
R803 VSS.n162 VSS.n108 0.46466
R804 VSS.n165 VSS.n109 0.46466
R805 VSS.n168 VSS.n110 0.46466
R806 VSS.n171 VSS.n111 0.46466
R807 VSS.n174 VSS.n112 0.46466
R808 VSS.n177 VSS.n113 0.46466
R809 VSS.n180 VSS.n114 0.46466
R810 VSS.n183 VSS.n115 0.46466
R811 VSS.n186 VSS.n116 0.46466
R812 VSS.n189 VSS.n117 0.46466
R813 VSS.n192 VSS.n118 0.46466
R814 VSS.n195 VSS.n119 0.46466
R815 VSS.n198 VSS.n120 0.46466
R816 VSS.n201 VSS.n121 0.46466
R817 VSS.n204 VSS.n122 0.46466
R818 VSS.n206 VSS.n123 0.46466
R819 VSS.n209 VSS.n124 0.46466
R820 VSS.n211 VSS.n125 0.46466
R821 VSS.n213 VSS.n126 0.46466
R822 VSS.n216 VSS.n127 0.46466
R823 VSS.n218 VSS.n128 0.46466
R824 VSS.n220 VSS.n129 0.46466
R825 VSS.n223 VSS.n130 0.46466
R826 VSS.n141 VSS.n100 0.45349
R827 VSS.n144 VSS.n101 0.45349
R828 VSS.n147 VSS.n102 0.45349
R829 VSS.n150 VSS.n103 0.45349
R830 VSS.n153 VSS.n104 0.45349
R831 VSS.n156 VSS.n105 0.45349
R832 VSS.n159 VSS.n106 0.45349
R833 VSS.n162 VSS.n107 0.45349
R834 VSS.n165 VSS.n108 0.45349
R835 VSS.n168 VSS.n109 0.45349
R836 VSS.n171 VSS.n110 0.45349
R837 VSS.n174 VSS.n111 0.45349
R838 VSS.n177 VSS.n112 0.45349
R839 VSS.n180 VSS.n113 0.45349
R840 VSS.n183 VSS.n114 0.45349
R841 VSS.n186 VSS.n115 0.45349
R842 VSS.n189 VSS.n116 0.45349
R843 VSS.n192 VSS.n117 0.45349
R844 VSS.n195 VSS.n118 0.45349
R845 VSS.n198 VSS.n119 0.45349
R846 VSS.n201 VSS.n120 0.45349
R847 VSS.n204 VSS.n121 0.45349
R848 VSS.n206 VSS.n122 0.45349
R849 VSS.n209 VSS.n123 0.45349
R850 VSS.n211 VSS.n124 0.45349
R851 VSS.n213 VSS.n125 0.45349
R852 VSS.n216 VSS.n126 0.45349
R853 VSS.n218 VSS.n127 0.45349
R854 VSS.n220 VSS.n128 0.45349
R855 VSS.n223 VSS.n129 0.45349
R856 VSS.n225 VSS.n130 0.45349
R857 VSS.n137 VSS.t31 0.441374
R858 VSS.n140 VSS.t18 0.441374
R859 VSS.n143 VSS.t37 0.441374
R860 VSS.n146 VSS.t7 0.441374
R861 VSS.n149 VSS.t9 0.441374
R862 VSS.n152 VSS.t60 0.441374
R863 VSS.n155 VSS.t58 0.441374
R864 VSS.n158 VSS.t56 0.441374
R865 VSS.n161 VSS.t34 0.441374
R866 VSS.n164 VSS.t2 0.441374
R867 VSS.n167 VSS.t63 0.441374
R868 VSS.n170 VSS.t51 0.441374
R869 VSS.n173 VSS.t66 0.441374
R870 VSS.n176 VSS.t5 0.441374
R871 VSS.n179 VSS.t16 0.441374
R872 VSS.n182 VSS.t23 0.441374
R873 VSS.n185 VSS.t117 0.441374
R874 VSS.n188 VSS.t110 0.441374
R875 VSS.n191 VSS.t42 0.441374
R876 VSS.n194 VSS.t20 0.441374
R877 VSS.n197 VSS.t119 0.441374
R878 VSS.n200 VSS.t75 0.441374
R879 VSS.n203 VSS.t72 0.441374
R880 VSS.n205 VSS.t69 0.441374
R881 VSS.n208 VSS.t27 0.441374
R882 VSS.n210 VSS.t87 0.441374
R883 VSS.n212 VSS.t84 0.441374
R884 VSS.n215 VSS.t12 0.441374
R885 VSS.n217 VSS.t29 0.441374
R886 VSS.n219 VSS.t121 0.441374
R887 VSS.n222 VSS.t154 0.441374
R888 VSS.n94 VSS.t96 0.380071
R889 VSS.n95 VSS.n94 0.280466
R890 VSS.t158 VSS.t154 0.301976
R891 VSS.n225 VSS.n131 0.290049
R892 VSS.n138 VSS.n99 0.276768
R893 VSS.n230 VSS.n99 0.271299
R894 VSS.n231 VSS.n136 0.271299
R895 VSS.t39 VSS.n136 0.265518
R896 VSS.t104 VSS.n96 0.234216
R897 VSS.t158 VSS.t103 0.254814
R898 VSS.n132 VSS.n131 0.244268
R899 VSS.t95 VSS.t99 0.1875
R900 VSS.n96 VSS.n80 1.49547
R901 VSS.n132 VSS.t100 0.135868
R902 VSS.t103 VSS.n226 0.124618
R903 VSS.n227 VSS.t100 0.122118
R904 VSS.t102 VSS.n226 0.122118
R905 VSS.t93 VSS.n95 0.0955
R906 VSS.n80 VSS.n1 0.0884098
R907 VSS.t95 VSS.n229 0.0851154
R908 VSS.t99 VSS.n230 0.0851154
R909 VSS.n80 VSS.n92 0.0844657
R910 VSS.t104 VSS.n133 0.0771176
R911 VSS.n229 VSS.n135 0.0746176
R912 VSS.n233 VSS.n232 0.0746176
R913 VSS.n227 VSS.n133 0.0696176
R914 VSS.n229 VSS.n134 0.06925
R915 VSS.n232 VSS.n228 0.06925
R916 VSS.n230 VSS.n134 0.05925
R917 VSS.n231 VSS.n228 0.05925
R918 VSS.n135 VSS.t96 0.0546176
R919 VSS.n233 VSS.t93 0.0546176
R920 VSS.n80 VSS.n0 0.0485965
R921 VSS.n80 VSS.n77 0.0444724
R922 VSS.n80 VSS.n38 0.0444724
R923 VSS.n80 VSS.n40 0.0444724
R924 VSS.n80 VSS.n72 0.0444724
R925 VSS.n80 VSS.n70 0.0444724
R926 VSS.n80 VSS.n68 0.0444724
R927 VSS.n80 VSS.n66 0.0444724
R928 VSS.n80 VSS.n65 0.0444724
R929 VSS.n80 VSS.n64 0.0444724
R930 VSS.n80 VSS.n45 0.0444724
R931 VSS.n80 VSS.n61 0.0444724
R932 VSS.n80 VSS.n59 0.0444724
R933 VSS.n80 VSS.n47 0.0444724
R934 VSS.n80 VSS.n48 0.0444724
R935 VSS.n80 VSS.n49 0.0444724
R936 VSS.n80 VSS.n50 0.0444724
R937 VSS.n80 VSS.n56 0.0444724
R938 VSS.n88 VSS.t156 11.8883
R939 VSS.n91 VSS.t83 15.9603
R940 VSS.n90 VSS.t11 67.0839
R941 VSS.n80 VSS.n88 0.085484
R942 VSS.n91 VSS.n80 0.0493843
R943 VSS.n90 VSS.n80 0.0483817
R944 VSS.n80 VSS.n55 0.0444724
R945 VSS.n80 VSS.n54 0.0444724
R946 VSS.n80 VSS.n51 0.0444724
R947 VSS.n80 VSS.n53 0.0444724
R948 VSS.n80 VSS.n52 0.0444724
R949 VSS.n80 VSS.n2 0.0444549
R950 VSS.n80 VSS.n33 0.0444549
R951 VSS.n80 VSS.n3 0.0444549
R952 VSS.n80 VSS.n4 0.0444549
R953 VSS.n80 VSS.n32 0.0444549
R954 VSS.n80 VSS.n5 0.0444549
R955 VSS.n80 VSS.n6 0.0444549
R956 VSS.n80 VSS.n7 0.0444549
R957 VSS.n80 VSS.n8 0.0444549
R958 VSS.n80 VSS.n9 0.0444549
R959 VSS.n80 VSS.n10 0.0444549
R960 VSS.n80 VSS.n31 0.0444549
R961 VSS.n80 VSS.n11 0.0444549
R962 VSS.n80 VSS.n30 0.0444549
R963 VSS.n80 VSS.n12 0.0444549
R964 VSS.n80 VSS.n13 0.0444549
R965 VSS.n80 VSS.n14 0.0444549
R966 VSS.n80 VSS.n29 0.0444549
R967 VSS.n80 VSS.n15 0.0444549
R968 VSS.n80 VSS.n16 0.0444549
R969 VSS.n80 VSS.n28 0.0444549
R970 VSS.n80 VSS.n17 0.0444549
R971 VSS.n80 VSS.n18 0.0444549
R972 VSS.n80 VSS.n27 0.0444549
R973 VSS.n80 VSS.n19 0.0444549
R974 VSS.n80 VSS.n20 0.0444549
R975 VSS.n80 VSS.n21 0.0444549
R976 VSS.n80 VSS.n22 0.0444549
R977 VSS.n83 VSS.t82 15.9613
R978 VSS.n80 VSS.n85 0.0773482
R979 VSS.n80 VSS.n84 0.0483803
R980 VSS.n80 VSS.n83 0.0464408
R981 VSS.n80 VSS.n23 0.0444549
R982 VSS.n80 VSS.n24 0.0444549
R983 VSS.n80 VSS.n25 0.0444549
R984 VSS.n80 VSS.n26 0.0444549
R985 VSS.n80 VSS.n79 0.0444549
R986 VSS.n80 VSS.n34 0.0444549
R987 VSS.n80 VSS.n78 0.0444549
R988 VSS.n80 VSS.n35 0.0444549
R989 VSS.n80 VSS.n36 0.0444549
R990 VSS.n80 VSS.n76 0.0444549
R991 VSS.n80 VSS.n75 0.0444549
R992 VSS.n80 VSS.n37 0.0444549
R993 VSS.n80 VSS.n74 0.0444549
R994 VSS.n80 VSS.n39 0.0444549
R995 VSS.n80 VSS.n73 0.0444549
R996 VSS.n80 VSS.n71 0.0444549
R997 VSS.n80 VSS.n41 0.0444549
R998 VSS.n80 VSS.n69 0.0444549
R999 VSS.n80 VSS.n42 0.0444549
R1000 VSS.n80 VSS.n43 0.0444549
R1001 VSS.n80 VSS.n67 0.0444549
R1002 VSS.n80 VSS.n44 0.0444549
R1003 VSS.n80 VSS.n63 0.0444549
R1004 VSS.n80 VSS.n62 0.0444549
R1005 VSS.n80 VSS.n60 0.0444549
R1006 VSS.n80 VSS.n46 0.0444549
R1007 VSS.n80 VSS.n58 0.0444549
R1008 VSS.n80 VSS.n57 0.0444549
R1009 VSS.n81 VSS.t118 15.9613
C518 DELAY_VBIASN VSS 16.43641f
C519 DELAY_OUT_LAST VSS 0.40486f
C520 DELAY_OUT_TAP31 VSS 0.6437f
C521 DELAY_OUT_TAP30 VSS 0.6437f
C522 DELAY_OUT_TAP29 VSS 0.6437f
C523 DELAY_OUT_TAP28 VSS 0.6437f
C524 DELAY_OUT_TAP27 VSS 0.6437f
C525 DELAY_OUT_TAP26 VSS 0.6437f
C526 DELAY_OUT_TAP25 VSS 0.6437f
C527 DELAY_OUT_TAP24 VSS 0.6437f
C528 DELAY_OUT_TAP23 VSS 0.6437f
C529 DELAY_OUT_TAP22 VSS 0.6437f
C530 DELAY_OUT_TAP21 VSS 0.6437f
C531 DELAY_OUT_TAP20 VSS 0.6437f
C532 DELAY_OUT_TAP19 VSS 0.6437f
C533 DELAY_OUT_TAP18 VSS 0.6437f
C534 DELAY_OUT_TAP17 VSS 0.6437f
C535 DELAY_OUT_TAP16 VSS 0.6437f
C536 DELAY_OUT_TAP15 VSS 0.6437f
C537 DELAY_OUT_TAP14 VSS 0.6437f
C538 DELAY_OUT_TAP13 VSS 0.6437f
C539 DELAY_OUT_TAP12 VSS 0.6437f
C540 DELAY_OUT_TAP11 VSS 0.6437f
C541 DELAY_OUT_TAP10 VSS 0.6437f
C542 DELAY_OUT_TAP9 VSS 0.6437f
C543 DELAY_OUT_TAP8 VSS 0.6437f
C544 DELAY_OUT_TAP7 VSS 0.6437f
C545 DELAY_OUT_TAP6 VSS 0.6437f
C546 DELAY_OUT_TAP5 VSS 0.6437f
C547 DELAY_OUT_TAP4 VSS 0.6437f
C548 DELAY_OUT_TAP3 VSS 0.6437f
C549 DELAY_OUT_TAP2 VSS 0.6437f
C550 DELAY_OUT_TAP1 VSS 0.64371f
C551 DELAY_VBIASP VSS 4.15787f
C552 DELAY_IN VSS 0.57171f
C553 VDD VSS 20.97692f
C554 a_27411_1842# VSS 0.01336f ; **FLOATING
C555 a_26651_1842# VSS 0.01336f ; **FLOATING
C556 a_25891_1842# VSS 0.01336f ; **FLOATING
C557 a_25131_1842# VSS 0.01336f ; **FLOATING
C558 a_24371_1842# VSS 0.01336f ; **FLOATING
C559 a_23611_1842# VSS 0.01336f ; **FLOATING
C560 a_22851_1842# VSS 0.01336f ; **FLOATING
C561 a_22091_1842# VSS 0.01336f ; **FLOATING
C562 a_21331_1842# VSS 0.01336f ; **FLOATING
C563 a_20571_1842# VSS 0.01336f ; **FLOATING
C564 a_19811_1842# VSS 0.01336f ; **FLOATING
C565 a_19051_1842# VSS 0.01336f ; **FLOATING
C566 a_18291_1842# VSS 0.01336f ; **FLOATING
C567 a_17531_1842# VSS 0.01336f ; **FLOATING
C568 a_16771_1842# VSS 0.01336f ; **FLOATING
C569 a_16011_1842# VSS 0.01336f ; **FLOATING
C570 a_15251_1842# VSS 0.01336f ; **FLOATING
C571 a_14491_1842# VSS 0.01336f ; **FLOATING
C572 a_13731_1842# VSS 0.01336f ; **FLOATING
C573 a_12971_1842# VSS 0.01336f ; **FLOATING
C574 a_12211_1842# VSS 0.01336f ; **FLOATING
C575 a_11451_1842# VSS 0.01336f ; **FLOATING
C576 a_10691_1842# VSS 0.01336f ; **FLOATING
C577 a_9931_1842# VSS 0.01336f ; **FLOATING
C578 a_9171_1842# VSS 0.01336f ; **FLOATING
C579 a_8411_1842# VSS 0.01336f ; **FLOATING
C580 a_7651_1842# VSS 0.01336f ; **FLOATING
C581 a_6891_1842# VSS 0.01336f ; **FLOATING
C582 a_6131_1842# VSS 0.01336f ; **FLOATING
C583 a_5371_1842# VSS 0.01336f ; **FLOATING
C584 a_4611_1842# VSS 0.01336f ; **FLOATING
C585 a_3851_1842# VSS 0.0139f ; **FLOATING
C586 a_27303_1842# VSS 0.54306f ; **FLOATING
C587 a_27737_1842# VSS 0.67217f ; **FLOATING
C588 a_27173_1842# VSS 0.48844f ; **FLOATING
C589 a_26543_1842# VSS 0.54063f ; **FLOATING
C590 a_26413_1842# VSS 0.48844f ; **FLOATING
C591 a_25783_1842# VSS 0.54063f ; **FLOATING
C592 a_25653_1842# VSS 0.48844f ; **FLOATING
C593 a_25023_1842# VSS 0.54063f ; **FLOATING
C594 a_24893_1842# VSS 0.48844f ; **FLOATING
C595 a_24263_1842# VSS 0.54063f ; **FLOATING
C596 a_24133_1842# VSS 0.48844f ; **FLOATING
C597 a_23503_1842# VSS 0.54063f ; **FLOATING
C598 a_23373_1842# VSS 0.48844f ; **FLOATING
C599 a_22743_1842# VSS 0.54063f ; **FLOATING
C600 a_22613_1842# VSS 0.48844f ; **FLOATING
C601 a_21983_1842# VSS 0.54063f ; **FLOATING
C602 a_21853_1842# VSS 0.48844f ; **FLOATING
C603 a_21223_1842# VSS 0.54063f ; **FLOATING
C604 a_21093_1842# VSS 0.48844f ; **FLOATING
C605 a_20463_1842# VSS 0.54063f ; **FLOATING
C606 a_20333_1842# VSS 0.48844f ; **FLOATING
C607 a_19703_1842# VSS 0.54063f ; **FLOATING
C608 a_19573_1842# VSS 0.48844f ; **FLOATING
C609 a_18943_1842# VSS 0.54063f ; **FLOATING
C610 a_18813_1842# VSS 0.48844f ; **FLOATING
C611 a_18183_1842# VSS 0.54063f ; **FLOATING
C612 a_18053_1842# VSS 0.48844f ; **FLOATING
C613 a_17423_1842# VSS 0.54063f ; **FLOATING
C614 a_17293_1842# VSS 0.48844f ; **FLOATING
C615 a_16663_1842# VSS 0.54063f ; **FLOATING
C616 a_16533_1842# VSS 0.48844f ; **FLOATING
C617 a_15903_1842# VSS 0.54063f ; **FLOATING
C618 a_15773_1842# VSS 0.48844f ; **FLOATING
C619 a_15143_1842# VSS 0.54063f ; **FLOATING
C620 a_15013_1842# VSS 0.48844f ; **FLOATING
C621 a_14383_1842# VSS 0.54063f ; **FLOATING
C622 a_14253_1842# VSS 0.48844f ; **FLOATING
C623 a_13623_1842# VSS 0.54063f ; **FLOATING
C624 a_13493_1842# VSS 0.48844f ; **FLOATING
C625 a_12863_1842# VSS 0.54063f ; **FLOATING
C626 a_12733_1842# VSS 0.48844f ; **FLOATING
C627 a_12103_1842# VSS 0.54063f ; **FLOATING
C628 a_11973_1842# VSS 0.48844f ; **FLOATING
C629 a_11343_1842# VSS 0.54063f ; **FLOATING
C630 a_11213_1842# VSS 0.48844f ; **FLOATING
C631 a_10583_1842# VSS 0.54063f ; **FLOATING
C632 a_10453_1842# VSS 0.48844f ; **FLOATING
C633 a_9823_1842# VSS 0.54063f ; **FLOATING
C634 a_9693_1842# VSS 0.48844f ; **FLOATING
C635 a_9063_1842# VSS 0.54063f ; **FLOATING
C636 a_8933_1842# VSS 0.48844f ; **FLOATING
C637 a_8303_1842# VSS 0.54063f ; **FLOATING
C638 a_8173_1842# VSS 0.48844f ; **FLOATING
C639 a_7543_1842# VSS 0.54063f ; **FLOATING
C640 a_7413_1842# VSS 0.48844f ; **FLOATING
C641 a_6783_1842# VSS 0.54063f ; **FLOATING
C642 a_6653_1842# VSS 0.48844f ; **FLOATING
C643 a_6023_1842# VSS 0.54063f ; **FLOATING
C644 a_5893_1842# VSS 0.48844f ; **FLOATING
C645 a_5263_1842# VSS 0.54063f ; **FLOATING
C646 a_5133_1842# VSS 0.48844f ; **FLOATING
C647 a_4503_1842# VSS 0.54063f ; **FLOATING
C648 a_4373_1842# VSS 0.48844f ; **FLOATING
C649 a_3743_1842# VSS 0.61828f ; **FLOATING
C650 VDD.n0 VSS 0.02735f ; **FLOATING
C651 VDD.n1 VSS 0.02735f ; **FLOATING
C652 VDD.n2 VSS 0.02735f ; **FLOATING
C653 VDD.n3 VSS 0.02735f ; **FLOATING
C654 VDD.n4 VSS 0.02735f ; **FLOATING
C655 VDD.n5 VSS 0.02735f ; **FLOATING
C656 VDD.n6 VSS 0.02735f ; **FLOATING
C657 VDD.n7 VSS 0.02735f ; **FLOATING
C658 VDD.n8 VSS 0.02735f ; **FLOATING
C659 VDD.n9 VSS 0.02735f ; **FLOATING
C660 VDD.n10 VSS 0.02735f ; **FLOATING
C661 VDD.n11 VSS 0.02735f ; **FLOATING
C662 VDD.n12 VSS 0.02735f ; **FLOATING
C663 VDD.t0 VSS 54.4874f ; **FLOATING
C664 VDD.n14 VSS 0.13812f ; **FLOATING
C665 VDD.n16 VSS 0.02735f ; **FLOATING
C666 VDD.n17 VSS 0.02735f ; **FLOATING
C667 VDD.n18 VSS 0.42829f ; **FLOATING
C668 VDD.t9 VSS 0.04209f ; **FLOATING
C669 VDD.n19 VSS 0.02735f ; **FLOATING
C670 VDD.n20 VSS 0.02735f ; **FLOATING
C671 VDD.n21 VSS 0.42823f ; **FLOATING
C672 VDD.n22 VSS 0.02735f ; **FLOATING
C673 VDD.n23 VSS 0.21408f ; **FLOATING
C674 VDD.n24 VSS 0.02735f ; **FLOATING
C675 VDD.n25 VSS 0.21416f ; **FLOATING
C676 VDD.t8 VSS 0.03951f ; **FLOATING
C677 VDD.n26 VSS 1.05795f ; **FLOATING
C678 VDD.t4 VSS 0.04253f ; **FLOATING
C679 VDD.n28 VSS 0.02735f ; **FLOATING
C680 VDD.n29 VSS 0.2141f ; **FLOATING
C681 VDD.n30 VSS 0.02735f ; **FLOATING
C682 VDD.n31 VSS 0.2141f ; **FLOATING
C683 VDD.n32 VSS 0.02735f ; **FLOATING
C684 VDD.n33 VSS 0.21413f ; **FLOATING
C685 VDD.n34 VSS 0.02735f ; **FLOATING
C686 VDD.n35 VSS 0.21414f ; **FLOATING
C687 VDD.n36 VSS 0.02735f ; **FLOATING
C688 VDD.n37 VSS 0.21415f ; **FLOATING
C689 VDD.n38 VSS 0.02735f ; **FLOATING
C690 VDD.n39 VSS 0.21419f ; **FLOATING
C691 VDD.n40 VSS 0.04522f ; **FLOATING
C692 VDD.n41 VSS 0.21414f ; **FLOATING
C693 VDD.n42 VSS 0.02735f ; **FLOATING
C694 VDD.n43 VSS 0.21417f ; **FLOATING
C695 VDD.n44 VSS 0.02735f ; **FLOATING
C696 VDD.n45 VSS 0.21414f ; **FLOATING
C697 VDD.n46 VSS 0.02735f ; **FLOATING
C698 VDD.n47 VSS 0.21414f ; **FLOATING
C699 VDD.n48 VSS 0.02735f ; **FLOATING
C700 VDD.n49 VSS 0.2142f ; **FLOATING
C701 VDD.n50 VSS 0.02735f ; **FLOATING
C702 VDD.n51 VSS 0.21421f ; **FLOATING
C703 VDD.t5 VSS 0.02172f ; **FLOATING
C704 VDD.n52 VSS 0.05612f ; **FLOATING
C705 VDD.n53 VSS 0.05607f ; **FLOATING
C706 VDD.n54 VSS 0.05603f ; **FLOATING
C707 VDD.n55 VSS 0.0561f ; **FLOATING
C708 VDD.n56 VSS 0.05606f ; **FLOATING
C709 VDD.n57 VSS 0.05607f ; **FLOATING
C710 VDD.n58 VSS 0.05614f ; **FLOATING
C711 VDD.n59 VSS 0.05611f ; **FLOATING
C712 VDD.n60 VSS 0.056f ; **FLOATING
C713 VDD.n61 VSS 0.05614f ; **FLOATING
C714 VDD.n62 VSS 0.05601f ; **FLOATING
C715 VDD.n63 VSS 0.05612f ; **FLOATING
C716 VDD.n64 VSS 0.05607f ; **FLOATING
C717 VDD.n65 VSS 0.05598f ; **FLOATING
C718 VDD.n66 VSS 0.05614f ; **FLOATING
C719 VDD.n67 VSS 0.05612f ; **FLOATING
C720 VDD.n68 VSS 0.05609f ; **FLOATING
C721 VDD.n69 VSS 0.05608f ; **FLOATING
C722 VDD.n70 VSS 0.05598f ; **FLOATING
C723 VDD.n71 VSS 0.05608f ; **FLOATING
C724 VDD.n72 VSS 0.05604f ; **FLOATING
C725 VDD.n73 VSS 0.05609f ; **FLOATING
C726 VDD.n74 VSS 0.05608f ; **FLOATING
C727 VDD.n75 VSS 0.05614f ; **FLOATING
C728 VDD.n76 VSS 0.05607f ; **FLOATING
C729 VDD.n77 VSS 0.05606f ; **FLOATING
C730 VDD.n78 VSS 0.0561f ; **FLOATING
C731 VDD.n79 VSS 0.05598f ; **FLOATING
C732 VDD.n80 VSS 0.05608f ; **FLOATING
C733 VDD.t7 VSS 0.07737f ; **FLOATING
C734 VDD.t12 VSS 0.03688f ; **FLOATING
C735 VDD.t10 VSS 0.03564f ; **FLOATING
C736 VDD.t100 VSS 0.04326f ; **FLOATING
C737 VDD.t20 VSS 0.03766f ; **FLOATING
C738 VDD.t99 VSS 0.04326f ; **FLOATING
C739 VDD.t50 VSS 0.03688f ; **FLOATING
C740 VDD.t54 VSS 0.04326f ; **FLOATING
C741 VDD.t21 VSS 0.03688f ; **FLOATING
C742 VDD.n81 VSS 0.14246f ; **FLOATING
C743 VDD.t16 VSS 0.04326f ; **FLOATING
C744 VDD.t48 VSS 0.03688f ; **FLOATING
C745 VDD.n82 VSS 0.12124f ; **FLOATING
C746 VDD.t82 VSS 0.04326f ; **FLOATING
C747 VDD.t49 VSS 0.03688f ; **FLOATING
C748 VDD.n83 VSS 0.12119f ; **FLOATING
C749 VDD.t84 VSS 0.04326f ; **FLOATING
C750 VDD.t22 VSS 0.03688f ; **FLOATING
C751 VDD.n84 VSS 0.12119f ; **FLOATING
C752 VDD.t53 VSS 0.04326f ; **FLOATING
C753 VDD.t47 VSS 0.03688f ; **FLOATING
C754 VDD.n85 VSS 0.12117f ; **FLOATING
C755 VDD.t72 VSS 0.04326f ; **FLOATING
C756 VDD.t43 VSS 0.03688f ; **FLOATING
C757 VDD.n86 VSS 0.12114f ; **FLOATING
C758 VDD.t73 VSS 0.04326f ; **FLOATING
C759 VDD.t46 VSS 0.03688f ; **FLOATING
C760 VDD.n87 VSS 0.12114f ; **FLOATING
C761 VDD.t74 VSS 0.04326f ; **FLOATING
C762 VDD.t45 VSS 0.03688f ; **FLOATING
C763 VDD.n88 VSS 0.12119f ; **FLOATING
C764 VDD.t98 VSS 0.04326f ; **FLOATING
C765 VDD.t44 VSS 0.03688f ; **FLOATING
C766 VDD.n89 VSS 0.1212f ; **FLOATING
C767 VDD.t51 VSS 0.04326f ; **FLOATING
C768 VDD.t26 VSS 0.03688f ; **FLOATING
C769 VDD.n90 VSS 0.12119f ; **FLOATING
C770 VDD.t60 VSS 0.04326f ; **FLOATING
C771 VDD.t29 VSS 0.03688f ; **FLOATING
C772 VDD.n91 VSS 0.12126f ; **FLOATING
C773 VDD.t92 VSS 0.04326f ; **FLOATING
C774 VDD.t41 VSS 0.03688f ; **FLOATING
C775 VDD.n92 VSS 0.12122f ; **FLOATING
C776 VDD.t97 VSS 0.04326f ; **FLOATING
C777 VDD.t42 VSS 0.03688f ; **FLOATING
C778 VDD.n93 VSS 0.12114f ; **FLOATING
C779 VDD.t52 VSS 0.04326f ; **FLOATING
C780 VDD.t34 VSS 0.03688f ; **FLOATING
C781 VDD.n94 VSS 0.12112f ; **FLOATING
C782 VDD.t17 VSS 0.04326f ; **FLOATING
C783 VDD.t40 VSS 0.03688f ; **FLOATING
C784 VDD.n95 VSS 0.12116f ; **FLOATING
C785 VDD.t13 VSS 0.04326f ; **FLOATING
C786 VDD.t39 VSS 0.03688f ; **FLOATING
C787 VDD.n96 VSS 0.12122f ; **FLOATING
C788 VDD.t71 VSS 0.04326f ; **FLOATING
C789 VDD.t19 VSS 0.03688f ; **FLOATING
C790 VDD.n97 VSS 0.12122f ; **FLOATING
C791 VDD.t64 VSS 0.04326f ; **FLOATING
C792 VDD.t23 VSS 0.03688f ; **FLOATING
C793 VDD.n98 VSS 0.12114f ; **FLOATING
C794 VDD.t69 VSS 0.04326f ; **FLOATING
C795 VDD.t24 VSS 0.03688f ; **FLOATING
C796 VDD.n99 VSS 0.12117f ; **FLOATING
C797 VDD.t1 VSS 0.04326f ; **FLOATING
C798 VDD.t25 VSS 0.03688f ; **FLOATING
C799 VDD.n100 VSS 0.1212f ; **FLOATING
C800 VDD.t56 VSS 0.04326f ; **FLOATING
C801 VDD.t31 VSS 0.03688f ; **FLOATING
C802 VDD.n101 VSS 0.12117f ; **FLOATING
C803 VDD.t66 VSS 0.04326f ; **FLOATING
C804 VDD.t32 VSS 0.03688f ; **FLOATING
C805 VDD.n102 VSS 0.12122f ; **FLOATING
C806 VDD.t67 VSS 0.04326f ; **FLOATING
C807 VDD.t38 VSS 0.03688f ; **FLOATING
C808 VDD.n103 VSS 0.12113f ; **FLOATING
C809 VDD.t68 VSS 0.04326f ; **FLOATING
C810 VDD.t37 VSS 0.03688f ; **FLOATING
C811 VDD.n104 VSS 0.12117f ; **FLOATING
C812 VDD.t15 VSS 0.04326f ; **FLOATING
C813 VDD.t36 VSS 0.03688f ; **FLOATING
C814 VDD.n105 VSS 0.12117f ; **FLOATING
C815 VDD.t14 VSS 0.04326f ; **FLOATING
C816 VDD.t28 VSS 0.03688f ; **FLOATING
C817 VDD.n106 VSS 0.12118f ; **FLOATING
C818 VDD.t57 VSS 0.04326f ; **FLOATING
C819 VDD.t33 VSS 0.03688f ; **FLOATING
C820 VDD.n107 VSS 0.12119f ; **FLOATING
C821 VDD.t18 VSS 0.04326f ; **FLOATING
C822 VDD.t35 VSS 0.03688f ; **FLOATING
C823 VDD.n108 VSS 0.12122f ; **FLOATING
C824 VDD.t55 VSS 0.04326f ; **FLOATING
C825 VDD.t27 VSS 0.03688f ; **FLOATING
C826 VDD.n109 VSS 0.12114f ; **FLOATING
C827 VDD.t58 VSS 0.04326f ; **FLOATING
C828 VDD.t30 VSS 0.03688f ; **FLOATING
C829 VDD.n110 VSS 0.10392f ; **FLOATING
C830 VDD.t6 VSS 0.0373f ; **FLOATING
C831 VDD.t3 VSS 0.03688f ; **FLOATING
C832 VDD.t2 VSS 0.02663f ; **FLOATING
C833 DELAY_VBIASP.n0 VSS 0.14347f ; **FLOATING
C834 DELAY_VBIASP.t31 VSS 0.36739f ; **FLOATING
C835 DELAY_VBIASP.t30 VSS 0.35917f ; **FLOATING
C836 DELAY_VBIASP.n1 VSS 0.64365f ; **FLOATING
C837 DELAY_VBIASP.t29 VSS 0.35917f ; **FLOATING
C838 DELAY_VBIASP.n2 VSS 0.44541f ; **FLOATING
C839 DELAY_VBIASP.t28 VSS 0.35917f ; **FLOATING
C840 DELAY_VBIASP.n3 VSS 0.44541f ; **FLOATING
C841 DELAY_VBIASP.t27 VSS 0.35917f ; **FLOATING
C842 DELAY_VBIASP.n4 VSS 0.44541f ; **FLOATING
C843 DELAY_VBIASP.t26 VSS 0.35917f ; **FLOATING
C844 DELAY_VBIASP.n5 VSS 0.44541f ; **FLOATING
C845 DELAY_VBIASP.t25 VSS 0.35917f ; **FLOATING
C846 DELAY_VBIASP.n6 VSS 0.44541f ; **FLOATING
C847 DELAY_VBIASP.t24 VSS 0.35917f ; **FLOATING
C848 DELAY_VBIASP.n7 VSS 0.44541f ; **FLOATING
C849 DELAY_VBIASP.t23 VSS 0.35917f ; **FLOATING
C850 DELAY_VBIASP.n8 VSS 0.44541f ; **FLOATING
C851 DELAY_VBIASP.t22 VSS 0.35917f ; **FLOATING
C852 DELAY_VBIASP.n9 VSS 0.44541f ; **FLOATING
C853 DELAY_VBIASP.t21 VSS 0.35917f ; **FLOATING
C854 DELAY_VBIASP.n10 VSS 0.44541f ; **FLOATING
C855 DELAY_VBIASP.t20 VSS 0.35917f ; **FLOATING
C856 DELAY_VBIASP.n11 VSS 0.44541f ; **FLOATING
C857 DELAY_VBIASP.t19 VSS 0.35917f ; **FLOATING
C858 DELAY_VBIASP.n12 VSS 0.44541f ; **FLOATING
C859 DELAY_VBIASP.t18 VSS 0.35917f ; **FLOATING
C860 DELAY_VBIASP.n13 VSS 0.44541f ; **FLOATING
C861 DELAY_VBIASP.t17 VSS 0.35917f ; **FLOATING
C862 DELAY_VBIASP.n14 VSS 0.44541f ; **FLOATING
C863 DELAY_VBIASP.t16 VSS 0.35917f ; **FLOATING
C864 DELAY_VBIASP.n15 VSS 0.44541f ; **FLOATING
C865 DELAY_VBIASP.t15 VSS 0.35917f ; **FLOATING
C866 DELAY_VBIASP.n16 VSS 0.44541f ; **FLOATING
C867 DELAY_VBIASP.t14 VSS 0.35917f ; **FLOATING
C868 DELAY_VBIASP.n17 VSS 0.44541f ; **FLOATING
C869 DELAY_VBIASP.t13 VSS 0.35917f ; **FLOATING
C870 DELAY_VBIASP.n18 VSS 0.44541f ; **FLOATING
C871 DELAY_VBIASP.t12 VSS 0.35917f ; **FLOATING
C872 DELAY_VBIASP.n19 VSS 0.44541f ; **FLOATING
C873 DELAY_VBIASP.t11 VSS 0.35917f ; **FLOATING
C874 DELAY_VBIASP.n20 VSS 0.44541f ; **FLOATING
C875 DELAY_VBIASP.t10 VSS 0.35917f ; **FLOATING
C876 DELAY_VBIASP.n21 VSS 0.44541f ; **FLOATING
C877 DELAY_VBIASP.t9 VSS 0.35917f ; **FLOATING
C878 DELAY_VBIASP.n22 VSS 0.44541f ; **FLOATING
C879 DELAY_VBIASP.t8 VSS 0.35917f ; **FLOATING
C880 DELAY_VBIASP.n23 VSS 0.44541f ; **FLOATING
C881 DELAY_VBIASP.t7 VSS 0.35917f ; **FLOATING
C882 DELAY_VBIASP.n24 VSS 0.44541f ; **FLOATING
C883 DELAY_VBIASP.t6 VSS 0.35917f ; **FLOATING
C884 DELAY_VBIASP.n25 VSS 0.44541f ; **FLOATING
C885 DELAY_VBIASP.t5 VSS 0.35917f ; **FLOATING
C886 DELAY_VBIASP.n26 VSS 0.44541f ; **FLOATING
C887 DELAY_VBIASP.t4 VSS 0.35917f ; **FLOATING
C888 DELAY_VBIASP.n27 VSS 0.44541f ; **FLOATING
C889 DELAY_VBIASP.t3 VSS 0.35917f ; **FLOATING
C890 DELAY_VBIASP.n28 VSS 0.44541f ; **FLOATING
C891 DELAY_VBIASP.t2 VSS 0.35917f ; **FLOATING
C892 DELAY_VBIASP.n29 VSS 0.44541f ; **FLOATING
C893 DELAY_VBIASP.t1 VSS 0.35917f ; **FLOATING
C894 DELAY_VBIASP.n30 VSS 0.44541f ; **FLOATING
C895 DELAY_VBIASP.t0 VSS 0.35917f ; **FLOATING
C896 DELAY_VBIASN.n0 VSS 0.25441f ; **FLOATING
C897 DELAY_VBIASN.t31 VSS 0.15177f ; **FLOATING
C898 DELAY_VBIASN.t30 VSS 0.14732f ; **FLOATING
C899 DELAY_VBIASN.n1 VSS 0.34864f ; **FLOATING
C900 DELAY_VBIASN.t29 VSS 0.14732f ; **FLOATING
C901 DELAY_VBIASN.n2 VSS 0.24183f ; **FLOATING
C902 DELAY_VBIASN.t28 VSS 0.14732f ; **FLOATING
C903 DELAY_VBIASN.n3 VSS 0.24183f ; **FLOATING
C904 DELAY_VBIASN.t27 VSS 0.14732f ; **FLOATING
C905 DELAY_VBIASN.n4 VSS 0.24183f ; **FLOATING
C906 DELAY_VBIASN.t26 VSS 0.14732f ; **FLOATING
C907 DELAY_VBIASN.n5 VSS 0.24183f ; **FLOATING
C908 DELAY_VBIASN.t25 VSS 0.14732f ; **FLOATING
C909 DELAY_VBIASN.n6 VSS 0.24183f ; **FLOATING
C910 DELAY_VBIASN.t24 VSS 0.14732f ; **FLOATING
C911 DELAY_VBIASN.n7 VSS 0.24183f ; **FLOATING
C912 DELAY_VBIASN.t23 VSS 0.14732f ; **FLOATING
C913 DELAY_VBIASN.n8 VSS 0.24183f ; **FLOATING
C914 DELAY_VBIASN.t22 VSS 0.14732f ; **FLOATING
C915 DELAY_VBIASN.n9 VSS 0.24183f ; **FLOATING
C916 DELAY_VBIASN.t21 VSS 0.14732f ; **FLOATING
C917 DELAY_VBIASN.n10 VSS 0.24183f ; **FLOATING
C918 DELAY_VBIASN.t20 VSS 0.14732f ; **FLOATING
C919 DELAY_VBIASN.n11 VSS 0.24183f ; **FLOATING
C920 DELAY_VBIASN.t19 VSS 0.14732f ; **FLOATING
C921 DELAY_VBIASN.n12 VSS 0.24183f ; **FLOATING
C922 DELAY_VBIASN.t18 VSS 0.14732f ; **FLOATING
C923 DELAY_VBIASN.n13 VSS 0.24183f ; **FLOATING
C924 DELAY_VBIASN.t17 VSS 0.14732f ; **FLOATING
C925 DELAY_VBIASN.n14 VSS 0.24183f ; **FLOATING
C926 DELAY_VBIASN.t16 VSS 0.14732f ; **FLOATING
C927 DELAY_VBIASN.n15 VSS 0.24183f ; **FLOATING
C928 DELAY_VBIASN.t15 VSS 0.14732f ; **FLOATING
C929 DELAY_VBIASN.n16 VSS 0.24183f ; **FLOATING
C930 DELAY_VBIASN.t14 VSS 0.14732f ; **FLOATING
C931 DELAY_VBIASN.n17 VSS 0.24183f ; **FLOATING
C932 DELAY_VBIASN.t13 VSS 0.14732f ; **FLOATING
C933 DELAY_VBIASN.n18 VSS 0.24183f ; **FLOATING
C934 DELAY_VBIASN.t12 VSS 0.14732f ; **FLOATING
C935 DELAY_VBIASN.n19 VSS 0.24183f ; **FLOATING
C936 DELAY_VBIASN.t11 VSS 0.14732f ; **FLOATING
C937 DELAY_VBIASN.n20 VSS 0.24183f ; **FLOATING
C938 DELAY_VBIASN.t10 VSS 0.14732f ; **FLOATING
C939 DELAY_VBIASN.n21 VSS 0.24183f ; **FLOATING
C940 DELAY_VBIASN.t9 VSS 0.14732f ; **FLOATING
C941 DELAY_VBIASN.n22 VSS 0.24183f ; **FLOATING
C942 DELAY_VBIASN.t8 VSS 0.14732f ; **FLOATING
C943 DELAY_VBIASN.n23 VSS 0.24183f ; **FLOATING
C944 DELAY_VBIASN.t7 VSS 0.14732f ; **FLOATING
C945 DELAY_VBIASN.n24 VSS 0.24183f ; **FLOATING
C946 DELAY_VBIASN.t6 VSS 0.14732f ; **FLOATING
C947 DELAY_VBIASN.n25 VSS 0.24183f ; **FLOATING
C948 DELAY_VBIASN.t5 VSS 0.14732f ; **FLOATING
C949 DELAY_VBIASN.n26 VSS 0.24183f ; **FLOATING
C950 DELAY_VBIASN.t4 VSS 0.14732f ; **FLOATING
C951 DELAY_VBIASN.n27 VSS 0.24183f ; **FLOATING
C952 DELAY_VBIASN.t3 VSS 0.14732f ; **FLOATING
C953 DELAY_VBIASN.n28 VSS 0.24183f ; **FLOATING
C954 DELAY_VBIASN.t2 VSS 0.14732f ; **FLOATING
C955 DELAY_VBIASN.n29 VSS 0.24183f ; **FLOATING
C956 DELAY_VBIASN.t1 VSS 0.14732f ; **FLOATING
C957 DELAY_VBIASN.n30 VSS 0.24183f ; **FLOATING
C958 DELAY_VBIASN.t0 VSS 0.14732f ; **FLOATING
.ends
