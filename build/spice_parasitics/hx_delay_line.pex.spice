* NGSPICE file created from hx_delay_line.ext - technology: ihp-sg13g2

.subckt hx_delay_line DELAY_IN DELAY_OUT_LAST DELAY_OUT_TAP1 DELAY_OUT_TAP2 DELAY_OUT_TAP3
+ DELAY_OUT_TAP4 DELAY_OUT_TAP5 DELAY_OUT_TAP6 DELAY_OUT_TAP7 DELAY_OUT_TAP8 DELAY_OUT_TAP9
+ DELAY_OUT_TAP10 DELAY_OUT_TAP11 DELAY_OUT_TAP12 DELAY_OUT_TAP13 DELAY_OUT_TAP14
+ DELAY_OUT_TAP15 DELAY_OUT_TAP16 DELAY_OUT_TAP17 DELAY_OUT_TAP18 DELAY_OUT_TAP19
+ DELAY_OUT_TAP20 DELAY_OUT_TAP21 DELAY_OUT_TAP22 DELAY_OUT_TAP23 DELAY_OUT_TAP24
+ DELAY_OUT_TAP25 DELAY_OUT_TAP26 DELAY_OUT_TAP27 DELAY_OUT_TAP28 DELAY_OUT_TAP29
+ DELAY_OUT_TAP30 DELAY_OUT_TAP31 VDD VSS DELAY_VBIASN DELAY_VBIASP
X0 VDD.t9 a_4003_1842# DELAY_OUT_TAP1 VDD.t0 sg13_lv_pmos ad=0.2128p pd=1.5u as=0.3808p ps=2.92u w=1.12u l=0.13u
X1 a_10951_2470# a_10713_1842# a_10843_1842# VDD.t0 sg13_lv_pmos ad=0.2128p pd=1.5u as=0.3808p ps=2.92u w=1.12u l=0.2u
X2 a_25153_1842# DELAY_OUT_TAP28 VSS.t75 VSS.t136 sg13_lv_nmos ad=0.2516p pd=2.16u as=0.1406p ps=1.12u w=0.74u l=0.13u
X3 VDD.t42 DELAY_VBIASP.t11 a_19311_2470# VDD.t0 sg13_lv_pmos ad=0.3808p pd=2.92u as=0.2128p ps=1.5u w=1.12u l=0.6u
X4 VDD.t16 DELAY_VBIASP.t24 a_9431_2470# VDD.t0 sg13_lv_pmos ad=0.3808p pd=2.92u as=0.2128p ps=1.5u w=1.12u l=0.6u
X5 VDD.t45 DELAY_VBIASP.t6 a_23111_2470# VDD.t0 sg13_lv_pmos ad=0.3808p pd=2.92u as=0.2128p ps=1.5u w=1.12u l=0.6u
X6 a_17791_1842# a_17553_1842# a_17683_1842# VSS.t83 sg13_lv_nmos ad=0.1406p pd=1.12u as=0.2516p ps=2.16u w=0.74u l=0.2u
X7 a_6153_1842# DELAY_OUT_TAP3 VSS.t15 VSS.t92 sg13_lv_nmos ad=0.2516p pd=2.16u as=0.1406p ps=1.12u w=0.74u l=0.13u
X8 a_21591_1842# a_21353_1842# a_21483_1842# VSS.t65 sg13_lv_nmos ad=0.1406p pd=1.12u as=0.2516p ps=2.16u w=0.74u l=0.2u
X9 VSS.t5 a_16163_1842# DELAY_OUT_TAP17 VSS.t4 sg13_lv_nmos ad=0.1406p pd=1.12u as=0.2516p ps=2.16u w=0.74u l=0.13u
X10 VDD.t11 a_11603_1842# DELAY_OUT_TAP11 VDD.t0 sg13_lv_pmos ad=0.2128p pd=1.5u as=0.3808p ps=2.92u w=1.12u l=0.13u
X11 VDD.t38 DELAY_VBIASP.t17 a_14751_2470# VDD.t0 sg13_lv_pmos ad=0.3808p pd=2.92u as=0.2128p ps=1.5u w=1.12u l=0.6u
X12 a_24393_1842# DELAY_OUT_TAP27 VDD.t30 VDD.t0 sg13_lv_pmos ad=0.3808p pd=2.92u as=0.2128p ps=1.5u w=1.12u l=0.13u
X13 VSS.t175 DELAY_VBIASN.t23 a_10191_1842# VSS.t174 sg13_lv_nmos ad=0.2516p pd=2.16u as=0.1406p ps=1.12u w=0.74u l=0.6u
X14 VDD.t9 DELAY_VBIASP.t31 a_4111_2470# VDD.t0 sg13_lv_pmos ad=0.3808p pd=2.92u as=0.2128p ps=1.5u w=1.12u l=0.6u
X15 VSS.t71 a_19963_1842# DELAY_OUT_TAP22 VSS.t70 sg13_lv_nmos ad=0.1406p pd=1.12u as=0.2516p ps=2.16u w=0.74u l=0.13u
X16 a_17031_2470# a_16793_1842# a_16923_1842# VDD.t0 sg13_lv_pmos ad=0.2128p pd=1.5u as=0.3808p ps=2.92u w=1.12u l=0.2u
X17 a_11473_1842# DELAY_OUT_TAP10 VSS.t73 VSS.t100 sg13_lv_nmos ad=0.2516p pd=2.16u as=0.1406p ps=1.12u w=0.74u l=0.13u
X18 a_5393_1842# DELAY_OUT_TAP2 VDD.t9 VDD.t0 sg13_lv_pmos ad=0.3808p pd=2.92u as=0.2128p ps=1.5u w=1.12u l=0.13u
X19 VDD.t41 DELAY_VBIASP.t14 a_17031_2470# VDD.t0 sg13_lv_pmos ad=0.3808p pd=2.92u as=0.2128p ps=1.5u w=1.12u l=0.6u
X20 a_20831_2470# a_20593_1842# a_20723_1842# VDD.t0 sg13_lv_pmos ad=0.2128p pd=1.5u as=0.3808p ps=2.92u w=1.12u l=0.2u
X21 VDD.t3 a_26803_1842# DELAY_OUT_TAP31 VDD.t0 sg13_lv_pmos ad=0.2128p pd=1.5u as=0.3808p ps=2.92u w=1.12u l=0.13u
X22 VSS.t201 DELAY_VBIASN.t3 a_25391_1842# VSS.t200 sg13_lv_nmos ad=0.2516p pd=2.16u as=0.1406p ps=1.12u w=0.74u l=0.6u
X23 a_19311_2470# a_19073_1842# a_19203_1842# VDD.t0 sg13_lv_pmos ad=0.2128p pd=1.5u as=0.3808p ps=2.92u w=1.12u l=0.2u
X24 a_10713_1842# DELAY_OUT_TAP9 VDD.t31 VDD.t0 sg13_lv_pmos ad=0.3808p pd=2.92u as=0.2128p ps=1.5u w=1.12u l=0.13u
X25 VDD.t12 a_17683_1842# DELAY_OUT_TAP19 VDD.t0 sg13_lv_pmos ad=0.2128p pd=1.5u as=0.3808p ps=2.92u w=1.12u l=0.13u
X26 a_23111_2470# a_22873_1842# a_23003_1842# VDD.t0 sg13_lv_pmos ad=0.2128p pd=1.5u as=0.3808p ps=2.92u w=1.12u l=0.2u
X27 VDD.t14 a_7803_1842# DELAY_OUT_TAP6 VDD.t0 sg13_lv_pmos ad=0.2128p pd=1.5u as=0.3808p ps=2.92u w=1.12u l=0.13u
X28 a_26673_1842# DELAY_OUT_TAP30 VSS.t127 VSS.t138 sg13_lv_nmos ad=0.2516p pd=2.16u as=0.1406p ps=1.12u w=0.74u l=0.13u
X29 VSS.t169 DELAY_VBIASN.t28 a_6391_1842# VSS.t168 sg13_lv_nmos ad=0.2516p pd=2.16u as=0.1406p ps=1.12u w=0.74u l=0.6u
X30 VSS.t193 DELAY_VBIASN.t9 a_20831_1842# VSS.t192 sg13_lv_nmos ad=0.2516p pd=2.16u as=0.1406p ps=1.12u w=0.74u l=0.6u
X31 a_14751_2470# a_14513_1842# a_14643_1842# VDD.t0 sg13_lv_pmos ad=0.2128p pd=1.5u as=0.3808p ps=2.92u w=1.12u l=0.2u
X32 a_10191_1842# a_9953_1842# a_10083_1842# VSS.t30 sg13_lv_nmos ad=0.1406p pd=1.12u as=0.2516p ps=2.16u w=0.74u l=0.2u
X33 VDD.t9 VDD.t9 VDD.t9 VDD.t0 sg13_lv_pmos ad=0.2128p pd=1.5u as=0 ps=0 w=1.12u l=0.13u
X34 a_4111_2470# DELAY_IN a_4003_1842# VDD.t0 sg13_lv_pmos ad=0.2128p pd=1.5u as=0.3808p ps=2.92u w=1.12u l=0.2u
X35 VDD.t4 a_13123_1842# DELAY_OUT_TAP13 VDD.t0 sg13_lv_pmos ad=0.2128p pd=1.5u as=0.3808p ps=2.92u w=1.12u l=0.13u
X36 a_25913_1842# DELAY_OUT_TAP29 VDD.t21 VDD.t0 sg13_lv_pmos ad=0.3808p pd=2.92u as=0.2128p ps=1.5u w=1.12u l=0.13u
X37 a_7673_1842# DELAY_OUT_TAP5 VSS.t46 VSS.t90 sg13_lv_nmos ad=0.2516p pd=2.16u as=0.1406p ps=1.12u w=0.74u l=0.13u
X38 VSS.t54 a_21483_1842# DELAY_OUT_TAP24 VSS.t53 sg13_lv_nmos ad=0.1406p pd=1.12u as=0.2516p ps=2.16u w=0.74u l=0.13u
X39 VSS.t161 DELAY_VBIASN.t21 a_11711_1842# VSS.t160 sg13_lv_nmos ad=0.2516p pd=2.16u as=0.1406p ps=1.12u w=0.74u l=0.6u
X40 a_25391_1842# a_25153_1842# a_25283_1842# VSS.t20 sg13_lv_nmos ad=0.1406p pd=1.12u as=0.2516p ps=2.16u w=0.74u l=0.2u
X41 a_12993_1842# DELAY_OUT_TAP12 VSS.t17 VSS.t98 sg13_lv_nmos ad=0.2516p pd=2.16u as=0.1406p ps=1.12u w=0.74u l=0.13u
X42 a_6913_1842# DELAY_OUT_TAP4 VDD.t24 VDD.t0 sg13_lv_pmos ad=0.3808p pd=2.92u as=0.2128p ps=1.5u w=1.12u l=0.13u
X43 VDD.t43 DELAY_VBIASP.t12 a_18551_2470# VDD.t0 sg13_lv_pmos ad=0.3808p pd=2.92u as=0.2128p ps=1.5u w=1.12u l=0.6u
X44 DELAY_OUT_LAST a_27997_1842# VDD.t29 VDD.t0 sg13_lv_pmos ad=0.3808p pd=2.92u as=0.2128p ps=1.5u w=1.12u l=0.13u
X45 VSS.t85 a_23763_1842# DELAY_OUT_TAP27 VSS.t84 sg13_lv_nmos ad=0.1406p pd=1.12u as=0.2516p ps=2.16u w=0.74u l=0.13u
X46 VSS.t155 DELAY_VBIASN.t18 a_13991_1842# VSS.t154 sg13_lv_nmos ad=0.2516p pd=2.16u as=0.1406p ps=1.12u w=0.74u l=0.6u
X47 VDD.t59 DELAY_VBIASP.t7 a_22351_2470# VDD.t0 sg13_lv_pmos ad=0.3808p pd=2.92u as=0.2128p ps=1.5u w=1.12u l=0.6u
X48 VSS.t205 DELAY_VBIASN.t1 a_26911_1842# VSS.t204 sg13_lv_nmos ad=0.2516p pd=2.16u as=0.1406p ps=1.12u w=0.74u l=0.6u
X49 a_9193_1842# DELAY_OUT_TAP7 VDD.t16 VDD.t0 sg13_lv_pmos ad=0.3808p pd=2.92u as=0.2128p ps=1.5u w=1.12u l=0.13u
X50 a_19833_1842# DELAY_OUT_TAP21 VDD.t5 VDD.t0 sg13_lv_pmos ad=0.3808p pd=2.92u as=0.2128p ps=1.5u w=1.12u l=0.13u
X51 a_24631_2470# a_24393_1842# a_24523_1842# VDD.t0 sg13_lv_pmos ad=0.2128p pd=1.5u as=0.3808p ps=2.92u w=1.12u l=0.2u
X52 a_6391_1842# a_6153_1842# a_6283_1842# VSS.t55 sg13_lv_nmos ad=0.1406p pd=1.12u as=0.2516p ps=2.16u w=0.74u l=0.2u
X53 a_15273_1842# DELAY_OUT_TAP15 VSS.t64 VSS.t134 sg13_lv_nmos ad=0.2516p pd=2.16u as=0.1406p ps=1.12u w=0.74u l=0.13u
X54 VDD.t16 a_9323_1842# DELAY_OUT_TAP8 VDD.t0 sg13_lv_pmos ad=0.2128p pd=1.5u as=0.3808p ps=2.92u w=1.12u l=0.13u
X55 a_23633_1842# DELAY_OUT_TAP26 VDD.t28 VDD.t0 sg13_lv_pmos ad=0.3808p pd=2.92u as=0.2128p ps=1.5u w=1.12u l=0.13u
X56 VSS.t24 a_4763_1842# DELAY_OUT_TAP2 VSS.t23 sg13_lv_nmos ad=0.1406p pd=1.12u as=0.2516p ps=2.16u w=0.74u l=0.13u
X57 VSS.t43 a_15403_1842# DELAY_OUT_TAP16 VSS.t42 sg13_lv_nmos ad=0.1406p pd=1.12u as=0.2516p ps=2.16u w=0.74u l=0.13u
X58 VSS.t167 DELAY_VBIASN.t26 a_7911_1842# VSS.t166 sg13_lv_nmos ad=0.2516p pd=2.16u as=0.1406p ps=1.12u w=0.74u l=0.6u
X59 a_11711_1842# a_11473_1842# a_11603_1842# VSS.t81 sg13_lv_nmos ad=0.1406p pd=1.12u as=0.2516p ps=2.16u w=0.74u l=0.2u
X60 a_5631_2470# a_5393_1842# a_5523_1842# VDD.t0 sg13_lv_pmos ad=0.2128p pd=1.5u as=0.3808p ps=2.92u w=1.12u l=0.2u
X61 a_14513_1842# DELAY_OUT_TAP14 VDD.t15 VDD.t0 sg13_lv_pmos ad=0.3808p pd=2.92u as=0.2128p ps=1.5u w=1.12u l=0.13u
X62 a_4633_1842# DELAY_OUT_TAP1 VDD.t9 VDD.t0 sg13_lv_pmos ad=0.3808p pd=2.92u as=0.2128p ps=1.5u w=1.12u l=0.13u
X63 VSS.t89 a_10083_1842# DELAY_OUT_TAP9 VSS.t88 sg13_lv_nmos ad=0.1406p pd=1.12u as=0.2516p ps=2.16u w=0.74u l=0.13u
X64 VSS.t197 DELAY_VBIASN.t4 a_24631_1842# VSS.t196 sg13_lv_nmos ad=0.2516p pd=2.16u as=0.1406p ps=1.12u w=0.74u l=0.6u
X65 a_18551_2470# a_18313_1842# a_18443_1842# VDD.t0 sg13_lv_pmos ad=0.2128p pd=1.5u as=0.3808p ps=2.92u w=1.12u l=0.2u
X66 VDD.t1 a_16923_1842# DELAY_OUT_TAP18 VDD.t0 sg13_lv_pmos ad=0.2128p pd=1.5u as=0.3808p ps=2.92u w=1.12u l=0.13u
X67 a_22351_2470# a_22113_1842# a_22243_1842# VDD.t0 sg13_lv_pmos ad=0.2128p pd=1.5u as=0.3808p ps=2.92u w=1.12u l=0.2u
X68 VSS.t110 VSS.t107 VSS.t109 VSS.t108 sg13_lv_nmos ad=0.2516p pd=2.16u as=0 ps=0 w=0.74u l=0.13u
X69 a_26911_1842# a_26673_1842# a_26803_1842# VSS.t125 sg13_lv_nmos ad=0.1406p pd=1.12u as=0.2516p ps=2.16u w=0.74u l=0.2u
X70 VDD.t56 DELAY_VBIASP.t22 a_10951_2470# VDD.t0 sg13_lv_pmos ad=0.3808p pd=2.92u as=0.2128p ps=1.5u w=1.12u l=0.6u
X71 VSS.t151 DELAY_VBIASN.t16 a_15511_1842# VSS.t150 sg13_lv_nmos ad=0.2516p pd=2.16u as=0.1406p ps=1.12u w=0.74u l=0.6u
X72 VDD.t19 a_20723_1842# DELAY_OUT_TAP23 VDD.t0 sg13_lv_pmos ad=0.2128p pd=1.5u as=0.3808p ps=2.92u w=1.12u l=0.13u
X73 VSS.t145 DELAY_VBIASN.t29 a_5631_1842# VSS.t144 sg13_lv_nmos ad=0.2516p pd=2.16u as=0.1406p ps=1.12u w=0.74u l=0.6u
X74 VSS.t59 a_25283_1842# DELAY_OUT_TAP29 VSS.t58 sg13_lv_nmos ad=0.1406p pd=1.12u as=0.2516p ps=2.16u w=0.74u l=0.13u
X75 a_13231_2470# a_12993_1842# a_13123_1842# VDD.t0 sg13_lv_pmos ad=0.2128p pd=1.5u as=0.3808p ps=2.92u w=1.12u l=0.2u
X76 VDD.t68 DELAY_VBIASP.t5 a_23871_2470# VDD.t0 sg13_lv_pmos ad=0.3808p pd=2.92u as=0.2128p ps=1.5u w=1.12u l=0.6u
X77 a_12233_1842# DELAY_OUT_TAP11 VDD.t11 VDD.t0 sg13_lv_pmos ad=0.3808p pd=2.92u as=0.2128p ps=1.5u w=1.12u l=0.13u
X78 a_7911_1842# a_7673_1842# a_7803_1842# VSS.t87 sg13_lv_nmos ad=0.1406p pd=1.12u as=0.2516p ps=2.16u w=0.74u l=0.2u
X79 a_16793_1842# DELAY_OUT_TAP17 VSS.t5 VSS.t129 sg13_lv_nmos ad=0.2516p pd=2.16u as=0.1406p ps=1.12u w=0.74u l=0.13u
X80 VSS.t67 a_6283_1842# DELAY_OUT_TAP4 VSS.t66 sg13_lv_nmos ad=0.1406p pd=1.12u as=0.2516p ps=2.16u w=0.74u l=0.13u
X81 VSS.t79 a_27563_1842# a_27997_1842# VSS.t78 sg13_lv_nmos ad=0.1406p pd=1.12u as=0.2516p ps=2.16u w=0.74u l=0.13u
X82 a_20593_1842# DELAY_OUT_TAP22 VSS.t71 VSS.t135 sg13_lv_nmos ad=0.2516p pd=2.16u as=0.1406p ps=1.12u w=0.74u l=0.13u
X83 VDD.t9 DELAY_VBIASP.t30 a_4871_2470# VDD.t0 sg13_lv_pmos ad=0.3808p pd=2.92u as=0.2128p ps=1.5u w=1.12u l=0.6u
X84 VDD.t65 DELAY_VBIASP.t2 a_26151_2470# VDD.t0 sg13_lv_pmos ad=0.3808p pd=2.92u as=0.2128p ps=1.5u w=1.12u l=0.6u
X85 a_19073_1842# DELAY_OUT_TAP20 VSS.t19 VSS.t106 sg13_lv_nmos ad=0.2516p pd=2.16u as=0.1406p ps=1.12u w=0.74u l=0.13u
X86 VDD.t88 VDD.t86 VDD.t87 VDD.t0 sg13_lv_pmos ad=0.3808p pd=2.92u as=0 ps=0 w=1.12u l=0.6u
X87 VSS.t12 a_19203_1842# DELAY_OUT_TAP21 VSS.t11 sg13_lv_nmos ad=0.1406p pd=1.12u as=0.2516p ps=2.16u w=0.74u l=0.13u
X88 a_27433_1842# DELAY_OUT_TAP31 VDD.t3 VDD.t0 sg13_lv_pmos ad=0.3808p pd=2.92u as=0.2128p ps=1.5u w=1.12u l=0.13u
X89 VSS.t62 a_8563_1842# DELAY_OUT_TAP7 VSS.t61 sg13_lv_nmos ad=0.1406p pd=1.12u as=0.2516p ps=2.16u w=0.74u l=0.13u
X90 VSS.t77 a_23003_1842# DELAY_OUT_TAP26 VSS.t76 sg13_lv_nmos ad=0.1406p pd=1.12u as=0.2516p ps=2.16u w=0.74u l=0.13u
X91 VSS.t157 DELAY_VBIASN.t19 a_13231_1842# VSS.t156 sg13_lv_nmos ad=0.2516p pd=2.16u as=0.1406p ps=1.12u w=0.74u l=0.6u
X92 VDD.t18 DELAY_VBIASP.t27 a_7151_2470# VDD.t0 sg13_lv_pmos ad=0.3808p pd=2.92u as=0.2128p ps=1.5u w=1.12u l=0.6u
X93 a_15511_1842# a_15273_1842# a_15403_1842# VSS.t52 sg13_lv_nmos ad=0.1406p pd=1.12u as=0.2516p ps=2.16u w=0.74u l=0.2u
X94 a_9431_2470# a_9193_1842# a_9323_1842# VDD.t0 sg13_lv_pmos ad=0.2128p pd=1.5u as=0.3808p ps=2.92u w=1.12u l=0.2u
X95 a_18313_1842# DELAY_OUT_TAP19 VDD.t12 VDD.t0 sg13_lv_pmos ad=0.3808p pd=2.92u as=0.2128p ps=1.5u w=1.12u l=0.13u
X96 a_23871_2470# a_23633_1842# a_23763_1842# VDD.t0 sg13_lv_pmos ad=0.2128p pd=1.5u as=0.3808p ps=2.92u w=1.12u l=0.2u
X97 VSS.t38 a_13883_1842# DELAY_OUT_TAP14 VSS.t37 sg13_lv_nmos ad=0.1406p pd=1.12u as=0.2516p ps=2.16u w=0.74u l=0.13u
X98 a_8433_1842# DELAY_OUT_TAP6 VDD.t14 VDD.t0 sg13_lv_pmos ad=0.3808p pd=2.92u as=0.2128p ps=1.5u w=1.12u l=0.13u
X99 VDD.t39 DELAY_VBIASP.t20 a_12471_2470# VDD.t0 sg13_lv_pmos ad=0.3808p pd=2.92u as=0.2128p ps=1.5u w=1.12u l=0.6u
X100 VDD.t8 a_18443_1842# DELAY_OUT_TAP20 VDD.t0 sg13_lv_pmos ad=0.2128p pd=1.5u as=0.3808p ps=2.92u w=1.12u l=0.13u
X101 a_22113_1842# DELAY_OUT_TAP24 VDD.t20 VDD.t0 sg13_lv_pmos ad=0.3808p pd=2.92u as=0.2128p ps=1.5u w=1.12u l=0.13u
X102 VSS.t22 a_4003_1842# DELAY_OUT_TAP1 VSS.t21 sg13_lv_nmos ad=0.1406p pd=1.12u as=0.2516p ps=2.16u w=0.74u l=0.13u
X103 VDD.t13 a_22243_1842# DELAY_OUT_TAP25 VDD.t0 sg13_lv_pmos ad=0.2128p pd=1.5u as=0.3808p ps=2.92u w=1.12u l=0.13u
X104 a_4871_2470# a_4633_1842# a_4763_1842# VDD.t0 sg13_lv_pmos ad=0.2128p pd=1.5u as=0.3808p ps=2.92u w=1.12u l=0.2u
X105 a_13753_1842# DELAY_OUT_TAP13 VDD.t4 VDD.t0 sg13_lv_pmos ad=0.3808p pd=2.92u as=0.2128p ps=1.5u w=1.12u l=0.13u
X106 a_26151_2470# a_25913_1842# a_26043_1842# VDD.t0 sg13_lv_pmos ad=0.2128p pd=1.5u as=0.3808p ps=2.92u w=1.12u l=0.2u
X107 a_10951_1842# a_10713_1842# a_10843_1842# VSS.t68 sg13_lv_nmos ad=0.1406p pd=1.12u as=0.2516p ps=2.16u w=0.74u l=0.2u
X108 VDD.t27 a_24523_1842# DELAY_OUT_TAP28 VDD.t0 sg13_lv_pmos ad=0.2128p pd=1.5u as=0.3808p ps=2.92u w=1.12u l=0.13u
X109 VSS.t181 DELAY_VBIASN.t11 a_19311_1842# VSS.t180 sg13_lv_nmos ad=0.2516p pd=2.16u as=0.1406p ps=1.12u w=0.74u l=0.6u
X110 VDD.t63 DELAY_VBIASP.t0 a_27671_2470# VDD.t0 sg13_lv_pmos ad=0.3808p pd=2.92u as=0.2128p ps=1.5u w=1.12u l=0.6u
X111 VSS.t177 DELAY_VBIASN.t24 a_9431_1842# VSS.t176 sg13_lv_nmos ad=0.2516p pd=2.16u as=0.1406p ps=1.12u w=0.74u l=0.6u
X112 VSS.t195 DELAY_VBIASN.t6 a_23111_1842# VSS.t194 sg13_lv_nmos ad=0.2516p pd=2.16u as=0.1406p ps=1.12u w=0.74u l=0.6u
X113 a_7151_2470# a_6913_1842# a_7043_1842# VDD.t0 sg13_lv_pmos ad=0.2128p pd=1.5u as=0.3808p ps=2.92u w=1.12u l=0.2u
X114 a_16033_1842# DELAY_OUT_TAP16 VDD.t17 VDD.t0 sg13_lv_pmos ad=0.3808p pd=2.92u as=0.2128p ps=1.5u w=1.12u l=0.13u
X115 VSS.t26 a_11603_1842# DELAY_OUT_TAP11 VSS.t25 sg13_lv_nmos ad=0.1406p pd=1.12u as=0.2516p ps=2.16u w=0.74u l=0.13u
X116 VDD.t6 a_5523_1842# DELAY_OUT_TAP3 VDD.t0 sg13_lv_pmos ad=0.2128p pd=1.5u as=0.3808p ps=2.92u w=1.12u l=0.13u
X117 a_24393_1842# DELAY_OUT_TAP27 VSS.t85 VSS.t139 sg13_lv_nmos ad=0.2516p pd=2.16u as=0.1406p ps=1.12u w=0.74u l=0.13u
X118 VSS.t153 DELAY_VBIASN.t17 a_14751_1842# VSS.t152 sg13_lv_nmos ad=0.2516p pd=2.16u as=0.1406p ps=1.12u w=0.74u l=0.6u
X119 VDD.t16 DELAY_VBIASP.t25 a_8671_2470# VDD.t0 sg13_lv_pmos ad=0.3808p pd=2.92u as=0.2128p ps=1.5u w=1.12u l=0.6u
X120 VSS.t163 DELAY_VBIASN.t31 a_4111_1842# VSS.t162 sg13_lv_nmos ad=0.2516p pd=2.16u as=0.1406p ps=1.12u w=0.74u l=0.6u
X121 a_12471_2470# a_12233_1842# a_12363_1842# VDD.t0 sg13_lv_pmos ad=0.2128p pd=1.5u as=0.3808p ps=2.92u w=1.12u l=0.2u
X122 a_17031_1842# a_16793_1842# a_16923_1842# VSS.t69 sg13_lv_nmos ad=0.1406p pd=1.12u as=0.2516p ps=2.16u w=0.74u l=0.2u
X123 a_20831_1842# a_20593_1842# a_20723_1842# VSS.t39 sg13_lv_nmos ad=0.1406p pd=1.12u as=0.2516p ps=2.16u w=0.74u l=0.2u
X124 a_9953_1842# DELAY_OUT_TAP8 VDD.t16 VDD.t0 sg13_lv_pmos ad=0.3808p pd=2.92u as=0.2128p ps=1.5u w=1.12u l=0.13u
X125 VDD.t26 a_10843_1842# DELAY_OUT_TAP10 VDD.t0 sg13_lv_pmos ad=0.2128p pd=1.5u as=0.3808p ps=2.92u w=1.12u l=0.13u
X126 a_5393_1842# DELAY_OUT_TAP2 VSS.t24 VSS.t93 sg13_lv_nmos ad=0.2516p pd=2.16u as=0.1406p ps=1.12u w=0.74u l=0.13u
X127 VSS.t8 a_26803_1842# DELAY_OUT_TAP31 VSS.t7 sg13_lv_nmos ad=0.1406p pd=1.12u as=0.2516p ps=2.16u w=0.74u l=0.13u
X128 VSS.t179 DELAY_VBIASN.t14 a_17031_1842# VSS.t178 sg13_lv_nmos ad=0.2516p pd=2.16u as=0.1406p ps=1.12u w=0.74u l=0.6u
X129 a_19311_1842# a_19073_1842# a_19203_1842# VSS.t57 sg13_lv_nmos ad=0.1406p pd=1.12u as=0.2516p ps=2.16u w=0.74u l=0.2u
X130 a_27671_2470# a_27433_1842# a_27563_1842# VDD.t0 sg13_lv_pmos ad=0.2128p pd=1.5u as=0.3808p ps=2.92u w=1.12u l=0.2u
X131 a_23111_1842# a_22873_1842# a_23003_1842# VSS.t13 sg13_lv_nmos ad=0.1406p pd=1.12u as=0.2516p ps=2.16u w=0.74u l=0.2u
X132 VSS.t28 a_17683_1842# DELAY_OUT_TAP19 VSS.t27 sg13_lv_nmos ad=0.1406p pd=1.12u as=0.2516p ps=2.16u w=0.74u l=0.13u
X133 a_10713_1842# DELAY_OUT_TAP9 VSS.t89 VSS.t101 sg13_lv_nmos ad=0.2516p pd=2.16u as=0.1406p ps=1.12u w=0.74u l=0.13u
X134 VDD.t52 DELAY_VBIASP.t15 a_16271_2470# VDD.t0 sg13_lv_pmos ad=0.3808p pd=2.92u as=0.2128p ps=1.5u w=1.12u l=0.6u
X135 VSS.t36 a_7803_1842# DELAY_OUT_TAP6 VSS.t35 sg13_lv_nmos ad=0.1406p pd=1.12u as=0.2516p ps=2.16u w=0.74u l=0.13u
X136 VDD.t61 DELAY_VBIASP.t10 a_20071_2470# VDD.t0 sg13_lv_pmos ad=0.3808p pd=2.92u as=0.2128p ps=1.5u w=1.12u l=0.6u
X137 VDD.t92 a_26043_1842# DELAY_OUT_TAP30 VDD.t0 sg13_lv_pmos ad=0.2128p pd=1.5u as=0.3808p ps=2.92u w=1.12u l=0.13u
X138 VSS.t113 VSS.t109 VSS.t109 VSS.t111 sg13_lv_nmos ad=0.1406p pd=1.12u as=0 ps=0 w=0.74u l=0.13u
X139 a_14751_1842# a_14513_1842# a_14643_1842# VSS.t48 sg13_lv_nmos ad=0.1406p pd=1.12u as=0.2516p ps=2.16u w=0.74u l=0.2u
X140 a_8671_2470# a_8433_1842# a_8563_1842# VDD.t0 sg13_lv_pmos ad=0.2128p pd=1.5u as=0.3808p ps=2.92u w=1.12u l=0.2u
X141 a_17553_1842# DELAY_OUT_TAP18 VDD.t1 VDD.t0 sg13_lv_pmos ad=0.3808p pd=2.92u as=0.2128p ps=1.5u w=1.12u l=0.13u
X142 a_4111_1842# DELAY_IN a_4003_1842# VSS.t95 sg13_lv_nmos ad=0.1406p pd=1.12u as=0.2516p ps=2.16u w=0.74u l=0.2u
X143 VDD.t18 a_7043_1842# DELAY_OUT_TAP5 VDD.t0 sg13_lv_pmos ad=0.2128p pd=1.5u as=0.3808p ps=2.92u w=1.12u l=0.13u
X144 a_21353_1842# DELAY_OUT_TAP23 VDD.t19 VDD.t0 sg13_lv_pmos ad=0.3808p pd=2.92u as=0.2128p ps=1.5u w=1.12u l=0.13u
X145 a_25913_1842# DELAY_OUT_TAP29 VSS.t59 VSS.t130 sg13_lv_nmos ad=0.2516p pd=2.16u as=0.1406p ps=1.12u w=0.74u l=0.13u
X146 VSS.t10 a_13123_1842# DELAY_OUT_TAP13 VSS.t9 sg13_lv_nmos ad=0.1406p pd=1.12u as=0.2516p ps=2.16u w=0.74u l=0.13u
X147 a_13991_2470# a_13753_1842# a_13883_1842# VDD.t0 sg13_lv_pmos ad=0.2128p pd=1.5u as=0.3808p ps=2.92u w=1.12u l=0.2u
X148 DELAY_OUT_LAST a_27997_1842# VSS.t79 VSS.t124 sg13_lv_nmos ad=0.2516p pd=2.16u as=0.1406p ps=1.12u w=0.74u l=0.13u
X149 VDD.t7 a_12363_1842# DELAY_OUT_TAP12 VDD.t0 sg13_lv_pmos ad=0.2128p pd=1.5u as=0.3808p ps=2.92u w=1.12u l=0.13u
X150 a_6913_1842# DELAY_OUT_TAP4 VSS.t67 VSS.t91 sg13_lv_nmos ad=0.2516p pd=2.16u as=0.1406p ps=1.12u w=0.74u l=0.13u
X151 VSS.t183 DELAY_VBIASN.t12 a_18551_1842# VSS.t182 sg13_lv_nmos ad=0.2516p pd=2.16u as=0.1406p ps=1.12u w=0.74u l=0.6u
X152 VSS.t187 DELAY_VBIASN.t7 a_22351_1842# VSS.t186 sg13_lv_nmos ad=0.2516p pd=2.16u as=0.1406p ps=1.12u w=0.74u l=0.6u
X153 a_16271_2470# a_16033_1842# a_16163_1842# VDD.t0 sg13_lv_pmos ad=0.2128p pd=1.5u as=0.3808p ps=2.92u w=1.12u l=0.2u
X154 VDD.t23 a_14643_1842# DELAY_OUT_TAP15 VDD.t0 sg13_lv_pmos ad=0.2128p pd=1.5u as=0.3808p ps=2.92u w=1.12u l=0.13u
X155 a_20071_2470# a_19833_1842# a_19963_1842# VDD.t0 sg13_lv_pmos ad=0.2128p pd=1.5u as=0.3808p ps=2.92u w=1.12u l=0.2u
X156 a_9193_1842# DELAY_OUT_TAP7 VSS.t62 VSS.t103 sg13_lv_nmos ad=0.2516p pd=2.16u as=0.1406p ps=1.12u w=0.74u l=0.13u
X157 a_24631_1842# a_24393_1842# a_24523_1842# VSS.t122 sg13_lv_nmos ad=0.1406p pd=1.12u as=0.2516p ps=2.16u w=0.74u l=0.2u
X158 a_19833_1842# DELAY_OUT_TAP21 VSS.t12 VSS.t105 sg13_lv_nmos ad=0.2516p pd=2.16u as=0.1406p ps=1.12u w=0.74u l=0.13u
X159 VDD.t44 DELAY_VBIASP.t13 a_17791_2470# VDD.t0 sg13_lv_pmos ad=0.3808p pd=2.92u as=0.2128p ps=1.5u w=1.12u l=0.6u
X160 VSS.t41 a_9323_1842# DELAY_OUT_TAP8 VSS.t40 sg13_lv_nmos ad=0.1406p pd=1.12u as=0.2516p ps=2.16u w=0.74u l=0.13u
X161 a_23633_1842# DELAY_OUT_TAP26 VSS.t77 VSS.t133 sg13_lv_nmos ad=0.2516p pd=2.16u as=0.1406p ps=1.12u w=0.74u l=0.13u
X162 VDD.t60 DELAY_VBIASP.t8 a_21591_2470# VDD.t0 sg13_lv_pmos ad=0.3808p pd=2.92u as=0.2128p ps=1.5u w=1.12u l=0.6u
X163 VDD.t91 VDD.t89 VDD.t88 VDD.t0 sg13_lv_pmos ad=0.2128p pd=1.5u as=0 ps=0 w=1.12u l=0.2u
X164 a_5631_1842# a_5393_1842# a_5523_1842# VSS.t86 sg13_lv_nmos ad=0.1406p pd=1.12u as=0.2516p ps=2.16u w=0.74u l=0.2u
X165 a_14513_1842# DELAY_OUT_TAP14 VSS.t38 VSS.t104 sg13_lv_nmos ad=0.2516p pd=2.16u as=0.1406p ps=1.12u w=0.74u l=0.13u
X166 a_22873_1842# DELAY_OUT_TAP25 VDD.t13 VDD.t0 sg13_lv_pmos ad=0.3808p pd=2.92u as=0.2128p ps=1.5u w=1.12u l=0.13u
X167 a_4633_1842# DELAY_OUT_TAP1 VSS.t22 VSS.t94 sg13_lv_nmos ad=0.2516p pd=2.16u as=0.1406p ps=1.12u w=0.74u l=0.13u
X168 a_18551_1842# a_18313_1842# a_18443_1842# VSS.t82 sg13_lv_nmos ad=0.1406p pd=1.12u as=0.2516p ps=2.16u w=0.74u l=0.2u
X169 a_22351_1842# a_22113_1842# a_22243_1842# VSS.t44 sg13_lv_nmos ad=0.1406p pd=1.12u as=0.2516p ps=2.16u w=0.74u l=0.2u
X170 VSS.t2 a_16923_1842# DELAY_OUT_TAP18 VSS.t1 sg13_lv_nmos ad=0.1406p pd=1.12u as=0.2516p ps=2.16u w=0.74u l=0.13u
X171 a_25153_1842# DELAY_OUT_TAP28 VDD.t27 VDD.t0 sg13_lv_pmos ad=0.3808p pd=2.92u as=0.2128p ps=1.5u w=1.12u l=0.13u
X172 VSS.t50 a_20723_1842# DELAY_OUT_TAP23 VSS.t49 sg13_lv_nmos ad=0.1406p pd=1.12u as=0.2516p ps=2.16u w=0.74u l=0.13u
X173 VSS.t147 DELAY_VBIASN.t22 a_10951_1842# VSS.t146 sg13_lv_nmos ad=0.2516p pd=2.16u as=0.1406p ps=1.12u w=0.74u l=0.6u
X174 VSS.t199 DELAY_VBIASN.t5 a_23871_1842# VSS.t198 sg13_lv_nmos ad=0.2516p pd=2.16u as=0.1406p ps=1.12u w=0.74u l=0.6u
X175 a_17791_2470# a_17553_1842# a_17683_1842# VDD.t0 sg13_lv_pmos ad=0.2128p pd=1.5u as=0.3808p ps=2.92u w=1.12u l=0.2u
X176 a_13231_1842# a_12993_1842# a_13123_1842# VSS.t56 sg13_lv_nmos ad=0.1406p pd=1.12u as=0.2516p ps=2.16u w=0.74u l=0.2u
X177 a_21591_2470# a_21353_1842# a_21483_1842# VDD.t0 sg13_lv_pmos ad=0.2128p pd=1.5u as=0.3808p ps=2.92u w=1.12u l=0.2u
X178 a_12233_1842# DELAY_OUT_TAP11 VSS.t26 VSS.t99 sg13_lv_nmos ad=0.2516p pd=2.16u as=0.1406p ps=1.12u w=0.74u l=0.13u
X179 a_6153_1842# DELAY_OUT_TAP3 VDD.t6 VDD.t0 sg13_lv_pmos ad=0.3808p pd=2.92u as=0.2128p ps=1.5u w=1.12u l=0.13u
X180 VDD.t16 DELAY_VBIASP.t23 a_10191_2470# VDD.t0 sg13_lv_pmos ad=0.3808p pd=2.92u as=0.2128p ps=1.5u w=1.12u l=0.6u
X181 VDD.t2 a_16163_1842# DELAY_OUT_TAP17 VDD.t0 sg13_lv_pmos ad=0.2128p pd=1.5u as=0.3808p ps=2.92u w=1.12u l=0.13u
X182 VDD.t25 a_19963_1842# DELAY_OUT_TAP22 VDD.t0 sg13_lv_pmos ad=0.2128p pd=1.5u as=0.3808p ps=2.92u w=1.12u l=0.13u
X183 VSS.t165 DELAY_VBIASN.t30 a_4871_1842# VSS.t164 sg13_lv_nmos ad=0.2516p pd=2.16u as=0.1406p ps=1.12u w=0.74u l=0.6u
X184 VSS.t143 DELAY_VBIASN.t2 a_26151_1842# VSS.t142 sg13_lv_nmos ad=0.2516p pd=2.16u as=0.1406p ps=1.12u w=0.74u l=0.6u
X185 a_11473_1842# DELAY_OUT_TAP10 VDD.t26 VDD.t0 sg13_lv_pmos ad=0.3808p pd=2.92u as=0.2128p ps=1.5u w=1.12u l=0.13u
X186 VSS.t117 VSS.t114 VSS.t116 VSS.t115 sg13_lv_nmos ad=0.2516p pd=2.16u as=0 ps=0 w=0.74u l=0.6u
X187 a_27433_1842# DELAY_OUT_TAP31 VSS.t8 VSS.t137 sg13_lv_nmos ad=0.2516p pd=2.16u as=0.1406p ps=1.12u w=0.74u l=0.13u
X188 VDD.t66 DELAY_VBIASP.t3 a_25391_2470# VDD.t0 sg13_lv_pmos ad=0.3808p pd=2.92u as=0.2128p ps=1.5u w=1.12u l=0.6u
X189 VSS.t171 DELAY_VBIASN.t27 a_7151_1842# VSS.t170 sg13_lv_nmos ad=0.2516p pd=2.16u as=0.1406p ps=1.12u w=0.74u l=0.6u
X190 a_8433_1842# DELAY_OUT_TAP6 VSS.t36 VSS.t96 sg13_lv_nmos ad=0.2516p pd=2.16u as=0.1406p ps=1.12u w=0.74u l=0.13u
X191 a_9431_1842# a_9193_1842# a_9323_1842# VSS.t51 sg13_lv_nmos ad=0.1406p pd=1.12u as=0.2516p ps=2.16u w=0.74u l=0.2u
X192 a_23871_1842# a_23633_1842# a_23763_1842# VSS.t29 sg13_lv_nmos ad=0.1406p pd=1.12u as=0.2516p ps=2.16u w=0.74u l=0.2u
X193 VSS.t19 a_18443_1842# DELAY_OUT_TAP20 VSS.t18 sg13_lv_nmos ad=0.1406p pd=1.12u as=0.2516p ps=2.16u w=0.74u l=0.13u
X194 a_18313_1842# DELAY_OUT_TAP19 VSS.t28 VSS.t121 sg13_lv_nmos ad=0.2516p pd=2.16u as=0.1406p ps=1.12u w=0.74u l=0.13u
X195 a_26673_1842# DELAY_OUT_TAP30 VDD.t92 VDD.t0 sg13_lv_pmos ad=0.3808p pd=2.92u as=0.2128p ps=1.5u w=1.12u l=0.13u
X196 a_22113_1842# DELAY_OUT_TAP24 VSS.t54 VSS.t140 sg13_lv_nmos ad=0.2516p pd=2.16u as=0.1406p ps=1.12u w=0.74u l=0.13u
X197 VSS.t159 DELAY_VBIASN.t20 a_12471_1842# VSS.t158 sg13_lv_nmos ad=0.2516p pd=2.16u as=0.1406p ps=1.12u w=0.74u l=0.6u
X198 VDD.t24 DELAY_VBIASP.t28 a_6391_2470# VDD.t0 sg13_lv_pmos ad=0.3808p pd=2.92u as=0.2128p ps=1.5u w=1.12u l=0.6u
X199 VSS.t33 a_22243_1842# DELAY_OUT_TAP25 VSS.t32 sg13_lv_nmos ad=0.1406p pd=1.12u as=0.2516p ps=2.16u w=0.74u l=0.13u
X200 a_10191_2470# a_9953_1842# a_10083_1842# VDD.t0 sg13_lv_pmos ad=0.2128p pd=1.5u as=0.3808p ps=2.92u w=1.12u l=0.2u
X201 VDD.t62 DELAY_VBIASP.t9 a_20831_2470# VDD.t0 sg13_lv_pmos ad=0.3808p pd=2.92u as=0.2128p ps=1.5u w=1.12u l=0.6u
X202 a_4871_1842# a_4633_1842# a_4763_1842# VSS.t60 sg13_lv_nmos ad=0.1406p pd=1.12u as=0.2516p ps=2.16u w=0.74u l=0.2u
X203 a_26151_1842# a_25913_1842# a_26043_1842# VSS.t123 sg13_lv_nmos ad=0.1406p pd=1.12u as=0.2516p ps=2.16u w=0.74u l=0.2u
X204 a_13753_1842# DELAY_OUT_TAP13 VSS.t10 VSS.t97 sg13_lv_nmos ad=0.2516p pd=2.16u as=0.1406p ps=1.12u w=0.74u l=0.13u
X205 a_7673_1842# DELAY_OUT_TAP5 VDD.t18 VDD.t0 sg13_lv_pmos ad=0.3808p pd=2.92u as=0.2128p ps=1.5u w=1.12u l=0.13u
X206 VSS.t75 a_24523_1842# DELAY_OUT_TAP28 VSS.t74 sg13_lv_nmos ad=0.1406p pd=1.12u as=0.2516p ps=2.16u w=0.74u l=0.13u
X207 VDD.t40 DELAY_VBIASP.t21 a_11711_2470# VDD.t0 sg13_lv_pmos ad=0.3808p pd=2.92u as=0.2128p ps=1.5u w=1.12u l=0.6u
X208 VDD.t20 a_21483_1842# DELAY_OUT_TAP24 VDD.t0 sg13_lv_pmos ad=0.2128p pd=1.5u as=0.3808p ps=2.92u w=1.12u l=0.13u
X209 VSS.t203 DELAY_VBIASN.t0 a_27671_1842# VSS.t202 sg13_lv_nmos ad=0.2516p pd=2.16u as=0.1406p ps=1.12u w=0.74u l=0.6u
X210 a_7151_1842# a_6913_1842# a_7043_1842# VSS.t34 sg13_lv_nmos ad=0.1406p pd=1.12u as=0.2516p ps=2.16u w=0.74u l=0.2u
X211 a_16033_1842# DELAY_OUT_TAP16 VSS.t43 VSS.t132 sg13_lv_nmos ad=0.2516p pd=2.16u as=0.1406p ps=1.12u w=0.74u l=0.13u
X212 a_12993_1842# DELAY_OUT_TAP12 VDD.t7 VDD.t0 sg13_lv_pmos ad=0.3808p pd=2.92u as=0.2128p ps=1.5u w=1.12u l=0.13u
X213 a_25391_2470# a_25153_1842# a_25283_1842# VDD.t0 sg13_lv_pmos ad=0.2128p pd=1.5u as=0.3808p ps=2.92u w=1.12u l=0.2u
X214 VDD.t57 DELAY_VBIASP.t18 a_13991_2470# VDD.t0 sg13_lv_pmos ad=0.3808p pd=2.92u as=0.2128p ps=1.5u w=1.12u l=0.6u
X215 VSS.t15 a_5523_1842# DELAY_OUT_TAP3 VSS.t14 sg13_lv_nmos ad=0.1406p pd=1.12u as=0.2516p ps=2.16u w=0.74u l=0.13u
X216 VDD.t30 a_23763_1842# DELAY_OUT_TAP27 VDD.t0 sg13_lv_pmos ad=0.2128p pd=1.5u as=0.3808p ps=2.92u w=1.12u l=0.13u
X217 VDD.t64 DELAY_VBIASP.t1 a_26911_2470# VDD.t0 sg13_lv_pmos ad=0.3808p pd=2.92u as=0.2128p ps=1.5u w=1.12u l=0.6u
X218 VSS.t173 DELAY_VBIASN.t25 a_8671_1842# VSS.t172 sg13_lv_nmos ad=0.2516p pd=2.16u as=0.1406p ps=1.12u w=0.74u l=0.6u
X219 a_12471_1842# a_12233_1842# a_12363_1842# VSS.t80 sg13_lv_nmos ad=0.1406p pd=1.12u as=0.2516p ps=2.16u w=0.74u l=0.2u
X220 a_6391_2470# a_6153_1842# a_6283_1842# VDD.t0 sg13_lv_pmos ad=0.2128p pd=1.5u as=0.3808p ps=2.92u w=1.12u l=0.2u
X221 a_15273_1842# DELAY_OUT_TAP15 VDD.t23 VDD.t0 sg13_lv_pmos ad=0.3808p pd=2.92u as=0.2128p ps=1.5u w=1.12u l=0.13u
X222 VDD.t9 a_4763_1842# DELAY_OUT_TAP2 VDD.t0 sg13_lv_pmos ad=0.2128p pd=1.5u as=0.3808p ps=2.92u w=1.12u l=0.13u
X223 VDD.t17 a_15403_1842# DELAY_OUT_TAP16 VDD.t0 sg13_lv_pmos ad=0.2128p pd=1.5u as=0.3808p ps=2.92u w=1.12u l=0.13u
X224 a_9953_1842# DELAY_OUT_TAP8 VSS.t41 VSS.t102 sg13_lv_nmos ad=0.2516p pd=2.16u as=0.1406p ps=1.12u w=0.74u l=0.13u
X225 VSS.t73 a_10843_1842# DELAY_OUT_TAP10 VSS.t72 sg13_lv_nmos ad=0.1406p pd=1.12u as=0.2516p ps=2.16u w=0.74u l=0.13u
X226 VDD.t14 DELAY_VBIASP.t26 a_7911_2470# VDD.t0 sg13_lv_pmos ad=0.3808p pd=2.92u as=0.2128p ps=1.5u w=1.12u l=0.6u
X227 a_11711_2470# a_11473_1842# a_11603_1842# VDD.t0 sg13_lv_pmos ad=0.2128p pd=1.5u as=0.3808p ps=2.92u w=1.12u l=0.2u
X228 a_27671_1842# a_27433_1842# a_27563_1842# VSS.t3 sg13_lv_nmos ad=0.1406p pd=1.12u as=0.2516p ps=2.16u w=0.74u l=0.2u
X229 VDD.t31 a_10083_1842# DELAY_OUT_TAP9 VDD.t0 sg13_lv_pmos ad=0.2128p pd=1.5u as=0.3808p ps=2.92u w=1.12u l=0.13u
X230 VSS.t127 a_26043_1842# DELAY_OUT_TAP30 VSS.t126 sg13_lv_nmos ad=0.1406p pd=1.12u as=0.2516p ps=2.16u w=0.74u l=0.13u
X231 VSS.t149 DELAY_VBIASN.t15 a_16271_1842# VSS.t148 sg13_lv_nmos ad=0.2516p pd=2.16u as=0.1406p ps=1.12u w=0.74u l=0.6u
X232 VDD.t67 DELAY_VBIASP.t4 a_24631_2470# VDD.t0 sg13_lv_pmos ad=0.3808p pd=2.92u as=0.2128p ps=1.5u w=1.12u l=0.6u
X233 VSS.t191 DELAY_VBIASN.t10 a_20071_1842# VSS.t190 sg13_lv_nmos ad=0.2516p pd=2.16u as=0.1406p ps=1.12u w=0.74u l=0.6u
X234 VDD.t9 VDD.t9 VDD.t9 VDD.t0 sg13_lv_pmos ad=0.3808p pd=2.92u as=0 ps=0 w=1.12u l=0.13u
X235 a_26911_2470# a_26673_1842# a_26803_1842# VDD.t0 sg13_lv_pmos ad=0.2128p pd=1.5u as=0.3808p ps=2.92u w=1.12u l=0.2u
X236 a_8671_1842# a_8433_1842# a_8563_1842# VSS.t47 sg13_lv_nmos ad=0.1406p pd=1.12u as=0.2516p ps=2.16u w=0.74u l=0.2u
X237 a_17553_1842# DELAY_OUT_TAP18 VSS.t2 VSS.t128 sg13_lv_nmos ad=0.2516p pd=2.16u as=0.1406p ps=1.12u w=0.74u l=0.13u
X238 VDD.t58 DELAY_VBIASP.t16 a_15511_2470# VDD.t0 sg13_lv_pmos ad=0.3808p pd=2.92u as=0.2128p ps=1.5u w=1.12u l=0.6u
X239 VSS.t46 a_7043_1842# DELAY_OUT_TAP5 VSS.t45 sg13_lv_nmos ad=0.1406p pd=1.12u as=0.2516p ps=2.16u w=0.74u l=0.13u
X240 a_21353_1842# DELAY_OUT_TAP23 VSS.t50 VSS.t141 sg13_lv_nmos ad=0.2516p pd=2.16u as=0.1406p ps=1.12u w=0.74u l=0.13u
X241 VDD.t6 DELAY_VBIASP.t29 a_5631_2470# VDD.t0 sg13_lv_pmos ad=0.3808p pd=2.92u as=0.2128p ps=1.5u w=1.12u l=0.6u
X242 VDD.t21 a_25283_1842# DELAY_OUT_TAP29 VDD.t0 sg13_lv_pmos ad=0.2128p pd=1.5u as=0.3808p ps=2.92u w=1.12u l=0.13u
X243 a_13991_1842# a_13753_1842# a_13883_1842# VSS.t0 sg13_lv_nmos ad=0.1406p pd=1.12u as=0.2516p ps=2.16u w=0.74u l=0.2u
X244 a_7911_2470# a_7673_1842# a_7803_1842# VDD.t0 sg13_lv_pmos ad=0.2128p pd=1.5u as=0.3808p ps=2.92u w=1.12u l=0.2u
X245 a_16793_1842# DELAY_OUT_TAP17 VDD.t2 VDD.t0 sg13_lv_pmos ad=0.3808p pd=2.92u as=0.2128p ps=1.5u w=1.12u l=0.13u
X246 a_20593_1842# DELAY_OUT_TAP22 VDD.t25 VDD.t0 sg13_lv_pmos ad=0.3808p pd=2.92u as=0.2128p ps=1.5u w=1.12u l=0.13u
X247 VDD.t29 a_27563_1842# a_27997_1842# VDD.t0 sg13_lv_pmos ad=0.2128p pd=1.5u as=0.3808p ps=2.92u w=1.12u l=0.13u
X248 VSS.t17 a_12363_1842# DELAY_OUT_TAP12 VSS.t16 sg13_lv_nmos ad=0.1406p pd=1.12u as=0.2516p ps=2.16u w=0.74u l=0.13u
X249 VDD.t24 a_6283_1842# DELAY_OUT_TAP4 VDD.t0 sg13_lv_pmos ad=0.2128p pd=1.5u as=0.3808p ps=2.92u w=1.12u l=0.13u
X250 a_16271_1842# a_16033_1842# a_16163_1842# VSS.t31 sg13_lv_nmos ad=0.1406p pd=1.12u as=0.2516p ps=2.16u w=0.74u l=0.2u
X251 a_19073_1842# DELAY_OUT_TAP20 VDD.t8 VDD.t0 sg13_lv_pmos ad=0.3808p pd=2.92u as=0.2128p ps=1.5u w=1.12u l=0.13u
X252 VDD.t5 a_19203_1842# DELAY_OUT_TAP21 VDD.t0 sg13_lv_pmos ad=0.2128p pd=1.5u as=0.3808p ps=2.92u w=1.12u l=0.13u
X253 a_20071_1842# a_19833_1842# a_19963_1842# VSS.t6 sg13_lv_nmos ad=0.1406p pd=1.12u as=0.2516p ps=2.16u w=0.74u l=0.2u
X254 VSS.t64 a_14643_1842# DELAY_OUT_TAP15 VSS.t63 sg13_lv_nmos ad=0.1406p pd=1.12u as=0.2516p ps=2.16u w=0.74u l=0.13u
X255 VDD.t16 a_8563_1842# DELAY_OUT_TAP7 VDD.t0 sg13_lv_pmos ad=0.2128p pd=1.5u as=0.3808p ps=2.92u w=1.12u l=0.13u
X256 VDD.t47 DELAY_VBIASP.t19 a_13231_2470# VDD.t0 sg13_lv_pmos ad=0.3808p pd=2.92u as=0.2128p ps=1.5u w=1.12u l=0.6u
X257 VSS.t185 DELAY_VBIASN.t13 a_17791_1842# VSS.t184 sg13_lv_nmos ad=0.2516p pd=2.16u as=0.1406p ps=1.12u w=0.74u l=0.6u
X258 VDD.t28 a_23003_1842# DELAY_OUT_TAP26 VDD.t0 sg13_lv_pmos ad=0.2128p pd=1.5u as=0.3808p ps=2.92u w=1.12u l=0.13u
X259 VSS.t189 DELAY_VBIASN.t8 a_21591_1842# VSS.t188 sg13_lv_nmos ad=0.2516p pd=2.16u as=0.1406p ps=1.12u w=0.74u l=0.6u
X260 a_15511_2470# a_15273_1842# a_15403_1842# VDD.t0 sg13_lv_pmos ad=0.2128p pd=1.5u as=0.3808p ps=2.92u w=1.12u l=0.2u
X261 VSS.t116 VSS.t118 VSS.t120 VSS.t119 sg13_lv_nmos ad=0.1406p pd=1.12u as=0 ps=0 w=0.74u l=0.2u
X262 VDD.t15 a_13883_1842# DELAY_OUT_TAP14 VDD.t0 sg13_lv_pmos ad=0.2128p pd=1.5u as=0.3808p ps=2.92u w=1.12u l=0.13u
X263 a_22873_1842# DELAY_OUT_TAP25 VSS.t33 VSS.t131 sg13_lv_nmos ad=0.2516p pd=2.16u as=0.1406p ps=1.12u w=0.74u l=0.13u
C0 DELAY_VBIASP a_17553_1842# 0.11005f
C1 a_16163_1842# a_16271_1842# 0.01163f
C2 a_20593_1842# a_20723_1842# 0.69911f
C3 a_6153_1842# DELAY_VBIASN 0.10296f
C4 DELAY_OUT_TAP17 DELAY_VBIASN 0.04023f
C5 a_6913_1842# a_7043_1842# 0.69911f
C6 DELAY_OUT_TAP3 a_5393_1842# 0.0114f
C7 VDD a_27433_1842# 0.70781f
C8 DELAY_VBIASN a_27563_1842# 0.06813f
C9 VDD a_21591_2470# 0.02372f
C10 a_25283_1842# DELAY_VBIASN 0.06812f
C11 VDD DELAY_OUT_TAP1 0.79811f
C12 a_21483_1842# a_21591_2470# 0.01697f
C13 a_16793_1842# DELAY_OUT_TAP18 0.0114f
C14 DELAY_OUT_TAP10 DELAY_VBIASP 0.03913f
C15 DELAY_VBIASP a_22113_1842# 0.11005f
C16 VDD a_11711_2470# 0.02372f
C17 DELAY_VBIASP a_23763_1842# 0.06316f
C18 VDD a_7803_1842# 0.85896f
C19 a_7151_2470# a_7043_1842# 0.01697f
C20 a_27433_1842# a_27997_1842# 0.0114f
C21 a_8563_1842# DELAY_VBIASN 0.06812f
C22 a_18443_1842# a_18551_2470# 0.01697f
C23 a_16033_1842# a_16163_1842# 0.69911f
C24 DELAY_VBIASP a_6153_1842# 0.11005f
C25 DELAY_VBIASP DELAY_OUT_TAP17 0.03913f
C26 DELAY_OUT_TAP2 VDD 0.7981f
C27 VDD DELAY_OUT_TAP28 0.7981f
C28 DELAY_OUT_TAP4 DELAY_VBIASN 0.04023f
C29 DELAY_VBIASP a_27563_1842# 0.06318f
C30 DELAY_OUT_TAP5 a_7673_1842# 0.70708f
C31 DELAY_VBIASN DELAY_OUT_TAP30 0.04023f
C32 VDD a_4763_1842# 0.85896f
C33 DELAY_VBIASP a_25283_1842# 0.06316f
C34 a_11473_1842# VDD 0.70781f
C35 DELAY_OUT_TAP13 a_12993_1842# 0.0114f
C36 a_13231_2470# a_13123_1842# 0.01697f
C37 a_5523_1842# DELAY_VBIASN 0.06812f
C38 a_23763_1842# DELAY_OUT_TAP27 0.69646f
C39 DELAY_OUT_TAP22 VDD 0.7981f
C40 a_10843_1842# DELAY_OUT_TAP10 0.69646f
C41 a_12233_1842# DELAY_VBIASN 0.10296f
C42 DELAY_OUT_TAP24 DELAY_VBIASN 0.04023f
C43 a_10843_1842# a_10951_1842# 0.01163f
C44 DELAY_OUT_TAP23 a_21353_1842# 0.70708f
C45 DELAY_OUT_TAP23 a_20593_1842# 0.0114f
C46 DELAY_VBIASP a_8563_1842# 0.06316f
C47 a_18313_1842# DELAY_OUT_TAP19 0.70708f
C48 a_25153_1842# DELAY_OUT_TAP28 0.70708f
C49 a_4003_1842# a_4111_2470# 0.01697f
C50 VDD a_14513_1842# 0.70781f
C51 VDD a_15511_2470# 0.02372f
C52 a_9323_1842# a_9431_2470# 0.01697f
C53 DELAY_OUT_TAP4 DELAY_VBIASP 0.03913f
C54 a_15273_1842# DELAY_VBIASN 0.10296f
C55 DELAY_VBIASP DELAY_OUT_TAP30 0.03913f
C56 DELAY_VBIASP a_5523_1842# 0.06316f
C57 VDD DELAY_VBIASN 0.34192f
C58 a_16923_1842# a_17031_2470# 0.01697f
C59 a_4871_2470# a_4763_1842# 0.01697f
C60 a_26043_1842# a_26151_2470# 0.01697f
C61 a_19963_1842# VDD 0.85896f
C62 a_7803_1842# a_7911_1842# 0.01163f
C63 DELAY_VBIASP a_12233_1842# 0.11005f
C64 DELAY_OUT_TAP9 DELAY_VBIASN 0.04023f
C65 a_14643_1842# DELAY_OUT_TAP15 0.69646f
C66 a_21483_1842# DELAY_VBIASN 0.06812f
C67 a_6283_1842# a_6391_1842# 0.01163f
C68 DELAY_OUT_TAP24 DELAY_VBIASP 0.03913f
C69 a_23633_1842# DELAY_VBIASN 0.10296f
C70 a_20723_1842# DELAY_VBIASN 0.06812f
C71 VDD DELAY_OUT_LAST 0.5592f
C72 VDD DELAY_OUT_TAP14 0.7981f
C73 a_11603_1842# a_11711_2470# 0.01697f
C74 a_16923_1842# VDD 0.85896f
C75 a_24631_1842# a_24523_1842# 0.01163f
C76 DELAY_OUT_TAP16 DELAY_VBIASN 0.04023f
C77 DELAY_OUT_TAP8 DELAY_VBIASN 0.04023f
C78 DELAY_OUT_TAP2 a_5393_1842# 0.70708f
C79 VDD a_26803_1842# 0.85896f
C80 DELAY_VBIASN a_27997_1842# 0.03845f
C81 a_10083_1842# a_10191_1842# 0.01163f
C82 VDD a_20831_2470# 0.02372f
C83 DELAY_VBIASP a_15273_1842# 0.11005f
C84 a_25153_1842# DELAY_VBIASN 0.10296f
C85 a_12993_1842# a_13123_1842# 0.69911f
C86 VDD DELAY_VBIASP 35.8265f
C87 a_16793_1842# DELAY_OUT_TAP17 0.70708f
C88 DELAY_OUT_LAST a_27997_1842# 0.70955f
C89 a_20723_1842# a_20831_2470# 0.01697f
C90 a_11473_1842# a_11603_1842# 0.69911f
C91 DELAY_OUT_TAP9 DELAY_VBIASP 0.03913f
C92 DELAY_VBIASP a_21483_1842# 0.06316f
C93 VDD a_10951_2470# 0.02372f
C94 DELAY_VBIASP a_23633_1842# 0.11005f
C95 a_20723_1842# DELAY_VBIASP 0.06316f
C96 a_9953_1842# a_10083_1842# 0.69911f
C97 a_8433_1842# DELAY_VBIASN 0.10296f
C98 DELAY_VBIASP DELAY_OUT_TAP16 0.03913f
C99 DELAY_OUT_TAP8 DELAY_VBIASP 0.03913f
C100 VDD DELAY_OUT_TAP27 0.7981f
C101 DELAY_OUT_TAP3 DELAY_VBIASN 0.04023f
C102 DELAY_VBIASP a_27997_1842# 0.03776f
C103 DELAY_OUT_TAP5 a_7043_1842# 0.69646f
C104 DELAY_VBIASN DELAY_OUT_TAP29 0.04023f
C105 VDD a_4633_1842# 0.70781f
C106 DELAY_VBIASP a_25153_1842# 0.11005f
C107 a_10843_1842# VDD 0.85896f
C108 a_5393_1842# DELAY_VBIASN 0.10296f
C109 DELAY_OUT_TAP12 a_12993_1842# 0.70708f
C110 VDD a_19073_1842# 0.70781f
C111 a_23633_1842# DELAY_OUT_TAP27 0.0114f
C112 a_4003_1842# a_4111_1842# 0.01163f
C113 DELAY_OUT_TAP21 VDD 0.7981f
C114 a_10713_1842# DELAY_OUT_TAP10 0.0114f
C115 a_26673_1842# DELAY_OUT_TAP31 0.0114f
C116 a_11603_1842# DELAY_VBIASN 0.06812f
C117 DELAY_OUT_TAP23 DELAY_VBIASN 0.04023f
C118 DELAY_OUT_TAP20 VDD 0.7981f
C119 DELAY_OUT_TAP22 a_20593_1842# 0.70708f
C120 DELAY_VBIASP a_8433_1842# 0.11005f
C121 a_14513_1842# a_14643_1842# 0.69911f
C122 a_17683_1842# DELAY_OUT_TAP19 0.69646f
C123 VDD a_13883_1842# 0.85896f
C124 VDD a_14751_2470# 0.02372f
C125 DELAY_OUT_TAP7 a_9193_1842# 0.70708f
C126 DELAY_OUT_TAP3 DELAY_VBIASP 0.03913f
C127 a_14643_1842# DELAY_VBIASN 0.06812f
C128 DELAY_VBIASP DELAY_OUT_TAP29 0.03913f
C129 DELAY_VBIASP a_5393_1842# 0.11005f
C130 VDD a_7673_1842# 0.70781f
C131 a_24393_1842# a_24523_1842# 0.69911f
C132 a_19833_1842# VDD 0.70781f
C133 DELAY_VBIASP a_11603_1842# 0.06316f
C134 a_14513_1842# DELAY_OUT_TAP15 0.0114f
C135 a_21353_1842# DELAY_VBIASN 0.10296f
C136 a_23003_1842# DELAY_VBIASN 0.06812f
C137 DELAY_OUT_TAP23 DELAY_VBIASP 0.03913f
C138 a_20593_1842# DELAY_VBIASN 0.10296f
C139 a_16793_1842# VDD 0.70781f
C140 DELAY_OUT_TAP15 DELAY_VBIASN 0.04023f
C141 DELAY_OUT_TAP2 a_4763_1842# 0.69646f
C142 DELAY_VBIASN a_27433_1842# 0.10297f
C143 VDD a_20071_2470# 0.02372f
C144 DELAY_VBIASP a_14643_1842# 0.06316f
C145 VDD DELAY_IN 0.64793f
C146 a_16163_1842# DELAY_OUT_TAP17 0.69646f
C147 a_25391_1842# a_25283_1842# 0.01163f
C148 DELAY_OUT_TAP1 DELAY_VBIASN 0.04023f
C149 a_25913_1842# a_26043_1842# 0.69911f
C150 DELAY_VBIASP a_21353_1842# 0.11005f
C151 VDD a_10191_2470# 0.02372f
C152 DELAY_VBIASP a_23003_1842# 0.06316f
C153 a_19963_1842# a_20071_1842# 0.01163f
C154 a_20593_1842# DELAY_VBIASP 0.11005f
C155 a_7803_1842# DELAY_VBIASN 0.06812f
C156 DELAY_VBIASP DELAY_OUT_TAP15 0.03913f
C157 VDD DELAY_OUT_TAP26 0.7981f
C158 DELAY_OUT_TAP2 DELAY_VBIASN 0.04023f
C159 DELAY_VBIASP a_27433_1842# 0.11005f
C160 DELAY_OUT_TAP5 a_6913_1842# 0.0114f
C161 DELAY_VBIASN DELAY_OUT_TAP28 0.04023f
C162 VDD a_4003_1842# 0.97904f
C163 a_10713_1842# VDD 0.70781f
C164 DELAY_OUT_TAP12 a_12363_1842# 0.69646f
C165 a_4763_1842# DELAY_VBIASN 0.06812f
C166 VDD a_18443_1842# 0.85896f
C167 a_23633_1842# DELAY_OUT_TAP26 0.70708f
C168 DELAY_OUT_TAP25 a_22873_1842# 0.70708f
C169 a_11473_1842# DELAY_VBIASN 0.10296f
C170 a_12363_1842# a_12471_1842# 0.01163f
C171 a_10713_1842# DELAY_OUT_TAP9 0.70708f
C172 DELAY_VBIASP DELAY_OUT_TAP1 0.03913f
C173 a_26673_1842# DELAY_OUT_TAP30 0.70708f
C174 DELAY_OUT_TAP22 DELAY_VBIASN 0.04023f
C175 VDD a_26911_2470# 0.02372f
C176 DELAY_OUT_TAP22 a_19963_1842# 0.69646f
C177 a_9193_1842# a_9323_1842# 0.69911f
C178 DELAY_VBIASP a_7803_1842# 0.06316f
C179 a_17553_1842# DELAY_OUT_TAP19 0.0114f
C180 a_14751_2470# a_14643_1842# 0.01697f
C181 a_24631_2470# a_24523_1842# 0.01697f
C182 VDD a_13753_1842# 0.70781f
C183 VDD a_13991_2470# 0.02372f
C184 DELAY_OUT_TAP7 a_8563_1842# 0.69646f
C185 DELAY_OUT_TAP13 VDD 0.7981f
C186 DELAY_OUT_TAP2 DELAY_VBIASP 0.03913f
C187 a_14513_1842# DELAY_VBIASN 0.10296f
C188 a_9323_1842# a_9431_1842# 0.01163f
C189 DELAY_VBIASP DELAY_OUT_TAP28 0.03913f
C190 DELAY_VBIASP a_4763_1842# 0.06316f
C191 DELAY_OUT_TAP1 a_4633_1842# 0.70708f
C192 VDD a_7043_1842# 0.85896f
C193 a_11473_1842# DELAY_VBIASP 0.11005f
C194 a_19203_1842# VDD 0.85896f
C195 a_14513_1842# DELAY_OUT_TAP14 0.70708f
C196 DELAY_OUT_TAP22 DELAY_VBIASP 0.03913f
C197 a_19963_1842# DELAY_VBIASN 0.06812f
C198 VDD a_26673_1842# 0.70781f
C199 DELAY_OUT_LAST DELAY_VBIASN 0.04506f
C200 a_15403_1842# a_15511_1842# 0.01163f
C201 a_16163_1842# VDD 0.85896f
C202 DELAY_OUT_TAP14 DELAY_VBIASN 0.04023f
C203 DELAY_OUT_TAP2 a_4633_1842# 0.0114f
C204 a_16923_1842# DELAY_VBIASN 0.06812f
C205 DELAY_VBIASN a_26803_1842# 0.06812f
C206 a_4633_1842# a_4763_1842# 0.69911f
C207 VDD a_7911_2470# 0.02372f
C208 DELAY_VBIASP a_14513_1842# 0.11005f
C209 a_22351_1842# a_22243_1842# 0.01163f
C210 a_26911_1842# a_26803_1842# 0.01163f
C211 a_16033_1842# DELAY_OUT_TAP17 0.0114f
C212 DELAY_VBIASP DELAY_VBIASN 2.36634f
C213 VDD a_9431_2470# 0.02372f
C214 DELAY_OUT_TAP7 VDD 0.7981f
C215 a_19963_1842# DELAY_VBIASP 0.06316f
C216 a_6391_2470# a_6283_1842# 0.01697f
C217 a_17553_1842# a_17683_1842# 0.69911f
C218 DELAY_VBIASP DELAY_OUT_LAST 0.21025f
C219 a_17683_1842# a_17791_2470# 0.01697f
C220 a_7803_1842# a_7673_1842# 0.69911f
C221 DELAY_VBIASP DELAY_OUT_TAP14 0.03913f
C222 a_5523_1842# a_5631_1842# 0.01163f
C223 a_16923_1842# DELAY_VBIASP 0.06316f
C224 VDD a_13123_1842# 0.85896f
C225 DELAY_VBIASP a_26803_1842# 0.06316f
C226 DELAY_VBIASN DELAY_OUT_TAP27 0.04023f
C227 DELAY_OUT_TAP4 a_6913_1842# 0.70708f
C228 a_10083_1842# VDD 0.85896f
C229 a_12471_2470# a_12363_1842# 0.01697f
C230 a_4633_1842# DELAY_VBIASN 0.10296f
C231 DELAY_OUT_TAP12 a_12233_1842# 0.0114f
C232 VDD a_18313_1842# 0.70781f
C233 a_23003_1842# DELAY_OUT_TAP26 0.69646f
C234 VDD a_19311_2470# 0.02372f
C235 DELAY_OUT_TAP25 a_22243_1842# 0.69646f
C236 a_10843_1842# DELAY_VBIASN 0.06812f
C237 a_19073_1842# DELAY_VBIASN 0.10296f
C238 a_27671_1842# a_27563_1842# 0.01163f
C239 a_10083_1842# DELAY_OUT_TAP9 0.69646f
C240 DELAY_IN DELAY_OUT_TAP1 0.01139f
C241 a_26043_1842# DELAY_OUT_TAP30 0.69646f
C242 DELAY_OUT_TAP21 DELAY_VBIASN 0.04023f
C243 VDD a_26151_2470# 0.02372f
C244 DELAY_OUT_TAP22 a_19833_1842# 0.0114f
C245 a_17553_1842# DELAY_OUT_TAP18 0.70708f
C246 DELAY_OUT_TAP20 DELAY_VBIASN 0.04023f
C247 VDD a_13231_2470# 0.02372f
C248 DELAY_OUT_TAP12 VDD 0.7981f
C249 DELAY_OUT_TAP7 a_8433_1842# 0.0114f
C250 VDD a_22873_1842# 0.70781f
C251 a_8563_1842# a_8671_2470# 0.01697f
C252 VDD a_24523_1842# 0.85896f
C253 a_13883_1842# DELAY_VBIASN 0.06812f
C254 DELAY_VBIASP DELAY_OUT_TAP27 0.03913f
C255 DELAY_OUT_TAP1 a_4003_1842# 0.69646f
C256 DELAY_VBIASP a_4633_1842# 0.11005f
C257 a_22113_1842# a_22243_1842# 0.69911f
C258 a_16163_1842# a_16271_2470# 0.01697f
C259 VDD DELAY_OUT_TAP19 0.7981f
C260 VDD a_6913_1842# 0.70781f
C261 a_10843_1842# DELAY_VBIASP 0.06316f
C262 DELAY_VBIASP a_19073_1842# 0.11005f
C263 a_25283_1842# a_25391_2470# 0.01697f
C264 a_7673_1842# DELAY_VBIASN 0.10296f
C265 a_13883_1842# DELAY_OUT_TAP14 0.69646f
C266 DELAY_OUT_TAP21 DELAY_VBIASP 0.03913f
C267 a_19833_1842# DELAY_VBIASN 0.10296f
C268 a_10843_1842# a_10951_2470# 0.01697f
C269 VDD a_26043_1842# 0.85896f
C270 a_19833_1842# a_19963_1842# 0.69911f
C271 a_16033_1842# VDD 0.70781f
C272 a_23871_1842# a_23763_1842# 0.01163f
C273 a_6153_1842# a_6283_1842# 0.69911f
C274 DELAY_OUT_TAP20 DELAY_VBIASP 0.03913f
C275 a_16793_1842# DELAY_VBIASN 0.10296f
C276 VDD a_7151_2470# 0.02372f
C277 DELAY_VBIASP a_13883_1842# 0.06316f
C278 VDD a_9323_1842# 0.85896f
C279 a_16033_1842# DELAY_OUT_TAP16 0.70708f
C280 a_19963_1842# a_20071_2470# 0.01697f
C281 DELAY_IN DELAY_VBIASN 0.06896f
C282 a_16793_1842# a_16923_1842# 0.69911f
C283 DELAY_VBIASP a_7673_1842# 0.11005f
C284 DELAY_OUT_TAP21 a_19073_1842# 0.0114f
C285 VDD a_8671_2470# 0.02372f
C286 DELAY_OUT_TAP6 VDD 0.7981f
C287 a_19833_1842# DELAY_VBIASP 0.11005f
C288 DELAY_OUT_TAP20 a_19073_1842# 0.70708f
C289 DELAY_OUT_TAP8 a_9323_1842# 0.69646f
C290 a_16793_1842# DELAY_VBIASP 0.11005f
C291 VDD a_12993_1842# 0.70781f
C292 DELAY_VBIASN DELAY_OUT_TAP26 0.04023f
C293 DELAY_OUT_TAP4 a_6283_1842# 0.69646f
C294 a_7043_1842# a_7151_1842# 0.01163f
C295 a_9953_1842# VDD 0.70781f
C296 a_4003_1842# DELAY_VBIASN 0.06133f
C297 DELAY_OUT_TAP11 a_12233_1842# 0.70708f
C298 VDD a_17683_1842# 0.85896f
C299 VDD a_18551_2470# 0.02372f
C300 DELAY_OUT_TAP25 a_22113_1842# 0.0114f
C301 a_10713_1842# DELAY_VBIASN 0.10296f
C302 a_18443_1842# DELAY_VBIASN 0.06812f
C303 a_9953_1842# DELAY_OUT_TAP9 0.0114f
C304 DELAY_IN DELAY_VBIASP 0.07311f
C305 a_25913_1842# DELAY_OUT_TAP30 0.0114f
C306 VDD a_25391_2470# 0.02372f
C307 a_7911_2470# a_7803_1842# 0.01697f
C308 DELAY_OUT_TAP21 a_19833_1842# 0.70708f
C309 a_9953_1842# DELAY_OUT_TAP8 0.70708f
C310 VDD a_12471_2470# 0.02372f
C311 a_13883_1842# a_13991_1842# 0.01163f
C312 DELAY_OUT_TAP11 VDD 0.7981f
C313 VDD a_22243_1842# 0.85896f
C314 DELAY_OUT_TAP6 a_8433_1842# 0.70708f
C315 VDD a_24393_1842# 0.70781f
C316 a_13753_1842# DELAY_VBIASN 0.10296f
C317 DELAY_VBIASP DELAY_OUT_TAP26 0.03913f
C318 DELAY_OUT_TAP13 DELAY_VBIASN 0.04023f
C319 DELAY_VBIASP a_4003_1842# 0.05735f
C320 VDD a_6283_1842# 0.85896f
C321 a_22873_1842# a_23003_1842# 0.69911f
C322 VDD DELAY_OUT_TAP18 0.7981f
C323 a_26911_2470# a_26803_1842# 0.01697f
C324 a_10713_1842# DELAY_VBIASP 0.11005f
C325 a_16923_1842# a_17031_1842# 0.01163f
C326 DELAY_VBIASP a_18443_1842# 0.06316f
C327 a_7043_1842# DELAY_VBIASN 0.06812f
C328 a_13753_1842# DELAY_OUT_TAP14 0.0114f
C329 VDD a_4111_2470# 0.02431f
C330 a_19203_1842# DELAY_VBIASN 0.06812f
C331 a_15403_1842# a_15273_1842# 0.69911f
C332 VDD a_25913_1842# 0.70781f
C333 a_26673_1842# DELAY_VBIASN 0.10296f
C334 a_15403_1842# VDD 0.85896f
C335 a_16163_1842# DELAY_VBIASN 0.06812f
C336 a_22243_1842# a_22351_2470# 0.01697f
C337 VDD a_6391_2470# 0.02372f
C338 DELAY_VBIASP a_13753_1842# 0.11005f
C339 DELAY_OUT_TAP13 DELAY_VBIASP 0.03913f
C340 a_12233_1842# a_12363_1842# 0.69911f
C341 VDD a_9193_1842# 0.70781f
C342 a_10713_1842# a_10843_1842# 0.69911f
C343 a_15403_1842# DELAY_OUT_TAP16 0.69646f
C344 a_26673_1842# a_26803_1842# 0.69911f
C345 DELAY_VBIASP a_7043_1842# 0.06316f
C346 DELAY_OUT_TAP5 VDD 0.7981f
C347 a_19203_1842# a_19311_1842# 0.01163f
C348 a_19203_1842# DELAY_VBIASP 0.06316f
C349 VDD DELAY_OUT_TAP31 0.7981f
C350 DELAY_OUT_TAP7 DELAY_VBIASN 0.04023f
C351 DELAY_VBIASP a_26673_1842# 0.11005f
C352 DELAY_OUT_TAP20 a_18443_1842# 0.69646f
C353 DELAY_OUT_TAP8 a_9193_1842# 0.0114f
C354 a_24523_1842# DELAY_OUT_TAP28 0.69646f
C355 a_16163_1842# DELAY_VBIASP 0.06316f
C356 VDD a_12363_1842# 0.85896f
C357 DELAY_OUT_TAP25 VDD 0.7981f
C358 DELAY_OUT_TAP4 a_6153_1842# 0.0114f
C359 a_13123_1842# DELAY_VBIASN 0.06812f
C360 DELAY_OUT_TAP11 a_11603_1842# 0.69646f
C361 VDD a_17553_1842# 0.70781f
C362 VDD a_17791_2470# 0.02372f
C363 DELAY_OUT_TAP24 a_22113_1842# 0.70708f
C364 a_10083_1842# DELAY_VBIASN 0.06812f
C365 a_18313_1842# DELAY_VBIASN 0.10296f
C366 a_11603_1842# a_11711_1842# 0.01163f
C367 a_25913_1842# DELAY_OUT_TAP29 0.70708f
C368 VDD a_24631_2470# 0.02372f
C369 a_19203_1842# a_19073_1842# 0.69911f
C370 DELAY_OUT_TAP7 DELAY_VBIASP 0.03913f
C371 DELAY_OUT_TAP21 a_19203_1842# 0.69646f
C372 a_13753_1842# a_13883_1842# 0.69911f
C373 a_23871_2470# a_23763_1842# 0.01697f
C374 a_13991_2470# a_13883_1842# 0.01697f
C375 DELAY_OUT_TAP10 VDD 0.7981f
C376 VDD a_22113_1842# 0.70781f
C377 DELAY_OUT_TAP6 a_7803_1842# 0.69646f
C378 a_5631_2470# a_5523_1842# 0.01697f
C379 VDD a_23763_1842# 0.85896f
C380 a_8563_1842# a_8671_1842# 0.01163f
C381 a_22873_1842# DELAY_VBIASN 0.10296f
C382 DELAY_OUT_TAP12 DELAY_VBIASN 0.04023f
C383 DELAY_VBIASP a_13123_1842# 0.06316f
C384 a_24523_1842# DELAY_VBIASN 0.06812f
C385 DELAY_IN a_4003_1842# 0.52007f
C386 VDD a_6153_1842# 0.70781f
C387 VDD DELAY_OUT_TAP17 0.7981f
C388 a_23633_1842# a_23763_1842# 0.69911f
C389 a_10083_1842# DELAY_VBIASP 0.06316f
C390 a_18551_1842# a_18443_1842# 0.01163f
C391 DELAY_VBIASP a_18313_1842# 0.11005f
C392 DELAY_OUT_TAP19 DELAY_VBIASN 0.04023f
C393 a_6913_1842# DELAY_VBIASN 0.10296f
C394 VDD a_27563_1842# 0.85978f
C395 VDD a_25283_1842# 0.85896f
C396 VDD a_23111_2470# 0.02372f
C397 a_27671_2470# a_27563_1842# 0.01697f
C398 a_26043_1842# DELAY_VBIASN 0.06812f
C399 a_16033_1842# DELAY_VBIASN 0.10296f
C400 VDD a_5631_2470# 0.02372f
C401 a_23111_1842# a_23003_1842# 0.01163f
C402 DELAY_OUT_TAP12 DELAY_VBIASP 0.03913f
C403 a_21591_1842# a_21483_1842# 0.01163f
C404 DELAY_VBIASP a_22873_1842# 0.11005f
C405 DELAY_VBIASP a_24523_1842# 0.06316f
C406 VDD a_8563_1842# 0.85896f
C407 a_27997_1842# a_27563_1842# 0.69646f
C408 a_9323_1842# DELAY_VBIASN 0.06812f
C409 DELAY_VBIASP a_6913_1842# 0.11005f
C410 DELAY_VBIASP DELAY_OUT_TAP19 0.03913f
C411 a_25153_1842# a_25283_1842# 0.69911f
C412 DELAY_OUT_TAP4 VDD 0.7981f
C413 VDD DELAY_OUT_TAP30 0.7981f
C414 DELAY_OUT_TAP6 DELAY_VBIASN 0.04023f
C415 VDD a_5523_1842# 0.85896f
C416 DELAY_VBIASP a_26043_1842# 0.06316f
C417 DELAY_OUT_TAP20 a_18313_1842# 0.0114f
C418 a_24393_1842# DELAY_OUT_TAP28 0.0114f
C419 a_4763_1842# a_4871_1842# 0.01163f
C420 a_16033_1842# DELAY_VBIASP 0.11005f
C421 VDD a_12233_1842# 0.70781f
C422 DELAY_OUT_TAP24 VDD 0.7981f
C423 DELAY_OUT_TAP3 a_6153_1842# 0.70708f
C424 a_11473_1842# DELAY_OUT_TAP11 0.0114f
C425 a_12993_1842# DELAY_VBIASN 0.10296f
C426 VDD a_17031_2470# 0.02372f
C427 DELAY_OUT_TAP24 a_21483_1842# 0.69646f
C428 a_9953_1842# DELAY_VBIASN 0.10296f
C429 a_27433_1842# DELAY_OUT_TAP31 0.70708f
C430 a_17683_1842# DELAY_VBIASN 0.06812f
C431 DELAY_VBIASP a_9323_1842# 0.06316f
C432 a_25283_1842# DELAY_OUT_TAP29 0.69646f
C433 a_14643_1842# a_14751_1842# 0.01163f
C434 VDD a_23871_2470# 0.02372f
C435 VDD a_15273_1842# 0.70781f
C436 DELAY_OUT_TAP6 DELAY_VBIASP 0.03913f
C437 a_8433_1842# a_8563_1842# 0.69911f
C438 DELAY_OUT_TAP13 a_13753_1842# 0.70708f
C439 VDD a_27671_2470# 0.02372f
C440 DELAY_OUT_TAP9 VDD 0.7981f
C441 VDD a_21483_1842# 0.85896f
C442 VDD a_23633_1842# 0.70781f
C443 a_20723_1842# VDD 0.85896f
C444 a_22243_1842# DELAY_VBIASN 0.06812f
C445 a_15273_1842# DELAY_OUT_TAP16 0.0114f
C446 DELAY_OUT_TAP11 DELAY_VBIASN 0.04023f
C447 DELAY_VBIASP a_12993_1842# 0.11005f
C448 a_24393_1842# DELAY_VBIASN 0.10296f
C449 VDD DELAY_OUT_TAP16 0.7981f
C450 DELAY_OUT_TAP8 VDD 0.7981f
C451 a_9953_1842# DELAY_VBIASP 0.11005f
C452 DELAY_VBIASP a_17683_1842# 0.06316f
C453 a_6283_1842# DELAY_VBIASN 0.06812f
C454 DELAY_OUT_TAP18 DELAY_VBIASN 0.04023f
C455 DELAY_OUT_TAP3 a_5523_1842# 0.69646f
C456 VDD a_27997_1842# 0.82658f
C457 a_10083_1842# a_10191_2470# 0.01697f
C458 VDD a_25153_1842# 0.70781f
C459 a_15403_1842# a_15511_2470# 0.01697f
C460 a_5393_1842# a_5523_1842# 0.69911f
C461 VDD a_22351_2470# 0.02372f
C462 a_25913_1842# DELAY_VBIASN 0.10296f
C463 a_15403_1842# DELAY_VBIASN 0.06812f
C464 a_23003_1842# a_23111_2470# 0.01697f
C465 a_16923_1842# DELAY_OUT_TAP18 0.69646f
C466 a_26151_1842# a_26043_1842# 0.01163f
C467 VDD a_4871_2470# 0.02372f
C468 DELAY_OUT_TAP11 DELAY_VBIASP 0.03913f
C469 DELAY_VBIASP a_22243_1842# 0.06316f
C470 DELAY_VBIASP a_24393_1842# 0.11005f
C471 a_20723_1842# a_20831_1842# 0.01163f
C472 VDD a_8433_1842# 0.70781f
C473 a_27433_1842# a_27563_1842# 0.69911f
C474 a_18313_1842# a_18443_1842# 0.69911f
C475 a_9193_1842# DELAY_VBIASN 0.10296f
C476 DELAY_VBIASP a_6283_1842# 0.06316f
C477 DELAY_VBIASP DELAY_OUT_TAP18 0.03913f
C478 DELAY_OUT_TAP3 VDD 0.7981f
C479 VDD DELAY_OUT_TAP29 0.7981f
C480 DELAY_OUT_TAP5 DELAY_VBIASN 0.04023f
C481 DELAY_OUT_TAP6 a_7673_1842# 0.0114f
C482 DELAY_VBIASN DELAY_OUT_TAP31 0.04023f
C483 VDD a_5393_1842# 0.70781f
C484 DELAY_VBIASP a_25913_1842# 0.11005f
C485 a_17683_1842# a_17791_1842# 0.01163f
C486 a_22873_1842# DELAY_OUT_TAP26 0.0114f
C487 DELAY_OUT_TAP13 a_13123_1842# 0.69646f
C488 a_24393_1842# DELAY_OUT_TAP27 0.70708f
C489 a_15403_1842# DELAY_VBIASP 0.06316f
C490 VDD a_11603_1842# 0.85896f
C491 DELAY_OUT_TAP23 VDD 0.7981f
C492 a_13123_1842# a_13231_1842# 0.01163f
C493 a_11473_1842# DELAY_OUT_TAP10 0.70708f
C494 a_12363_1842# DELAY_VBIASN 0.06812f
C495 DELAY_OUT_TAP25 DELAY_VBIASN 0.04023f
C496 VDD a_16271_2470# 0.02372f
C497 DELAY_OUT_TAP24 a_21353_1842# 0.0114f
C498 a_17553_1842# DELAY_VBIASN 0.10296f
C499 a_26803_1842# DELAY_OUT_TAP31 0.69646f
C500 DELAY_OUT_TAP23 a_20723_1842# 0.69646f
C501 DELAY_VBIASP a_9193_1842# 0.11005f
C502 a_25153_1842# DELAY_OUT_TAP29 0.0114f
C503 VDD a_14643_1842# 0.85896f
C504 a_19203_1842# a_19311_2470# 0.01697f
C505 DELAY_OUT_TAP5 DELAY_VBIASP 0.03913f
C506 DELAY_VBIASP DELAY_OUT_TAP31 0.03913f
C507 VDD a_21353_1842# 0.70781f
C508 VDD a_23003_1842# 0.85896f
C509 a_20593_1842# VDD 0.70781f
C510 DELAY_VBIASP a_12363_1842# 0.06316f
C511 DELAY_OUT_TAP10 DELAY_VBIASN 0.04023f
C512 a_15273_1842# DELAY_OUT_TAP15 0.70708f
C513 a_22113_1842# DELAY_VBIASN 0.10296f
C514 DELAY_OUT_TAP25 DELAY_VBIASP 0.03913f
C515 a_23763_1842# DELAY_VBIASN 0.06812f
C516 a_21353_1842# a_21483_1842# 0.69911f
C517 VDD DELAY_OUT_TAP15 0.7981f
R0 DELAY_VBIASN.n1 DELAY_VBIASN.t31 34.3755
R1 DELAY_VBIASN.n1 DELAY_VBIASN.t30 33.0005
R2 DELAY_VBIASN.n2 DELAY_VBIASN.t29 33.0005
R3 DELAY_VBIASN.n3 DELAY_VBIASN.t28 33.0005
R4 DELAY_VBIASN.n4 DELAY_VBIASN.t27 33.0005
R5 DELAY_VBIASN.n5 DELAY_VBIASN.t26 33.0005
R6 DELAY_VBIASN.n6 DELAY_VBIASN.t25 33.0005
R7 DELAY_VBIASN.n7 DELAY_VBIASN.t24 33.0005
R8 DELAY_VBIASN.n8 DELAY_VBIASN.t23 33.0005
R9 DELAY_VBIASN.n9 DELAY_VBIASN.t22 33.0005
R10 DELAY_VBIASN.n10 DELAY_VBIASN.t21 33.0005
R11 DELAY_VBIASN.n11 DELAY_VBIASN.t20 33.0005
R12 DELAY_VBIASN.n12 DELAY_VBIASN.t19 33.0005
R13 DELAY_VBIASN.n13 DELAY_VBIASN.t18 33.0005
R14 DELAY_VBIASN.n14 DELAY_VBIASN.t17 33.0005
R15 DELAY_VBIASN.n15 DELAY_VBIASN.t16 33.0005
R16 DELAY_VBIASN.n16 DELAY_VBIASN.t15 33.0005
R17 DELAY_VBIASN.n17 DELAY_VBIASN.t14 33.0005
R18 DELAY_VBIASN.n18 DELAY_VBIASN.t13 33.0005
R19 DELAY_VBIASN.n19 DELAY_VBIASN.t12 33.0005
R20 DELAY_VBIASN.n20 DELAY_VBIASN.t11 33.0005
R21 DELAY_VBIASN.n21 DELAY_VBIASN.t10 33.0005
R22 DELAY_VBIASN.n22 DELAY_VBIASN.t9 33.0005
R23 DELAY_VBIASN.n23 DELAY_VBIASN.t8 33.0005
R24 DELAY_VBIASN.n24 DELAY_VBIASN.t7 33.0005
R25 DELAY_VBIASN.n25 DELAY_VBIASN.t6 33.0005
R26 DELAY_VBIASN.n26 DELAY_VBIASN.t5 33.0005
R27 DELAY_VBIASN.n27 DELAY_VBIASN.t4 33.0005
R28 DELAY_VBIASN.n28 DELAY_VBIASN.t3 33.0005
R29 DELAY_VBIASN.n29 DELAY_VBIASN.t2 33.0005
R30 DELAY_VBIASN.n30 DELAY_VBIASN.t1 33.0005
R31 DELAY_VBIASN.n0 DELAY_VBIASN.t0 33.0005
R32 DELAY_VBIASN DELAY_VBIASN.n0 1.55517
R33 DELAY_VBIASN.n0 DELAY_VBIASN.n30 1.3755
R34 DELAY_VBIASN.n30 DELAY_VBIASN.n29 1.3755
R35 DELAY_VBIASN.n29 DELAY_VBIASN.n28 1.3755
R36 DELAY_VBIASN.n28 DELAY_VBIASN.n27 1.3755
R37 DELAY_VBIASN.n27 DELAY_VBIASN.n26 1.3755
R38 DELAY_VBIASN.n26 DELAY_VBIASN.n25 1.3755
R39 DELAY_VBIASN.n25 DELAY_VBIASN.n24 1.3755
R40 DELAY_VBIASN.n24 DELAY_VBIASN.n23 1.3755
R41 DELAY_VBIASN.n23 DELAY_VBIASN.n22 1.3755
R42 DELAY_VBIASN.n22 DELAY_VBIASN.n21 1.3755
R43 DELAY_VBIASN.n21 DELAY_VBIASN.n20 1.3755
R44 DELAY_VBIASN.n20 DELAY_VBIASN.n19 1.3755
R45 DELAY_VBIASN.n19 DELAY_VBIASN.n18 1.3755
R46 DELAY_VBIASN.n18 DELAY_VBIASN.n17 1.3755
R47 DELAY_VBIASN.n17 DELAY_VBIASN.n16 1.3755
R48 DELAY_VBIASN.n16 DELAY_VBIASN.n15 1.3755
R49 DELAY_VBIASN.n15 DELAY_VBIASN.n14 1.3755
R50 DELAY_VBIASN.n14 DELAY_VBIASN.n13 1.3755
R51 DELAY_VBIASN.n13 DELAY_VBIASN.n12 1.3755
R52 DELAY_VBIASN.n12 DELAY_VBIASN.n11 1.3755
R53 DELAY_VBIASN.n11 DELAY_VBIASN.n10 1.3755
R54 DELAY_VBIASN.n10 DELAY_VBIASN.n9 1.3755
R55 DELAY_VBIASN.n9 DELAY_VBIASN.n8 1.3755
R56 DELAY_VBIASN.n8 DELAY_VBIASN.n7 1.3755
R57 DELAY_VBIASN.n7 DELAY_VBIASN.n6 1.3755
R58 DELAY_VBIASN.n6 DELAY_VBIASN.n5 1.3755
R59 DELAY_VBIASN.n5 DELAY_VBIASN.n4 1.3755
R60 DELAY_VBIASN.n4 DELAY_VBIASN.n3 1.3755
R61 DELAY_VBIASN.n3 DELAY_VBIASN.n2 1.3755
R62 DELAY_VBIASN.n2 DELAY_VBIASN.n1 1.3755
R63 DELAY_VBIASP.n1 DELAY_VBIASP.t31 34.3685
R64 DELAY_VBIASP.n1 DELAY_VBIASP.t30 33.0005
R65 DELAY_VBIASP.n2 DELAY_VBIASP.t29 33.0005
R66 DELAY_VBIASP.n3 DELAY_VBIASP.t28 33.0005
R67 DELAY_VBIASP.n4 DELAY_VBIASP.t27 33.0005
R68 DELAY_VBIASP.n5 DELAY_VBIASP.t26 33.0005
R69 DELAY_VBIASP.n6 DELAY_VBIASP.t25 33.0005
R70 DELAY_VBIASP.n7 DELAY_VBIASP.t24 33.0005
R71 DELAY_VBIASP.n8 DELAY_VBIASP.t23 33.0005
R72 DELAY_VBIASP.n9 DELAY_VBIASP.t22 33.0005
R73 DELAY_VBIASP.n10 DELAY_VBIASP.t21 33.0005
R74 DELAY_VBIASP.n11 DELAY_VBIASP.t20 33.0005
R75 DELAY_VBIASP.n12 DELAY_VBIASP.t19 33.0005
R76 DELAY_VBIASP.n13 DELAY_VBIASP.t18 33.0005
R77 DELAY_VBIASP.n14 DELAY_VBIASP.t17 33.0005
R78 DELAY_VBIASP.n15 DELAY_VBIASP.t16 33.0005
R79 DELAY_VBIASP.n16 DELAY_VBIASP.t15 33.0005
R80 DELAY_VBIASP.n17 DELAY_VBIASP.t14 33.0005
R81 DELAY_VBIASP.n18 DELAY_VBIASP.t13 33.0005
R82 DELAY_VBIASP.n19 DELAY_VBIASP.t12 33.0005
R83 DELAY_VBIASP.n20 DELAY_VBIASP.t11 33.0005
R84 DELAY_VBIASP.n21 DELAY_VBIASP.t10 33.0005
R85 DELAY_VBIASP.n22 DELAY_VBIASP.t9 33.0005
R86 DELAY_VBIASP.n23 DELAY_VBIASP.t8 33.0005
R87 DELAY_VBIASP.n24 DELAY_VBIASP.t7 33.0005
R88 DELAY_VBIASP.n25 DELAY_VBIASP.t6 33.0005
R89 DELAY_VBIASP.n26 DELAY_VBIASP.t5 33.0005
R90 DELAY_VBIASP.n27 DELAY_VBIASP.t4 33.0005
R91 DELAY_VBIASP.n28 DELAY_VBIASP.t3 33.0005
R92 DELAY_VBIASP.n29 DELAY_VBIASP.t2 33.0005
R93 DELAY_VBIASP.n30 DELAY_VBIASP.t1 33.0005
R94 DELAY_VBIASP.n0 DELAY_VBIASP.t0 33.0005
R95 DELAY_VBIASP DELAY_VBIASP.n0 1.70586
R96 DELAY_VBIASP.n0 DELAY_VBIASP.n30 1.36852
R97 DELAY_VBIASP.n30 DELAY_VBIASP.n29 1.36852
R98 DELAY_VBIASP.n29 DELAY_VBIASP.n28 1.36852
R99 DELAY_VBIASP.n28 DELAY_VBIASP.n27 1.36852
R100 DELAY_VBIASP.n27 DELAY_VBIASP.n26 1.36852
R101 DELAY_VBIASP.n26 DELAY_VBIASP.n25 1.36852
R102 DELAY_VBIASP.n25 DELAY_VBIASP.n24 1.36852
R103 DELAY_VBIASP.n24 DELAY_VBIASP.n23 1.36852
R104 DELAY_VBIASP.n23 DELAY_VBIASP.n22 1.36852
R105 DELAY_VBIASP.n22 DELAY_VBIASP.n21 1.36852
R106 DELAY_VBIASP.n21 DELAY_VBIASP.n20 1.36852
R107 DELAY_VBIASP.n20 DELAY_VBIASP.n19 1.36852
R108 DELAY_VBIASP.n19 DELAY_VBIASP.n18 1.36852
R109 DELAY_VBIASP.n18 DELAY_VBIASP.n17 1.36852
R110 DELAY_VBIASP.n17 DELAY_VBIASP.n16 1.36852
R111 DELAY_VBIASP.n16 DELAY_VBIASP.n15 1.36852
R112 DELAY_VBIASP.n15 DELAY_VBIASP.n14 1.36852
R113 DELAY_VBIASP.n14 DELAY_VBIASP.n13 1.36852
R114 DELAY_VBIASP.n13 DELAY_VBIASP.n12 1.36852
R115 DELAY_VBIASP.n12 DELAY_VBIASP.n11 1.36852
R116 DELAY_VBIASP.n11 DELAY_VBIASP.n10 1.36852
R117 DELAY_VBIASP.n10 DELAY_VBIASP.n9 1.36852
R118 DELAY_VBIASP.n9 DELAY_VBIASP.n8 1.36852
R119 DELAY_VBIASP.n8 DELAY_VBIASP.n7 1.36852
R120 DELAY_VBIASP.n7 DELAY_VBIASP.n6 1.36852
R121 DELAY_VBIASP.n6 DELAY_VBIASP.n5 1.36852
R122 DELAY_VBIASP.n5 DELAY_VBIASP.n4 1.36852
R123 DELAY_VBIASP.n4 DELAY_VBIASP.n3 1.36852
R124 DELAY_VBIASP.n3 DELAY_VBIASP.n2 1.36852
R125 DELAY_VBIASP.n2 DELAY_VBIASP.n1 1.36852
R126 VDD.n58 VDD.n48 1.01297
R127 VDD.n43 VDD.t86 15.1333
R128 VDD.n180 VDD.t89 15.0005
R129 VDD.n636 VDD.n635 9.0005
R130 VDD.n634 VDD.n179 9.0005
R131 VDD.n633 VDD.n632 9.0005
R132 VDD.n631 VDD.n181 9.0005
R133 VDD.n630 VDD.n629 9.0005
R134 VDD.n628 VDD.n182 9.0005
R135 VDD.n627 VDD.n626 9.0005
R136 VDD.n625 VDD.n183 9.0005
R137 VDD.n624 VDD.n623 9.0005
R138 VDD.n622 VDD.n178 9.0005
R139 VDD.n621 VDD.n620 9.0005
R140 VDD.n619 VDD.n184 9.0005
R141 VDD.n618 VDD.n617 9.0005
R142 VDD.n616 VDD.n185 9.0005
R143 VDD.n615 VDD.n614 9.0005
R144 VDD.n187 VDD.n186 9.0005
R145 VDD.n285 VDD.n284 9.0005
R146 VDD.n287 VDD.n286 9.0005
R147 VDD.n288 VDD.n283 9.0005
R148 VDD.n290 VDD.n289 9.0005
R149 VDD.n291 VDD.n282 9.0005
R150 VDD.n293 VDD.n292 9.0005
R151 VDD.n294 VDD.n281 9.0005
R152 VDD.n296 VDD.n295 9.0005
R153 VDD.n297 VDD.n280 9.0005
R154 VDD.n299 VDD.n298 9.0005
R155 VDD.n300 VDD.n279 9.0005
R156 VDD.n302 VDD.n301 9.0005
R157 VDD.n303 VDD.n278 9.0005
R158 VDD.n305 VDD.n304 9.0005
R159 VDD.n306 VDD.n277 9.0005
R160 VDD.n308 VDD.n307 9.0005
R161 VDD.n309 VDD.n276 9.0005
R162 VDD.n311 VDD.n310 9.0005
R163 VDD.n312 VDD.n275 9.0005
R164 VDD.n314 VDD.n313 9.0005
R165 VDD.n315 VDD.n274 9.0005
R166 VDD.n317 VDD.n316 9.0005
R167 VDD.n318 VDD.n273 9.0005
R168 VDD.n320 VDD.n319 9.0005
R169 VDD.n321 VDD.n272 9.0005
R170 VDD.n323 VDD.n322 9.0005
R171 VDD.n324 VDD.n271 9.0005
R172 VDD.n326 VDD.n325 9.0005
R173 VDD.n327 VDD.n270 9.0005
R174 VDD.n329 VDD.n328 9.0005
R175 VDD.n330 VDD.n269 9.0005
R176 VDD.n332 VDD.n331 9.0005
R177 VDD.n333 VDD.n268 9.0005
R178 VDD.n335 VDD.n334 9.0005
R179 VDD.n336 VDD.n267 9.0005
R180 VDD.n338 VDD.n337 9.0005
R181 VDD.n339 VDD.n266 9.0005
R182 VDD.n341 VDD.n340 9.0005
R183 VDD.n342 VDD.n265 9.0005
R184 VDD.n344 VDD.n343 9.0005
R185 VDD.n345 VDD.n264 9.0005
R186 VDD.n347 VDD.n346 9.0005
R187 VDD.n348 VDD.n263 9.0005
R188 VDD.n350 VDD.n349 9.0005
R189 VDD.n351 VDD.n262 9.0005
R190 VDD.n353 VDD.n352 9.0005
R191 VDD.n354 VDD.n261 9.0005
R192 VDD.n356 VDD.n355 9.0005
R193 VDD.n357 VDD.n260 9.0005
R194 VDD.n359 VDD.n358 9.0005
R195 VDD.n360 VDD.n259 9.0005
R196 VDD.n362 VDD.n361 9.0005
R197 VDD.n363 VDD.n258 9.0005
R198 VDD.n365 VDD.n364 9.0005
R199 VDD.n366 VDD.n257 9.0005
R200 VDD.n368 VDD.n367 9.0005
R201 VDD.n369 VDD.n256 9.0005
R202 VDD.n371 VDD.n370 9.0005
R203 VDD.n372 VDD.n255 9.0005
R204 VDD.n374 VDD.n373 9.0005
R205 VDD.n375 VDD.n254 9.0005
R206 VDD.n377 VDD.n376 9.0005
R207 VDD.n378 VDD.n253 9.0005
R208 VDD.n380 VDD.n379 9.0005
R209 VDD.n381 VDD.n252 9.0005
R210 VDD.n383 VDD.n382 9.0005
R211 VDD.n384 VDD.n251 9.0005
R212 VDD.n386 VDD.n385 9.0005
R213 VDD.n387 VDD.n250 9.0005
R214 VDD.n389 VDD.n388 9.0005
R215 VDD.n390 VDD.n249 9.0005
R216 VDD.n392 VDD.n391 9.0005
R217 VDD.n393 VDD.n248 9.0005
R218 VDD.n395 VDD.n394 9.0005
R219 VDD.n396 VDD.n247 9.0005
R220 VDD.n398 VDD.n397 9.0005
R221 VDD.n399 VDD.n246 9.0005
R222 VDD.n401 VDD.n400 9.0005
R223 VDD.n402 VDD.n245 9.0005
R224 VDD.n404 VDD.n403 9.0005
R225 VDD.n405 VDD.n244 9.0005
R226 VDD.n407 VDD.n406 9.0005
R227 VDD.n408 VDD.n243 9.0005
R228 VDD.n410 VDD.n409 9.0005
R229 VDD.n411 VDD.n242 9.0005
R230 VDD.n413 VDD.n412 9.0005
R231 VDD.n414 VDD.n241 9.0005
R232 VDD.n416 VDD.n415 9.0005
R233 VDD.n417 VDD.n240 9.0005
R234 VDD.n419 VDD.n418 9.0005
R235 VDD.n420 VDD.n239 9.0005
R236 VDD.n422 VDD.n421 9.0005
R237 VDD.n423 VDD.n238 9.0005
R238 VDD.n425 VDD.n424 9.0005
R239 VDD.n426 VDD.n237 9.0005
R240 VDD.n428 VDD.n427 9.0005
R241 VDD.n429 VDD.n236 9.0005
R242 VDD.n431 VDD.n430 9.0005
R243 VDD.n432 VDD.n235 9.0005
R244 VDD.n434 VDD.n433 9.0005
R245 VDD.n435 VDD.n234 9.0005
R246 VDD.n437 VDD.n436 9.0005
R247 VDD.n438 VDD.n233 9.0005
R248 VDD.n440 VDD.n439 9.0005
R249 VDD.n441 VDD.n232 9.0005
R250 VDD.n443 VDD.n442 9.0005
R251 VDD.n444 VDD.n231 9.0005
R252 VDD.n446 VDD.n445 9.0005
R253 VDD.n447 VDD.n230 9.0005
R254 VDD.n449 VDD.n448 9.0005
R255 VDD.n450 VDD.n229 9.0005
R256 VDD.n452 VDD.n451 9.0005
R257 VDD.n453 VDD.n228 9.0005
R258 VDD.n455 VDD.n454 9.0005
R259 VDD.n456 VDD.n227 9.0005
R260 VDD.n458 VDD.n457 9.0005
R261 VDD.n459 VDD.n226 9.0005
R262 VDD.n461 VDD.n460 9.0005
R263 VDD.n462 VDD.n225 9.0005
R264 VDD.n464 VDD.n463 9.0005
R265 VDD.n465 VDD.n224 9.0005
R266 VDD.n467 VDD.n466 9.0005
R267 VDD.n468 VDD.n223 9.0005
R268 VDD.n470 VDD.n469 9.0005
R269 VDD.n471 VDD.n222 9.0005
R270 VDD.n473 VDD.n472 9.0005
R271 VDD.n474 VDD.n221 9.0005
R272 VDD.n476 VDD.n475 9.0005
R273 VDD.n477 VDD.n220 9.0005
R274 VDD.n479 VDD.n478 9.0005
R275 VDD.n480 VDD.n219 9.0005
R276 VDD.n482 VDD.n481 9.0005
R277 VDD.n483 VDD.n218 9.0005
R278 VDD.n485 VDD.n484 9.0005
R279 VDD.n486 VDD.n217 9.0005
R280 VDD.n176 VDD.n636 9.0005
R281 VDD.n632 VDD.t9 9.0005
R282 VDD.n630 VDD.n111 0.114852
R283 VDD.n626 VDD.n137 0.114852
R284 VDD.n624 VDD.n0 9.0005
R285 VDD.n620 VDD.n168 0.114852
R286 VDD.n618 VDD.n77 9.0005
R287 VDD.n113 VDD.n78 4.44407
R288 VDD.n142 VDD.n78 4.44407
R289 VDD.n283 VDD.n63 9.0005
R290 VDD.n133 VDD.n63 4.44407
R291 VDD.n281 VDD.n112 0.114852
R292 VDD.n297 VDD.n152 0.114852
R293 VDD.n279 VDD.n129 9.0005
R294 VDD.n303 VDD.n81 0.114852
R295 VDD.n143 VDD.n32 4.44407
R296 VDD.n309 VDD.n136 0.114852
R297 VDD.n275 VDD.n167 0.114852
R298 VDD.n87 VDD.t16 4.44407
R299 VDD.n273 VDD.t16 9.0005
R300 VDD.n321 VDD.n166 0.114852
R301 VDD.n271 VDD.n128 0.114852
R302 VDD.n327 VDD.n171 0.114852
R303 VDD.n269 VDD.n151 9.0005
R304 VDD.n333 VDD.n134 0.114852
R305 VDD.n267 VDD.n76 9.0005
R306 VDD.n339 VDD.n135 0.114852
R307 VDD.n165 VDD.n58 4.44407
R308 VDD.n345 VDD.n58 9.0005
R309 VDD.n263 VDD.n145 0.114852
R310 VDD.n351 VDD.n164 0.114852
R311 VDD.n261 VDD.n141 0.114852
R312 VDD.n357 VDD.n163 0.114852
R313 VDD.n86 VDD.t0 4.44407
R314 VDD.n363 VDD.t0 9.0005
R315 VDD.n162 VDD.n50 4.44407
R316 VDD.n85 VDD.n50 4.44407
R317 VDD.n255 VDD.n149 0.114852
R318 VDD.n375 VDD.n50 9.0005
R319 VDD.n127 VDD.n50 4.44407
R320 VDD.n169 VDD.n50 4.44407
R321 VDD.n251 VDD.n140 0.114852
R322 VDD.n148 VDD.n50 4.44407
R323 VDD.n249 VDD.n50 9.0005
R324 VDD.n126 VDD.n50 4.44407
R325 VDD.n170 VDD.n40 4.44407
R326 VDD.n84 VDD.n40 4.44407
R327 VDD.n245 VDD.n147 0.114852
R328 VDD.n405 VDD.n40 9.0005
R329 VDD.n125 VDD.n40 4.44407
R330 VDD.n411 VDD.n161 0.114852
R331 VDD.n122 VDD.n60 4.44407
R332 VDD.n417 VDD.n160 0.114852
R333 VDD.n239 VDD.n60 9.0005
R334 VDD.n423 VDD.n83 0.114852
R335 VDD.n144 VDD.n35 4.44407
R336 VDD.n429 VDD.n139 0.114852
R337 VDD.n235 VDD.n146 0.114852
R338 VDD.n435 VDD.n35 9.0005
R339 VDD.n124 VDD.n45 4.44407
R340 VDD.n441 VDD.n159 0.114852
R341 VDD.n231 VDD.n132 0.114852
R342 VDD.n447 VDD.n158 0.114852
R343 VDD.n229 VDD.n82 0.114852
R344 VDD.n453 VDD.n21 9.0005
R345 VDD.n227 VDD.n157 0.114852
R346 VDD.n459 VDD.n138 0.114852
R347 VDD.n225 VDD.n156 0.114852
R348 VDD.n465 VDD.n131 0.114852
R349 VDD.n223 VDD.n54 9.0005
R350 VDD.n471 VDD.n155 0.114852
R351 VDD.n221 VDD.n79 0.114852
R352 VDD.n154 VDD.n4 4.44407
R353 VDD.n219 VDD.n123 0.114852
R354 VDD.n483 VDD.n4 9.0005
R355 VDD.n153 VDD.n4 4.44407
R356 VDD.n487 VDD.n4 9.0005
R357 VDD.n484 VDD.n153 0.114852
R358 VDD.n123 VDD.n4 4.44407
R359 VDD.n478 VDD.n154 0.114852
R360 VDD.n79 VDD.n4 4.44407
R361 VDD.n472 VDD.n4 9.0005
R362 VDD.n155 VDD.n4 4.44407
R363 VDD.n131 VDD.n54 4.44407
R364 VDD.n156 VDD.n54 4.44407
R365 VDD.n138 VDD.n54 4.44407
R366 VDD.n458 VDD.n21 9.0005
R367 VDD.n157 VDD.n21 4.44407
R368 VDD.n82 VDD.n21 4.44407
R369 VDD.n158 VDD.n21 4.44407
R370 VDD.n446 VDD.n21 9.0005
R371 VDD.n132 VDD.n45 4.44407
R372 VDD.n159 VDD.n45 4.44407
R373 VDD.n436 VDD.n124 0.114852
R374 VDD.n146 VDD.n35 4.44407
R375 VDD.n139 VDD.n35 4.44407
R376 VDD.n428 VDD.n35 9.0005
R377 VDD.n424 VDD.n144 0.114852
R378 VDD.n83 VDD.n35 4.44407
R379 VDD.n160 VDD.n60 4.44407
R380 VDD.n416 VDD.n60 9.0005
R381 VDD.n412 VDD.n122 0.114852
R382 VDD.n161 VDD.n40 4.44407
R383 VDD.n406 VDD.n125 0.114852
R384 VDD.n147 VDD.n40 4.44407
R385 VDD.n400 VDD.n84 0.114852
R386 VDD.n398 VDD.n40 9.0005
R387 VDD.n394 VDD.n170 0.114852
R388 VDD.n392 VDD.n126 0.114852
R389 VDD.n388 VDD.n148 0.114852
R390 VDD.n140 VDD.n50 4.44407
R391 VDD.n382 VDD.n50 9.0005
R392 VDD.n380 VDD.n169 0.114852
R393 VDD.n376 VDD.n127 0.114852
R394 VDD.n149 VDD.n50 4.44407
R395 VDD.n370 VDD.n85 0.114852
R396 VDD.n368 VDD.n50 9.0005
R397 VDD.n364 VDD.n162 0.114852
R398 VDD.n362 VDD.n86 0.114852
R399 VDD.n163 VDD.t0 4.44407
R400 VDD.n141 VDD.t0 4.44407
R401 VDD.n164 VDD.n58 4.44407
R402 VDD.n145 VDD.n58 4.44407
R403 VDD.n344 VDD.n165 0.114852
R404 VDD.n340 VDD.n58 9.0005
R405 VDD.n135 VDD.n76 4.44407
R406 VDD.n134 VDD.n76 4.44407
R407 VDD.n332 VDD.n75 9.0005
R408 VDD.n171 VDD.n151 4.44407
R409 VDD.n326 VDD.n30 9.0005
R410 VDD.n128 VDD.t16 4.44407
R411 VDD.n166 VDD.t16 4.44407
R412 VDD.n316 VDD.n87 0.114852
R413 VDD.n167 VDD.t16 4.44407
R414 VDD.n136 VDD.t16 4.44407
R415 VDD.n308 VDD.n32 9.0005
R416 VDD.n304 VDD.n143 0.114852
R417 VDD.n81 VDD.n32 4.44407
R418 VDD.n152 VDD.n129 4.44407
R419 VDD.n296 VDD.n62 9.0005
R420 VDD.n112 VDD.n63 4.44407
R421 VDD.n290 VDD.n133 0.114852
R422 VDD.n286 VDD.n142 0.114852
R423 VDD.n187 VDD.n78 9.0005
R424 VDD.n185 VDD.n113 0.114852
R425 VDD.n619 VDD.n177 9.0005
R426 VDD.n0 VDD.n168 4.44407
R427 VDD.n137 VDD.n0 4.44407
R428 VDD.n111 VDD.n0 4.44407
R429 VDD.n631 VDD.n0 9.23512
R430 VDD.t9 VDD.n179 9.0005
R431 VDD.n88 VDD.t9 4.44407
R432 VDD.n604 VDD.t9 9.0005
R433 VDD.n121 VDD.t9 4.44407
R434 VDD.n608 VDD.t9 9.0005
R435 VDD.n120 VDD.t6 4.44407
R436 VDD.t6 VDD.n613 9.0005
R437 VDD.n119 VDD.t24 4.44407
R438 VDD.n597 VDD.t24 9.0005
R439 VDD.n118 VDD.t18 4.44407
R440 VDD.n593 VDD.t18 9.0005
R441 VDD.n117 VDD.t14 4.44407
R442 VDD.n589 VDD.t14 9.0005
R443 VDD.n116 VDD.t16 4.44407
R444 VDD.n585 VDD.t16 9.0005
R445 VDD.n115 VDD.t16 4.44407
R446 VDD.n581 VDD.t16 9.0005
R447 VDD.n114 VDD.t16 4.44407
R448 VDD.n577 VDD.t16 9.0005
R449 VDD.n89 VDD.t16 4.44407
R450 VDD.n574 VDD.n89 0.114852
R451 VDD.n573 VDD.n66 9.0005
R452 VDD.n90 VDD.n66 4.44407
R453 VDD.n570 VDD.n90 0.114852
R454 VDD.n569 VDD.n67 9.0005
R455 VDD.n91 VDD.n67 4.44407
R456 VDD.n566 VDD.n91 0.114852
R457 VDD.n565 VDD.n7 9.0005
R458 VDD.n92 VDD.n7 4.44407
R459 VDD.n562 VDD.n92 0.114852
R460 VDD.n561 VDD.n8 9.0005
R461 VDD.n93 VDD.n8 4.44407
R462 VDD.n558 VDD.n93 0.114852
R463 VDD.n557 VDD.n8 9.0005
R464 VDD.n94 VDD.n8 4.44407
R465 VDD.n554 VDD.n94 0.114852
R466 VDD.n553 VDD.n5 9.0005
R467 VDD.n95 VDD.n5 4.44407
R468 VDD.n550 VDD.n95 0.114852
R469 VDD.n549 VDD.n6 9.0005
R470 VDD.n96 VDD.n6 4.44407
R471 VDD.n546 VDD.n96 0.114852
R472 VDD.n545 VDD.n6 9.0005
R473 VDD.n97 VDD.n6 4.44407
R474 VDD.n542 VDD.n97 0.114852
R475 VDD.n541 VDD.n15 9.0005
R476 VDD.n98 VDD.n15 4.44407
R477 VDD.n538 VDD.n98 0.114852
R478 VDD.n537 VDD.n16 9.0005
R479 VDD.n99 VDD.n16 4.44407
R480 VDD.n534 VDD.n99 0.114852
R481 VDD.n533 VDD.n16 9.0005
R482 VDD.n100 VDD.n16 4.44407
R483 VDD.n530 VDD.n100 0.114852
R484 VDD.n529 VDD.n12 9.0005
R485 VDD.n101 VDD.n12 4.44407
R486 VDD.n526 VDD.n101 0.114852
R487 VDD.n525 VDD.n12 9.0005
R488 VDD.n102 VDD.n12 4.44407
R489 VDD.n522 VDD.n102 0.114852
R490 VDD.n521 VDD.n13 9.0005
R491 VDD.n103 VDD.n13 4.44407
R492 VDD.n518 VDD.n103 0.114852
R493 VDD.n517 VDD.n13 9.0005
R494 VDD.n104 VDD.n13 4.44407
R495 VDD.n514 VDD.n104 0.114852
R496 VDD.n513 VDD.n9 9.0005
R497 VDD.n105 VDD.n9 4.44407
R498 VDD.n510 VDD.n105 0.114852
R499 VDD.n509 VDD.n9 9.0005
R500 VDD.n106 VDD.n9 4.44407
R501 VDD.n506 VDD.n106 0.114852
R502 VDD.n505 VDD.n10 9.0005
R503 VDD.n107 VDD.n10 4.44407
R504 VDD.n502 VDD.n107 0.114852
R505 VDD.n501 VDD.n10 9.0005
R506 VDD.n108 VDD.n10 4.44407
R507 VDD.n498 VDD.n108 0.114852
R508 VDD.n497 VDD.n64 9.0005
R509 VDD.n109 VDD.n64 4.44407
R510 VDD.n494 VDD.n109 0.114852
R511 VDD.n493 VDD.n28 9.0005
R512 VDD.n110 VDD.n28 4.44407
R513 VDD.n490 VDD.n110 0.114852
R514 VDD.n489 VDD.n28 9.0005
R515 VDD.n88 VDD.n602 9.11485
R516 VDD.n603 VDD.n601 9.0005
R517 VDD.n605 VDD.n604 9.0005
R518 VDD.n121 VDD.n606 9.11485
R519 VDD.n607 VDD.n600 9.0005
R520 VDD.n609 VDD.n608 9.0005
R521 VDD.n610 VDD.n120 9.11485
R522 VDD.n611 VDD.n188 9.0005
R523 VDD.n613 VDD.n612 9.0005
R524 VDD.n599 VDD.n119 9.11485
R525 VDD.n598 VDD.n189 9.0005
R526 VDD.n597 VDD.n596 9.0005
R527 VDD.n595 VDD.n118 9.11485
R528 VDD.n594 VDD.n190 9.0005
R529 VDD.n593 VDD.n592 9.0005
R530 VDD.n591 VDD.n117 9.11485
R531 VDD.n590 VDD.n191 9.0005
R532 VDD.n589 VDD.n588 9.0005
R533 VDD.n587 VDD.n116 9.11485
R534 VDD.n586 VDD.n192 9.0005
R535 VDD.n585 VDD.n584 9.0005
R536 VDD.n583 VDD.n115 9.11485
R537 VDD.n582 VDD.n193 9.0005
R538 VDD.n581 VDD.n580 9.0005
R539 VDD.n579 VDD.n114 9.11485
R540 VDD.n578 VDD.n194 9.0005
R541 VDD.n577 VDD.n576 9.0005
R542 VDD.n574 VDD.n195 9.0005
R543 VDD.n573 VDD.n572 9.0005
R544 VDD.n570 VDD.n196 9.0005
R545 VDD.n569 VDD.n568 9.0005
R546 VDD.n566 VDD.n197 9.0005
R547 VDD.n565 VDD.n564 9.0005
R548 VDD.n562 VDD.n198 9.0005
R549 VDD.n561 VDD.n560 9.0005
R550 VDD.n558 VDD.n199 9.0005
R551 VDD.n557 VDD.n556 9.0005
R552 VDD.n554 VDD.n200 9.0005
R553 VDD.n553 VDD.n552 9.0005
R554 VDD.n550 VDD.n201 9.0005
R555 VDD.n549 VDD.n548 9.0005
R556 VDD.n546 VDD.n202 9.0005
R557 VDD.n545 VDD.n544 9.0005
R558 VDD.n542 VDD.n203 9.0005
R559 VDD.n541 VDD.n540 9.0005
R560 VDD.n538 VDD.n204 9.0005
R561 VDD.n537 VDD.n536 9.0005
R562 VDD.n534 VDD.n205 9.0005
R563 VDD.n533 VDD.n532 9.0005
R564 VDD.n530 VDD.n206 9.0005
R565 VDD.n529 VDD.n528 9.0005
R566 VDD.n526 VDD.n207 9.0005
R567 VDD.n525 VDD.n524 9.0005
R568 VDD.n522 VDD.n208 9.0005
R569 VDD.n521 VDD.n520 9.0005
R570 VDD.n518 VDD.n209 9.0005
R571 VDD.n517 VDD.n516 9.0005
R572 VDD.n514 VDD.n210 9.0005
R573 VDD.n513 VDD.n512 9.0005
R574 VDD.n510 VDD.n211 9.0005
R575 VDD.n509 VDD.n508 9.0005
R576 VDD.n506 VDD.n212 9.0005
R577 VDD.n505 VDD.n504 9.0005
R578 VDD.n502 VDD.n213 9.0005
R579 VDD.n501 VDD.n500 9.0005
R580 VDD.n498 VDD.n214 9.0005
R581 VDD.n497 VDD.n496 9.0005
R582 VDD.n494 VDD.n215 9.0005
R583 VDD.n493 VDD.n492 9.0005
R584 VDD.n490 VDD.n216 9.0005
R585 VDD.n489 VDD.n488 9.0005
R586 VDD.n23 VDD.n176 0.653254
R587 VDD.t0 VDD.n0 1.4532
R588 VDD.n0 VDD.n177 0.162881
R589 VDD.t0 VDD.n71 0.689025
R590 VDD.n130 VDD.n62 0.298772
R591 VDD.t0 VDD.n130 1.43803
R592 VDD.t0 VDD.n31 0.356284
R593 VDD.n150 VDD.n30 0.209275
R594 VDD.t0 VDD.n150 1.47558
R595 VDD.t0 VDD.n68 0.50628
R596 VDD.n68 VDD.n58 0.46391
R597 VDD.t0 VDD.n48 0.64736
R598 VDD.n47 VDD.n40 0.705904
R599 VDD.t0 VDD.n72 0.334519
R600 VDD.n36 VDD.n35 0.552178
R601 VDD.t0 VDD.n36 0.371988
R602 VDD.n52 VDD.n54 0.432954
R603 VDD.n175 VDD.n43 0.291571
R604 VDD.t0 VDD.n23 0.281781
R605 VDD.t0 VDD.n55 0.608154
R606 VDD.n55 VDD.t24 0.359066
R607 VDD.t0 VDD.t18 1.57285
R608 VDD.n22 VDD.t14 0.462537
R609 VDD.n22 VDD.t16 0.195942
R610 VDD.n19 VDD.n174 0.285322
R611 VDD.n61 VDD.n80 3.06081
R612 VDD.t16 VDD.t31 6.09901
R613 VDD.n66 VDD.t26 6.09901
R614 VDD.n67 VDD.t11 6.09901
R615 VDD.n7 VDD.t7 6.09901
R616 VDD.n8 VDD.t4 6.09901
R617 VDD.n8 VDD.t15 6.09901
R618 VDD.n5 VDD.t23 6.09901
R619 VDD.n6 VDD.t17 6.09901
R620 VDD.n6 VDD.t2 6.09901
R621 VDD.n15 VDD.t1 6.09901
R622 VDD.n16 VDD.t12 6.09901
R623 VDD.n16 VDD.t8 6.09901
R624 VDD.n12 VDD.t5 6.09901
R625 VDD.n12 VDD.t25 6.09901
R626 VDD.n13 VDD.t19 6.09901
R627 VDD.n13 VDD.t20 6.09901
R628 VDD.n9 VDD.t13 6.09901
R629 VDD.n9 VDD.t28 6.09901
R630 VDD.n10 VDD.t30 6.09901
R631 VDD.n10 VDD.t27 6.09901
R632 VDD.n64 VDD.t21 6.09901
R633 VDD.n28 VDD.t92 6.09901
R634 VDD.n28 VDD.t3 6.09901
R635 VDD.n19 VDD.t29 6.09901
R636 VDD.n71 VDD.n78 0.309689
R637 VDD.t0 VDD.n47 0.299539
R638 VDD.t0 VDD.n27 0.13322
R639 VDD.n27 VDD.n25 0.367568
R640 VDD.n65 VDD.n67 0.363564
R641 VDD.t0 VDD.n65 0.61812
R642 VDD.t0 VDD.n41 0.353262
R643 VDD.n41 VDD.n5 0.461583
R644 VDD.t0 VDD.n42 0.353262
R645 VDD.n42 VDD.n15 0.461583
R646 VDD.n14 VDD.n16 0.284639
R647 VDD.t0 VDD.n14 0.217932
R648 VDD.n11 VDD.n13 0.284639
R649 VDD.t0 VDD.n11 0.217932
R650 VDD.t0 VDD.n10 0.718004
R651 VDD.n28 VDD.n64 0.471263
R652 VDD.t0 VDD.n29 0.575646
R653 VDD.n172 VDD.t91 5.60347
R654 VDD.n173 VDD.t88 5.60347
R655 VDD.n74 VDD.t56 5.59675
R656 VDD.n56 VDD.t40 5.59675
R657 VDD.n57 VDD.t39 5.59675
R658 VDD.n46 VDD.t47 5.59675
R659 VDD.n50 VDD.t57 5.59675
R660 VDD.n73 VDD.t38 5.59675
R661 VDD.n49 VDD.t58 5.59675
R662 VDD.n69 VDD.t52 5.59675
R663 VDD.n37 VDD.t41 5.59675
R664 VDD.n38 VDD.t44 5.59675
R665 VDD.n39 VDD.t43 5.59675
R666 VDD.n59 VDD.t42 5.59675
R667 VDD.n34 VDD.t61 5.59675
R668 VDD.n33 VDD.t62 5.59675
R669 VDD.n44 VDD.t60 5.59675
R670 VDD.n51 VDD.t59 5.59675
R671 VDD.n20 VDD.t45 5.59675
R672 VDD.n53 VDD.t68 5.59675
R673 VDD.n3 VDD.t67 5.59675
R674 VDD.n1 VDD.t66 5.59675
R675 VDD.n2 VDD.t65 5.59675
R676 VDD.n24 VDD.t64 5.59675
R677 VDD.n18 VDD.t63 5.59675
R678 VDD.n17 VDD.t87 5.59675
R679 VDD.n635 VDD 4.16808
R680 VDD.t0 VDD.n175 1.0646
R681 VDD.n78 VDD.t6 0.973539
R682 VDD.n63 VDD.t24 0.973539
R683 VDD.n129 VDD.t18 0.973539
R684 VDD.n32 VDD.t14 0.973539
R685 VDD.n151 VDD.t16 0.973539
R686 VDD.n606 VDD.n605 0.692362
R687 VDD.n610 VDD.n609 0.692362
R688 VDD.n612 VDD.n599 0.692362
R689 VDD.n596 VDD.n595 0.692362
R690 VDD.n592 VDD.n591 0.692362
R691 VDD.n588 VDD.n587 0.692362
R692 VDD.n584 VDD.n583 0.692362
R693 VDD.n580 VDD.n579 0.692362
R694 VDD.n576 VDD.n575 0.692362
R695 VDD.n572 VDD.n571 0.692362
R696 VDD.n568 VDD.n567 0.692362
R697 VDD.n564 VDD.n563 0.692362
R698 VDD.n560 VDD.n559 0.692362
R699 VDD.n556 VDD.n555 0.692362
R700 VDD.n552 VDD.n551 0.692362
R701 VDD.n548 VDD.n547 0.692362
R702 VDD.n544 VDD.n543 0.692362
R703 VDD.n540 VDD.n539 0.692362
R704 VDD.n536 VDD.n535 0.692362
R705 VDD.n532 VDD.n531 0.692362
R706 VDD.n528 VDD.n527 0.692362
R707 VDD.n524 VDD.n523 0.692362
R708 VDD.n520 VDD.n519 0.692362
R709 VDD.n516 VDD.n515 0.692362
R710 VDD.n512 VDD.n511 0.692362
R711 VDD.n508 VDD.n507 0.692362
R712 VDD.n504 VDD.n503 0.692362
R713 VDD.n500 VDD.n499 0.692362
R714 VDD.n496 VDD.n495 0.692362
R715 VDD.n492 VDD.n491 0.692362
R716 VDD.n488 VDD.n19 6.7288
R717 VDD.n76 VDD.n74 0.495398
R718 VDD.n58 VDD.n56 0.495398
R719 VDD.n58 VDD.n57 0.495398
R720 VDD.t0 VDD.n46 0.495398
R721 VDD.n50 VDD.n49 0.495398
R722 VDD.n40 VDD.n37 0.495398
R723 VDD.n40 VDD.n38 0.495398
R724 VDD.n40 VDD.n39 0.495398
R725 VDD.n60 VDD.n59 0.495398
R726 VDD.n35 VDD.n34 0.495398
R727 VDD.n35 VDD.n33 0.495398
R728 VDD.n45 VDD.n44 0.495398
R729 VDD.n21 VDD.n20 0.495398
R730 VDD.n54 VDD.n53 0.495398
R731 VDD.n4 VDD.n3 0.495398
R732 VDD.n4 VDD.n1 0.495398
R733 VDD.n4 VDD.n2 0.495398
R734 VDD.n18 VDD.n25 0.495398
R735 VDD.n17 VDD.n43 0.495398
R736 VDD.n74 VDD.n66 0.478641
R737 VDD.n56 VDD.n67 0.478641
R738 VDD.n57 VDD.n7 0.478641
R739 VDD.n46 VDD.n8 0.478641
R740 VDD.n73 VDD.n5 0.478641
R741 VDD.n49 VDD.n6 0.478641
R742 VDD.n69 VDD.n6 0.478641
R743 VDD.n37 VDD.n15 0.478641
R744 VDD.n38 VDD.n16 0.478641
R745 VDD.n59 VDD.n12 0.478641
R746 VDD.n33 VDD.n13 0.478641
R747 VDD.n51 VDD.n9 0.478641
R748 VDD.n53 VDD.n10 0.478641
R749 VDD.n1 VDD.n64 0.478641
R750 VDD.n2 VDD.n28 0.478641
R751 VDD.n24 VDD.n28 0.478641
R752 VDD.n19 VDD.n18 0.478641
R753 VDD.n19 VDD.n17 0.478641
R754 VDD.n173 VDD.n43 0.446112
R755 VDD.n175 VDD.n174 0.535684
R756 VDD.n174 VDD.n172 0.426806
R757 VDD.n174 VDD.n173 0.426806
R758 VDD.n151 VDD.n150 0.405949
R759 VDD.n176 VDD.n61 0.196296
R760 VDD.n634 VDD.n633 0.346431
R761 VDD.n602 VDD.n70 0.460801
R762 VDD.n76 VDD.n75 0.334506
R763 VDD.n130 VDD.n129 0.1153
R764 VDD.n78 VDD.n77 0.3345
R765 VDD.n63 VDD.n62 0.3345
R766 VDD.n172 VDD.n180 0.313353
R767 VDD.n180 VDD.n43 0.278994
R768 VDD.n151 VDD.n75 0.237981
R769 VDD.n177 VDD.n77 0.237981
R770 VDD.n635 VDD.n634 0.231121
R771 VDD.n633 VDD.n181 0.231121
R772 VDD.n629 VDD.n181 0.231121
R773 VDD.n629 VDD.n628 0.231121
R774 VDD.n628 VDD.n627 0.231121
R775 VDD.n627 VDD.n183 0.231121
R776 VDD.n623 VDD.n183 0.231121
R777 VDD.n623 VDD.n622 0.231121
R778 VDD.n622 VDD.n621 0.231121
R779 VDD.n621 VDD.n184 0.231121
R780 VDD.n617 VDD.n184 0.231121
R781 VDD.n617 VDD.n616 0.231121
R782 VDD.n616 VDD.n615 0.231121
R783 VDD.n615 VDD.n186 0.231121
R784 VDD.n284 VDD.n186 0.231121
R785 VDD.n287 VDD.n284 0.231121
R786 VDD.n288 VDD.n287 0.231121
R787 VDD.n289 VDD.n288 0.231121
R788 VDD.n289 VDD.n282 0.231121
R789 VDD.n293 VDD.n282 0.231121
R790 VDD.n294 VDD.n293 0.231121
R791 VDD.n295 VDD.n294 0.231121
R792 VDD.n295 VDD.n280 0.231121
R793 VDD.n299 VDD.n280 0.231121
R794 VDD.n300 VDD.n299 0.231121
R795 VDD.n301 VDD.n300 0.231121
R796 VDD.n301 VDD.n278 0.231121
R797 VDD.n305 VDD.n278 0.231121
R798 VDD.n306 VDD.n305 0.231121
R799 VDD.n307 VDD.n306 0.231121
R800 VDD.n307 VDD.n276 0.231121
R801 VDD.n311 VDD.n276 0.231121
R802 VDD.n312 VDD.n311 0.231121
R803 VDD.n313 VDD.n312 0.231121
R804 VDD.n313 VDD.n274 0.231121
R805 VDD.n317 VDD.n274 0.231121
R806 VDD.n318 VDD.n317 0.231121
R807 VDD.n319 VDD.n318 0.231121
R808 VDD.n319 VDD.n272 0.231121
R809 VDD.n323 VDD.n272 0.231121
R810 VDD.n324 VDD.n323 0.231121
R811 VDD.n325 VDD.n324 0.231121
R812 VDD.n325 VDD.n270 0.231121
R813 VDD.n329 VDD.n270 0.231121
R814 VDD.n330 VDD.n329 0.231121
R815 VDD.n331 VDD.n330 0.231121
R816 VDD.n331 VDD.n268 0.231121
R817 VDD.n335 VDD.n268 0.231121
R818 VDD.n336 VDD.n335 0.231121
R819 VDD.n337 VDD.n336 0.231121
R820 VDD.n337 VDD.n266 0.231121
R821 VDD.n341 VDD.n266 0.231121
R822 VDD.n342 VDD.n341 0.231121
R823 VDD.n343 VDD.n342 0.231121
R824 VDD.n343 VDD.n264 0.231121
R825 VDD.n347 VDD.n264 0.231121
R826 VDD.n348 VDD.n347 0.231121
R827 VDD.n349 VDD.n348 0.231121
R828 VDD.n349 VDD.n262 0.231121
R829 VDD.n353 VDD.n262 0.231121
R830 VDD.n354 VDD.n353 0.231121
R831 VDD.n355 VDD.n354 0.231121
R832 VDD.n355 VDD.n260 0.231121
R833 VDD.n359 VDD.n260 0.231121
R834 VDD.n360 VDD.n359 0.231121
R835 VDD.n361 VDD.n360 0.231121
R836 VDD.n361 VDD.n258 0.231121
R837 VDD.n365 VDD.n258 0.231121
R838 VDD.n366 VDD.n365 0.231121
R839 VDD.n367 VDD.n366 0.231121
R840 VDD.n367 VDD.n256 0.231121
R841 VDD.n371 VDD.n256 0.231121
R842 VDD.n372 VDD.n371 0.231121
R843 VDD.n373 VDD.n372 0.231121
R844 VDD.n373 VDD.n254 0.231121
R845 VDD.n377 VDD.n254 0.231121
R846 VDD.n378 VDD.n377 0.231121
R847 VDD.n379 VDD.n378 0.231121
R848 VDD.n379 VDD.n252 0.231121
R849 VDD.n383 VDD.n252 0.231121
R850 VDD.n384 VDD.n383 0.231121
R851 VDD.n385 VDD.n384 0.231121
R852 VDD.n385 VDD.n250 0.231121
R853 VDD.n389 VDD.n250 0.231121
R854 VDD.n390 VDD.n389 0.231121
R855 VDD.n391 VDD.n390 0.231121
R856 VDD.n391 VDD.n248 0.231121
R857 VDD.n395 VDD.n248 0.231121
R858 VDD.n396 VDD.n395 0.231121
R859 VDD.n397 VDD.n396 0.231121
R860 VDD.n397 VDD.n246 0.231121
R861 VDD.n401 VDD.n246 0.231121
R862 VDD.n402 VDD.n401 0.231121
R863 VDD.n403 VDD.n402 0.231121
R864 VDD.n403 VDD.n244 0.231121
R865 VDD.n407 VDD.n244 0.231121
R866 VDD.n408 VDD.n407 0.231121
R867 VDD.n409 VDD.n408 0.231121
R868 VDD.n409 VDD.n242 0.231121
R869 VDD.n413 VDD.n242 0.231121
R870 VDD.n414 VDD.n413 0.231121
R871 VDD.n415 VDD.n414 0.231121
R872 VDD.n415 VDD.n240 0.231121
R873 VDD.n419 VDD.n240 0.231121
R874 VDD.n420 VDD.n419 0.231121
R875 VDD.n421 VDD.n420 0.231121
R876 VDD.n421 VDD.n238 0.231121
R877 VDD.n425 VDD.n238 0.231121
R878 VDD.n426 VDD.n425 0.231121
R879 VDD.n427 VDD.n426 0.231121
R880 VDD.n427 VDD.n236 0.231121
R881 VDD.n431 VDD.n236 0.231121
R882 VDD.n432 VDD.n431 0.231121
R883 VDD.n433 VDD.n432 0.231121
R884 VDD.n433 VDD.n234 0.231121
R885 VDD.n437 VDD.n234 0.231121
R886 VDD.n438 VDD.n437 0.231121
R887 VDD.n439 VDD.n438 0.231121
R888 VDD.n439 VDD.n232 0.231121
R889 VDD.n443 VDD.n232 0.231121
R890 VDD.n444 VDD.n443 0.231121
R891 VDD.n445 VDD.n444 0.231121
R892 VDD.n445 VDD.n230 0.231121
R893 VDD.n449 VDD.n230 0.231121
R894 VDD.n450 VDD.n449 0.231121
R895 VDD.n451 VDD.n450 0.231121
R896 VDD.n451 VDD.n228 0.231121
R897 VDD.n455 VDD.n228 0.231121
R898 VDD.n456 VDD.n455 0.231121
R899 VDD.n457 VDD.n456 0.231121
R900 VDD.n457 VDD.n226 0.231121
R901 VDD.n461 VDD.n226 0.231121
R902 VDD.n462 VDD.n461 0.231121
R903 VDD.n463 VDD.n462 0.231121
R904 VDD.n463 VDD.n224 0.231121
R905 VDD.n467 VDD.n224 0.231121
R906 VDD.n468 VDD.n467 0.231121
R907 VDD.n469 VDD.n468 0.231121
R908 VDD.n469 VDD.n222 0.231121
R909 VDD.n473 VDD.n222 0.231121
R910 VDD.n474 VDD.n473 0.231121
R911 VDD.n475 VDD.n474 0.231121
R912 VDD.n475 VDD.n220 0.231121
R913 VDD.n479 VDD.n220 0.231121
R914 VDD.n480 VDD.n479 0.231121
R915 VDD.n481 VDD.n480 0.231121
R916 VDD.n481 VDD.n218 0.231121
R917 VDD.n485 VDD.n218 0.231121
R918 VDD.n486 VDD.n485 0.231121
R919 VDD.n26 VDD.n486 1.52954
R920 VDD.n26 VDD.n25 1.07131
R921 VDD.n70 VDD 4.2828
R922 VDD.n602 VDD.n601 0.231121
R923 VDD.n605 VDD.n601 0.231121
R924 VDD.n606 VDD.n600 0.231121
R925 VDD.n609 VDD.n600 0.231121
R926 VDD.n611 VDD.n610 0.231121
R927 VDD.n612 VDD.n611 0.231121
R928 VDD.n599 VDD.n189 0.231121
R929 VDD.n596 VDD.n189 0.231121
R930 VDD.n595 VDD.n190 0.231121
R931 VDD.n592 VDD.n190 0.231121
R932 VDD.n591 VDD.n191 0.231121
R933 VDD.n588 VDD.n191 0.231121
R934 VDD.n587 VDD.n192 0.231121
R935 VDD.n584 VDD.n192 0.231121
R936 VDD.n583 VDD.n193 0.231121
R937 VDD.n580 VDD.n193 0.231121
R938 VDD.n579 VDD.n194 0.231121
R939 VDD.n576 VDD.n194 0.231121
R940 VDD.n575 VDD.n195 0.231121
R941 VDD.n572 VDD.n195 0.231121
R942 VDD.n571 VDD.n196 0.231121
R943 VDD.n568 VDD.n196 0.231121
R944 VDD.n567 VDD.n197 0.231121
R945 VDD.n564 VDD.n197 0.231121
R946 VDD.n563 VDD.n198 0.231121
R947 VDD.n560 VDD.n198 0.231121
R948 VDD.n559 VDD.n199 0.231121
R949 VDD.n556 VDD.n199 0.231121
R950 VDD.n555 VDD.n200 0.231121
R951 VDD.n552 VDD.n200 0.231121
R952 VDD.n551 VDD.n201 0.231121
R953 VDD.n548 VDD.n201 0.231121
R954 VDD.n547 VDD.n202 0.231121
R955 VDD.n544 VDD.n202 0.231121
R956 VDD.n543 VDD.n203 0.231121
R957 VDD.n540 VDD.n203 0.231121
R958 VDD.n539 VDD.n204 0.231121
R959 VDD.n536 VDD.n204 0.231121
R960 VDD.n535 VDD.n205 0.231121
R961 VDD.n532 VDD.n205 0.231121
R962 VDD.n531 VDD.n206 0.231121
R963 VDD.n528 VDD.n206 0.231121
R964 VDD.n527 VDD.n207 0.231121
R965 VDD.n524 VDD.n207 0.231121
R966 VDD.n523 VDD.n208 0.231121
R967 VDD.n520 VDD.n208 0.231121
R968 VDD.n519 VDD.n209 0.231121
R969 VDD.n516 VDD.n209 0.231121
R970 VDD.n515 VDD.n210 0.231121
R971 VDD.n512 VDD.n210 0.231121
R972 VDD.n511 VDD.n211 0.231121
R973 VDD.n508 VDD.n211 0.231121
R974 VDD.n507 VDD.n212 0.231121
R975 VDD.n504 VDD.n212 0.231121
R976 VDD.n503 VDD.n213 0.231121
R977 VDD.n500 VDD.n213 0.231121
R978 VDD.n499 VDD.n214 0.231121
R979 VDD.n496 VDD.n214 0.231121
R980 VDD.n495 VDD.n215 0.231121
R981 VDD.n492 VDD.n215 0.231121
R982 VDD.n491 VDD.n216 0.231121
R983 VDD.n488 VDD.n216 0.231121
R984 VDD.n491 VDD.n110 9.11485
R985 VDD.n490 VDD.n489 0.231121
R986 VDD.n495 VDD.n109 9.11485
R987 VDD.n494 VDD.n493 0.231121
R988 VDD.n499 VDD.n108 9.11485
R989 VDD.n498 VDD.n497 0.231121
R990 VDD.n503 VDD.n107 9.11485
R991 VDD.n502 VDD.n501 0.231121
R992 VDD.n507 VDD.n106 9.11485
R993 VDD.n506 VDD.n505 0.231121
R994 VDD.n511 VDD.n105 9.11485
R995 VDD.n510 VDD.n509 0.231121
R996 VDD.n515 VDD.n104 9.11485
R997 VDD.n514 VDD.n513 0.231121
R998 VDD.n519 VDD.n103 9.11485
R999 VDD.n518 VDD.n517 0.231121
R1000 VDD.n523 VDD.n102 9.11485
R1001 VDD.n522 VDD.n521 0.231121
R1002 VDD.n527 VDD.n101 9.11485
R1003 VDD.n526 VDD.n525 0.231121
R1004 VDD.n531 VDD.n100 9.11485
R1005 VDD.n530 VDD.n529 0.231121
R1006 VDD.n535 VDD.n99 9.11485
R1007 VDD.n534 VDD.n533 0.231121
R1008 VDD.n539 VDD.n98 9.11485
R1009 VDD.n538 VDD.n537 0.231121
R1010 VDD.n543 VDD.n97 9.11485
R1011 VDD.n542 VDD.n541 0.231121
R1012 VDD.n547 VDD.n96 9.11485
R1013 VDD.n546 VDD.n545 0.231121
R1014 VDD.n551 VDD.n95 9.11485
R1015 VDD.n550 VDD.n549 0.231121
R1016 VDD.n555 VDD.n94 9.11485
R1017 VDD.n554 VDD.n553 0.231121
R1018 VDD.n559 VDD.n93 9.11485
R1019 VDD.n558 VDD.n557 0.231121
R1020 VDD.n563 VDD.n92 9.11485
R1021 VDD.n562 VDD.n561 0.231121
R1022 VDD.n567 VDD.n91 9.11485
R1023 VDD.n566 VDD.n565 0.231121
R1024 VDD.n571 VDD.n90 9.11485
R1025 VDD.n570 VDD.n569 0.231121
R1026 VDD.n575 VDD.n89 9.11485
R1027 VDD.n574 VDD.n573 0.231121
R1028 VDD.n114 VDD.n578 0.114852
R1029 VDD.n578 VDD.n577 0.231121
R1030 VDD.n115 VDD.n582 0.114852
R1031 VDD.n582 VDD.n581 0.231121
R1032 VDD.n116 VDD.n586 0.114852
R1033 VDD.n586 VDD.n585 0.231121
R1034 VDD.n117 VDD.n590 0.114852
R1035 VDD.n590 VDD.n589 0.231121
R1036 VDD.n118 VDD.n594 0.114852
R1037 VDD.n594 VDD.n593 0.231121
R1038 VDD.n119 VDD.n598 0.114852
R1039 VDD.n598 VDD.n597 0.231121
R1040 VDD.n120 VDD.n188 0.114852
R1041 VDD.n613 VDD.n188 0.231121
R1042 VDD.n607 VDD.n121 0.114852
R1043 VDD.n608 VDD.n607 0.231121
R1044 VDD.n603 VDD.n88 0.114852
R1045 VDD.n604 VDD.n603 0.231121
R1046 VDD.t9 VDD.n70 8.94481
R1047 VDD.n636 VDD.n179 0.231121
R1048 VDD.n632 VDD.n631 0.231121
R1049 VDD.n631 VDD.n630 0.231121
R1050 VDD.n111 VDD.n182 0.114852
R1051 VDD.n626 VDD.n182 0.231121
R1052 VDD.n137 VDD.n625 0.114852
R1053 VDD.n625 VDD.n624 0.231121
R1054 VDD.n624 VDD.n178 0.231121
R1055 VDD.n168 VDD.n178 0.114852
R1056 VDD.n620 VDD.n619 0.231121
R1057 VDD.n619 VDD.n618 0.231121
R1058 VDD.n618 VDD.n185 0.231121
R1059 VDD.n614 VDD.n113 0.114852
R1060 VDD.n614 VDD.n187 0.231121
R1061 VDD.n285 VDD.n187 0.231121
R1062 VDD.n142 VDD.n285 0.114852
R1063 VDD.n286 VDD.n283 0.231121
R1064 VDD.n290 VDD.n283 0.231121
R1065 VDD.n291 VDD.n133 0.114852
R1066 VDD.n292 VDD.n291 0.231121
R1067 VDD.n292 VDD.n112 0.114852
R1068 VDD.n296 VDD.n281 0.231121
R1069 VDD.n297 VDD.n296 0.231121
R1070 VDD.n298 VDD.n152 0.114852
R1071 VDD.n298 VDD.n279 0.231121
R1072 VDD.n302 VDD.n279 0.231121
R1073 VDD.n81 VDD.n302 0.114852
R1074 VDD.n304 VDD.n303 0.231121
R1075 VDD.n143 VDD.n277 0.114852
R1076 VDD.n308 VDD.n277 0.231121
R1077 VDD.n309 VDD.n308 0.231121
R1078 VDD.n310 VDD.n136 0.114852
R1079 VDD.n310 VDD.n275 0.231121
R1080 VDD.n314 VDD.n167 0.114852
R1081 VDD.n315 VDD.n314 0.231121
R1082 VDD.n87 VDD.n315 0.114852
R1083 VDD.n316 VDD.n273 0.231121
R1084 VDD.n320 VDD.n273 0.231121
R1085 VDD.n166 VDD.n320 0.114852
R1086 VDD.n322 VDD.n321 0.231121
R1087 VDD.n322 VDD.n128 0.114852
R1088 VDD.n326 VDD.n271 0.231121
R1089 VDD.n327 VDD.n326 0.231121
R1090 VDD.n328 VDD.n171 0.114852
R1091 VDD.n328 VDD.n269 0.231121
R1092 VDD.n332 VDD.n269 0.231121
R1093 VDD.n333 VDD.n332 0.231121
R1094 VDD.n334 VDD.n134 0.114852
R1095 VDD.n334 VDD.n267 0.231121
R1096 VDD.n338 VDD.n267 0.231121
R1097 VDD.n135 VDD.n338 0.114852
R1098 VDD.n340 VDD.n339 0.231121
R1099 VDD.n340 VDD.n265 0.231121
R1100 VDD.n165 VDD.n265 0.114852
R1101 VDD.n345 VDD.n344 0.231121
R1102 VDD.n346 VDD.n345 0.231121
R1103 VDD.n346 VDD.n145 0.114852
R1104 VDD.n350 VDD.n263 0.231121
R1105 VDD.n164 VDD.n350 0.114852
R1106 VDD.n352 VDD.n351 0.231121
R1107 VDD.n352 VDD.n261 0.231121
R1108 VDD.n356 VDD.n141 0.114852
R1109 VDD.n357 VDD.n356 0.231121
R1110 VDD.n358 VDD.n163 0.114852
R1111 VDD.n358 VDD.n259 0.231121
R1112 VDD.n86 VDD.n259 0.114852
R1113 VDD.n363 VDD.n362 0.231121
R1114 VDD.n364 VDD.n363 0.231121
R1115 VDD.n162 VDD.n257 0.114852
R1116 VDD.n368 VDD.n257 0.231121
R1117 VDD.n369 VDD.n368 0.231121
R1118 VDD.n85 VDD.n369 0.114852
R1119 VDD.n370 VDD.n255 0.231121
R1120 VDD.n374 VDD.n149 0.114852
R1121 VDD.n375 VDD.n374 0.231121
R1122 VDD.n376 VDD.n375 0.231121
R1123 VDD.n127 VDD.n253 0.114852
R1124 VDD.n380 VDD.n253 0.231121
R1125 VDD.n381 VDD.n169 0.114852
R1126 VDD.n382 VDD.n381 0.231121
R1127 VDD.n382 VDD.n251 0.231121
R1128 VDD.n386 VDD.n140 0.114852
R1129 VDD.n387 VDD.n386 0.231121
R1130 VDD.n148 VDD.n387 0.114852
R1131 VDD.n388 VDD.n249 0.231121
R1132 VDD.n392 VDD.n249 0.231121
R1133 VDD.n393 VDD.n126 0.114852
R1134 VDD.n394 VDD.n393 0.231121
R1135 VDD.n170 VDD.n247 0.114852
R1136 VDD.n398 VDD.n247 0.231121
R1137 VDD.n399 VDD.n398 0.231121
R1138 VDD.n84 VDD.n399 0.114852
R1139 VDD.n400 VDD.n245 0.231121
R1140 VDD.n404 VDD.n147 0.114852
R1141 VDD.n405 VDD.n404 0.231121
R1142 VDD.n406 VDD.n405 0.231121
R1143 VDD.n125 VDD.n243 0.114852
R1144 VDD.n410 VDD.n243 0.231121
R1145 VDD.n161 VDD.n410 0.114852
R1146 VDD.n412 VDD.n411 0.231121
R1147 VDD.n122 VDD.n241 0.114852
R1148 VDD.n416 VDD.n241 0.231121
R1149 VDD.n417 VDD.n416 0.231121
R1150 VDD.n418 VDD.n160 0.114852
R1151 VDD.n418 VDD.n239 0.231121
R1152 VDD.n422 VDD.n239 0.231121
R1153 VDD.n83 VDD.n422 0.114852
R1154 VDD.n424 VDD.n423 0.231121
R1155 VDD.n144 VDD.n237 0.114852
R1156 VDD.n428 VDD.n237 0.231121
R1157 VDD.n429 VDD.n428 0.231121
R1158 VDD.n430 VDD.n139 0.114852
R1159 VDD.n430 VDD.n235 0.231121
R1160 VDD.n434 VDD.n146 0.114852
R1161 VDD.n435 VDD.n434 0.231121
R1162 VDD.n436 VDD.n435 0.231121
R1163 VDD.n124 VDD.n233 0.114852
R1164 VDD.n440 VDD.n233 0.231121
R1165 VDD.n159 VDD.n440 0.114852
R1166 VDD.n442 VDD.n441 0.231121
R1167 VDD.n442 VDD.n132 0.114852
R1168 VDD.n446 VDD.n231 0.231121
R1169 VDD.n447 VDD.n446 0.231121
R1170 VDD.n448 VDD.n158 0.114852
R1171 VDD.n448 VDD.n229 0.231121
R1172 VDD.n452 VDD.n82 0.114852
R1173 VDD.n453 VDD.n452 0.231121
R1174 VDD.n454 VDD.n453 0.231121
R1175 VDD.n454 VDD.n157 0.114852
R1176 VDD.n458 VDD.n227 0.231121
R1177 VDD.n459 VDD.n458 0.231121
R1178 VDD.n460 VDD.n138 0.114852
R1179 VDD.n460 VDD.n225 0.231121
R1180 VDD.n464 VDD.n156 0.114852
R1181 VDD.n465 VDD.n464 0.231121
R1182 VDD.n466 VDD.n131 0.114852
R1183 VDD.n466 VDD.n223 0.231121
R1184 VDD.n470 VDD.n223 0.231121
R1185 VDD.n155 VDD.n470 0.114852
R1186 VDD.n472 VDD.n471 0.231121
R1187 VDD.n472 VDD.n221 0.231121
R1188 VDD.n476 VDD.n79 0.114852
R1189 VDD.n477 VDD.n476 0.231121
R1190 VDD.n154 VDD.n477 0.114852
R1191 VDD.n478 VDD.n219 0.231121
R1192 VDD.n482 VDD.n123 0.114852
R1193 VDD.n483 VDD.n482 0.231121
R1194 VDD.n484 VDD.n483 0.231121
R1195 VDD.n153 VDD.n217 0.114852
R1196 VDD.n487 VDD.n217 0.231121
R1197 VDD.n26 VDD.n487 0.522799
R1198 VDD VDD.n80 3.09434
R1199 VDD VDD.n80 2.93359
R1200 VDD.n50 VDD.n8 1.19433
R1201 VDD.n21 VDD.n51 1.17889
R1202 VDD.n47 VDD.n50 0.332356
R1203 VDD.n50 VDD.n69 1.05723
R1204 VDD.t0 VDD.n52 1.04414
R1205 VDD.n50 VDD.n73 1.01895
R1206 VDD.n72 VDD.n60 0.998192
R1207 VDD.n45 VDD.n36 0.178026
R1208 VDD.n7 VDD.n65 0.939145
R1209 VDD.n67 VDD.n66 0.938638
R1210 VDD.n8 VDD.n7 0.938638
R1211 VDD.n6 VDD.n5 0.938638
R1212 VDD.n16 VDD.n15 0.938638
R1213 VDD.n12 VDD.n14 0.284639
R1214 VDD.n13 VDD.n12 0.938638
R1215 VDD.n9 VDD.n11 0.284639
R1216 VDD.n10 VDD.n9 0.938638
R1217 VDD.n64 VDD.n10 0.938638
R1218 VDD.t18 VDD.t14 0.928035
R1219 VDD.t9 VDD.t6 0.927945
R1220 VDD.t24 VDD.t18 0.927912
R1221 VDD.t6 VDD.n55 0.35908
R1222 VDD.n61 VDD.t9 0.85967
R1223 VDD.n71 VDD.n63 0.853486
R1224 VDD.n66 VDD.t16 0.465816
R1225 VDD.n68 VDD.n76 0.542243
R1226 VDD.n27 VDD.n4 0.542837
R1227 VDD.n31 VDD.n32 0.493139
R1228 VDD.n48 VDD.n352 9.02486
R1229 VDD.n4 VDD.n54 1.40754
R1230 VDD.n39 VDD.n16 1.38082
R1231 VDD.n34 VDD.n12 1.38082
R1232 VDD.n44 VDD.n13 1.38082
R1233 VDD.n20 VDD.n9 1.38082
R1234 VDD.n3 VDD.n10 1.38082
R1235 VDD.n25 VDD.n24 1.28666
R1236 VDD.n72 VDD.n40 1.247
R1237 VDD.n60 VDD.n35 1.18963
R1238 VDD.n129 VDD.n32 1.18836
R1239 VDD.t16 VDD.n30 1.16481
R1240 VDD.t9 VDD.n0 1.146
R1241 VDD.t0 VDD.n22 0.331321
R1242 VDD.n23 VDD.t9 0.228544
R1243 VDD.n25 VDD.n43 1.14542
R1244 VDD.n29 VDD.n28 0.136568
R1245 VDD.n45 VDD.n21 1.11088
R1246 VDD.n41 VDD.n8 1.11013
R1247 VDD.n42 VDD.n6 1.11013
R1248 VDD.n52 VDD.n21 1.05407
R1249 VDD.n29 VDD.n19 1.0359
R1250 VDD.n31 VDD.t16 1.03286
R1251 VSS.t160 VSS.n19 108.746
R1252 VSS.t192 VSS.n98 108.746
R1253 VSS.n1 VSS.t162 108.746
R1254 VSS.t164 VSS.n4 108.746
R1255 VSS.n6 VSS.t168 108.746
R1256 VSS.n8 VSS.t170 108.746
R1257 VSS.n10 VSS.t166 108.746
R1258 VSS.n11 VSS.t172 108.746
R1259 VSS.n14 VSS.t174 108.746
R1260 VSS.n16 VSS.t146 108.746
R1261 VSS.t156 VSS.n24 108.746
R1262 VSS.t152 VSS.n28 108.746
R1263 VSS.n76 VSS.t150 108.746
R1264 VSS.n30 VSS.t148 108.746
R1265 VSS.n32 VSS.t178 108.746
R1266 VSS.n33 VSS.t184 108.746
R1267 VSS.t180 VSS.n38 108.746
R1268 VSS.n69 VSS.t190 108.746
R1269 VSS.n66 VSS.t188 108.746
R1270 VSS.t186 VSS.n43 108.746
R1271 VSS.n45 VSS.t194 108.746
R1272 VSS.n60 VSS.t196 108.746
R1273 VSS.t200 VSS.n97 108.746
R1274 VSS.t142 VSS.n58 108.746
R1275 VSS.n51 VSS.t204 108.746
R1276 VSS.n92 VSS.t144 108.746
R1277 VSS.n62 VSS.t198 108.746
R1278 VSS.t176 VSS.n13 108.746
R1279 VSS.n21 VSS.t158 108.746
R1280 VSS.n26 VSS.t154 108.746
R1281 VSS.n35 VSS.t182 108.746
R1282 VSS.n53 VSS.t202 108.746
R1283 VSS.n2 VSS.t60 106.056
R1284 VSS.n7 VSS.t34 106.056
R1285 VSS.n17 VSS.t81 106.056
R1286 VSS.n20 VSS.t80 106.056
R1287 VSS.n25 VSS.t0 106.056
R1288 VSS.n39 VSS.t6 106.056
R1289 VSS.n44 VSS.t13 106.056
R1290 VSS.n48 VSS.t20 106.056
R1291 VSS.t95 VSS.n95 106.056
R1292 VSS.n5 VSS.t86 106.056
R1293 VSS.t55 VSS.n91 106.056
R1294 VSS.n9 VSS.t87 106.056
R1295 VSS.t47 VSS.n87 106.056
R1296 VSS.t51 VSS.n85 106.056
R1297 VSS.t30 VSS.n84 106.056
R1298 VSS.n15 VSS.t68 106.056
R1299 VSS.n22 VSS.t56 106.056
R1300 VSS.t48 VSS.n79 106.056
R1301 VSS.t52 VSS.n78 106.056
R1302 VSS.n29 VSS.t31 106.056
R1303 VSS.n31 VSS.t69 106.056
R1304 VSS.t83 VSS.n73 106.056
R1305 VSS.n34 VSS.t82 106.056
R1306 VSS.n36 VSS.t57 106.056
R1307 VSS.n40 VSS.t39 106.056
R1308 VSS.n41 VSS.t65 106.056
R1309 VSS.t44 VSS.n65 106.056
R1310 VSS.n46 VSS.t29 106.056
R1311 VSS.n47 VSS.t122 106.056
R1312 VSS.n49 VSS.t123 106.056
R1313 VSS.t125 VSS.n57 106.056
R1314 VSS.n52 VSS.t3 106.056
R1315 VSS.t111 VSS.t108 99.7537
R1316 VSS.t94 VSS.n214 94.1709
R1317 VSS.t93 VSS.n219 94.1709
R1318 VSS.t92 VSS.n224 94.1709
R1319 VSS.t91 VSS.n229 94.1709
R1320 VSS.t90 VSS.n234 94.1709
R1321 VSS.t96 VSS.n239 94.1709
R1322 VSS.t103 VSS.n244 94.1709
R1323 VSS.t102 VSS.n249 94.1709
R1324 VSS.t101 VSS.n254 94.1709
R1325 VSS.t100 VSS.n259 94.1709
R1326 VSS.t99 VSS.n264 94.1709
R1327 VSS.t98 VSS.n269 94.1709
R1328 VSS.t97 VSS.n274 94.1709
R1329 VSS.t104 VSS.n279 94.1709
R1330 VSS.t134 VSS.n284 94.1709
R1331 VSS.t132 VSS.n289 94.1709
R1332 VSS.t129 VSS.n294 94.1709
R1333 VSS.t128 VSS.n299 94.1709
R1334 VSS.t121 VSS.n304 94.1709
R1335 VSS.t106 VSS.n309 94.1709
R1336 VSS.t105 VSS.n314 94.1709
R1337 VSS.t135 VSS.n319 94.1709
R1338 VSS.t141 VSS.n324 94.1709
R1339 VSS.t140 VSS.n329 94.1709
R1340 VSS.t131 VSS.n334 94.1709
R1341 VSS.t133 VSS.n339 94.1709
R1342 VSS.t139 VSS.n344 94.1709
R1343 VSS.t136 VSS.n349 94.1709
R1344 VSS.t130 VSS.n354 94.1709
R1345 VSS.t138 VSS.n359 94.1709
R1346 VSS.t137 VSS.n364 94.1709
R1347 VSS.n369 VSS.t124 94.1709
R1348 VSS.n13 VSS.t40 67.0429
R1349 VSS.n21 VSS.t16 67.0429
R1350 VSS.n26 VSS.t37 67.0429
R1351 VSS.n35 VSS.t18 67.0429
R1352 VSS.n53 VSS.t78 67.0429
R1353 VSS.n1 VSS.t21 67.0426
R1354 VSS.n4 VSS.t23 67.0426
R1355 VSS.n6 VSS.t66 67.0426
R1356 VSS.n8 VSS.t45 67.0426
R1357 VSS.n10 VSS.t35 67.0426
R1358 VSS.n11 VSS.t61 67.0426
R1359 VSS.n14 VSS.t88 67.0426
R1360 VSS.n16 VSS.t72 67.0426
R1361 VSS.n19 VSS.t25 67.0426
R1362 VSS.n24 VSS.t9 67.0426
R1363 VSS.n28 VSS.t63 67.0426
R1364 VSS.t42 VSS.n76 67.0426
R1365 VSS.n30 VSS.t4 67.0426
R1366 VSS.n32 VSS.t1 67.0426
R1367 VSS.n33 VSS.t27 67.0426
R1368 VSS.n38 VSS.t11 67.0426
R1369 VSS.t70 VSS.n69 67.0426
R1370 VSS.t53 VSS.n66 67.0426
R1371 VSS.n43 VSS.t32 67.0426
R1372 VSS.n45 VSS.t76 67.0426
R1373 VSS.t74 VSS.n60 67.0426
R1374 VSS.t126 VSS.n58 67.0426
R1375 VSS.n51 VSS.t7 67.0426
R1376 VSS.t49 VSS.n98 67.0426
R1377 VSS.t58 VSS.n97 67.0426
R1378 VSS.t14 VSS.n92 67.042
R1379 VSS.t84 VSS.n62 67.042
R1380 VSS.n54 VSS.t119 62.4463
R1381 VSS.n54 VSS.t115 59.7564
R1382 VSS.t115 VSS.n96 57.6669
R1383 VSS.t21 VSS.n214 43.0498
R1384 VSS.t23 VSS.n219 43.0498
R1385 VSS.n224 VSS.t14 43.0498
R1386 VSS.t66 VSS.n229 43.0498
R1387 VSS.t45 VSS.n234 43.0498
R1388 VSS.t35 VSS.n239 43.0498
R1389 VSS.t61 VSS.n244 43.0498
R1390 VSS.t40 VSS.n249 43.0498
R1391 VSS.t88 VSS.n254 43.0498
R1392 VSS.t72 VSS.n259 43.0498
R1393 VSS.t25 VSS.n264 43.0498
R1394 VSS.t16 VSS.n269 43.0498
R1395 VSS.t9 VSS.n274 43.0498
R1396 VSS.t37 VSS.n279 43.0498
R1397 VSS.t63 VSS.n284 43.0498
R1398 VSS.n289 VSS.t42 43.0498
R1399 VSS.t4 VSS.n294 43.0498
R1400 VSS.t1 VSS.n299 43.0498
R1401 VSS.t27 VSS.n304 43.0498
R1402 VSS.t18 VSS.n309 43.0498
R1403 VSS.t11 VSS.n314 43.0498
R1404 VSS.n319 VSS.t70 43.0498
R1405 VSS.n324 VSS.t49 43.0498
R1406 VSS.n329 VSS.t53 43.0498
R1407 VSS.t32 VSS.n334 43.0498
R1408 VSS.t76 VSS.n339 43.0498
R1409 VSS.n344 VSS.t84 43.0498
R1410 VSS.n349 VSS.t74 43.0498
R1411 VSS.n354 VSS.t58 43.0498
R1412 VSS.n359 VSS.t126 43.0498
R1413 VSS.t7 VSS.n364 43.0498
R1414 VSS.t78 VSS.n369 43.0498
R1415 VSS.n742 VSS.n741 18.4617
R1416 VSS.n1053 VSS.n1052 18.0005
R1417 VSS.n106 VSS.n99 17.0005
R1418 VSS.n99 VSS.n1051 17.0005
R1419 VSS.n99 VSS.n209 17.0005
R1420 VSS.n99 VSS.n108 17.0005
R1421 VSS.n99 VSS.n208 17.0005
R1422 VSS.t124 VSS.n96 15.9618
R1423 VSS.n5 VSS.t93 15.9213
R1424 VSS.n91 VSS.t92 15.9213
R1425 VSS.n9 VSS.t90 15.9213
R1426 VSS.n87 VSS.t96 15.9213
R1427 VSS.n85 VSS.t103 15.9213
R1428 VSS.n84 VSS.t102 15.9213
R1429 VSS.n15 VSS.t101 15.9213
R1430 VSS.n22 VSS.t98 15.9213
R1431 VSS.n79 VSS.t104 15.9213
R1432 VSS.n78 VSS.t134 15.9213
R1433 VSS.n29 VSS.t132 15.9213
R1434 VSS.n31 VSS.t129 15.9213
R1435 VSS.n73 VSS.t128 15.9213
R1436 VSS.n34 VSS.t121 15.9213
R1437 VSS.n36 VSS.t106 15.9213
R1438 VSS.n40 VSS.t135 15.9213
R1439 VSS.n41 VSS.t141 15.9213
R1440 VSS.n65 VSS.t140 15.9213
R1441 VSS.n46 VSS.t133 15.9213
R1442 VSS.n47 VSS.t139 15.9213
R1443 VSS.n49 VSS.t130 15.9213
R1444 VSS.n57 VSS.t138 15.9213
R1445 VSS.n52 VSS.t137 15.9213
R1446 VSS.n2 VSS.t94 15.9203
R1447 VSS.n7 VSS.t91 15.9203
R1448 VSS.n17 VSS.t100 15.9203
R1449 VSS.n20 VSS.t99 15.9203
R1450 VSS.n25 VSS.t97 15.9203
R1451 VSS.n39 VSS.t105 15.9203
R1452 VSS.n44 VSS.t131 15.9203
R1453 VSS.n48 VSS.t136 15.9203
R1454 VSS.n100 VSS.t119 54.98
R1455 VSS.n95 VSS.t111 13.2307
R1456 VSS.n94 VSS.t95 11.8854
R1457 VSS.t60 VSS.n3 11.8854
R1458 VSS.t34 VSS.n89 11.8854
R1459 VSS.n86 VSS.t47 11.8854
R1460 VSS.n12 VSS.t51 11.8854
R1461 VSS.n83 VSS.t30 11.8854
R1462 VSS.t68 VSS.n82 11.8854
R1463 VSS.t81 VSS.n18 11.8854
R1464 VSS.t80 VSS.n81 11.8854
R1465 VSS.t56 VSS.n23 11.8854
R1466 VSS.t0 VSS.n80 11.8854
R1467 VSS.n27 VSS.t48 11.8854
R1468 VSS.t69 VSS.n74 11.8854
R1469 VSS.n72 VSS.t83 11.8854
R1470 VSS.t82 VSS.n71 11.8854
R1471 VSS.t57 VSS.n37 11.8854
R1472 VSS.t6 VSS.n70 11.8854
R1473 VSS.t65 VSS.n67 11.8854
R1474 VSS.n42 VSS.t44 11.8854
R1475 VSS.t13 VSS.n64 11.8854
R1476 VSS.t29 VSS.n63 11.8854
R1477 VSS.t123 VSS.n50 11.8854
R1478 VSS.t3 VSS.n55 11.8854
R1479 VSS.t86 VSS.n93 11.8844
R1480 VSS.n90 VSS.t55 11.8844
R1481 VSS.t87 VSS.n88 11.8844
R1482 VSS.n77 VSS.t52 11.8844
R1483 VSS.t31 VSS.n75 11.8844
R1484 VSS.t39 VSS.n68 11.8844
R1485 VSS.t122 VSS.n61 11.8844
R1486 VSS.t20 VSS.n59 11.8844
R1487 VSS.n56 VSS.t125 11.8844
R1488 VSS.t144 VSS.n93 9.19536
R1489 VSS.t168 VSS.n90 9.19536
R1490 VSS.t166 VSS.n88 9.19536
R1491 VSS.t150 VSS.n77 9.19536
R1492 VSS.t148 VSS.n75 9.19536
R1493 VSS.n68 VSS.t192 9.19536
R1494 VSS.t196 VSS.n61 9.19536
R1495 VSS.n59 VSS.t200 9.19536
R1496 VSS.t204 VSS.n56 9.19536
R1497 VSS.t162 VSS.n94 9.19506
R1498 VSS.n3 VSS.t164 9.19506
R1499 VSS.t170 VSS.n89 9.19506
R1500 VSS.t172 VSS.n86 9.19506
R1501 VSS.n12 VSS.t176 9.19506
R1502 VSS.t174 VSS.n83 9.19506
R1503 VSS.t146 VSS.n82 9.19506
R1504 VSS.n18 VSS.t160 9.19506
R1505 VSS.t158 VSS.n81 9.19506
R1506 VSS.n23 VSS.t156 9.19506
R1507 VSS.t154 VSS.n80 9.19506
R1508 VSS.n27 VSS.t152 9.19506
R1509 VSS.t178 VSS.n74 9.19506
R1510 VSS.t184 VSS.n72 9.19506
R1511 VSS.t182 VSS.n71 9.19506
R1512 VSS.n37 VSS.t180 9.19506
R1513 VSS.t190 VSS.n70 9.19506
R1514 VSS.t188 VSS.n67 9.19506
R1515 VSS.n42 VSS.t186 9.19506
R1516 VSS.t194 VSS.n64 9.19506
R1517 VSS.t198 VSS.n63 9.19506
R1518 VSS.n50 VSS.t142 9.19506
R1519 VSS.t202 VSS.n55 9.19506
R1520 VSS.n207 VSS.n737 9.11631
R1521 VSS.n1015 VSS.n104 9.0005
R1522 VSS.n1016 VSS.n1012 9.0005
R1523 VSS.n1020 VSS.n1019 9.0005
R1524 VSS.n1024 VSS.n1021 9.0005
R1525 VSS.n1029 VSS.n1028 9.0005
R1526 VSS.n1026 VSS.n1025 9.0005
R1527 VSS.n1027 VSS.n383 9.0005
R1528 VSS.n1011 VSS.n1010 9.0005
R1529 VSS.n1003 VSS.n385 9.0005
R1530 VSS.n1008 VSS.n384 9.0005
R1531 VSS.n1006 VSS.n1004 9.0005
R1532 VSS.n1002 VSS.n1001 9.0005
R1533 VSS.n994 VSS.n387 9.0005
R1534 VSS.n999 VSS.n386 9.0005
R1535 VSS.n997 VSS.n995 9.0005
R1536 VSS.n993 VSS.n992 9.0005
R1537 VSS.n985 VSS.n389 9.0005
R1538 VSS.n990 VSS.n388 9.0005
R1539 VSS.n988 VSS.n986 9.0005
R1540 VSS.n984 VSS.n983 9.0005
R1541 VSS.n976 VSS.n391 9.0005
R1542 VSS.n981 VSS.n390 9.0005
R1543 VSS.n979 VSS.n977 9.0005
R1544 VSS.n975 VSS.n974 9.0005
R1545 VSS.n967 VSS.n393 9.0005
R1546 VSS.n972 VSS.n392 9.0005
R1547 VSS.n970 VSS.n968 9.0005
R1548 VSS.n966 VSS.n965 9.0005
R1549 VSS.n958 VSS.n395 9.0005
R1550 VSS.n963 VSS.n394 9.0005
R1551 VSS.n961 VSS.n959 9.0005
R1552 VSS.n957 VSS.n956 9.0005
R1553 VSS.n949 VSS.n397 9.0005
R1554 VSS.n954 VSS.n396 9.0005
R1555 VSS.n952 VSS.n950 9.0005
R1556 VSS.n948 VSS.n947 9.0005
R1557 VSS.n940 VSS.n399 9.0005
R1558 VSS.n945 VSS.n398 9.0005
R1559 VSS.n943 VSS.n941 9.0005
R1560 VSS.n939 VSS.n938 9.0005
R1561 VSS.n931 VSS.n401 9.0005
R1562 VSS.n936 VSS.n400 9.0005
R1563 VSS.n934 VSS.n932 9.0005
R1564 VSS.n930 VSS.n929 9.0005
R1565 VSS.n922 VSS.n403 9.0005
R1566 VSS.n927 VSS.n402 9.0005
R1567 VSS.n925 VSS.n923 9.0005
R1568 VSS.n921 VSS.n920 9.0005
R1569 VSS.n913 VSS.n405 9.0005
R1570 VSS.n918 VSS.n404 9.0005
R1571 VSS.n916 VSS.n914 9.0005
R1572 VSS.n912 VSS.n911 9.0005
R1573 VSS.n904 VSS.n407 9.0005
R1574 VSS.n909 VSS.n406 9.0005
R1575 VSS.n907 VSS.n905 9.0005
R1576 VSS.n903 VSS.n902 9.0005
R1577 VSS.n895 VSS.n409 9.0005
R1578 VSS.n900 VSS.n408 9.0005
R1579 VSS.n898 VSS.n896 9.0005
R1580 VSS.n894 VSS.n893 9.0005
R1581 VSS.n886 VSS.n411 9.0005
R1582 VSS.n891 VSS.n410 9.0005
R1583 VSS.n889 VSS.n887 9.0005
R1584 VSS.n885 VSS.n884 9.0005
R1585 VSS.n877 VSS.n413 9.0005
R1586 VSS.n882 VSS.n412 9.0005
R1587 VSS.n880 VSS.n878 9.0005
R1588 VSS.n876 VSS.n875 9.0005
R1589 VSS.n868 VSS.n415 9.0005
R1590 VSS.n873 VSS.n414 9.0005
R1591 VSS.n871 VSS.n869 9.0005
R1592 VSS.n867 VSS.n866 9.0005
R1593 VSS.n859 VSS.n417 9.0005
R1594 VSS.n864 VSS.n416 9.0005
R1595 VSS.n862 VSS.n860 9.0005
R1596 VSS.n858 VSS.n857 9.0005
R1597 VSS.n850 VSS.n419 9.0005
R1598 VSS.n855 VSS.n418 9.0005
R1599 VSS.n853 VSS.n851 9.0005
R1600 VSS.n849 VSS.n848 9.0005
R1601 VSS.n841 VSS.n421 9.0005
R1602 VSS.n846 VSS.n420 9.0005
R1603 VSS.n844 VSS.n842 9.0005
R1604 VSS.n840 VSS.n839 9.0005
R1605 VSS.n832 VSS.n423 9.0005
R1606 VSS.n837 VSS.n422 9.0005
R1607 VSS.n835 VSS.n833 9.0005
R1608 VSS.n831 VSS.n830 9.0005
R1609 VSS.n823 VSS.n425 9.0005
R1610 VSS.n828 VSS.n424 9.0005
R1611 VSS.n826 VSS.n824 9.0005
R1612 VSS.n822 VSS.n821 9.0005
R1613 VSS.n814 VSS.n427 9.0005
R1614 VSS.n819 VSS.n426 9.0005
R1615 VSS.n817 VSS.n815 9.0005
R1616 VSS.n813 VSS.n812 9.0005
R1617 VSS.n805 VSS.n429 9.0005
R1618 VSS.n810 VSS.n428 9.0005
R1619 VSS.n808 VSS.n806 9.0005
R1620 VSS.n804 VSS.n803 9.0005
R1621 VSS.n796 VSS.n431 9.0005
R1622 VSS.n801 VSS.n430 9.0005
R1623 VSS.n799 VSS.n797 9.0005
R1624 VSS.n795 VSS.n794 9.0005
R1625 VSS.n787 VSS.n433 9.0005
R1626 VSS.n792 VSS.n432 9.0005
R1627 VSS.n790 VSS.n788 9.0005
R1628 VSS.n786 VSS.n785 9.0005
R1629 VSS.n778 VSS.n435 9.0005
R1630 VSS.n783 VSS.n434 9.0005
R1631 VSS.n781 VSS.n779 9.0005
R1632 VSS.n777 VSS.n776 9.0005
R1633 VSS.n769 VSS.n437 9.0005
R1634 VSS.n774 VSS.n436 9.0005
R1635 VSS.n772 VSS.n770 9.0005
R1636 VSS.n768 VSS.n767 9.0005
R1637 VSS.n760 VSS.n439 9.0005
R1638 VSS.n765 VSS.n438 9.0005
R1639 VSS.n763 VSS.n761 9.0005
R1640 VSS.n759 VSS.n758 9.0005
R1641 VSS.n751 VSS.n441 9.0005
R1642 VSS.n756 VSS.n440 9.0005
R1643 VSS.n754 VSS.n752 9.0005
R1644 VSS.n750 VSS.n749 9.0005
R1645 VSS.n742 VSS.n740 9.0005
R1646 VSS.n747 VSS.n442 9.0005
R1647 VSS.n745 VSS.n743 9.0005
R1648 VSS.n1015 VSS.n1014 9.0005
R1649 VSS.n1016 VSS.n1013 9.0005
R1650 VSS.n1019 VSS.n1018 9.0005
R1651 VSS.n1024 VSS.n1023 9.0005
R1652 VSS.n1030 VSS.n1029 9.0005
R1653 VSS.n1010 VSS.n1009 9.0005
R1654 VSS.n516 VSS.n385 9.0005
R1655 VSS.n1001 VSS.n1000 9.0005
R1656 VSS.n529 VSS.n387 9.0005
R1657 VSS.n992 VSS.n991 9.0005
R1658 VSS.n511 VSS.n389 9.0005
R1659 VSS.n983 VSS.n982 9.0005
R1660 VSS.n544 VSS.n391 9.0005
R1661 VSS.n974 VSS.n973 9.0005
R1662 VSS.n506 VSS.n393 9.0005
R1663 VSS.n965 VSS.n964 9.0005
R1664 VSS.n559 VSS.n395 9.0005
R1665 VSS.n956 VSS.n955 9.0005
R1666 VSS.n501 VSS.n397 9.0005
R1667 VSS.n947 VSS.n946 9.0005
R1668 VSS.n574 VSS.n399 9.0005
R1669 VSS.n938 VSS.n937 9.0005
R1670 VSS.n496 VSS.n401 9.0005
R1671 VSS.n929 VSS.n928 9.0005
R1672 VSS.n589 VSS.n403 9.0005
R1673 VSS.n920 VSS.n919 9.0005
R1674 VSS.n491 VSS.n405 9.0005
R1675 VSS.n911 VSS.n910 9.0005
R1676 VSS.n604 VSS.n407 9.0005
R1677 VSS.n902 VSS.n901 9.0005
R1678 VSS.n486 VSS.n409 9.0005
R1679 VSS.n893 VSS.n892 9.0005
R1680 VSS.n619 VSS.n411 9.0005
R1681 VSS.n884 VSS.n883 9.0005
R1682 VSS.n481 VSS.n413 9.0005
R1683 VSS.n875 VSS.n874 9.0005
R1684 VSS.n634 VSS.n415 9.0005
R1685 VSS.n866 VSS.n865 9.0005
R1686 VSS.n476 VSS.n417 9.0005
R1687 VSS.n857 VSS.n856 9.0005
R1688 VSS.n649 VSS.n419 9.0005
R1689 VSS.n848 VSS.n847 9.0005
R1690 VSS.n471 VSS.n421 9.0005
R1691 VSS.n839 VSS.n838 9.0005
R1692 VSS.n664 VSS.n423 9.0005
R1693 VSS.n830 VSS.n829 9.0005
R1694 VSS.n466 VSS.n425 9.0005
R1695 VSS.n821 VSS.n820 9.0005
R1696 VSS.n679 VSS.n427 9.0005
R1697 VSS.n812 VSS.n811 9.0005
R1698 VSS.n461 VSS.n429 9.0005
R1699 VSS.n803 VSS.n802 9.0005
R1700 VSS.n694 VSS.n431 9.0005
R1701 VSS.n794 VSS.n793 9.0005
R1702 VSS.n456 VSS.n433 9.0005
R1703 VSS.n785 VSS.n784 9.0005
R1704 VSS.n709 VSS.n435 9.0005
R1705 VSS.n776 VSS.n775 9.0005
R1706 VSS.n451 VSS.n437 9.0005
R1707 VSS.n767 VSS.n766 9.0005
R1708 VSS.n724 VSS.n439 9.0005
R1709 VSS.n758 VSS.n757 9.0005
R1710 VSS.n446 VSS.n441 9.0005
R1711 VSS.n749 VSS.n748 9.0005
R1712 VSS.n740 VSS.n739 9.0005
R1713 VSS.n747 VSS.n746 9.0005
R1714 VSS.n745 VSS.n744 9.0005
R1715 VSS.n756 VSS.n755 9.0005
R1716 VSS.n754 VSS.n753 9.0005
R1717 VSS.n765 VSS.n764 9.0005
R1718 VSS.n763 VSS.n762 9.0005
R1719 VSS.n774 VSS.n773 9.0005
R1720 VSS.n772 VSS.n771 9.0005
R1721 VSS.n783 VSS.n782 9.0005
R1722 VSS.n781 VSS.n780 9.0005
R1723 VSS.n792 VSS.n791 9.0005
R1724 VSS.n790 VSS.n789 9.0005
R1725 VSS.n801 VSS.n800 9.0005
R1726 VSS.n799 VSS.n798 9.0005
R1727 VSS.n810 VSS.n809 9.0005
R1728 VSS.n808 VSS.n807 9.0005
R1729 VSS.n819 VSS.n818 9.0005
R1730 VSS.n817 VSS.n816 9.0005
R1731 VSS.n828 VSS.n827 9.0005
R1732 VSS.n826 VSS.n825 9.0005
R1733 VSS.n837 VSS.n836 9.0005
R1734 VSS.n835 VSS.n834 9.0005
R1735 VSS.n846 VSS.n845 9.0005
R1736 VSS.n844 VSS.n843 9.0005
R1737 VSS.n855 VSS.n854 9.0005
R1738 VSS.n853 VSS.n852 9.0005
R1739 VSS.n864 VSS.n863 9.0005
R1740 VSS.n862 VSS.n861 9.0005
R1741 VSS.n873 VSS.n872 9.0005
R1742 VSS.n871 VSS.n870 9.0005
R1743 VSS.n882 VSS.n881 9.0005
R1744 VSS.n880 VSS.n879 9.0005
R1745 VSS.n891 VSS.n890 9.0005
R1746 VSS.n889 VSS.n888 9.0005
R1747 VSS.n900 VSS.n899 9.0005
R1748 VSS.n898 VSS.n897 9.0005
R1749 VSS.n909 VSS.n908 9.0005
R1750 VSS.n907 VSS.n906 9.0005
R1751 VSS.n918 VSS.n917 9.0005
R1752 VSS.n916 VSS.n915 9.0005
R1753 VSS.n927 VSS.n926 9.0005
R1754 VSS.n925 VSS.n924 9.0005
R1755 VSS.n936 VSS.n935 9.0005
R1756 VSS.n934 VSS.n933 9.0005
R1757 VSS.n945 VSS.n944 9.0005
R1758 VSS.n943 VSS.n942 9.0005
R1759 VSS.n954 VSS.n953 9.0005
R1760 VSS.n952 VSS.n951 9.0005
R1761 VSS.n963 VSS.n962 9.0005
R1762 VSS.n961 VSS.n960 9.0005
R1763 VSS.n972 VSS.n971 9.0005
R1764 VSS.n970 VSS.n969 9.0005
R1765 VSS.n981 VSS.n980 9.0005
R1766 VSS.n979 VSS.n978 9.0005
R1767 VSS.n990 VSS.n989 9.0005
R1768 VSS.n988 VSS.n987 9.0005
R1769 VSS.n999 VSS.n998 9.0005
R1770 VSS.n997 VSS.n996 9.0005
R1771 VSS.n1008 VSS.n1007 9.0005
R1772 VSS.n1006 VSS.n1005 9.0005
R1773 VSS.n1025 VSS.n1022 9.0005
R1774 VSS.n383 VSS.n382 9.0005
R1775 VSS.n1046 VSS.n209 9.0005
R1776 VSS.n1043 VSS.n1042 9.0005
R1777 VSS.n1039 VSS.n111 9.0005
R1778 VSS.n1034 VSS.n1033 9.0005
R1779 VSS.n519 VSS.n115 9.0005
R1780 VSS.n522 VSS.n517 9.0005
R1781 VSS.n527 VSS.n526 9.0005
R1782 VSS.n534 VSS.n121 9.0005
R1783 VSS.n537 VSS.n512 9.0005
R1784 VSS.n542 VSS.n541 9.0005
R1785 VSS.n549 VSS.n127 9.0005
R1786 VSS.n552 VSS.n507 9.0005
R1787 VSS.n557 VSS.n556 9.0005
R1788 VSS.n564 VSS.n133 9.0005
R1789 VSS.n567 VSS.n502 9.0005
R1790 VSS.n572 VSS.n571 9.0005
R1791 VSS.n579 VSS.n139 9.0005
R1792 VSS.n582 VSS.n497 9.0005
R1793 VSS.n587 VSS.n586 9.0005
R1794 VSS.n594 VSS.n145 9.0005
R1795 VSS.n597 VSS.n492 9.0005
R1796 VSS.n602 VSS.n601 9.0005
R1797 VSS.n609 VSS.n151 9.0005
R1798 VSS.n612 VSS.n487 9.0005
R1799 VSS.n617 VSS.n616 9.0005
R1800 VSS.n624 VSS.n157 9.0005
R1801 VSS.n627 VSS.n482 9.0005
R1802 VSS.n632 VSS.n631 9.0005
R1803 VSS.n639 VSS.n163 9.0005
R1804 VSS.n642 VSS.n477 9.0005
R1805 VSS.n647 VSS.n646 9.0005
R1806 VSS.n654 VSS.n169 9.0005
R1807 VSS.n657 VSS.n472 9.0005
R1808 VSS.n662 VSS.n661 9.0005
R1809 VSS.n669 VSS.n175 9.0005
R1810 VSS.n672 VSS.n467 9.0005
R1811 VSS.n677 VSS.n676 9.0005
R1812 VSS.n684 VSS.n181 9.0005
R1813 VSS.n687 VSS.n462 9.0005
R1814 VSS.n692 VSS.n691 9.0005
R1815 VSS.n699 VSS.n187 9.0005
R1816 VSS.n702 VSS.n457 9.0005
R1817 VSS.n707 VSS.n706 9.0005
R1818 VSS.n714 VSS.n193 9.0005
R1819 VSS.n717 VSS.n452 9.0005
R1820 VSS.n722 VSS.n721 9.0005
R1821 VSS.n729 VSS.n199 9.0005
R1822 VSS.n732 VSS.n447 9.0005
R1823 VSS.n444 VSS.n443 9.0005
R1824 VSS.n735 VSS.n734 9.0005
R1825 VSS.n731 VSS.n730 9.0005
R1826 VSS.n726 VSS.n725 9.0005
R1827 VSS.n720 VSS.n449 9.0005
R1828 VSS.n716 VSS.n715 9.0005
R1829 VSS.n711 VSS.n710 9.0005
R1830 VSS.n705 VSS.n454 9.0005
R1831 VSS.n701 VSS.n700 9.0005
R1832 VSS.n696 VSS.n695 9.0005
R1833 VSS.n690 VSS.n459 9.0005
R1834 VSS.n686 VSS.n685 9.0005
R1835 VSS.n681 VSS.n680 9.0005
R1836 VSS.n675 VSS.n464 9.0005
R1837 VSS.n671 VSS.n670 9.0005
R1838 VSS.n666 VSS.n665 9.0005
R1839 VSS.n660 VSS.n469 9.0005
R1840 VSS.n656 VSS.n655 9.0005
R1841 VSS.n651 VSS.n650 9.0005
R1842 VSS.n645 VSS.n474 9.0005
R1843 VSS.n641 VSS.n640 9.0005
R1844 VSS.n636 VSS.n635 9.0005
R1845 VSS.n630 VSS.n479 9.0005
R1846 VSS.n626 VSS.n625 9.0005
R1847 VSS.n621 VSS.n620 9.0005
R1848 VSS.n615 VSS.n484 9.0005
R1849 VSS.n611 VSS.n610 9.0005
R1850 VSS.n606 VSS.n605 9.0005
R1851 VSS.n600 VSS.n489 9.0005
R1852 VSS.n596 VSS.n595 9.0005
R1853 VSS.n591 VSS.n590 9.0005
R1854 VSS.n585 VSS.n494 9.0005
R1855 VSS.n581 VSS.n580 9.0005
R1856 VSS.n576 VSS.n575 9.0005
R1857 VSS.n570 VSS.n499 9.0005
R1858 VSS.n566 VSS.n565 9.0005
R1859 VSS.n561 VSS.n560 9.0005
R1860 VSS.n555 VSS.n504 9.0005
R1861 VSS.n551 VSS.n550 9.0005
R1862 VSS.n546 VSS.n545 9.0005
R1863 VSS.n540 VSS.n509 9.0005
R1864 VSS.n536 VSS.n535 9.0005
R1865 VSS.n531 VSS.n530 9.0005
R1866 VSS.n525 VSS.n514 9.0005
R1867 VSS.n521 VSS.n520 9.0005
R1868 VSS.n1032 VSS.n1031 9.0005
R1869 VSS.n1036 VSS.n1035 9.0005
R1870 VSS.n1041 VSS.n1040 9.0005
R1871 VSS.n1048 VSS.n1047 9.0005
R1872 VSS.n1046 VSS.n101 9.0005
R1873 VSS.n1047 VSS.n1045 9.0005
R1874 VSS.n1044 VSS.n1043 9.0005
R1875 VSS.n1041 VSS.n378 9.0005
R1876 VSS.n1039 VSS.n1038 9.0005
R1877 VSS.n1034 VSS.n379 9.0005
R1878 VSS.n1032 VSS.n380 9.0005
R1879 VSS.n1037 VSS.n1036 9.0005
R1880 VSS.n519 VSS.n518 9.0005
R1881 VSS.n521 VSS.n515 9.0005
R1882 VSS.n523 VSS.n522 9.0005
R1883 VSS.n527 VSS.n513 9.0005
R1884 VSS.n532 VSS.n531 9.0005
R1885 VSS.n525 VSS.n524 9.0005
R1886 VSS.n534 VSS.n533 9.0005
R1887 VSS.n536 VSS.n510 9.0005
R1888 VSS.n538 VSS.n537 9.0005
R1889 VSS.n542 VSS.n508 9.0005
R1890 VSS.n547 VSS.n546 9.0005
R1891 VSS.n540 VSS.n539 9.0005
R1892 VSS.n549 VSS.n548 9.0005
R1893 VSS.n551 VSS.n505 9.0005
R1894 VSS.n553 VSS.n552 9.0005
R1895 VSS.n557 VSS.n503 9.0005
R1896 VSS.n562 VSS.n561 9.0005
R1897 VSS.n555 VSS.n554 9.0005
R1898 VSS.n564 VSS.n563 9.0005
R1899 VSS.n566 VSS.n500 9.0005
R1900 VSS.n568 VSS.n567 9.0005
R1901 VSS.n572 VSS.n498 9.0005
R1902 VSS.n577 VSS.n576 9.0005
R1903 VSS.n570 VSS.n569 9.0005
R1904 VSS.n579 VSS.n578 9.0005
R1905 VSS.n581 VSS.n495 9.0005
R1906 VSS.n583 VSS.n582 9.0005
R1907 VSS.n587 VSS.n493 9.0005
R1908 VSS.n592 VSS.n591 9.0005
R1909 VSS.n585 VSS.n584 9.0005
R1910 VSS.n594 VSS.n593 9.0005
R1911 VSS.n596 VSS.n490 9.0005
R1912 VSS.n598 VSS.n597 9.0005
R1913 VSS.n602 VSS.n488 9.0005
R1914 VSS.n607 VSS.n606 9.0005
R1915 VSS.n600 VSS.n599 9.0005
R1916 VSS.n609 VSS.n608 9.0005
R1917 VSS.n611 VSS.n485 9.0005
R1918 VSS.n613 VSS.n612 9.0005
R1919 VSS.n617 VSS.n483 9.0005
R1920 VSS.n622 VSS.n621 9.0005
R1921 VSS.n615 VSS.n614 9.0005
R1922 VSS.n624 VSS.n623 9.0005
R1923 VSS.n626 VSS.n480 9.0005
R1924 VSS.n628 VSS.n627 9.0005
R1925 VSS.n632 VSS.n478 9.0005
R1926 VSS.n637 VSS.n636 9.0005
R1927 VSS.n630 VSS.n629 9.0005
R1928 VSS.n639 VSS.n638 9.0005
R1929 VSS.n641 VSS.n475 9.0005
R1930 VSS.n643 VSS.n642 9.0005
R1931 VSS.n647 VSS.n473 9.0005
R1932 VSS.n652 VSS.n651 9.0005
R1933 VSS.n645 VSS.n644 9.0005
R1934 VSS.n654 VSS.n653 9.0005
R1935 VSS.n656 VSS.n470 9.0005
R1936 VSS.n658 VSS.n657 9.0005
R1937 VSS.n662 VSS.n468 9.0005
R1938 VSS.n667 VSS.n666 9.0005
R1939 VSS.n660 VSS.n659 9.0005
R1940 VSS.n669 VSS.n668 9.0005
R1941 VSS.n671 VSS.n465 9.0005
R1942 VSS.n673 VSS.n672 9.0005
R1943 VSS.n677 VSS.n463 9.0005
R1944 VSS.n682 VSS.n681 9.0005
R1945 VSS.n675 VSS.n674 9.0005
R1946 VSS.n684 VSS.n683 9.0005
R1947 VSS.n686 VSS.n460 9.0005
R1948 VSS.n688 VSS.n687 9.0005
R1949 VSS.n692 VSS.n458 9.0005
R1950 VSS.n697 VSS.n696 9.0005
R1951 VSS.n690 VSS.n689 9.0005
R1952 VSS.n699 VSS.n698 9.0005
R1953 VSS.n701 VSS.n455 9.0005
R1954 VSS.n703 VSS.n702 9.0005
R1955 VSS.n707 VSS.n453 9.0005
R1956 VSS.n712 VSS.n711 9.0005
R1957 VSS.n705 VSS.n704 9.0005
R1958 VSS.n714 VSS.n713 9.0005
R1959 VSS.n716 VSS.n450 9.0005
R1960 VSS.n718 VSS.n717 9.0005
R1961 VSS.n722 VSS.n448 9.0005
R1962 VSS.n727 VSS.n726 9.0005
R1963 VSS.n720 VSS.n719 9.0005
R1964 VSS.n729 VSS.n728 9.0005
R1965 VSS.n731 VSS.n445 9.0005
R1966 VSS.n733 VSS.n732 9.0005
R1967 VSS.n736 VSS.n735 9.0005
R1968 VSS.n100 VSS.n99 0.00100257
R1969 VSS.n99 VSS.n214 8.5005
R1970 VSS.n99 VSS.n219 8.5005
R1971 VSS.n99 VSS.n224 8.5005
R1972 VSS.n99 VSS.n229 8.5005
R1973 VSS.n99 VSS.n234 8.5005
R1974 VSS.n99 VSS.n239 8.5005
R1975 VSS.n99 VSS.n244 8.5005
R1976 VSS.n99 VSS.n249 8.5005
R1977 VSS.n99 VSS.n254 8.5005
R1978 VSS.n99 VSS.n259 8.5005
R1979 VSS.n99 VSS.n264 8.5005
R1980 VSS.n99 VSS.n269 8.5005
R1981 VSS.n99 VSS.n274 8.5005
R1982 VSS.n99 VSS.n279 8.5005
R1983 VSS.n99 VSS.n284 8.5005
R1984 VSS.n99 VSS.n289 8.5005
R1985 VSS.n99 VSS.n294 8.5005
R1986 VSS.n99 VSS.n299 8.5005
R1987 VSS.n99 VSS.n304 8.5005
R1988 VSS.n99 VSS.n309 8.5005
R1989 VSS.n99 VSS.n314 8.5005
R1990 VSS.n99 VSS.n319 8.5005
R1991 VSS.n99 VSS.n324 8.5005
R1992 VSS.n99 VSS.n329 8.5005
R1993 VSS.n99 VSS.n334 8.5005
R1994 VSS.n99 VSS.n339 8.5005
R1995 VSS.n99 VSS.n344 8.5005
R1996 VSS.n99 VSS.n349 8.5005
R1997 VSS.n99 VSS.n354 8.5005
R1998 VSS.n99 VSS.n359 8.5005
R1999 VSS.n99 VSS.n364 8.5005
R2000 VSS.n99 VSS.n369 8.5005
R2001 VSS.n99 VSS.n0 8.47732
R2002 VSS.n99 VSS.n210 8.47732
R2003 VSS.n99 VSS.n211 8.47732
R2004 VSS.n99 VSS.n212 8.47732
R2005 VSS.n99 VSS.n215 8.47732
R2006 VSS.n99 VSS.n216 8.47732
R2007 VSS.n99 VSS.n217 8.47732
R2008 VSS.n99 VSS.n220 8.47732
R2009 VSS.n99 VSS.n221 8.47732
R2010 VSS.n99 VSS.n222 8.47732
R2011 VSS.n99 VSS.n225 8.47732
R2012 VSS.n99 VSS.n226 8.47732
R2013 VSS.n99 VSS.n227 8.47732
R2014 VSS.n99 VSS.n230 8.47732
R2015 VSS.n99 VSS.n231 8.47732
R2016 VSS.n99 VSS.n232 8.47732
R2017 VSS.n99 VSS.n235 8.47732
R2018 VSS.n99 VSS.n236 8.47732
R2019 VSS.n99 VSS.n237 8.47732
R2020 VSS.n99 VSS.n240 8.47732
R2021 VSS.n99 VSS.n241 8.47732
R2022 VSS.n99 VSS.n242 8.47732
R2023 VSS.n99 VSS.n245 8.47732
R2024 VSS.n99 VSS.n246 8.47732
R2025 VSS.n99 VSS.n247 8.47732
R2026 VSS.n99 VSS.n250 8.47732
R2027 VSS.n99 VSS.n251 8.47732
R2028 VSS.n99 VSS.n252 8.47732
R2029 VSS.n99 VSS.n255 8.47732
R2030 VSS.n99 VSS.n256 8.47732
R2031 VSS.n99 VSS.n257 8.47732
R2032 VSS.n99 VSS.n260 8.47732
R2033 VSS.n99 VSS.n261 8.47732
R2034 VSS.n99 VSS.n262 8.47732
R2035 VSS.n99 VSS.n265 8.47732
R2036 VSS.n99 VSS.n266 8.47732
R2037 VSS.n99 VSS.n267 8.47732
R2038 VSS.n99 VSS.n270 8.47732
R2039 VSS.n99 VSS.n271 8.47732
R2040 VSS.n99 VSS.n272 8.47732
R2041 VSS.n99 VSS.n275 8.47732
R2042 VSS.n99 VSS.n276 8.47732
R2043 VSS.n99 VSS.n277 8.47732
R2044 VSS.n99 VSS.n280 8.47732
R2045 VSS.n99 VSS.n281 8.47732
R2046 VSS.n99 VSS.n282 8.47732
R2047 VSS.n99 VSS.n285 8.47732
R2048 VSS.n99 VSS.n286 8.47732
R2049 VSS.n99 VSS.n287 8.47732
R2050 VSS.n99 VSS.n290 8.47732
R2051 VSS.n99 VSS.n291 8.47732
R2052 VSS.n99 VSS.n292 8.47732
R2053 VSS.n99 VSS.n295 8.47732
R2054 VSS.n99 VSS.n296 8.47732
R2055 VSS.n99 VSS.n297 8.47732
R2056 VSS.n99 VSS.n300 8.47732
R2057 VSS.n99 VSS.n301 8.47732
R2058 VSS.n99 VSS.n302 8.47732
R2059 VSS.n99 VSS.n305 8.47732
R2060 VSS.n99 VSS.n306 8.47732
R2061 VSS.n99 VSS.n307 8.47732
R2062 VSS.n99 VSS.n310 8.47732
R2063 VSS.n99 VSS.n311 8.47732
R2064 VSS.n99 VSS.n312 8.47732
R2065 VSS.n99 VSS.n315 8.47732
R2066 VSS.n99 VSS.n316 8.47732
R2067 VSS.n99 VSS.n317 8.47732
R2068 VSS.n99 VSS.n320 8.47732
R2069 VSS.n99 VSS.n321 8.47732
R2070 VSS.n99 VSS.n322 8.47732
R2071 VSS.n99 VSS.n325 8.47732
R2072 VSS.n99 VSS.n326 8.47732
R2073 VSS.n99 VSS.n327 8.47732
R2074 VSS.n99 VSS.n330 8.47732
R2075 VSS.n99 VSS.n331 8.47732
R2076 VSS.n99 VSS.n332 8.47732
R2077 VSS.n99 VSS.n335 8.47732
R2078 VSS.n99 VSS.n336 8.47732
R2079 VSS.n99 VSS.n337 8.47732
R2080 VSS.n99 VSS.n340 8.47732
R2081 VSS.n99 VSS.n341 8.47732
R2082 VSS.n99 VSS.n342 8.47732
R2083 VSS.n99 VSS.n345 8.47732
R2084 VSS.n99 VSS.n346 8.47732
R2085 VSS.n99 VSS.n347 8.47732
R2086 VSS.n99 VSS.n350 8.47732
R2087 VSS.n99 VSS.n351 8.47732
R2088 VSS.n99 VSS.n352 8.47732
R2089 VSS.n99 VSS.n355 8.47732
R2090 VSS.n99 VSS.n356 8.47732
R2091 VSS.n99 VSS.n357 8.47732
R2092 VSS.n99 VSS.n360 8.47732
R2093 VSS.n99 VSS.n361 8.47732
R2094 VSS.n99 VSS.n362 8.47732
R2095 VSS.n99 VSS.n365 8.47732
R2096 VSS.n99 VSS.n366 8.47732
R2097 VSS.n99 VSS.n367 8.47732
R2098 VSS.n99 VSS.n370 8.47732
R2099 VSS.n99 VSS.t114 8.47732
R2100 VSS.n99 VSS.n373 8.47732
R2101 VSS.n99 VSS.n105 8.47732
R2102 VSS.n99 VSS.n109 8.47732
R2103 VSS.n99 VSS.n112 8.47732
R2104 VSS.n99 VSS.n114 8.47732
R2105 VSS.n99 VSS.n118 8.47732
R2106 VSS.n99 VSS.n120 8.47732
R2107 VSS.n99 VSS.n124 8.47732
R2108 VSS.n99 VSS.n126 8.47732
R2109 VSS.n99 VSS.n130 8.47732
R2110 VSS.n99 VSS.n132 8.47732
R2111 VSS.n99 VSS.n136 8.47732
R2112 VSS.n99 VSS.n138 8.47732
R2113 VSS.n99 VSS.n142 8.47732
R2114 VSS.n99 VSS.n144 8.47732
R2115 VSS.n99 VSS.n148 8.47732
R2116 VSS.n99 VSS.n150 8.47732
R2117 VSS.n99 VSS.n154 8.47732
R2118 VSS.n99 VSS.n156 8.47732
R2119 VSS.n99 VSS.n160 8.47732
R2120 VSS.n99 VSS.n162 8.47732
R2121 VSS.n99 VSS.n166 8.47732
R2122 VSS.n99 VSS.n168 8.47732
R2123 VSS.n99 VSS.n172 8.47732
R2124 VSS.n99 VSS.n174 8.47732
R2125 VSS.n99 VSS.n178 8.47732
R2126 VSS.n99 VSS.n180 8.47732
R2127 VSS.n99 VSS.n184 8.47732
R2128 VSS.n99 VSS.n186 8.47732
R2129 VSS.n99 VSS.n190 8.47732
R2130 VSS.n99 VSS.n192 8.47732
R2131 VSS.n99 VSS.n196 8.47732
R2132 VSS.n99 VSS.n198 8.47732
R2133 VSS.n99 VSS.n202 8.47732
R2134 VSS.n99 VSS.n206 8.47732
R2135 VSS.n99 VSS.n205 8.47732
R2136 VSS.n1055 VSS.n103 6.85994
R2137 VSS.n1056 VSS.n102 6.85994
R2138 VSS.n99 VSS.n374 5.63777
R2139 VSS.n99 VSS.n110 5.62581
R2140 VSS.n99 VSS.n113 5.62581
R2141 VSS.n99 VSS.n116 5.62581
R2142 VSS.n99 VSS.n119 5.62581
R2143 VSS.n99 VSS.n122 5.62581
R2144 VSS.n99 VSS.n125 5.62581
R2145 VSS.n99 VSS.n128 5.62581
R2146 VSS.n99 VSS.n131 5.62581
R2147 VSS.n99 VSS.n134 5.62581
R2148 VSS.n99 VSS.n137 5.62581
R2149 VSS.n99 VSS.n140 5.62581
R2150 VSS.n99 VSS.n143 5.62581
R2151 VSS.n99 VSS.n146 5.62581
R2152 VSS.n99 VSS.n149 5.62581
R2153 VSS.n99 VSS.n152 5.62581
R2154 VSS.n99 VSS.n155 5.62581
R2155 VSS.n99 VSS.n158 5.62581
R2156 VSS.n99 VSS.n161 5.62581
R2157 VSS.n99 VSS.n164 5.62581
R2158 VSS.n99 VSS.n167 5.62581
R2159 VSS.n99 VSS.n170 5.62581
R2160 VSS.n99 VSS.n173 5.62581
R2161 VSS.n99 VSS.n176 5.62581
R2162 VSS.n99 VSS.n179 5.62581
R2163 VSS.n99 VSS.n182 5.62581
R2164 VSS.n99 VSS.n185 5.62581
R2165 VSS.n99 VSS.n188 5.62581
R2166 VSS.n99 VSS.n191 5.62581
R2167 VSS.n99 VSS.n194 5.62581
R2168 VSS.n99 VSS.n197 5.62581
R2169 VSS.n99 VSS.n200 5.62581
R2170 VSS.n99 VSS.n203 5.62581
R2171 VSS.n1054 VSS.n1053 5.01167
R2172 VSS.n99 VSS.t108 5.00029
R2173 VSS.n1057 VSS.n101 4.8967
R2174 VSS.n737 VSS.n736 4.73162
R2175 VSS.n99 VSS.n204 4.20662
R2176 VSS.n99 VSS.n213 4.19244
R2177 VSS.n99 VSS.n218 4.19244
R2178 VSS.n99 VSS.n223 4.19244
R2179 VSS.n99 VSS.n228 4.19244
R2180 VSS.n99 VSS.n233 4.19244
R2181 VSS.n99 VSS.n238 4.19244
R2182 VSS.n99 VSS.n243 4.19244
R2183 VSS.n99 VSS.n248 4.19244
R2184 VSS.n99 VSS.n253 4.19244
R2185 VSS.n99 VSS.n258 4.19244
R2186 VSS.n99 VSS.n263 4.19244
R2187 VSS.n99 VSS.n268 4.19244
R2188 VSS.n99 VSS.n273 4.19244
R2189 VSS.n99 VSS.n278 4.19244
R2190 VSS.n99 VSS.n283 4.19244
R2191 VSS.n99 VSS.n288 4.19244
R2192 VSS.n99 VSS.n293 4.19244
R2193 VSS.n99 VSS.n298 4.19244
R2194 VSS.n99 VSS.n303 4.19244
R2195 VSS.n99 VSS.n308 4.19244
R2196 VSS.n99 VSS.n313 4.19244
R2197 VSS.n99 VSS.n318 4.19244
R2198 VSS.n99 VSS.n323 4.19244
R2199 VSS.n99 VSS.n328 4.19244
R2200 VSS.n99 VSS.n333 4.19244
R2201 VSS.n99 VSS.n338 4.19244
R2202 VSS.n99 VSS.n343 4.19244
R2203 VSS.n99 VSS.n348 4.19244
R2204 VSS.n99 VSS.n353 4.19244
R2205 VSS.n99 VSS.n358 4.19244
R2206 VSS.n99 VSS.n363 4.19244
R2207 VSS.n99 VSS.n368 4.19244
R2208 VSS.n99 VSS.n107 3.32778
R2209 VSS.n99 VSS.t15 3.32623
R2210 VSS.n99 VSS.t89 3.32623
R2211 VSS.n99 VSS.t26 3.32623
R2212 VSS.n99 VSS.t64 3.32623
R2213 VSS.n99 VSS.t28 3.32623
R2214 VSS.n99 VSS.t85 3.32623
R2215 VSS.n99 VSS.t59 3.32623
R2216 VSS.n99 VSS.t8 3.32623
R2217 VSS.n99 VSS.t33 3.32623
R2218 VSS.n99 VSS.t50 3.32623
R2219 VSS.n99 VSS.t12 3.32623
R2220 VSS.n99 VSS.t5 3.32623
R2221 VSS.n99 VSS.t10 3.32623
R2222 VSS.n99 VSS.t62 3.32623
R2223 VSS.n99 VSS.t46 3.32623
R2224 VSS.n99 VSS.t22 3.32623
R2225 VSS.n99 VSS.t24 3.32615
R2226 VSS.n99 VSS.t67 3.32615
R2227 VSS.n99 VSS.t36 3.32615
R2228 VSS.n99 VSS.t41 3.32615
R2229 VSS.n99 VSS.t73 3.32615
R2230 VSS.n99 VSS.t17 3.32615
R2231 VSS.n99 VSS.t38 3.32615
R2232 VSS.n99 VSS.t43 3.32615
R2233 VSS.n99 VSS.t2 3.32615
R2234 VSS.n99 VSS.t19 3.32615
R2235 VSS.n99 VSS.t71 3.32615
R2236 VSS.n99 VSS.t54 3.32615
R2237 VSS.n99 VSS.t77 3.32615
R2238 VSS.n99 VSS.t75 3.32615
R2239 VSS.n99 VSS.t127 3.32615
R2240 VSS.n1055 VSS.n1054 2.93359
R2241 VSS.n1057 VSS.n1056 2.93359
R2242 VSS.n99 VSS.t79 2.74394
R2243 VSS.t107 VSS.t110 0.806856
R2244 VSS.t165 VSS.n381 0.802775
R2245 VSS.n1017 VSS.t163 0.802775
R2246 VSS.n738 VSS.t203 0.802775
R2247 VSS.t143 VSS.n723 0.802775
R2248 VSS.t197 VSS.n708 0.802775
R2249 VSS.t195 VSS.n693 0.802775
R2250 VSS.t189 VSS.n678 0.802775
R2251 VSS.t191 VSS.n663 0.802775
R2252 VSS.t183 VSS.n648 0.802775
R2253 VSS.t179 VSS.n633 0.802775
R2254 VSS.t151 VSS.n618 0.802775
R2255 VSS.t155 VSS.n603 0.802775
R2256 VSS.t159 VSS.n588 0.802775
R2257 VSS.t147 VSS.n573 0.802775
R2258 VSS.t177 VSS.n558 0.802775
R2259 VSS.t167 VSS.n543 0.802775
R2260 VSS.t169 VSS.n528 0.802775
R2261 VSS.t145 VSS.n117 0.802775
R2262 VSS.t171 VSS.n123 0.802775
R2263 VSS.t173 VSS.n129 0.802775
R2264 VSS.t175 VSS.n135 0.802775
R2265 VSS.t161 VSS.n141 0.802775
R2266 VSS.t157 VSS.n147 0.802775
R2267 VSS.t153 VSS.n153 0.802775
R2268 VSS.t149 VSS.n159 0.802775
R2269 VSS.t185 VSS.n165 0.802775
R2270 VSS.t181 VSS.n171 0.802775
R2271 VSS.t193 VSS.n177 0.802775
R2272 VSS.t187 VSS.n183 0.802775
R2273 VSS.t199 VSS.n189 0.802775
R2274 VSS.t201 VSS.n195 0.802775
R2275 VSS.t205 VSS.n201 0.802775
R2276 VSS.n371 VSS.t117 0.802775
R2277 VSS.n372 VSS.t116 0.723599
R2278 VSS.t118 VSS.t120 0.723599
R2279 VSS.n1038 VSS.n1037 0.692362
R2280 VSS.n518 VSS.n380 0.692362
R2281 VSS.n524 VSS.n523 0.692362
R2282 VSS.n533 VSS.n532 0.692362
R2283 VSS.n539 VSS.n538 0.692362
R2284 VSS.n548 VSS.n547 0.692362
R2285 VSS.n554 VSS.n553 0.692362
R2286 VSS.n563 VSS.n562 0.692362
R2287 VSS.n569 VSS.n568 0.692362
R2288 VSS.n578 VSS.n577 0.692362
R2289 VSS.n584 VSS.n583 0.692362
R2290 VSS.n593 VSS.n592 0.692362
R2291 VSS.n599 VSS.n598 0.692362
R2292 VSS.n608 VSS.n607 0.692362
R2293 VSS.n614 VSS.n613 0.692362
R2294 VSS.n623 VSS.n622 0.692362
R2295 VSS.n629 VSS.n628 0.692362
R2296 VSS.n638 VSS.n637 0.692362
R2297 VSS.n644 VSS.n643 0.692362
R2298 VSS.n653 VSS.n652 0.692362
R2299 VSS.n659 VSS.n658 0.692362
R2300 VSS.n668 VSS.n667 0.692362
R2301 VSS.n674 VSS.n673 0.692362
R2302 VSS.n683 VSS.n682 0.692362
R2303 VSS.n689 VSS.n688 0.692362
R2304 VSS.n698 VSS.n697 0.692362
R2305 VSS.n704 VSS.n703 0.692362
R2306 VSS.n713 VSS.n712 0.692362
R2307 VSS.n719 VSS.n718 0.692362
R2308 VSS.n728 VSS.n727 0.692362
R2309 VSS.n736 VSS.n733 0.692362
R2310 VSS.n99 VSS.n54 0.607264
R2311 VSS.t113 VSS.n1049 0.595317
R2312 VSS.t109 VSS.n377 0.595317
R2313 VSS.n1053 VSS.n104 0.461741
R2314 VSS.n1021 VSS.n1020 0.461741
R2315 VSS.n1028 VSS.n1011 0.461741
R2316 VSS.n1003 VSS.n1002 0.461741
R2317 VSS.n994 VSS.n993 0.461741
R2318 VSS.n985 VSS.n984 0.461741
R2319 VSS.n976 VSS.n975 0.461741
R2320 VSS.n967 VSS.n966 0.461741
R2321 VSS.n958 VSS.n957 0.461741
R2322 VSS.n949 VSS.n948 0.461741
R2323 VSS.n940 VSS.n939 0.461741
R2324 VSS.n931 VSS.n930 0.461741
R2325 VSS.n922 VSS.n921 0.461741
R2326 VSS.n913 VSS.n912 0.461741
R2327 VSS.n904 VSS.n903 0.461741
R2328 VSS.n895 VSS.n894 0.461741
R2329 VSS.n886 VSS.n885 0.461741
R2330 VSS.n877 VSS.n876 0.461741
R2331 VSS.n868 VSS.n867 0.461741
R2332 VSS.n859 VSS.n858 0.461741
R2333 VSS.n850 VSS.n849 0.461741
R2334 VSS.n841 VSS.n840 0.461741
R2335 VSS.n832 VSS.n831 0.461741
R2336 VSS.n823 VSS.n822 0.461741
R2337 VSS.n814 VSS.n813 0.461741
R2338 VSS.n805 VSS.n804 0.461741
R2339 VSS.n796 VSS.n795 0.461741
R2340 VSS.n787 VSS.n786 0.461741
R2341 VSS.n778 VSS.n777 0.461741
R2342 VSS.n769 VSS.n768 0.461741
R2343 VSS.n760 VSS.n759 0.461741
R2344 VSS.n751 VSS.n750 0.461741
R2345 VSS.n1045 VSS.n1044 0.346431
R2346 VSS.t203 VSS.t79 0.301976
R2347 VSS.n107 VSS.n103 0.289639
R2348 VSS.n199 VSS.t127 0.28485
R2349 VSS.n193 VSS.t75 0.28485
R2350 VSS.n187 VSS.t77 0.28485
R2351 VSS.n181 VSS.t54 0.28485
R2352 VSS.n175 VSS.t71 0.28485
R2353 VSS.n169 VSS.t19 0.28485
R2354 VSS.n163 VSS.t2 0.28485
R2355 VSS.n157 VSS.t43 0.28485
R2356 VSS.n151 VSS.t38 0.28485
R2357 VSS.n145 VSS.t17 0.28485
R2358 VSS.n139 VSS.t73 0.28485
R2359 VSS.n133 VSS.t41 0.28485
R2360 VSS.n127 VSS.t36 0.28485
R2361 VSS.n121 VSS.t67 0.28485
R2362 VSS.n115 VSS.t24 0.28485
R2363 VSS.n514 VSS.t15 0.284653
R2364 VSS.n499 VSS.t89 0.284653
R2365 VSS.n494 VSS.t26 0.284653
R2366 VSS.n484 VSS.t64 0.284653
R2367 VSS.n474 VSS.t28 0.284653
R2368 VSS.n454 VSS.t85 0.284653
R2369 VSS.n449 VSS.t59 0.284653
R2370 VSS.n734 VSS.t8 0.284653
R2371 VSS.n459 VSS.t33 0.284653
R2372 VSS.n464 VSS.t50 0.284653
R2373 VSS.n469 VSS.t12 0.284653
R2374 VSS.n479 VSS.t5 0.284653
R2375 VSS.n489 VSS.t10 0.284653
R2376 VSS.n504 VSS.t62 0.284653
R2377 VSS.n509 VSS.t46 0.284653
R2378 VSS.n1035 VSS.t22 0.284653
R2379 VSS.n107 VSS.n102 0.28352
R2380 VSS.n375 VSS.n204 0.259448
R2381 VSS.t205 VSS.t8 0.256315
R2382 VSS.t201 VSS.t59 0.256315
R2383 VSS.t199 VSS.t85 0.256315
R2384 VSS.t187 VSS.t33 0.256315
R2385 VSS.t193 VSS.t50 0.256315
R2386 VSS.t181 VSS.t12 0.256315
R2387 VSS.t185 VSS.t28 0.256315
R2388 VSS.t149 VSS.t5 0.256315
R2389 VSS.t153 VSS.t64 0.256315
R2390 VSS.t157 VSS.t10 0.256315
R2391 VSS.t161 VSS.t26 0.256315
R2392 VSS.t175 VSS.t89 0.256315
R2393 VSS.t173 VSS.t62 0.256315
R2394 VSS.t171 VSS.t46 0.256315
R2395 VSS.t145 VSS.t15 0.256315
R2396 VSS.t163 VSS.t22 0.256315
R2397 VSS.t165 VSS.t24 0.256107
R2398 VSS.t169 VSS.t67 0.256107
R2399 VSS.t167 VSS.t36 0.256107
R2400 VSS.t177 VSS.t41 0.256107
R2401 VSS.t147 VSS.t73 0.256107
R2402 VSS.t159 VSS.t17 0.256107
R2403 VSS.t155 VSS.t38 0.256107
R2404 VSS.t151 VSS.t43 0.256107
R2405 VSS.t179 VSS.t2 0.256107
R2406 VSS.t183 VSS.t19 0.256107
R2407 VSS.t191 VSS.t71 0.256107
R2408 VSS.t189 VSS.t54 0.256107
R2409 VSS.t195 VSS.t77 0.256107
R2410 VSS.t197 VSS.t75 0.256107
R2411 VSS.t143 VSS.t127 0.256107
R2412 VSS.t117 VSS.t79 0.254814
R2413 VSS.n1012 VSS.n104 0.231121
R2414 VSS.n1020 VSS.n1012 0.231121
R2415 VSS.n1026 VSS.n1021 0.231121
R2416 VSS.n1027 VSS.n1026 0.231121
R2417 VSS.n1028 VSS.n1027 0.231121
R2418 VSS.n1011 VSS.n384 0.231121
R2419 VSS.n1004 VSS.n384 0.231121
R2420 VSS.n1004 VSS.n1003 0.231121
R2421 VSS.n1002 VSS.n386 0.231121
R2422 VSS.n995 VSS.n386 0.231121
R2423 VSS.n995 VSS.n994 0.231121
R2424 VSS.n993 VSS.n388 0.231121
R2425 VSS.n986 VSS.n388 0.231121
R2426 VSS.n986 VSS.n985 0.231121
R2427 VSS.n984 VSS.n390 0.231121
R2428 VSS.n977 VSS.n390 0.231121
R2429 VSS.n977 VSS.n976 0.231121
R2430 VSS.n975 VSS.n392 0.231121
R2431 VSS.n968 VSS.n392 0.231121
R2432 VSS.n968 VSS.n967 0.231121
R2433 VSS.n966 VSS.n394 0.231121
R2434 VSS.n959 VSS.n394 0.231121
R2435 VSS.n959 VSS.n958 0.231121
R2436 VSS.n957 VSS.n396 0.231121
R2437 VSS.n950 VSS.n396 0.231121
R2438 VSS.n950 VSS.n949 0.231121
R2439 VSS.n948 VSS.n398 0.231121
R2440 VSS.n941 VSS.n398 0.231121
R2441 VSS.n941 VSS.n940 0.231121
R2442 VSS.n939 VSS.n400 0.231121
R2443 VSS.n932 VSS.n400 0.231121
R2444 VSS.n932 VSS.n931 0.231121
R2445 VSS.n930 VSS.n402 0.231121
R2446 VSS.n923 VSS.n402 0.231121
R2447 VSS.n923 VSS.n922 0.231121
R2448 VSS.n921 VSS.n404 0.231121
R2449 VSS.n914 VSS.n404 0.231121
R2450 VSS.n914 VSS.n913 0.231121
R2451 VSS.n912 VSS.n406 0.231121
R2452 VSS.n905 VSS.n406 0.231121
R2453 VSS.n905 VSS.n904 0.231121
R2454 VSS.n903 VSS.n408 0.231121
R2455 VSS.n896 VSS.n408 0.231121
R2456 VSS.n896 VSS.n895 0.231121
R2457 VSS.n894 VSS.n410 0.231121
R2458 VSS.n887 VSS.n410 0.231121
R2459 VSS.n887 VSS.n886 0.231121
R2460 VSS.n885 VSS.n412 0.231121
R2461 VSS.n878 VSS.n412 0.231121
R2462 VSS.n878 VSS.n877 0.231121
R2463 VSS.n876 VSS.n414 0.231121
R2464 VSS.n869 VSS.n414 0.231121
R2465 VSS.n869 VSS.n868 0.231121
R2466 VSS.n867 VSS.n416 0.231121
R2467 VSS.n860 VSS.n416 0.231121
R2468 VSS.n860 VSS.n859 0.231121
R2469 VSS.n858 VSS.n418 0.231121
R2470 VSS.n851 VSS.n418 0.231121
R2471 VSS.n851 VSS.n850 0.231121
R2472 VSS.n849 VSS.n420 0.231121
R2473 VSS.n842 VSS.n420 0.231121
R2474 VSS.n842 VSS.n841 0.231121
R2475 VSS.n840 VSS.n422 0.231121
R2476 VSS.n833 VSS.n422 0.231121
R2477 VSS.n833 VSS.n832 0.231121
R2478 VSS.n831 VSS.n424 0.231121
R2479 VSS.n824 VSS.n424 0.231121
R2480 VSS.n824 VSS.n823 0.231121
R2481 VSS.n822 VSS.n426 0.231121
R2482 VSS.n815 VSS.n426 0.231121
R2483 VSS.n815 VSS.n814 0.231121
R2484 VSS.n813 VSS.n428 0.231121
R2485 VSS.n806 VSS.n428 0.231121
R2486 VSS.n806 VSS.n805 0.231121
R2487 VSS.n804 VSS.n430 0.231121
R2488 VSS.n797 VSS.n430 0.231121
R2489 VSS.n797 VSS.n796 0.231121
R2490 VSS.n795 VSS.n432 0.231121
R2491 VSS.n788 VSS.n432 0.231121
R2492 VSS.n788 VSS.n787 0.231121
R2493 VSS.n786 VSS.n434 0.231121
R2494 VSS.n779 VSS.n434 0.231121
R2495 VSS.n779 VSS.n778 0.231121
R2496 VSS.n777 VSS.n436 0.231121
R2497 VSS.n770 VSS.n436 0.231121
R2498 VSS.n770 VSS.n769 0.231121
R2499 VSS.n768 VSS.n438 0.231121
R2500 VSS.n761 VSS.n438 0.231121
R2501 VSS.n761 VSS.n760 0.231121
R2502 VSS.n759 VSS.n440 0.231121
R2503 VSS.n752 VSS.n440 0.231121
R2504 VSS.n752 VSS.n751 0.231121
R2505 VSS.n750 VSS.n442 0.231121
R2506 VSS.n743 VSS.n442 0.231121
R2507 VSS.n743 VSS.n742 0.231121
R2508 VSS.n1047 VSS.n1046 0.231121
R2509 VSS.n1045 VSS.n101 0.231121
R2510 VSS.n1044 VSS.n378 0.231121
R2511 VSS.n1038 VSS.n378 0.231121
R2512 VSS.n1037 VSS.n379 0.231121
R2513 VSS.n380 VSS.n379 0.231121
R2514 VSS.n518 VSS.n515 0.231121
R2515 VSS.n523 VSS.n515 0.231121
R2516 VSS.n524 VSS.n513 0.231121
R2517 VSS.n532 VSS.n513 0.231121
R2518 VSS.n533 VSS.n510 0.231121
R2519 VSS.n538 VSS.n510 0.231121
R2520 VSS.n539 VSS.n508 0.231121
R2521 VSS.n547 VSS.n508 0.231121
R2522 VSS.n548 VSS.n505 0.231121
R2523 VSS.n553 VSS.n505 0.231121
R2524 VSS.n554 VSS.n503 0.231121
R2525 VSS.n562 VSS.n503 0.231121
R2526 VSS.n563 VSS.n500 0.231121
R2527 VSS.n568 VSS.n500 0.231121
R2528 VSS.n569 VSS.n498 0.231121
R2529 VSS.n577 VSS.n498 0.231121
R2530 VSS.n578 VSS.n495 0.231121
R2531 VSS.n583 VSS.n495 0.231121
R2532 VSS.n584 VSS.n493 0.231121
R2533 VSS.n592 VSS.n493 0.231121
R2534 VSS.n593 VSS.n490 0.231121
R2535 VSS.n598 VSS.n490 0.231121
R2536 VSS.n599 VSS.n488 0.231121
R2537 VSS.n607 VSS.n488 0.231121
R2538 VSS.n608 VSS.n485 0.231121
R2539 VSS.n613 VSS.n485 0.231121
R2540 VSS.n614 VSS.n483 0.231121
R2541 VSS.n622 VSS.n483 0.231121
R2542 VSS.n623 VSS.n480 0.231121
R2543 VSS.n628 VSS.n480 0.231121
R2544 VSS.n629 VSS.n478 0.231121
R2545 VSS.n637 VSS.n478 0.231121
R2546 VSS.n638 VSS.n475 0.231121
R2547 VSS.n643 VSS.n475 0.231121
R2548 VSS.n644 VSS.n473 0.231121
R2549 VSS.n652 VSS.n473 0.231121
R2550 VSS.n653 VSS.n470 0.231121
R2551 VSS.n658 VSS.n470 0.231121
R2552 VSS.n659 VSS.n468 0.231121
R2553 VSS.n667 VSS.n468 0.231121
R2554 VSS.n668 VSS.n465 0.231121
R2555 VSS.n673 VSS.n465 0.231121
R2556 VSS.n674 VSS.n463 0.231121
R2557 VSS.n682 VSS.n463 0.231121
R2558 VSS.n683 VSS.n460 0.231121
R2559 VSS.n688 VSS.n460 0.231121
R2560 VSS.n689 VSS.n458 0.231121
R2561 VSS.n697 VSS.n458 0.231121
R2562 VSS.n698 VSS.n455 0.231121
R2563 VSS.n703 VSS.n455 0.231121
R2564 VSS.n704 VSS.n453 0.231121
R2565 VSS.n712 VSS.n453 0.231121
R2566 VSS.n713 VSS.n450 0.231121
R2567 VSS.n718 VSS.n450 0.231121
R2568 VSS.n719 VSS.n448 0.231121
R2569 VSS.n727 VSS.n448 0.231121
R2570 VSS.n728 VSS.n445 0.231121
R2571 VSS.n733 VSS.n445 0.231121
R2572 VSS.n735 VSS.n444 0.231121
R2573 VSS.n731 VSS.n729 0.231121
R2574 VSS.n732 VSS.n731 0.231121
R2575 VSS.n722 VSS.n720 0.231121
R2576 VSS.n726 VSS.n722 0.231121
R2577 VSS.n716 VSS.n714 0.231121
R2578 VSS.n717 VSS.n716 0.231121
R2579 VSS.n707 VSS.n705 0.231121
R2580 VSS.n711 VSS.n707 0.231121
R2581 VSS.n701 VSS.n699 0.231121
R2582 VSS.n702 VSS.n701 0.231121
R2583 VSS.n692 VSS.n690 0.231121
R2584 VSS.n696 VSS.n692 0.231121
R2585 VSS.n686 VSS.n684 0.231121
R2586 VSS.n687 VSS.n686 0.231121
R2587 VSS.n677 VSS.n675 0.231121
R2588 VSS.n681 VSS.n677 0.231121
R2589 VSS.n671 VSS.n669 0.231121
R2590 VSS.n672 VSS.n671 0.231121
R2591 VSS.n662 VSS.n660 0.231121
R2592 VSS.n666 VSS.n662 0.231121
R2593 VSS.n656 VSS.n654 0.231121
R2594 VSS.n657 VSS.n656 0.231121
R2595 VSS.n647 VSS.n645 0.231121
R2596 VSS.n651 VSS.n647 0.231121
R2597 VSS.n641 VSS.n639 0.231121
R2598 VSS.n642 VSS.n641 0.231121
R2599 VSS.n632 VSS.n630 0.231121
R2600 VSS.n636 VSS.n632 0.231121
R2601 VSS.n626 VSS.n624 0.231121
R2602 VSS.n627 VSS.n626 0.231121
R2603 VSS.n617 VSS.n615 0.231121
R2604 VSS.n621 VSS.n617 0.231121
R2605 VSS.n611 VSS.n609 0.231121
R2606 VSS.n612 VSS.n611 0.231121
R2607 VSS.n602 VSS.n600 0.231121
R2608 VSS.n606 VSS.n602 0.231121
R2609 VSS.n596 VSS.n594 0.231121
R2610 VSS.n597 VSS.n596 0.231121
R2611 VSS.n587 VSS.n585 0.231121
R2612 VSS.n591 VSS.n587 0.231121
R2613 VSS.n581 VSS.n579 0.231121
R2614 VSS.n582 VSS.n581 0.231121
R2615 VSS.n572 VSS.n570 0.231121
R2616 VSS.n576 VSS.n572 0.231121
R2617 VSS.n566 VSS.n564 0.231121
R2618 VSS.n567 VSS.n566 0.231121
R2619 VSS.n557 VSS.n555 0.231121
R2620 VSS.n561 VSS.n557 0.231121
R2621 VSS.n551 VSS.n549 0.231121
R2622 VSS.n552 VSS.n551 0.231121
R2623 VSS.n542 VSS.n540 0.231121
R2624 VSS.n546 VSS.n542 0.231121
R2625 VSS.n536 VSS.n534 0.231121
R2626 VSS.n537 VSS.n536 0.231121
R2627 VSS.n527 VSS.n525 0.231121
R2628 VSS.n531 VSS.n527 0.231121
R2629 VSS.n521 VSS.n519 0.231121
R2630 VSS.n522 VSS.n521 0.231121
R2631 VSS.n1036 VSS.n1034 0.231121
R2632 VSS.n1034 VSS.n1032 0.231121
R2633 VSS.n1043 VSS.n1041 0.231121
R2634 VSS.n1041 VSS.n1039 0.231121
R2635 VSS.n1025 VSS.n1024 0.231121
R2636 VSS.n1025 VSS.n383 0.231121
R2637 VSS.n1029 VSS.n383 0.231121
R2638 VSS.n1010 VSS.n1008 0.231121
R2639 VSS.n1008 VSS.n1006 0.231121
R2640 VSS.n1006 VSS.n385 0.231121
R2641 VSS.n1001 VSS.n999 0.231121
R2642 VSS.n999 VSS.n997 0.231121
R2643 VSS.n997 VSS.n387 0.231121
R2644 VSS.n992 VSS.n990 0.231121
R2645 VSS.n990 VSS.n988 0.231121
R2646 VSS.n988 VSS.n389 0.231121
R2647 VSS.n983 VSS.n981 0.231121
R2648 VSS.n981 VSS.n979 0.231121
R2649 VSS.n979 VSS.n391 0.231121
R2650 VSS.n974 VSS.n972 0.231121
R2651 VSS.n972 VSS.n970 0.231121
R2652 VSS.n970 VSS.n393 0.231121
R2653 VSS.n965 VSS.n963 0.231121
R2654 VSS.n963 VSS.n961 0.231121
R2655 VSS.n961 VSS.n395 0.231121
R2656 VSS.n956 VSS.n954 0.231121
R2657 VSS.n954 VSS.n952 0.231121
R2658 VSS.n952 VSS.n397 0.231121
R2659 VSS.n947 VSS.n945 0.231121
R2660 VSS.n945 VSS.n943 0.231121
R2661 VSS.n943 VSS.n399 0.231121
R2662 VSS.n938 VSS.n936 0.231121
R2663 VSS.n936 VSS.n934 0.231121
R2664 VSS.n934 VSS.n401 0.231121
R2665 VSS.n929 VSS.n927 0.231121
R2666 VSS.n927 VSS.n925 0.231121
R2667 VSS.n925 VSS.n403 0.231121
R2668 VSS.n920 VSS.n918 0.231121
R2669 VSS.n918 VSS.n916 0.231121
R2670 VSS.n916 VSS.n405 0.231121
R2671 VSS.n911 VSS.n909 0.231121
R2672 VSS.n909 VSS.n907 0.231121
R2673 VSS.n907 VSS.n407 0.231121
R2674 VSS.n902 VSS.n900 0.231121
R2675 VSS.n900 VSS.n898 0.231121
R2676 VSS.n898 VSS.n409 0.231121
R2677 VSS.n893 VSS.n891 0.231121
R2678 VSS.n891 VSS.n889 0.231121
R2679 VSS.n889 VSS.n411 0.231121
R2680 VSS.n884 VSS.n882 0.231121
R2681 VSS.n882 VSS.n880 0.231121
R2682 VSS.n880 VSS.n413 0.231121
R2683 VSS.n875 VSS.n873 0.231121
R2684 VSS.n873 VSS.n871 0.231121
R2685 VSS.n871 VSS.n415 0.231121
R2686 VSS.n866 VSS.n864 0.231121
R2687 VSS.n864 VSS.n862 0.231121
R2688 VSS.n862 VSS.n417 0.231121
R2689 VSS.n857 VSS.n855 0.231121
R2690 VSS.n855 VSS.n853 0.231121
R2691 VSS.n853 VSS.n419 0.231121
R2692 VSS.n848 VSS.n846 0.231121
R2693 VSS.n846 VSS.n844 0.231121
R2694 VSS.n844 VSS.n421 0.231121
R2695 VSS.n839 VSS.n837 0.231121
R2696 VSS.n837 VSS.n835 0.231121
R2697 VSS.n835 VSS.n423 0.231121
R2698 VSS.n830 VSS.n828 0.231121
R2699 VSS.n828 VSS.n826 0.231121
R2700 VSS.n826 VSS.n425 0.231121
R2701 VSS.n821 VSS.n819 0.231121
R2702 VSS.n819 VSS.n817 0.231121
R2703 VSS.n817 VSS.n427 0.231121
R2704 VSS.n812 VSS.n810 0.231121
R2705 VSS.n810 VSS.n808 0.231121
R2706 VSS.n808 VSS.n429 0.231121
R2707 VSS.n803 VSS.n801 0.231121
R2708 VSS.n801 VSS.n799 0.231121
R2709 VSS.n799 VSS.n431 0.231121
R2710 VSS.n794 VSS.n792 0.231121
R2711 VSS.n792 VSS.n790 0.231121
R2712 VSS.n790 VSS.n433 0.231121
R2713 VSS.n785 VSS.n783 0.231121
R2714 VSS.n783 VSS.n781 0.231121
R2715 VSS.n781 VSS.n435 0.231121
R2716 VSS.n776 VSS.n774 0.231121
R2717 VSS.n774 VSS.n772 0.231121
R2718 VSS.n772 VSS.n437 0.231121
R2719 VSS.n767 VSS.n765 0.231121
R2720 VSS.n765 VSS.n763 0.231121
R2721 VSS.n763 VSS.n439 0.231121
R2722 VSS.n758 VSS.n756 0.231121
R2723 VSS.n756 VSS.n754 0.231121
R2724 VSS.n754 VSS.n441 0.231121
R2725 VSS.n749 VSS.n747 0.231121
R2726 VSS.n747 VSS.n745 0.231121
R2727 VSS.n745 VSS.n740 0.231121
R2728 VSS.n1016 VSS.n1015 0.231121
R2729 VSS.n1019 VSS.n1016 0.231121
R2730 VSS.n1054 VSS 0.226636
R2731 VSS VSS.n1057 0.226288
R2732 VSS.n375 VSS.n374 0.206787
R2733 VSS.n1017 VSS.n213 0.197793
R2734 VSS.n381 VSS.n218 0.197793
R2735 VSS.n117 VSS.n223 0.197793
R2736 VSS.n528 VSS.n228 0.197793
R2737 VSS.n123 VSS.n233 0.197793
R2738 VSS.n543 VSS.n238 0.197793
R2739 VSS.n129 VSS.n243 0.197793
R2740 VSS.n558 VSS.n248 0.197793
R2741 VSS.n135 VSS.n253 0.197793
R2742 VSS.n573 VSS.n258 0.197793
R2743 VSS.n141 VSS.n263 0.197793
R2744 VSS.n588 VSS.n268 0.197793
R2745 VSS.n147 VSS.n273 0.197793
R2746 VSS.n603 VSS.n278 0.197793
R2747 VSS.n153 VSS.n283 0.197793
R2748 VSS.n618 VSS.n288 0.197793
R2749 VSS.n159 VSS.n293 0.197793
R2750 VSS.n633 VSS.n298 0.197793
R2751 VSS.n165 VSS.n303 0.197793
R2752 VSS.n648 VSS.n308 0.197793
R2753 VSS.n171 VSS.n313 0.197793
R2754 VSS.n663 VSS.n318 0.197793
R2755 VSS.n177 VSS.n323 0.197793
R2756 VSS.n678 VSS.n328 0.197793
R2757 VSS.n183 VSS.n333 0.197793
R2758 VSS.n693 VSS.n338 0.197793
R2759 VSS.n189 VSS.n343 0.197793
R2760 VSS.n708 VSS.n348 0.197793
R2761 VSS.n195 VSS.n353 0.197793
R2762 VSS.n723 VSS.n358 0.197793
R2763 VSS.n201 VSS.n363 0.197793
R2764 VSS.n738 VSS.n368 0.197793
R2765 VSS.t109 VSS.t113 0.1875
R2766 VSS.t120 VSS.n204 0.177116
R2767 VSS.n1023 VSS.n213 0.143558
R2768 VSS.n1009 VSS.n218 0.143558
R2769 VSS.n1000 VSS.n223 0.143558
R2770 VSS.n991 VSS.n228 0.143558
R2771 VSS.n982 VSS.n233 0.143558
R2772 VSS.n973 VSS.n238 0.143558
R2773 VSS.n964 VSS.n243 0.143558
R2774 VSS.n955 VSS.n248 0.143558
R2775 VSS.n946 VSS.n253 0.143558
R2776 VSS.n937 VSS.n258 0.143558
R2777 VSS.n928 VSS.n263 0.143558
R2778 VSS.n919 VSS.n268 0.143558
R2779 VSS.n910 VSS.n273 0.143558
R2780 VSS.n901 VSS.n278 0.143558
R2781 VSS.n892 VSS.n283 0.143558
R2782 VSS.n883 VSS.n288 0.143558
R2783 VSS.n874 VSS.n293 0.143558
R2784 VSS.n865 VSS.n298 0.143558
R2785 VSS.n856 VSS.n303 0.143558
R2786 VSS.n847 VSS.n308 0.143558
R2787 VSS.n838 VSS.n313 0.143558
R2788 VSS.n829 VSS.n318 0.143558
R2789 VSS.n820 VSS.n323 0.143558
R2790 VSS.n811 VSS.n328 0.143558
R2791 VSS.n802 VSS.n333 0.143558
R2792 VSS.n793 VSS.n338 0.143558
R2793 VSS.n784 VSS.n343 0.143558
R2794 VSS.n775 VSS.n348 0.143558
R2795 VSS.n766 VSS.n353 0.143558
R2796 VSS.n757 VSS.n358 0.143558
R2797 VSS.n748 VSS.n363 0.143558
R2798 VSS.n741 VSS.n368 0.143558
R2799 VSS.n1014 VSS.n211 0.143368
R2800 VSS.n1013 VSS.n212 0.143368
R2801 VSS.n1023 VSS.n215 0.143368
R2802 VSS.n1022 VSS.n216 0.143368
R2803 VSS.n382 VSS.n217 0.143368
R2804 VSS.n1009 VSS.n220 0.143368
R2805 VSS.n1007 VSS.n221 0.143368
R2806 VSS.n1005 VSS.n222 0.143368
R2807 VSS.n1000 VSS.n225 0.143368
R2808 VSS.n998 VSS.n226 0.143368
R2809 VSS.n996 VSS.n227 0.143368
R2810 VSS.n991 VSS.n230 0.143368
R2811 VSS.n989 VSS.n231 0.143368
R2812 VSS.n987 VSS.n232 0.143368
R2813 VSS.n982 VSS.n235 0.143368
R2814 VSS.n980 VSS.n236 0.143368
R2815 VSS.n978 VSS.n237 0.143368
R2816 VSS.n973 VSS.n240 0.143368
R2817 VSS.n971 VSS.n241 0.143368
R2818 VSS.n969 VSS.n242 0.143368
R2819 VSS.n964 VSS.n245 0.143368
R2820 VSS.n962 VSS.n246 0.143368
R2821 VSS.n960 VSS.n247 0.143368
R2822 VSS.n955 VSS.n250 0.143368
R2823 VSS.n953 VSS.n251 0.143368
R2824 VSS.n951 VSS.n252 0.143368
R2825 VSS.n946 VSS.n255 0.143368
R2826 VSS.n944 VSS.n256 0.143368
R2827 VSS.n942 VSS.n257 0.143368
R2828 VSS.n937 VSS.n260 0.143368
R2829 VSS.n935 VSS.n261 0.143368
R2830 VSS.n933 VSS.n262 0.143368
R2831 VSS.n928 VSS.n265 0.143368
R2832 VSS.n926 VSS.n266 0.143368
R2833 VSS.n924 VSS.n267 0.143368
R2834 VSS.n919 VSS.n270 0.143368
R2835 VSS.n917 VSS.n271 0.143368
R2836 VSS.n915 VSS.n272 0.143368
R2837 VSS.n910 VSS.n275 0.143368
R2838 VSS.n908 VSS.n276 0.143368
R2839 VSS.n906 VSS.n277 0.143368
R2840 VSS.n901 VSS.n280 0.143368
R2841 VSS.n899 VSS.n281 0.143368
R2842 VSS.n897 VSS.n282 0.143368
R2843 VSS.n892 VSS.n285 0.143368
R2844 VSS.n890 VSS.n286 0.143368
R2845 VSS.n888 VSS.n287 0.143368
R2846 VSS.n883 VSS.n290 0.143368
R2847 VSS.n881 VSS.n291 0.143368
R2848 VSS.n879 VSS.n292 0.143368
R2849 VSS.n874 VSS.n295 0.143368
R2850 VSS.n872 VSS.n296 0.143368
R2851 VSS.n870 VSS.n297 0.143368
R2852 VSS.n865 VSS.n300 0.143368
R2853 VSS.n863 VSS.n301 0.143368
R2854 VSS.n861 VSS.n302 0.143368
R2855 VSS.n856 VSS.n305 0.143368
R2856 VSS.n854 VSS.n306 0.143368
R2857 VSS.n852 VSS.n307 0.143368
R2858 VSS.n847 VSS.n310 0.143368
R2859 VSS.n845 VSS.n311 0.143368
R2860 VSS.n843 VSS.n312 0.143368
R2861 VSS.n838 VSS.n315 0.143368
R2862 VSS.n836 VSS.n316 0.143368
R2863 VSS.n834 VSS.n317 0.143368
R2864 VSS.n829 VSS.n320 0.143368
R2865 VSS.n827 VSS.n321 0.143368
R2866 VSS.n825 VSS.n322 0.143368
R2867 VSS.n820 VSS.n325 0.143368
R2868 VSS.n818 VSS.n326 0.143368
R2869 VSS.n816 VSS.n327 0.143368
R2870 VSS.n811 VSS.n330 0.143368
R2871 VSS.n809 VSS.n331 0.143368
R2872 VSS.n807 VSS.n332 0.143368
R2873 VSS.n802 VSS.n335 0.143368
R2874 VSS.n800 VSS.n336 0.143368
R2875 VSS.n798 VSS.n337 0.143368
R2876 VSS.n793 VSS.n340 0.143368
R2877 VSS.n791 VSS.n341 0.143368
R2878 VSS.n789 VSS.n342 0.143368
R2879 VSS.n784 VSS.n345 0.143368
R2880 VSS.n782 VSS.n346 0.143368
R2881 VSS.n780 VSS.n347 0.143368
R2882 VSS.n775 VSS.n350 0.143368
R2883 VSS.n773 VSS.n351 0.143368
R2884 VSS.n771 VSS.n352 0.143368
R2885 VSS.n766 VSS.n355 0.143368
R2886 VSS.n764 VSS.n356 0.143368
R2887 VSS.n762 VSS.n357 0.143368
R2888 VSS.n757 VSS.n360 0.143368
R2889 VSS.n755 VSS.n361 0.143368
R2890 VSS.n753 VSS.n362 0.143368
R2891 VSS.n748 VSS.n365 0.143368
R2892 VSS.n746 VSS.n366 0.143368
R2893 VSS.n744 VSS.n367 0.143368
R2894 VSS.n741 VSS.n370 0.143368
R2895 VSS.n1040 VSS.n109 0.143368
R2896 VSS.n1033 VSS.n112 0.143368
R2897 VSS.n520 VSS.n114 0.143368
R2898 VSS.n526 VSS.n118 0.143368
R2899 VSS.n535 VSS.n120 0.143368
R2900 VSS.n541 VSS.n124 0.143368
R2901 VSS.n550 VSS.n126 0.143368
R2902 VSS.n556 VSS.n130 0.143368
R2903 VSS.n565 VSS.n132 0.143368
R2904 VSS.n571 VSS.n136 0.143368
R2905 VSS.n580 VSS.n138 0.143368
R2906 VSS.n586 VSS.n142 0.143368
R2907 VSS.n595 VSS.n144 0.143368
R2908 VSS.n601 VSS.n148 0.143368
R2909 VSS.n610 VSS.n150 0.143368
R2910 VSS.n616 VSS.n154 0.143368
R2911 VSS.n625 VSS.n156 0.143368
R2912 VSS.n631 VSS.n160 0.143368
R2913 VSS.n640 VSS.n162 0.143368
R2914 VSS.n646 VSS.n166 0.143368
R2915 VSS.n655 VSS.n168 0.143368
R2916 VSS.n661 VSS.n172 0.143368
R2917 VSS.n670 VSS.n174 0.143368
R2918 VSS.n676 VSS.n178 0.143368
R2919 VSS.n685 VSS.n180 0.143368
R2920 VSS.n691 VSS.n184 0.143368
R2921 VSS.n700 VSS.n186 0.143368
R2922 VSS.n706 VSS.n190 0.143368
R2923 VSS.n715 VSS.n192 0.143368
R2924 VSS.n721 VSS.n196 0.143368
R2925 VSS.n730 VSS.n198 0.143368
R2926 VSS.n443 VSS.n202 0.143368
R2927 VSS.n374 VSS.t118 0.141022
R2928 VSS.n1056 VSS.n1055 0.138073
R2929 VSS.t114 VSS.n371 0.135868
R2930 VSS.t117 VSS.n206 0.124618
R2931 VSS.t114 VSS.n372 0.122118
R2932 VSS.t116 VSS.n206 0.122118
R2933 VSS.n737 VSS.n444 0.113429
R2934 VSS.n111 VSS.n110 0.0961384
R2935 VSS.n1031 VSS.n113 0.0961384
R2936 VSS.n517 VSS.n116 0.0961384
R2937 VSS.n530 VSS.n119 0.0961384
R2938 VSS.n512 VSS.n122 0.0961384
R2939 VSS.n545 VSS.n125 0.0961384
R2940 VSS.n507 VSS.n128 0.0961384
R2941 VSS.n560 VSS.n131 0.0961384
R2942 VSS.n502 VSS.n134 0.0961384
R2943 VSS.n575 VSS.n137 0.0961384
R2944 VSS.n497 VSS.n140 0.0961384
R2945 VSS.n590 VSS.n143 0.0961384
R2946 VSS.n492 VSS.n146 0.0961384
R2947 VSS.n605 VSS.n149 0.0961384
R2948 VSS.n487 VSS.n152 0.0961384
R2949 VSS.n620 VSS.n155 0.0961384
R2950 VSS.n482 VSS.n158 0.0961384
R2951 VSS.n635 VSS.n161 0.0961384
R2952 VSS.n477 VSS.n164 0.0961384
R2953 VSS.n650 VSS.n167 0.0961384
R2954 VSS.n472 VSS.n170 0.0961384
R2955 VSS.n665 VSS.n173 0.0961384
R2956 VSS.n467 VSS.n176 0.0961384
R2957 VSS.n680 VSS.n179 0.0961384
R2958 VSS.n462 VSS.n182 0.0961384
R2959 VSS.n695 VSS.n185 0.0961384
R2960 VSS.n457 VSS.n188 0.0961384
R2961 VSS.n710 VSS.n191 0.0961384
R2962 VSS.n452 VSS.n194 0.0961384
R2963 VSS.n725 VSS.n197 0.0961384
R2964 VSS.n447 VSS.n200 0.0961384
R2965 VSS.n207 VSS.n203 0.0961384
R2966 VSS.n1040 VSS.n110 0.0958002
R2967 VSS.n1033 VSS.n113 0.0958002
R2968 VSS.n520 VSS.n116 0.0958002
R2969 VSS.n526 VSS.n119 0.0958002
R2970 VSS.n535 VSS.n122 0.0958002
R2971 VSS.n541 VSS.n125 0.0958002
R2972 VSS.n550 VSS.n128 0.0958002
R2973 VSS.n556 VSS.n131 0.0958002
R2974 VSS.n565 VSS.n134 0.0958002
R2975 VSS.n571 VSS.n137 0.0958002
R2976 VSS.n580 VSS.n140 0.0958002
R2977 VSS.n586 VSS.n143 0.0958002
R2978 VSS.n595 VSS.n146 0.0958002
R2979 VSS.n601 VSS.n149 0.0958002
R2980 VSS.n610 VSS.n152 0.0958002
R2981 VSS.n616 VSS.n155 0.0958002
R2982 VSS.n625 VSS.n158 0.0958002
R2983 VSS.n631 VSS.n161 0.0958002
R2984 VSS.n640 VSS.n164 0.0958002
R2985 VSS.n646 VSS.n167 0.0958002
R2986 VSS.n655 VSS.n170 0.0958002
R2987 VSS.n661 VSS.n173 0.0958002
R2988 VSS.n670 VSS.n176 0.0958002
R2989 VSS.n676 VSS.n179 0.0958002
R2990 VSS.n685 VSS.n182 0.0958002
R2991 VSS.n691 VSS.n185 0.0958002
R2992 VSS.n700 VSS.n188 0.0958002
R2993 VSS.n706 VSS.n191 0.0958002
R2994 VSS.n715 VSS.n194 0.0958002
R2995 VSS.n721 VSS.n197 0.0958002
R2996 VSS.n730 VSS.n200 0.0958002
R2997 VSS.n443 VSS.n203 0.0958002
R2998 VSS.n1042 VSS.n208 0.0955
R2999 VSS.t110 VSS.n106 0.08925
R3000 VSS.n209 VSS.t107 0.08925
R3001 VSS.n1050 VSS.t109 0.0851154
R3002 VSS.t113 VSS.n376 0.0851154
R3003 VSS.n376 VSS.n210 0.0846176
R3004 VSS.t118 VSS.n373 0.0771176
R3005 VSS.t120 VSS.n205 0.0771176
R3006 VSS.n1050 VSS.n0 0.0746176
R3007 VSS.n372 VSS.n373 0.0696176
R3008 VSS.t116 VSS.n205 0.0696176
R3009 VSS.n1051 VSS.n1050 0.06925
R3010 VSS.n377 VSS.n108 0.06925
R3011 VSS.n1051 VSS.n376 0.05925
R3012 VSS.n1049 VSS.n108 0.05925
R3013 VSS.n371 VSS.n370 0.0558676
R3014 VSS.t107 VSS.n105 0.0546176
R3015 VSS.n1014 VSS.n210 0.0483676
R3016 VSS.n1013 VSS.n211 0.0483676
R3017 VSS.n1018 VSS.n212 0.0483676
R3018 VSS.n1022 VSS.n215 0.0483676
R3019 VSS.n382 VSS.n216 0.0483676
R3020 VSS.n1030 VSS.n217 0.0483676
R3021 VSS.n1007 VSS.n220 0.0483676
R3022 VSS.n1005 VSS.n221 0.0483676
R3023 VSS.n516 VSS.n222 0.0483676
R3024 VSS.n998 VSS.n225 0.0483676
R3025 VSS.n996 VSS.n226 0.0483676
R3026 VSS.n529 VSS.n227 0.0483676
R3027 VSS.n989 VSS.n230 0.0483676
R3028 VSS.n987 VSS.n231 0.0483676
R3029 VSS.n511 VSS.n232 0.0483676
R3030 VSS.n980 VSS.n235 0.0483676
R3031 VSS.n978 VSS.n236 0.0483676
R3032 VSS.n544 VSS.n237 0.0483676
R3033 VSS.n971 VSS.n240 0.0483676
R3034 VSS.n969 VSS.n241 0.0483676
R3035 VSS.n506 VSS.n242 0.0483676
R3036 VSS.n962 VSS.n245 0.0483676
R3037 VSS.n960 VSS.n246 0.0483676
R3038 VSS.n559 VSS.n247 0.0483676
R3039 VSS.n953 VSS.n250 0.0483676
R3040 VSS.n951 VSS.n251 0.0483676
R3041 VSS.n501 VSS.n252 0.0483676
R3042 VSS.n944 VSS.n255 0.0483676
R3043 VSS.n942 VSS.n256 0.0483676
R3044 VSS.n574 VSS.n257 0.0483676
R3045 VSS.n935 VSS.n260 0.0483676
R3046 VSS.n933 VSS.n261 0.0483676
R3047 VSS.n496 VSS.n262 0.0483676
R3048 VSS.n926 VSS.n265 0.0483676
R3049 VSS.n924 VSS.n266 0.0483676
R3050 VSS.n589 VSS.n267 0.0483676
R3051 VSS.n917 VSS.n270 0.0483676
R3052 VSS.n915 VSS.n271 0.0483676
R3053 VSS.n491 VSS.n272 0.0483676
R3054 VSS.n908 VSS.n275 0.0483676
R3055 VSS.n906 VSS.n276 0.0483676
R3056 VSS.n604 VSS.n277 0.0483676
R3057 VSS.n899 VSS.n280 0.0483676
R3058 VSS.n897 VSS.n281 0.0483676
R3059 VSS.n486 VSS.n282 0.0483676
R3060 VSS.n890 VSS.n285 0.0483676
R3061 VSS.n888 VSS.n286 0.0483676
R3062 VSS.n619 VSS.n287 0.0483676
R3063 VSS.n881 VSS.n290 0.0483676
R3064 VSS.n879 VSS.n291 0.0483676
R3065 VSS.n481 VSS.n292 0.0483676
R3066 VSS.n872 VSS.n295 0.0483676
R3067 VSS.n870 VSS.n296 0.0483676
R3068 VSS.n634 VSS.n297 0.0483676
R3069 VSS.n863 VSS.n300 0.0483676
R3070 VSS.n861 VSS.n301 0.0483676
R3071 VSS.n476 VSS.n302 0.0483676
R3072 VSS.n854 VSS.n305 0.0483676
R3073 VSS.n852 VSS.n306 0.0483676
R3074 VSS.n649 VSS.n307 0.0483676
R3075 VSS.n845 VSS.n310 0.0483676
R3076 VSS.n843 VSS.n311 0.0483676
R3077 VSS.n471 VSS.n312 0.0483676
R3078 VSS.n836 VSS.n315 0.0483676
R3079 VSS.n834 VSS.n316 0.0483676
R3080 VSS.n664 VSS.n317 0.0483676
R3081 VSS.n827 VSS.n320 0.0483676
R3082 VSS.n825 VSS.n321 0.0483676
R3083 VSS.n466 VSS.n322 0.0483676
R3084 VSS.n818 VSS.n325 0.0483676
R3085 VSS.n816 VSS.n326 0.0483676
R3086 VSS.n679 VSS.n327 0.0483676
R3087 VSS.n809 VSS.n330 0.0483676
R3088 VSS.n807 VSS.n331 0.0483676
R3089 VSS.n461 VSS.n332 0.0483676
R3090 VSS.n800 VSS.n335 0.0483676
R3091 VSS.n798 VSS.n336 0.0483676
R3092 VSS.n694 VSS.n337 0.0483676
R3093 VSS.n791 VSS.n340 0.0483676
R3094 VSS.n789 VSS.n341 0.0483676
R3095 VSS.n456 VSS.n342 0.0483676
R3096 VSS.n782 VSS.n345 0.0483676
R3097 VSS.n780 VSS.n346 0.0483676
R3098 VSS.n709 VSS.n347 0.0483676
R3099 VSS.n773 VSS.n350 0.0483676
R3100 VSS.n771 VSS.n351 0.0483676
R3101 VSS.n451 VSS.n352 0.0483676
R3102 VSS.n764 VSS.n355 0.0483676
R3103 VSS.n762 VSS.n356 0.0483676
R3104 VSS.n724 VSS.n357 0.0483676
R3105 VSS.n755 VSS.n360 0.0483676
R3106 VSS.n753 VSS.n361 0.0483676
R3107 VSS.n446 VSS.n362 0.0483676
R3108 VSS.n746 VSS.n365 0.0483676
R3109 VSS.n744 VSS.n366 0.0483676
R3110 VSS.n739 VSS.n367 0.0483676
R3111 VSS.n1052 VSS.n0 0.0483676
R3112 VSS.n1048 VSS.n105 0.0483676
R3113 VSS.n1042 VSS.n109 0.0483676
R3114 VSS.n1035 VSS.n112 0.0483676
R3115 VSS.n115 VSS.n114 0.0483676
R3116 VSS.n514 VSS.n118 0.0483676
R3117 VSS.n121 VSS.n120 0.0483676
R3118 VSS.n509 VSS.n124 0.0483676
R3119 VSS.n127 VSS.n126 0.0483676
R3120 VSS.n504 VSS.n130 0.0483676
R3121 VSS.n133 VSS.n132 0.0483676
R3122 VSS.n499 VSS.n136 0.0483676
R3123 VSS.n139 VSS.n138 0.0483676
R3124 VSS.n494 VSS.n142 0.0483676
R3125 VSS.n145 VSS.n144 0.0483676
R3126 VSS.n489 VSS.n148 0.0483676
R3127 VSS.n151 VSS.n150 0.0483676
R3128 VSS.n484 VSS.n154 0.0483676
R3129 VSS.n157 VSS.n156 0.0483676
R3130 VSS.n479 VSS.n160 0.0483676
R3131 VSS.n163 VSS.n162 0.0483676
R3132 VSS.n474 VSS.n166 0.0483676
R3133 VSS.n169 VSS.n168 0.0483676
R3134 VSS.n469 VSS.n172 0.0483676
R3135 VSS.n175 VSS.n174 0.0483676
R3136 VSS.n464 VSS.n178 0.0483676
R3137 VSS.n181 VSS.n180 0.0483676
R3138 VSS.n459 VSS.n184 0.0483676
R3139 VSS.n187 VSS.n186 0.0483676
R3140 VSS.n454 VSS.n190 0.0483676
R3141 VSS.n193 VSS.n192 0.0483676
R3142 VSS.n449 VSS.n196 0.0483676
R3143 VSS.n199 VSS.n198 0.0483676
R3144 VSS.n734 VSS.n202 0.0483676
R3145 VSS.n99 VSS.n92 0.0447034
R3146 VSS.n99 VSS.n62 0.0447034
R3147 VSS.n99 VSS.n2 0.0444724
R3148 VSS.n99 VSS.n93 0.0444724
R3149 VSS.n99 VSS.n90 0.0444724
R3150 VSS.n99 VSS.n7 0.0444724
R3151 VSS.n99 VSS.n88 0.0444724
R3152 VSS.n99 VSS.n13 0.0444724
R3153 VSS.n99 VSS.n17 0.0444724
R3154 VSS.n99 VSS.n20 0.0444724
R3155 VSS.n99 VSS.n21 0.0444724
R3156 VSS.n99 VSS.n25 0.0444724
R3157 VSS.n99 VSS.n26 0.0444724
R3158 VSS.n99 VSS.n77 0.0444724
R3159 VSS.n99 VSS.n75 0.0444724
R3160 VSS.n99 VSS.n35 0.0444724
R3161 VSS.n99 VSS.n39 0.0444724
R3162 VSS.n99 VSS.n68 0.0444724
R3163 VSS.n99 VSS.n44 0.0444724
R3164 VSS.n99 VSS.n61 0.0444724
R3165 VSS.n99 VSS.n48 0.0444724
R3166 VSS.n99 VSS.n59 0.0444724
R3167 VSS.n99 VSS.n56 0.0444724
R3168 VSS.n99 VSS.n53 0.0444724
R3169 VSS.n99 VSS.n95 0.0444549
R3170 VSS.n99 VSS.n94 0.0444549
R3171 VSS.n99 VSS.n1 0.0444549
R3172 VSS.n99 VSS.n3 0.0444549
R3173 VSS.n99 VSS.n4 0.0444549
R3174 VSS.n99 VSS.n5 0.0444549
R3175 VSS.n99 VSS.n91 0.0444549
R3176 VSS.n99 VSS.n6 0.0444549
R3177 VSS.n99 VSS.n89 0.0444549
R3178 VSS.n99 VSS.n8 0.0444549
R3179 VSS.n99 VSS.n9 0.0444549
R3180 VSS.n99 VSS.n10 0.0444549
R3181 VSS.n99 VSS.n87 0.0444549
R3182 VSS.n99 VSS.n86 0.0444549
R3183 VSS.n99 VSS.n11 0.0444549
R3184 VSS.n99 VSS.n85 0.0444549
R3185 VSS.n99 VSS.n12 0.0444549
R3186 VSS.n99 VSS.n84 0.0444549
R3187 VSS.n99 VSS.n83 0.0444549
R3188 VSS.n99 VSS.n14 0.0444549
R3189 VSS.n99 VSS.n15 0.0444549
R3190 VSS.n99 VSS.n82 0.0444549
R3191 VSS.n99 VSS.n16 0.0444549
R3192 VSS.n99 VSS.n18 0.0444549
R3193 VSS.n99 VSS.n19 0.0444549
R3194 VSS.n99 VSS.n81 0.0444549
R3195 VSS.n99 VSS.n22 0.0444549
R3196 VSS.n99 VSS.n23 0.0444549
R3197 VSS.n99 VSS.n24 0.0444549
R3198 VSS.n99 VSS.n80 0.0444549
R3199 VSS.n99 VSS.n79 0.0444549
R3200 VSS.n99 VSS.n27 0.0444549
R3201 VSS.n99 VSS.n28 0.0444549
R3202 VSS.n99 VSS.n78 0.0444549
R3203 VSS.n99 VSS.n76 0.0444549
R3204 VSS.n99 VSS.n29 0.0444549
R3205 VSS.n99 VSS.n30 0.0444549
R3206 VSS.n99 VSS.n31 0.0444549
R3207 VSS.n99 VSS.n74 0.0444549
R3208 VSS.n99 VSS.n32 0.0444549
R3209 VSS.n99 VSS.n73 0.0444549
R3210 VSS.n99 VSS.n72 0.0444549
R3211 VSS.n99 VSS.n33 0.0444549
R3212 VSS.n99 VSS.n34 0.0444549
R3213 VSS.n99 VSS.n71 0.0444549
R3214 VSS.n99 VSS.n36 0.0444549
R3215 VSS.n99 VSS.n37 0.0444549
R3216 VSS.n99 VSS.n38 0.0444549
R3217 VSS.n99 VSS.n70 0.0444549
R3218 VSS.n99 VSS.n69 0.0444549
R3219 VSS.n99 VSS.n40 0.0444549
R3220 VSS.n99 VSS.n41 0.0444549
R3221 VSS.n99 VSS.n67 0.0444549
R3222 VSS.n99 VSS.n66 0.0444549
R3223 VSS.n99 VSS.n65 0.0444549
R3224 VSS.n99 VSS.n42 0.0444549
R3225 VSS.n99 VSS.n43 0.0444549
R3226 VSS.n99 VSS.n64 0.0444549
R3227 VSS.n99 VSS.n45 0.0444549
R3228 VSS.n99 VSS.n46 0.0444549
R3229 VSS.n99 VSS.n63 0.0444549
R3230 VSS.n99 VSS.n47 0.0444549
R3231 VSS.n99 VSS.n60 0.0444549
R3232 VSS.n99 VSS.n49 0.0444549
R3233 VSS.n99 VSS.n50 0.0444549
R3234 VSS.n99 VSS.n58 0.0444549
R3235 VSS.n99 VSS.n57 0.0444549
R3236 VSS.n99 VSS.n51 0.0444549
R3237 VSS.n99 VSS.n52 0.0444549
R3238 VSS.n99 VSS.n55 0.0444549
R3239 VSS.n99 VSS.n97 0.0444549
R3240 VSS.n99 VSS.n98 0.0444549
R3241 VSS.n1018 VSS.n1017 0.0405
R3242 VSS.n381 VSS.n1030 0.0405
R3243 VSS.n117 VSS.n516 0.0405
R3244 VSS.n528 VSS.n529 0.0405
R3245 VSS.n123 VSS.n511 0.0405
R3246 VSS.n543 VSS.n544 0.0405
R3247 VSS.n129 VSS.n506 0.0405
R3248 VSS.n558 VSS.n559 0.0405
R3249 VSS.n135 VSS.n501 0.0405
R3250 VSS.n573 VSS.n574 0.0405
R3251 VSS.n141 VSS.n496 0.0405
R3252 VSS.n588 VSS.n589 0.0405
R3253 VSS.n147 VSS.n491 0.0405
R3254 VSS.n603 VSS.n604 0.0405
R3255 VSS.n153 VSS.n486 0.0405
R3256 VSS.n618 VSS.n619 0.0405
R3257 VSS.n159 VSS.n481 0.0405
R3258 VSS.n633 VSS.n634 0.0405
R3259 VSS.n165 VSS.n476 0.0405
R3260 VSS.n648 VSS.n649 0.0405
R3261 VSS.n171 VSS.n471 0.0405
R3262 VSS.n663 VSS.n664 0.0405
R3263 VSS.n177 VSS.n466 0.0405
R3264 VSS.n678 VSS.n679 0.0405
R3265 VSS.n183 VSS.n461 0.0405
R3266 VSS.n693 VSS.n694 0.0405
R3267 VSS.n189 VSS.n456 0.0405
R3268 VSS.n708 VSS.n709 0.0405
R3269 VSS.n195 VSS.n451 0.0405
R3270 VSS.n723 VSS.n724 0.0405
R3271 VSS.n201 VSS.n446 0.0405
R3272 VSS.n739 VSS.n738 0.0405
R3273 VSS.n1049 VSS.n208 0.03675
R3274 VSS.t163 VSS.n111 0.02925
R3275 VSS.n1031 VSS.t165 0.02925
R3276 VSS.n517 VSS.t145 0.02925
R3277 VSS.n530 VSS.t169 0.02925
R3278 VSS.n512 VSS.t171 0.02925
R3279 VSS.n545 VSS.t167 0.02925
R3280 VSS.n507 VSS.t173 0.02925
R3281 VSS.n560 VSS.t177 0.02925
R3282 VSS.n502 VSS.t175 0.02925
R3283 VSS.n575 VSS.t147 0.02925
R3284 VSS.n497 VSS.t161 0.02925
R3285 VSS.n590 VSS.t159 0.02925
R3286 VSS.n492 VSS.t157 0.02925
R3287 VSS.n605 VSS.t155 0.02925
R3288 VSS.n487 VSS.t153 0.02925
R3289 VSS.n620 VSS.t151 0.02925
R3290 VSS.n482 VSS.t149 0.02925
R3291 VSS.n635 VSS.t179 0.02925
R3292 VSS.n477 VSS.t185 0.02925
R3293 VSS.n650 VSS.t183 0.02925
R3294 VSS.n472 VSS.t181 0.02925
R3295 VSS.n665 VSS.t191 0.02925
R3296 VSS.n467 VSS.t193 0.02925
R3297 VSS.n680 VSS.t189 0.02925
R3298 VSS.n462 VSS.t187 0.02925
R3299 VSS.n695 VSS.t195 0.02925
R3300 VSS.n457 VSS.t199 0.02925
R3301 VSS.n710 VSS.t197 0.02925
R3302 VSS.n452 VSS.t201 0.02925
R3303 VSS.n725 VSS.t143 0.02925
R3304 VSS.n447 VSS.t205 0.02925
R3305 VSS.t203 VSS.n207 0.02925
R3306 VSS.n377 VSS.n1048 0.02675
R3307 VSS.n106 VSS.n103 0.00675
R3308 VSS.n1052 VSS.t110 0.00675
R3309 VSS.n209 VSS.n102 0.00675
R3310 VSS.n99 VSS.n96 0.00413369
R3311 VSS.n100 VSS.n375 8.47948
C518 DELAY_VBIASN VSS 36.86696f
C519 DELAY_OUT_LAST VSS 0.48296f
C520 DELAY_OUT_TAP31 VSS 0.66256f
C521 DELAY_OUT_TAP30 VSS 0.66256f
C522 DELAY_OUT_TAP29 VSS 0.66256f
C523 DELAY_OUT_TAP28 VSS 0.66256f
C524 DELAY_OUT_TAP27 VSS 0.66256f
C525 DELAY_OUT_TAP26 VSS 0.66256f
C526 DELAY_OUT_TAP25 VSS 0.66256f
C527 DELAY_OUT_TAP24 VSS 0.66256f
C528 DELAY_OUT_TAP23 VSS 0.66256f
C529 DELAY_OUT_TAP22 VSS 0.66256f
C530 DELAY_OUT_TAP21 VSS 0.66256f
C531 DELAY_OUT_TAP20 VSS 0.66256f
C532 DELAY_OUT_TAP19 VSS 0.66256f
C533 DELAY_OUT_TAP18 VSS 0.66256f
C534 DELAY_OUT_TAP17 VSS 0.66256f
C535 DELAY_OUT_TAP16 VSS 0.66256f
C536 DELAY_OUT_TAP15 VSS 0.66256f
C537 DELAY_OUT_TAP14 VSS 0.66256f
C538 DELAY_OUT_TAP13 VSS 0.66256f
C539 DELAY_OUT_TAP12 VSS 0.66256f
C540 DELAY_OUT_TAP11 VSS 0.66256f
C541 DELAY_OUT_TAP10 VSS 0.66256f
C542 DELAY_OUT_TAP9 VSS 0.66256f
C543 DELAY_OUT_TAP8 VSS 0.66256f
C544 DELAY_OUT_TAP7 VSS 0.66256f
C545 DELAY_OUT_TAP6 VSS 0.66256f
C546 DELAY_OUT_TAP5 VSS 0.66256f
C547 DELAY_OUT_TAP4 VSS 0.66256f
C548 DELAY_OUT_TAP3 VSS 0.66256f
C549 DELAY_OUT_TAP2 VSS 0.66256f
C550 DELAY_OUT_TAP1 VSS 0.66256f
C551 DELAY_IN VSS 0.73859f
C552 VDD VSS 46.33067f
C553 a_27671_1842# VSS 0.01732f ; **FLOATING
C554 a_26911_1842# VSS 0.01732f ; **FLOATING
C555 a_26151_1842# VSS 0.01732f ; **FLOATING
C556 a_25391_1842# VSS 0.01732f ; **FLOATING
C557 a_24631_1842# VSS 0.01732f ; **FLOATING
C558 a_23871_1842# VSS 0.01732f ; **FLOATING
C559 a_23111_1842# VSS 0.01732f ; **FLOATING
C560 a_22351_1842# VSS 0.01732f ; **FLOATING
C561 a_21591_1842# VSS 0.01732f ; **FLOATING
C562 a_20831_1842# VSS 0.01732f ; **FLOATING
C563 a_20071_1842# VSS 0.01732f ; **FLOATING
C564 a_19311_1842# VSS 0.01732f ; **FLOATING
C565 a_18551_1842# VSS 0.01732f ; **FLOATING
C566 a_17791_1842# VSS 0.01732f ; **FLOATING
C567 a_17031_1842# VSS 0.01732f ; **FLOATING
C568 a_16271_1842# VSS 0.01732f ; **FLOATING
C569 a_15511_1842# VSS 0.01732f ; **FLOATING
C570 a_14751_1842# VSS 0.01732f ; **FLOATING
C571 a_13991_1842# VSS 0.01732f ; **FLOATING
C572 a_13231_1842# VSS 0.01732f ; **FLOATING
C573 a_12471_1842# VSS 0.01732f ; **FLOATING
C574 a_11711_1842# VSS 0.01732f ; **FLOATING
C575 a_10951_1842# VSS 0.01732f ; **FLOATING
C576 a_10191_1842# VSS 0.01732f ; **FLOATING
C577 a_9431_1842# VSS 0.01732f ; **FLOATING
C578 a_8671_1842# VSS 0.01732f ; **FLOATING
C579 a_7911_1842# VSS 0.01732f ; **FLOATING
C580 a_7151_1842# VSS 0.01732f ; **FLOATING
C581 a_6391_1842# VSS 0.01732f ; **FLOATING
C582 a_5631_1842# VSS 0.01732f ; **FLOATING
C583 a_4871_1842# VSS 0.01732f ; **FLOATING
C584 a_4111_1842# VSS 0.01786f ; **FLOATING
C585 a_27563_1842# VSS 0.85349f ; **FLOATING
C586 a_27997_1842# VSS 0.69075f ; **FLOATING
C587 a_27433_1842# VSS 0.66121f ; **FLOATING
C588 a_26803_1842# VSS 0.85106f ; **FLOATING
C589 a_26673_1842# VSS 0.66121f ; **FLOATING
C590 a_26043_1842# VSS 0.85106f ; **FLOATING
C591 a_25913_1842# VSS 0.66121f ; **FLOATING
C592 a_25283_1842# VSS 0.85106f ; **FLOATING
C593 a_25153_1842# VSS 0.66121f ; **FLOATING
C594 a_24523_1842# VSS 0.85106f ; **FLOATING
C595 a_24393_1842# VSS 0.66121f ; **FLOATING
C596 a_23763_1842# VSS 0.85106f ; **FLOATING
C597 a_23633_1842# VSS 0.66121f ; **FLOATING
C598 a_23003_1842# VSS 0.85106f ; **FLOATING
C599 a_22873_1842# VSS 0.66121f ; **FLOATING
C600 a_22243_1842# VSS 0.85106f ; **FLOATING
C601 a_22113_1842# VSS 0.66121f ; **FLOATING
C602 a_21483_1842# VSS 0.85106f ; **FLOATING
C603 a_21353_1842# VSS 0.66121f ; **FLOATING
C604 a_20723_1842# VSS 0.85106f ; **FLOATING
C605 a_20593_1842# VSS 0.66121f ; **FLOATING
C606 a_19963_1842# VSS 0.85106f ; **FLOATING
C607 a_19833_1842# VSS 0.66121f ; **FLOATING
C608 a_19203_1842# VSS 0.85106f ; **FLOATING
C609 a_19073_1842# VSS 0.66121f ; **FLOATING
C610 a_18443_1842# VSS 0.85106f ; **FLOATING
C611 a_18313_1842# VSS 0.66121f ; **FLOATING
C612 a_17683_1842# VSS 0.85106f ; **FLOATING
C613 a_17553_1842# VSS 0.66121f ; **FLOATING
C614 a_16923_1842# VSS 0.85106f ; **FLOATING
C615 a_16793_1842# VSS 0.66121f ; **FLOATING
C616 a_16163_1842# VSS 0.85106f ; **FLOATING
C617 a_16033_1842# VSS 0.66121f ; **FLOATING
C618 a_15403_1842# VSS 0.85106f ; **FLOATING
C619 a_15273_1842# VSS 0.66121f ; **FLOATING
C620 a_14643_1842# VSS 0.85106f ; **FLOATING
C621 a_14513_1842# VSS 0.66121f ; **FLOATING
C622 a_13883_1842# VSS 0.85106f ; **FLOATING
C623 a_13753_1842# VSS 0.66121f ; **FLOATING
C624 a_13123_1842# VSS 0.85106f ; **FLOATING
C625 a_12993_1842# VSS 0.66121f ; **FLOATING
C626 a_12363_1842# VSS 0.85106f ; **FLOATING
C627 a_12233_1842# VSS 0.66121f ; **FLOATING
C628 a_11603_1842# VSS 0.85106f ; **FLOATING
C629 a_11473_1842# VSS 0.66121f ; **FLOATING
C630 a_10843_1842# VSS 0.85106f ; **FLOATING
C631 a_10713_1842# VSS 0.66121f ; **FLOATING
C632 a_10083_1842# VSS 0.85106f ; **FLOATING
C633 a_9953_1842# VSS 0.66121f ; **FLOATING
C634 a_9323_1842# VSS 0.85106f ; **FLOATING
C635 a_9193_1842# VSS 0.66121f ; **FLOATING
C636 a_8563_1842# VSS 0.85106f ; **FLOATING
C637 a_8433_1842# VSS 0.66121f ; **FLOATING
C638 a_7803_1842# VSS 0.85106f ; **FLOATING
C639 a_7673_1842# VSS 0.66121f ; **FLOATING
C640 a_7043_1842# VSS 0.85106f ; **FLOATING
C641 a_6913_1842# VSS 0.66121f ; **FLOATING
C642 a_6283_1842# VSS 0.85106f ; **FLOATING
C643 a_6153_1842# VSS 0.66121f ; **FLOATING
C644 a_5523_1842# VSS 0.85106f ; **FLOATING
C645 a_5393_1842# VSS 0.66121f ; **FLOATING
C646 a_4763_1842# VSS 0.85106f ; **FLOATING
C647 a_4633_1842# VSS 0.66121f ; **FLOATING
C648 a_4003_1842# VSS 0.93266f ; **FLOATING
C649 VDD.n0 VSS 0.48071f ; **FLOATING
C650 VDD.n1 VSS 0.03705f ; **FLOATING
C651 VDD.n2 VSS 0.03705f ; **FLOATING
C652 VDD.n3 VSS 0.03705f ; **FLOATING
C653 VDD.n4 VSS 0.63978f ; **FLOATING
C654 VDD.n5 VSS 0.29006f ; **FLOATING
C655 VDD.n6 VSS 0.58011f ; **FLOATING
C656 VDD.n7 VSS 0.29006f ; **FLOATING
C657 VDD.n8 VSS 0.58011f ; **FLOATING
C658 VDD.n9 VSS 0.58011f ; **FLOATING
C659 VDD.n10 VSS 0.58011f ; **FLOATING
C660 VDD.n12 VSS 0.58011f ; **FLOATING
C661 VDD.n13 VSS 0.58011f ; **FLOATING
C662 VDD.n15 VSS 0.29006f ; **FLOATING
C663 VDD.n16 VSS 0.58011f ; **FLOATING
C664 VDD.t16 VSS 1.85847f ; **FLOATING
C665 VDD.n17 VSS 0.03705f ; **FLOATING
C666 VDD.n18 VSS 0.03705f ; **FLOATING
C667 VDD.n19 VSS 0.402f ; **FLOATING
C668 VDD.n20 VSS 0.03705f ; **FLOATING
C669 VDD.n21 VSS 0.44355f ; **FLOATING
C670 VDD.t9 VSS 2.1159f ; **FLOATING
C671 VDD.n24 VSS 0.03705f ; **FLOATING
C672 VDD.n25 VSS 0.58231f ; **FLOATING
C673 VDD.n26 VSS 0.29211f ; **FLOATING
C674 VDD.n28 VSS 0.5272f ; **FLOATING
C675 VDD.n30 VSS 0.0477f ; **FLOATING
C676 VDD.t14 VSS 0.39298f ; **FLOATING
C677 VDD.n32 VSS 0.28308f ; **FLOATING
C678 VDD.n33 VSS 0.03705f ; **FLOATING
C679 VDD.n34 VSS 0.03705f ; **FLOATING
C680 VDD.n35 VSS 0.47231f ; **FLOATING
C681 VDD.n37 VSS 0.03705f ; **FLOATING
C682 VDD.n38 VSS 0.03705f ; **FLOATING
C683 VDD.n39 VSS 0.03705f ; **FLOATING
C684 VDD.n40 VSS 0.58301f ; **FLOATING
C685 VDD.n43 VSS 0.25856f ; **FLOATING
C686 VDD.n44 VSS 0.03705f ; **FLOATING
C687 VDD.n45 VSS 0.28397f ; **FLOATING
C688 VDD.n46 VSS 0.03705f ; **FLOATING
C689 VDD.t0 VSS 69.1046f ; **FLOATING
C690 VDD.n48 VSS 0.04695f ; **FLOATING
C691 VDD.n49 VSS 0.03705f ; **FLOATING
C692 VDD.n50 VSS 0.99568f ; **FLOATING
C693 VDD.n51 VSS 0.03705f ; **FLOATING
C694 VDD.n53 VSS 0.03705f ; **FLOATING
C695 VDD.n54 VSS 0.3206f ; **FLOATING
C696 VDD.t6 VSS 0.3929f ; **FLOATING
C697 VDD.t18 VSS 0.3929f ; **FLOATING
C698 VDD.t24 VSS 0.39283f ; **FLOATING
C699 VDD.n56 VSS 0.03705f ; **FLOATING
C700 VDD.n57 VSS 0.03705f ; **FLOATING
C701 VDD.n58 VSS 0.39649f ; **FLOATING
C702 VDD.n59 VSS 0.03705f ; **FLOATING
C703 VDD.n60 VSS 0.29185f ; **FLOATING
C704 VDD.n62 VSS 0.04866f ; **FLOATING
C705 VDD.n63 VSS 0.28285f ; **FLOATING
C706 VDD.n64 VSS 0.29006f ; **FLOATING
C707 VDD.n66 VSS 0.29006f ; **FLOATING
C708 VDD.n67 VSS 0.29006f ; **FLOATING
C709 VDD.n69 VSS 0.03705f ; **FLOATING
C710 VDD.n70 VSS 0.32336f ; **FLOATING
C711 VDD.n73 VSS 0.03705f ; **FLOATING
C712 VDD.n74 VSS 0.03705f ; **FLOATING
C713 VDD.n75 VSS 0.04387f ; **FLOATING
C714 VDD.n76 VSS 0.23286f ; **FLOATING
C715 VDD.n77 VSS 0.04387f ; **FLOATING
C716 VDD.n78 VSS 0.27561f ; **FLOATING
C717 VDD.n80 VSS 1.75529f ; **FLOATING
C718 VDD.n88 VSS 0.02141f ; **FLOATING
C719 VDD.n89 VSS 0.02141f ; **FLOATING
C720 VDD.n90 VSS 0.02141f ; **FLOATING
C721 VDD.n91 VSS 0.02141f ; **FLOATING
C722 VDD.n92 VSS 0.02141f ; **FLOATING
C723 VDD.n93 VSS 0.02141f ; **FLOATING
C724 VDD.n94 VSS 0.02141f ; **FLOATING
C725 VDD.n95 VSS 0.02141f ; **FLOATING
C726 VDD.n96 VSS 0.02141f ; **FLOATING
C727 VDD.n97 VSS 0.02141f ; **FLOATING
C728 VDD.n98 VSS 0.02141f ; **FLOATING
C729 VDD.n99 VSS 0.02141f ; **FLOATING
C730 VDD.n100 VSS 0.02141f ; **FLOATING
C731 VDD.n101 VSS 0.02141f ; **FLOATING
C732 VDD.n102 VSS 0.02141f ; **FLOATING
C733 VDD.n103 VSS 0.02141f ; **FLOATING
C734 VDD.n104 VSS 0.02141f ; **FLOATING
C735 VDD.n105 VSS 0.02141f ; **FLOATING
C736 VDD.n106 VSS 0.02141f ; **FLOATING
C737 VDD.n107 VSS 0.02141f ; **FLOATING
C738 VDD.n108 VSS 0.02141f ; **FLOATING
C739 VDD.n109 VSS 0.02141f ; **FLOATING
C740 VDD.n110 VSS 0.02141f ; **FLOATING
C741 VDD.n114 VSS 0.02141f ; **FLOATING
C742 VDD.n115 VSS 0.02141f ; **FLOATING
C743 VDD.n116 VSS 0.02141f ; **FLOATING
C744 VDD.n117 VSS 0.02141f ; **FLOATING
C745 VDD.n118 VSS 0.02141f ; **FLOATING
C746 VDD.n119 VSS 0.02141f ; **FLOATING
C747 VDD.n120 VSS 0.02141f ; **FLOATING
C748 VDD.n121 VSS 0.02141f ; **FLOATING
C749 VDD.n129 VSS 0.1951f ; **FLOATING
C750 VDD.n151 VSS 0.19533f ; **FLOATING
C751 VDD.n172 VSS 0.03317f ; **FLOATING
C752 VDD.n173 VSS 0.04051f ; **FLOATING
C753 VDD.n174 VSS 0.19086f ; **FLOATING
C754 VDD.n175 VSS 0.06358f ; **FLOATING
C755 VDD.n176 VSS 0.68421f ; **FLOATING
C756 VDD.n177 VSS 0.04724f ; **FLOATING
C757 VDD.n178 VSS 0.02892f ; **FLOATING
C758 VDD.n179 VSS 0.02055f ; **FLOATING
C759 VDD.t86 VSS 0.1048f ; **FLOATING
C760 VDD.t89 VSS 0.04828f ; **FLOATING
C761 VDD.n180 VSS 0.02462f ; **FLOATING
C762 VDD.t91 VSS 0.04996f ; **FLOATING
C763 VDD.t88 VSS 0.05584f ; **FLOATING
C764 VDD.t87 VSS 0.04996f ; **FLOATING
C765 VDD.t29 VSS 0.0586f ; **FLOATING
C766 VDD.t3 VSS 0.0586f ; **FLOATING
C767 VDD.t92 VSS 0.0586f ; **FLOATING
C768 VDD.t21 VSS 0.0586f ; **FLOATING
C769 VDD.t27 VSS 0.0586f ; **FLOATING
C770 VDD.t30 VSS 0.0586f ; **FLOATING
C771 VDD.t28 VSS 0.0586f ; **FLOATING
C772 VDD.t13 VSS 0.0586f ; **FLOATING
C773 VDD.t20 VSS 0.0586f ; **FLOATING
C774 VDD.t19 VSS 0.0586f ; **FLOATING
C775 VDD.t25 VSS 0.0586f ; **FLOATING
C776 VDD.t5 VSS 0.0586f ; **FLOATING
C777 VDD.t8 VSS 0.0586f ; **FLOATING
C778 VDD.t12 VSS 0.0586f ; **FLOATING
C779 VDD.t1 VSS 0.0586f ; **FLOATING
C780 VDD.t2 VSS 0.0586f ; **FLOATING
C781 VDD.t17 VSS 0.0586f ; **FLOATING
C782 VDD.t23 VSS 0.0586f ; **FLOATING
C783 VDD.t15 VSS 0.0586f ; **FLOATING
C784 VDD.t4 VSS 0.0586f ; **FLOATING
C785 VDD.t7 VSS 0.0586f ; **FLOATING
C786 VDD.t11 VSS 0.0586f ; **FLOATING
C787 VDD.t26 VSS 0.0586f ; **FLOATING
C788 VDD.t31 VSS 0.0586f ; **FLOATING
C789 VDD.n181 VSS 0.02892f ; **FLOATING
C790 VDD.n182 VSS 0.02892f ; **FLOATING
C791 VDD.n183 VSS 0.02892f ; **FLOATING
C792 VDD.n184 VSS 0.02892f ; **FLOATING
C793 VDD.n185 VSS 0.02892f ; **FLOATING
C794 VDD.n186 VSS 0.02892f ; **FLOATING
C795 VDD.n187 VSS 0.02892f ; **FLOATING
C796 VDD.n188 VSS 0.02892f ; **FLOATING
C797 VDD.n189 VSS 0.02892f ; **FLOATING
C798 VDD.n190 VSS 0.02892f ; **FLOATING
C799 VDD.n191 VSS 0.02892f ; **FLOATING
C800 VDD.n192 VSS 0.02892f ; **FLOATING
C801 VDD.n193 VSS 0.02892f ; **FLOATING
C802 VDD.n194 VSS 0.02892f ; **FLOATING
C803 VDD.n195 VSS 0.02892f ; **FLOATING
C804 VDD.n196 VSS 0.02892f ; **FLOATING
C805 VDD.n197 VSS 0.02892f ; **FLOATING
C806 VDD.n198 VSS 0.02892f ; **FLOATING
C807 VDD.n199 VSS 0.02892f ; **FLOATING
C808 VDD.n200 VSS 0.02892f ; **FLOATING
C809 VDD.n201 VSS 0.02892f ; **FLOATING
C810 VDD.n202 VSS 0.02892f ; **FLOATING
C811 VDD.n203 VSS 0.02892f ; **FLOATING
C812 VDD.n204 VSS 0.02892f ; **FLOATING
C813 VDD.n205 VSS 0.02892f ; **FLOATING
C814 VDD.n206 VSS 0.02892f ; **FLOATING
C815 VDD.n207 VSS 0.02892f ; **FLOATING
C816 VDD.n208 VSS 0.02892f ; **FLOATING
C817 VDD.n209 VSS 0.02892f ; **FLOATING
C818 VDD.n210 VSS 0.02892f ; **FLOATING
C819 VDD.n211 VSS 0.02892f ; **FLOATING
C820 VDD.n212 VSS 0.02892f ; **FLOATING
C821 VDD.n213 VSS 0.02892f ; **FLOATING
C822 VDD.n214 VSS 0.02892f ; **FLOATING
C823 VDD.n215 VSS 0.02892f ; **FLOATING
C824 VDD.n216 VSS 0.02892f ; **FLOATING
C825 VDD.t63 VSS 0.04996f ; **FLOATING
C826 VDD.t64 VSS 0.04996f ; **FLOATING
C827 VDD.n217 VSS 0.02892f ; **FLOATING
C828 VDD.n218 VSS 0.02892f ; **FLOATING
C829 VDD.t65 VSS 0.04996f ; **FLOATING
C830 VDD.n219 VSS 0.02892f ; **FLOATING
C831 VDD.n220 VSS 0.02892f ; **FLOATING
C832 VDD.t66 VSS 0.04996f ; **FLOATING
C833 VDD.n221 VSS 0.02892f ; **FLOATING
C834 VDD.n222 VSS 0.02892f ; **FLOATING
C835 VDD.t67 VSS 0.04996f ; **FLOATING
C836 VDD.n223 VSS 0.02892f ; **FLOATING
C837 VDD.n224 VSS 0.02892f ; **FLOATING
C838 VDD.t68 VSS 0.04996f ; **FLOATING
C839 VDD.n225 VSS 0.02892f ; **FLOATING
C840 VDD.n226 VSS 0.02892f ; **FLOATING
C841 VDD.n227 VSS 0.02892f ; **FLOATING
C842 VDD.n228 VSS 0.02892f ; **FLOATING
C843 VDD.t45 VSS 0.04996f ; **FLOATING
C844 VDD.n229 VSS 0.02892f ; **FLOATING
C845 VDD.n230 VSS 0.02892f ; **FLOATING
C846 VDD.t59 VSS 0.04996f ; **FLOATING
C847 VDD.n231 VSS 0.02892f ; **FLOATING
C848 VDD.n232 VSS 0.02892f ; **FLOATING
C849 VDD.t60 VSS 0.04996f ; **FLOATING
C850 VDD.n233 VSS 0.02892f ; **FLOATING
C851 VDD.n234 VSS 0.02892f ; **FLOATING
C852 VDD.t62 VSS 0.04996f ; **FLOATING
C853 VDD.n235 VSS 0.02892f ; **FLOATING
C854 VDD.n236 VSS 0.02892f ; **FLOATING
C855 VDD.n237 VSS 0.02892f ; **FLOATING
C856 VDD.n238 VSS 0.02892f ; **FLOATING
C857 VDD.t61 VSS 0.04996f ; **FLOATING
C858 VDD.n239 VSS 0.02892f ; **FLOATING
C859 VDD.n240 VSS 0.02892f ; **FLOATING
C860 VDD.t42 VSS 0.04996f ; **FLOATING
C861 VDD.n241 VSS 0.02892f ; **FLOATING
C862 VDD.n242 VSS 0.02892f ; **FLOATING
C863 VDD.t43 VSS 0.04996f ; **FLOATING
C864 VDD.n243 VSS 0.02892f ; **FLOATING
C865 VDD.n244 VSS 0.02892f ; **FLOATING
C866 VDD.t44 VSS 0.04996f ; **FLOATING
C867 VDD.n245 VSS 0.02892f ; **FLOATING
C868 VDD.n246 VSS 0.02892f ; **FLOATING
C869 VDD.n247 VSS 0.02892f ; **FLOATING
C870 VDD.n248 VSS 0.02892f ; **FLOATING
C871 VDD.t41 VSS 0.04996f ; **FLOATING
C872 VDD.n249 VSS 0.02892f ; **FLOATING
C873 VDD.n250 VSS 0.02892f ; **FLOATING
C874 VDD.t52 VSS 0.04996f ; **FLOATING
C875 VDD.n251 VSS 0.02892f ; **FLOATING
C876 VDD.n252 VSS 0.02892f ; **FLOATING
C877 VDD.t58 VSS 0.04996f ; **FLOATING
C878 VDD.n253 VSS 0.02892f ; **FLOATING
C879 VDD.n254 VSS 0.02892f ; **FLOATING
C880 VDD.t38 VSS 0.04996f ; **FLOATING
C881 VDD.n255 VSS 0.02892f ; **FLOATING
C882 VDD.n256 VSS 0.02892f ; **FLOATING
C883 VDD.n257 VSS 0.02892f ; **FLOATING
C884 VDD.n258 VSS 0.02892f ; **FLOATING
C885 VDD.t57 VSS 0.04996f ; **FLOATING
C886 VDD.n259 VSS 0.02892f ; **FLOATING
C887 VDD.n260 VSS 0.02892f ; **FLOATING
C888 VDD.t47 VSS 0.04996f ; **FLOATING
C889 VDD.n261 VSS 0.02892f ; **FLOATING
C890 VDD.n262 VSS 0.02892f ; **FLOATING
C891 VDD.t39 VSS 0.04996f ; **FLOATING
C892 VDD.n263 VSS 0.02892f ; **FLOATING
C893 VDD.n264 VSS 0.02892f ; **FLOATING
C894 VDD.t40 VSS 0.04996f ; **FLOATING
C895 VDD.n265 VSS 0.02892f ; **FLOATING
C896 VDD.n266 VSS 0.02892f ; **FLOATING
C897 VDD.n267 VSS 0.02892f ; **FLOATING
C898 VDD.n268 VSS 0.02892f ; **FLOATING
C899 VDD.t56 VSS 0.04996f ; **FLOATING
C900 VDD.n269 VSS 0.02892f ; **FLOATING
C901 VDD.n270 VSS 0.02892f ; **FLOATING
C902 VDD.n271 VSS 0.02892f ; **FLOATING
C903 VDD.n272 VSS 0.02892f ; **FLOATING
C904 VDD.n273 VSS 0.02892f ; **FLOATING
C905 VDD.n274 VSS 0.02892f ; **FLOATING
C906 VDD.n275 VSS 0.02892f ; **FLOATING
C907 VDD.n276 VSS 0.02892f ; **FLOATING
C908 VDD.n277 VSS 0.02892f ; **FLOATING
C909 VDD.n278 VSS 0.02892f ; **FLOATING
C910 VDD.n279 VSS 0.02892f ; **FLOATING
C911 VDD.n280 VSS 0.02892f ; **FLOATING
C912 VDD.n281 VSS 0.02892f ; **FLOATING
C913 VDD.n282 VSS 0.02892f ; **FLOATING
C914 VDD.n283 VSS 0.02892f ; **FLOATING
C915 VDD.n284 VSS 0.02892f ; **FLOATING
C916 VDD.n285 VSS 0.02892f ; **FLOATING
C917 VDD.n286 VSS 0.02892f ; **FLOATING
C918 VDD.n287 VSS 0.02892f ; **FLOATING
C919 VDD.n288 VSS 0.02892f ; **FLOATING
C920 VDD.n289 VSS 0.02892f ; **FLOATING
C921 VDD.n290 VSS 0.02892f ; **FLOATING
C922 VDD.n291 VSS 0.02892f ; **FLOATING
C923 VDD.n292 VSS 0.02892f ; **FLOATING
C924 VDD.n293 VSS 0.02892f ; **FLOATING
C925 VDD.n294 VSS 0.02892f ; **FLOATING
C926 VDD.n295 VSS 0.02892f ; **FLOATING
C927 VDD.n296 VSS 0.02892f ; **FLOATING
C928 VDD.n297 VSS 0.02892f ; **FLOATING
C929 VDD.n298 VSS 0.02892f ; **FLOATING
C930 VDD.n299 VSS 0.02892f ; **FLOATING
C931 VDD.n300 VSS 0.02892f ; **FLOATING
C932 VDD.n301 VSS 0.02892f ; **FLOATING
C933 VDD.n302 VSS 0.02892f ; **FLOATING
C934 VDD.n303 VSS 0.02892f ; **FLOATING
C935 VDD.n304 VSS 0.02892f ; **FLOATING
C936 VDD.n305 VSS 0.02892f ; **FLOATING
C937 VDD.n306 VSS 0.02892f ; **FLOATING
C938 VDD.n307 VSS 0.02892f ; **FLOATING
C939 VDD.n308 VSS 0.02892f ; **FLOATING
C940 VDD.n309 VSS 0.02892f ; **FLOATING
C941 VDD.n310 VSS 0.02892f ; **FLOATING
C942 VDD.n311 VSS 0.02892f ; **FLOATING
C943 VDD.n312 VSS 0.02892f ; **FLOATING
C944 VDD.n313 VSS 0.02892f ; **FLOATING
C945 VDD.n314 VSS 0.02892f ; **FLOATING
C946 VDD.n315 VSS 0.02892f ; **FLOATING
C947 VDD.n316 VSS 0.02892f ; **FLOATING
C948 VDD.n317 VSS 0.02892f ; **FLOATING
C949 VDD.n318 VSS 0.02892f ; **FLOATING
C950 VDD.n319 VSS 0.02892f ; **FLOATING
C951 VDD.n320 VSS 0.02892f ; **FLOATING
C952 VDD.n321 VSS 0.02892f ; **FLOATING
C953 VDD.n322 VSS 0.02892f ; **FLOATING
C954 VDD.n323 VSS 0.02892f ; **FLOATING
C955 VDD.n324 VSS 0.02892f ; **FLOATING
C956 VDD.n325 VSS 0.02892f ; **FLOATING
C957 VDD.n326 VSS 0.02892f ; **FLOATING
C958 VDD.n327 VSS 0.02892f ; **FLOATING
C959 VDD.n328 VSS 0.02892f ; **FLOATING
C960 VDD.n329 VSS 0.02892f ; **FLOATING
C961 VDD.n330 VSS 0.02892f ; **FLOATING
C962 VDD.n331 VSS 0.02892f ; **FLOATING
C963 VDD.n332 VSS 0.02892f ; **FLOATING
C964 VDD.n333 VSS 0.02892f ; **FLOATING
C965 VDD.n334 VSS 0.02892f ; **FLOATING
C966 VDD.n335 VSS 0.02892f ; **FLOATING
C967 VDD.n336 VSS 0.02892f ; **FLOATING
C968 VDD.n337 VSS 0.02892f ; **FLOATING
C969 VDD.n338 VSS 0.02892f ; **FLOATING
C970 VDD.n339 VSS 0.02892f ; **FLOATING
C971 VDD.n340 VSS 0.02892f ; **FLOATING
C972 VDD.n341 VSS 0.02892f ; **FLOATING
C973 VDD.n342 VSS 0.02892f ; **FLOATING
C974 VDD.n343 VSS 0.02892f ; **FLOATING
C975 VDD.n344 VSS 0.02892f ; **FLOATING
C976 VDD.n345 VSS 0.02892f ; **FLOATING
C977 VDD.n346 VSS 0.02892f ; **FLOATING
C978 VDD.n347 VSS 0.02892f ; **FLOATING
C979 VDD.n348 VSS 0.02892f ; **FLOATING
C980 VDD.n349 VSS 0.02892f ; **FLOATING
C981 VDD.n350 VSS 0.02892f ; **FLOATING
C982 VDD.n351 VSS 0.02892f ; **FLOATING
C983 VDD.n352 VSS 0.02903f ; **FLOATING
C984 VDD.n353 VSS 0.02892f ; **FLOATING
C985 VDD.n354 VSS 0.02892f ; **FLOATING
C986 VDD.n355 VSS 0.02892f ; **FLOATING
C987 VDD.n356 VSS 0.02892f ; **FLOATING
C988 VDD.n357 VSS 0.02892f ; **FLOATING
C989 VDD.n358 VSS 0.02892f ; **FLOATING
C990 VDD.n359 VSS 0.02892f ; **FLOATING
C991 VDD.n360 VSS 0.02892f ; **FLOATING
C992 VDD.n361 VSS 0.02892f ; **FLOATING
C993 VDD.n362 VSS 0.02892f ; **FLOATING
C994 VDD.n363 VSS 0.02892f ; **FLOATING
C995 VDD.n364 VSS 0.02892f ; **FLOATING
C996 VDD.n365 VSS 0.02892f ; **FLOATING
C997 VDD.n366 VSS 0.02892f ; **FLOATING
C998 VDD.n367 VSS 0.02892f ; **FLOATING
C999 VDD.n368 VSS 0.02892f ; **FLOATING
C1000 VDD.n369 VSS 0.02892f ; **FLOATING
C1001 VDD.n370 VSS 0.02892f ; **FLOATING
C1002 VDD.n371 VSS 0.02892f ; **FLOATING
C1003 VDD.n372 VSS 0.02892f ; **FLOATING
C1004 VDD.n373 VSS 0.02892f ; **FLOATING
C1005 VDD.n374 VSS 0.02892f ; **FLOATING
C1006 VDD.n375 VSS 0.02892f ; **FLOATING
C1007 VDD.n376 VSS 0.02892f ; **FLOATING
C1008 VDD.n377 VSS 0.02892f ; **FLOATING
C1009 VDD.n378 VSS 0.02892f ; **FLOATING
C1010 VDD.n379 VSS 0.02892f ; **FLOATING
C1011 VDD.n380 VSS 0.02892f ; **FLOATING
C1012 VDD.n381 VSS 0.02892f ; **FLOATING
C1013 VDD.n382 VSS 0.02892f ; **FLOATING
C1014 VDD.n383 VSS 0.02892f ; **FLOATING
C1015 VDD.n384 VSS 0.02892f ; **FLOATING
C1016 VDD.n385 VSS 0.02892f ; **FLOATING
C1017 VDD.n386 VSS 0.02892f ; **FLOATING
C1018 VDD.n387 VSS 0.02892f ; **FLOATING
C1019 VDD.n388 VSS 0.02892f ; **FLOATING
C1020 VDD.n389 VSS 0.02892f ; **FLOATING
C1021 VDD.n390 VSS 0.02892f ; **FLOATING
C1022 VDD.n391 VSS 0.02892f ; **FLOATING
C1023 VDD.n392 VSS 0.02892f ; **FLOATING
C1024 VDD.n393 VSS 0.02892f ; **FLOATING
C1025 VDD.n394 VSS 0.02892f ; **FLOATING
C1026 VDD.n395 VSS 0.02892f ; **FLOATING
C1027 VDD.n396 VSS 0.02892f ; **FLOATING
C1028 VDD.n397 VSS 0.02892f ; **FLOATING
C1029 VDD.n398 VSS 0.02892f ; **FLOATING
C1030 VDD.n399 VSS 0.02892f ; **FLOATING
C1031 VDD.n400 VSS 0.02892f ; **FLOATING
C1032 VDD.n401 VSS 0.02892f ; **FLOATING
C1033 VDD.n402 VSS 0.02892f ; **FLOATING
C1034 VDD.n403 VSS 0.02892f ; **FLOATING
C1035 VDD.n404 VSS 0.02892f ; **FLOATING
C1036 VDD.n405 VSS 0.02892f ; **FLOATING
C1037 VDD.n406 VSS 0.02892f ; **FLOATING
C1038 VDD.n407 VSS 0.02892f ; **FLOATING
C1039 VDD.n408 VSS 0.02892f ; **FLOATING
C1040 VDD.n409 VSS 0.02892f ; **FLOATING
C1041 VDD.n410 VSS 0.02892f ; **FLOATING
C1042 VDD.n411 VSS 0.02892f ; **FLOATING
C1043 VDD.n412 VSS 0.02892f ; **FLOATING
C1044 VDD.n413 VSS 0.02892f ; **FLOATING
C1045 VDD.n414 VSS 0.02892f ; **FLOATING
C1046 VDD.n415 VSS 0.02892f ; **FLOATING
C1047 VDD.n416 VSS 0.02892f ; **FLOATING
C1048 VDD.n417 VSS 0.02892f ; **FLOATING
C1049 VDD.n418 VSS 0.02892f ; **FLOATING
C1050 VDD.n419 VSS 0.02892f ; **FLOATING
C1051 VDD.n420 VSS 0.02892f ; **FLOATING
C1052 VDD.n421 VSS 0.02892f ; **FLOATING
C1053 VDD.n422 VSS 0.02892f ; **FLOATING
C1054 VDD.n423 VSS 0.02892f ; **FLOATING
C1055 VDD.n424 VSS 0.02892f ; **FLOATING
C1056 VDD.n425 VSS 0.02892f ; **FLOATING
C1057 VDD.n426 VSS 0.02892f ; **FLOATING
C1058 VDD.n427 VSS 0.02892f ; **FLOATING
C1059 VDD.n428 VSS 0.02892f ; **FLOATING
C1060 VDD.n429 VSS 0.02892f ; **FLOATING
C1061 VDD.n430 VSS 0.02892f ; **FLOATING
C1062 VDD.n431 VSS 0.02892f ; **FLOATING
C1063 VDD.n432 VSS 0.02892f ; **FLOATING
C1064 VDD.n433 VSS 0.02892f ; **FLOATING
C1065 VDD.n434 VSS 0.02892f ; **FLOATING
C1066 VDD.n435 VSS 0.02892f ; **FLOATING
C1067 VDD.n436 VSS 0.02892f ; **FLOATING
C1068 VDD.n437 VSS 0.02892f ; **FLOATING
C1069 VDD.n438 VSS 0.02892f ; **FLOATING
C1070 VDD.n439 VSS 0.02892f ; **FLOATING
C1071 VDD.n440 VSS 0.02892f ; **FLOATING
C1072 VDD.n441 VSS 0.02892f ; **FLOATING
C1073 VDD.n442 VSS 0.02892f ; **FLOATING
C1074 VDD.n443 VSS 0.02892f ; **FLOATING
C1075 VDD.n444 VSS 0.02892f ; **FLOATING
C1076 VDD.n445 VSS 0.02892f ; **FLOATING
C1077 VDD.n446 VSS 0.02892f ; **FLOATING
C1078 VDD.n447 VSS 0.02892f ; **FLOATING
C1079 VDD.n448 VSS 0.02892f ; **FLOATING
C1080 VDD.n449 VSS 0.02892f ; **FLOATING
C1081 VDD.n450 VSS 0.02892f ; **FLOATING
C1082 VDD.n451 VSS 0.02892f ; **FLOATING
C1083 VDD.n452 VSS 0.02892f ; **FLOATING
C1084 VDD.n453 VSS 0.02892f ; **FLOATING
C1085 VDD.n454 VSS 0.02892f ; **FLOATING
C1086 VDD.n455 VSS 0.02892f ; **FLOATING
C1087 VDD.n456 VSS 0.02892f ; **FLOATING
C1088 VDD.n457 VSS 0.02892f ; **FLOATING
C1089 VDD.n458 VSS 0.02892f ; **FLOATING
C1090 VDD.n459 VSS 0.02892f ; **FLOATING
C1091 VDD.n460 VSS 0.02892f ; **FLOATING
C1092 VDD.n461 VSS 0.02892f ; **FLOATING
C1093 VDD.n462 VSS 0.02892f ; **FLOATING
C1094 VDD.n463 VSS 0.02892f ; **FLOATING
C1095 VDD.n464 VSS 0.02892f ; **FLOATING
C1096 VDD.n465 VSS 0.02892f ; **FLOATING
C1097 VDD.n466 VSS 0.02892f ; **FLOATING
C1098 VDD.n467 VSS 0.02892f ; **FLOATING
C1099 VDD.n468 VSS 0.02892f ; **FLOATING
C1100 VDD.n469 VSS 0.02892f ; **FLOATING
C1101 VDD.n470 VSS 0.02892f ; **FLOATING
C1102 VDD.n471 VSS 0.02892f ; **FLOATING
C1103 VDD.n472 VSS 0.02892f ; **FLOATING
C1104 VDD.n473 VSS 0.02892f ; **FLOATING
C1105 VDD.n474 VSS 0.02892f ; **FLOATING
C1106 VDD.n475 VSS 0.02892f ; **FLOATING
C1107 VDD.n476 VSS 0.02892f ; **FLOATING
C1108 VDD.n477 VSS 0.02892f ; **FLOATING
C1109 VDD.n478 VSS 0.02892f ; **FLOATING
C1110 VDD.n479 VSS 0.02892f ; **FLOATING
C1111 VDD.n480 VSS 0.02892f ; **FLOATING
C1112 VDD.n481 VSS 0.02892f ; **FLOATING
C1113 VDD.n482 VSS 0.02892f ; **FLOATING
C1114 VDD.n483 VSS 0.02892f ; **FLOATING
C1115 VDD.n484 VSS 0.02892f ; **FLOATING
C1116 VDD.n485 VSS 0.02892f ; **FLOATING
C1117 VDD.n486 VSS 0.20868f ; **FLOATING
C1118 VDD.n487 VSS 0.07533f ; **FLOATING
C1119 VDD.n488 VSS 0.25078f ; **FLOATING
C1120 VDD.n489 VSS 0.02911f ; **FLOATING
C1121 VDD.n490 VSS 0.02892f ; **FLOATING
C1122 VDD.n491 VSS 0.0581f ; **FLOATING
C1123 VDD.n492 VSS 0.05783f ; **FLOATING
C1124 VDD.n493 VSS 0.02911f ; **FLOATING
C1125 VDD.n494 VSS 0.02892f ; **FLOATING
C1126 VDD.n495 VSS 0.0581f ; **FLOATING
C1127 VDD.n496 VSS 0.05783f ; **FLOATING
C1128 VDD.n497 VSS 0.02911f ; **FLOATING
C1129 VDD.n498 VSS 0.02892f ; **FLOATING
C1130 VDD.n499 VSS 0.0581f ; **FLOATING
C1131 VDD.n500 VSS 0.05783f ; **FLOATING
C1132 VDD.n501 VSS 0.02911f ; **FLOATING
C1133 VDD.n502 VSS 0.02892f ; **FLOATING
C1134 VDD.n503 VSS 0.0581f ; **FLOATING
C1135 VDD.n504 VSS 0.05783f ; **FLOATING
C1136 VDD.n505 VSS 0.02911f ; **FLOATING
C1137 VDD.n506 VSS 0.02892f ; **FLOATING
C1138 VDD.n507 VSS 0.0581f ; **FLOATING
C1139 VDD.n508 VSS 0.05783f ; **FLOATING
C1140 VDD.n509 VSS 0.02911f ; **FLOATING
C1141 VDD.n510 VSS 0.02892f ; **FLOATING
C1142 VDD.n511 VSS 0.0581f ; **FLOATING
C1143 VDD.n512 VSS 0.05783f ; **FLOATING
C1144 VDD.n513 VSS 0.02911f ; **FLOATING
C1145 VDD.n514 VSS 0.02892f ; **FLOATING
C1146 VDD.n515 VSS 0.0581f ; **FLOATING
C1147 VDD.n516 VSS 0.05783f ; **FLOATING
C1148 VDD.n517 VSS 0.02911f ; **FLOATING
C1149 VDD.n518 VSS 0.02892f ; **FLOATING
C1150 VDD.n519 VSS 0.0581f ; **FLOATING
C1151 VDD.n520 VSS 0.05783f ; **FLOATING
C1152 VDD.n521 VSS 0.02911f ; **FLOATING
C1153 VDD.n522 VSS 0.02892f ; **FLOATING
C1154 VDD.n523 VSS 0.0581f ; **FLOATING
C1155 VDD.n524 VSS 0.05783f ; **FLOATING
C1156 VDD.n525 VSS 0.02911f ; **FLOATING
C1157 VDD.n526 VSS 0.02892f ; **FLOATING
C1158 VDD.n527 VSS 0.0581f ; **FLOATING
C1159 VDD.n528 VSS 0.05783f ; **FLOATING
C1160 VDD.n529 VSS 0.02911f ; **FLOATING
C1161 VDD.n530 VSS 0.02892f ; **FLOATING
C1162 VDD.n531 VSS 0.0581f ; **FLOATING
C1163 VDD.n532 VSS 0.05783f ; **FLOATING
C1164 VDD.n533 VSS 0.02911f ; **FLOATING
C1165 VDD.n534 VSS 0.02892f ; **FLOATING
C1166 VDD.n535 VSS 0.0581f ; **FLOATING
C1167 VDD.n536 VSS 0.05783f ; **FLOATING
C1168 VDD.n537 VSS 0.02911f ; **FLOATING
C1169 VDD.n538 VSS 0.02892f ; **FLOATING
C1170 VDD.n539 VSS 0.0581f ; **FLOATING
C1171 VDD.n540 VSS 0.05783f ; **FLOATING
C1172 VDD.n541 VSS 0.02911f ; **FLOATING
C1173 VDD.n542 VSS 0.02892f ; **FLOATING
C1174 VDD.n543 VSS 0.0581f ; **FLOATING
C1175 VDD.n544 VSS 0.05783f ; **FLOATING
C1176 VDD.n545 VSS 0.02911f ; **FLOATING
C1177 VDD.n546 VSS 0.02892f ; **FLOATING
C1178 VDD.n547 VSS 0.0581f ; **FLOATING
C1179 VDD.n548 VSS 0.05783f ; **FLOATING
C1180 VDD.n549 VSS 0.02911f ; **FLOATING
C1181 VDD.n550 VSS 0.02892f ; **FLOATING
C1182 VDD.n551 VSS 0.0581f ; **FLOATING
C1183 VDD.n552 VSS 0.05783f ; **FLOATING
C1184 VDD.n553 VSS 0.02911f ; **FLOATING
C1185 VDD.n554 VSS 0.02892f ; **FLOATING
C1186 VDD.n555 VSS 0.0581f ; **FLOATING
C1187 VDD.n556 VSS 0.05783f ; **FLOATING
C1188 VDD.n557 VSS 0.02911f ; **FLOATING
C1189 VDD.n558 VSS 0.02892f ; **FLOATING
C1190 VDD.n559 VSS 0.0581f ; **FLOATING
C1191 VDD.n560 VSS 0.05783f ; **FLOATING
C1192 VDD.n561 VSS 0.02911f ; **FLOATING
C1193 VDD.n562 VSS 0.02892f ; **FLOATING
C1194 VDD.n563 VSS 0.0581f ; **FLOATING
C1195 VDD.n564 VSS 0.05783f ; **FLOATING
C1196 VDD.n565 VSS 0.02911f ; **FLOATING
C1197 VDD.n566 VSS 0.02892f ; **FLOATING
C1198 VDD.n567 VSS 0.0581f ; **FLOATING
C1199 VDD.n568 VSS 0.05783f ; **FLOATING
C1200 VDD.n569 VSS 0.02911f ; **FLOATING
C1201 VDD.n570 VSS 0.02892f ; **FLOATING
C1202 VDD.n571 VSS 0.0581f ; **FLOATING
C1203 VDD.n572 VSS 0.05783f ; **FLOATING
C1204 VDD.n573 VSS 0.02911f ; **FLOATING
C1205 VDD.n574 VSS 0.02892f ; **FLOATING
C1206 VDD.n575 VSS 0.0581f ; **FLOATING
C1207 VDD.n576 VSS 0.05783f ; **FLOATING
C1208 VDD.n577 VSS 0.02911f ; **FLOATING
C1209 VDD.n578 VSS 0.02892f ; **FLOATING
C1210 VDD.n579 VSS 0.0581f ; **FLOATING
C1211 VDD.n580 VSS 0.05783f ; **FLOATING
C1212 VDD.n581 VSS 0.02911f ; **FLOATING
C1213 VDD.n582 VSS 0.02892f ; **FLOATING
C1214 VDD.n583 VSS 0.0581f ; **FLOATING
C1215 VDD.n584 VSS 0.05783f ; **FLOATING
C1216 VDD.n585 VSS 0.02911f ; **FLOATING
C1217 VDD.n586 VSS 0.02892f ; **FLOATING
C1218 VDD.n587 VSS 0.0581f ; **FLOATING
C1219 VDD.n588 VSS 0.05783f ; **FLOATING
C1220 VDD.n589 VSS 0.02911f ; **FLOATING
C1221 VDD.n590 VSS 0.02892f ; **FLOATING
C1222 VDD.n591 VSS 0.0581f ; **FLOATING
C1223 VDD.n592 VSS 0.05783f ; **FLOATING
C1224 VDD.n593 VSS 0.02911f ; **FLOATING
C1225 VDD.n594 VSS 0.02892f ; **FLOATING
C1226 VDD.n595 VSS 0.0581f ; **FLOATING
C1227 VDD.n596 VSS 0.05783f ; **FLOATING
C1228 VDD.n597 VSS 0.02911f ; **FLOATING
C1229 VDD.n598 VSS 0.02892f ; **FLOATING
C1230 VDD.n599 VSS 0.0581f ; **FLOATING
C1231 VDD.n600 VSS 0.02892f ; **FLOATING
C1232 VDD.n601 VSS 0.02892f ; **FLOATING
C1233 VDD.n602 VSS 0.04547f ; **FLOATING
C1234 VDD.n603 VSS 0.02892f ; **FLOATING
C1235 VDD.n604 VSS 0.02911f ; **FLOATING
C1236 VDD.n605 VSS 0.05783f ; **FLOATING
C1237 VDD.n606 VSS 0.0581f ; **FLOATING
C1238 VDD.n607 VSS 0.02892f ; **FLOATING
C1239 VDD.n608 VSS 0.02911f ; **FLOATING
C1240 VDD.n609 VSS 0.05783f ; **FLOATING
C1241 VDD.n610 VSS 0.0581f ; **FLOATING
C1242 VDD.n611 VSS 0.02892f ; **FLOATING
C1243 VDD.n612 VSS 0.05783f ; **FLOATING
C1244 VDD.n613 VSS 0.02911f ; **FLOATING
C1245 VDD.n614 VSS 0.02892f ; **FLOATING
C1246 VDD.n615 VSS 0.02892f ; **FLOATING
C1247 VDD.n616 VSS 0.02892f ; **FLOATING
C1248 VDD.n617 VSS 0.02892f ; **FLOATING
C1249 VDD.n618 VSS 0.02892f ; **FLOATING
C1250 VDD.n619 VSS 0.02892f ; **FLOATING
C1251 VDD.n620 VSS 0.02892f ; **FLOATING
C1252 VDD.n621 VSS 0.02892f ; **FLOATING
C1253 VDD.n622 VSS 0.02892f ; **FLOATING
C1254 VDD.n623 VSS 0.02892f ; **FLOATING
C1255 VDD.n624 VSS 0.02892f ; **FLOATING
C1256 VDD.n625 VSS 0.02892f ; **FLOATING
C1257 VDD.n626 VSS 0.02892f ; **FLOATING
C1258 VDD.n627 VSS 0.02892f ; **FLOATING
C1259 VDD.n628 VSS 0.02892f ; **FLOATING
C1260 VDD.n629 VSS 0.02892f ; **FLOATING
C1261 VDD.n630 VSS 0.02892f ; **FLOATING
C1262 VDD.n631 VSS 0.03003f ; **FLOATING
C1263 VDD.n632 VSS 0.02169f ; **FLOATING
C1264 VDD.n633 VSS 0.03614f ; **FLOATING
C1265 VDD.n634 VSS 0.03614f ; **FLOATING
C1266 VDD.n635 VSS 0.27596f ; **FLOATING
C1267 VDD.n636 VSS 0.03253f ; **FLOATING
C1268 DELAY_VBIASP.n0 VSS 0.26973f ; **FLOATING
C1269 DELAY_VBIASP.t31 VSS 0.69071f ; **FLOATING
C1270 DELAY_VBIASP.t30 VSS 0.67526f ; **FLOATING
C1271 DELAY_VBIASP.n1 VSS 1.21008f ; **FLOATING
C1272 DELAY_VBIASP.t29 VSS 0.67526f ; **FLOATING
C1273 DELAY_VBIASP.n2 VSS 0.8374f ; **FLOATING
C1274 DELAY_VBIASP.t28 VSS 0.67526f ; **FLOATING
C1275 DELAY_VBIASP.n3 VSS 0.8374f ; **FLOATING
C1276 DELAY_VBIASP.t27 VSS 0.67526f ; **FLOATING
C1277 DELAY_VBIASP.n4 VSS 0.8374f ; **FLOATING
C1278 DELAY_VBIASP.t26 VSS 0.67526f ; **FLOATING
C1279 DELAY_VBIASP.n5 VSS 0.8374f ; **FLOATING
C1280 DELAY_VBIASP.t25 VSS 0.67526f ; **FLOATING
C1281 DELAY_VBIASP.n6 VSS 0.8374f ; **FLOATING
C1282 DELAY_VBIASP.t24 VSS 0.67526f ; **FLOATING
C1283 DELAY_VBIASP.n7 VSS 0.8374f ; **FLOATING
C1284 DELAY_VBIASP.t23 VSS 0.67526f ; **FLOATING
C1285 DELAY_VBIASP.n8 VSS 0.8374f ; **FLOATING
C1286 DELAY_VBIASP.t22 VSS 0.67526f ; **FLOATING
C1287 DELAY_VBIASP.n9 VSS 0.8374f ; **FLOATING
C1288 DELAY_VBIASP.t21 VSS 0.67526f ; **FLOATING
C1289 DELAY_VBIASP.n10 VSS 0.8374f ; **FLOATING
C1290 DELAY_VBIASP.t20 VSS 0.67526f ; **FLOATING
C1291 DELAY_VBIASP.n11 VSS 0.8374f ; **FLOATING
C1292 DELAY_VBIASP.t19 VSS 0.67526f ; **FLOATING
C1293 DELAY_VBIASP.n12 VSS 0.8374f ; **FLOATING
C1294 DELAY_VBIASP.t18 VSS 0.67526f ; **FLOATING
C1295 DELAY_VBIASP.n13 VSS 0.8374f ; **FLOATING
C1296 DELAY_VBIASP.t17 VSS 0.67526f ; **FLOATING
C1297 DELAY_VBIASP.n14 VSS 0.8374f ; **FLOATING
C1298 DELAY_VBIASP.t16 VSS 0.67526f ; **FLOATING
C1299 DELAY_VBIASP.n15 VSS 0.8374f ; **FLOATING
C1300 DELAY_VBIASP.t15 VSS 0.67526f ; **FLOATING
C1301 DELAY_VBIASP.n16 VSS 0.8374f ; **FLOATING
C1302 DELAY_VBIASP.t14 VSS 0.67526f ; **FLOATING
C1303 DELAY_VBIASP.n17 VSS 0.8374f ; **FLOATING
C1304 DELAY_VBIASP.t13 VSS 0.67526f ; **FLOATING
C1305 DELAY_VBIASP.n18 VSS 0.8374f ; **FLOATING
C1306 DELAY_VBIASP.t12 VSS 0.67526f ; **FLOATING
C1307 DELAY_VBIASP.n19 VSS 0.8374f ; **FLOATING
C1308 DELAY_VBIASP.t11 VSS 0.67526f ; **FLOATING
C1309 DELAY_VBIASP.n20 VSS 0.8374f ; **FLOATING
C1310 DELAY_VBIASP.t10 VSS 0.67526f ; **FLOATING
C1311 DELAY_VBIASP.n21 VSS 0.8374f ; **FLOATING
C1312 DELAY_VBIASP.t9 VSS 0.67526f ; **FLOATING
C1313 DELAY_VBIASP.n22 VSS 0.8374f ; **FLOATING
C1314 DELAY_VBIASP.t8 VSS 0.67526f ; **FLOATING
C1315 DELAY_VBIASP.n23 VSS 0.8374f ; **FLOATING
C1316 DELAY_VBIASP.t7 VSS 0.67526f ; **FLOATING
C1317 DELAY_VBIASP.n24 VSS 0.8374f ; **FLOATING
C1318 DELAY_VBIASP.t6 VSS 0.67526f ; **FLOATING
C1319 DELAY_VBIASP.n25 VSS 0.8374f ; **FLOATING
C1320 DELAY_VBIASP.t5 VSS 0.67526f ; **FLOATING
C1321 DELAY_VBIASP.n26 VSS 0.8374f ; **FLOATING
C1322 DELAY_VBIASP.t4 VSS 0.67526f ; **FLOATING
C1323 DELAY_VBIASP.n27 VSS 0.8374f ; **FLOATING
C1324 DELAY_VBIASP.t3 VSS 0.67526f ; **FLOATING
C1325 DELAY_VBIASP.n28 VSS 0.8374f ; **FLOATING
C1326 DELAY_VBIASP.t2 VSS 0.67526f ; **FLOATING
C1327 DELAY_VBIASP.n29 VSS 0.8374f ; **FLOATING
C1328 DELAY_VBIASP.t1 VSS 0.67526f ; **FLOATING
C1329 DELAY_VBIASP.n30 VSS 0.8374f ; **FLOATING
C1330 DELAY_VBIASP.t0 VSS 0.67526f ; **FLOATING
C1331 DELAY_VBIASN.n0 VSS 0.20958f ; **FLOATING
C1332 DELAY_VBIASN.t31 VSS 0.12503f ; **FLOATING
C1333 DELAY_VBIASN.t30 VSS 0.12136f ; **FLOATING
C1334 DELAY_VBIASN.n1 VSS 0.2872f ; **FLOATING
C1335 DELAY_VBIASN.t29 VSS 0.12136f ; **FLOATING
C1336 DELAY_VBIASN.n2 VSS 0.19922f ; **FLOATING
C1337 DELAY_VBIASN.t28 VSS 0.12136f ; **FLOATING
C1338 DELAY_VBIASN.n3 VSS 0.19922f ; **FLOATING
C1339 DELAY_VBIASN.t27 VSS 0.12136f ; **FLOATING
C1340 DELAY_VBIASN.n4 VSS 0.19922f ; **FLOATING
C1341 DELAY_VBIASN.t26 VSS 0.12136f ; **FLOATING
C1342 DELAY_VBIASN.n5 VSS 0.19922f ; **FLOATING
C1343 DELAY_VBIASN.t25 VSS 0.12136f ; **FLOATING
C1344 DELAY_VBIASN.n6 VSS 0.19922f ; **FLOATING
C1345 DELAY_VBIASN.t24 VSS 0.12136f ; **FLOATING
C1346 DELAY_VBIASN.n7 VSS 0.19922f ; **FLOATING
C1347 DELAY_VBIASN.t23 VSS 0.12136f ; **FLOATING
C1348 DELAY_VBIASN.n8 VSS 0.19922f ; **FLOATING
C1349 DELAY_VBIASN.t22 VSS 0.12136f ; **FLOATING
C1350 DELAY_VBIASN.n9 VSS 0.19922f ; **FLOATING
C1351 DELAY_VBIASN.t21 VSS 0.12136f ; **FLOATING
C1352 DELAY_VBIASN.n10 VSS 0.19922f ; **FLOATING
C1353 DELAY_VBIASN.t20 VSS 0.12136f ; **FLOATING
C1354 DELAY_VBIASN.n11 VSS 0.19922f ; **FLOATING
C1355 DELAY_VBIASN.t19 VSS 0.12136f ; **FLOATING
C1356 DELAY_VBIASN.n12 VSS 0.19922f ; **FLOATING
C1357 DELAY_VBIASN.t18 VSS 0.12136f ; **FLOATING
C1358 DELAY_VBIASN.n13 VSS 0.19922f ; **FLOATING
C1359 DELAY_VBIASN.t17 VSS 0.12136f ; **FLOATING
C1360 DELAY_VBIASN.n14 VSS 0.19922f ; **FLOATING
C1361 DELAY_VBIASN.t16 VSS 0.12136f ; **FLOATING
C1362 DELAY_VBIASN.n15 VSS 0.19922f ; **FLOATING
C1363 DELAY_VBIASN.t15 VSS 0.12136f ; **FLOATING
C1364 DELAY_VBIASN.n16 VSS 0.19922f ; **FLOATING
C1365 DELAY_VBIASN.t14 VSS 0.12136f ; **FLOATING
C1366 DELAY_VBIASN.n17 VSS 0.19922f ; **FLOATING
C1367 DELAY_VBIASN.t13 VSS 0.12136f ; **FLOATING
C1368 DELAY_VBIASN.n18 VSS 0.19922f ; **FLOATING
C1369 DELAY_VBIASN.t12 VSS 0.12136f ; **FLOATING
C1370 DELAY_VBIASN.n19 VSS 0.19922f ; **FLOATING
C1371 DELAY_VBIASN.t11 VSS 0.12136f ; **FLOATING
C1372 DELAY_VBIASN.n20 VSS 0.19922f ; **FLOATING
C1373 DELAY_VBIASN.t10 VSS 0.12136f ; **FLOATING
C1374 DELAY_VBIASN.n21 VSS 0.19922f ; **FLOATING
C1375 DELAY_VBIASN.t9 VSS 0.12136f ; **FLOATING
C1376 DELAY_VBIASN.n22 VSS 0.19922f ; **FLOATING
C1377 DELAY_VBIASN.t8 VSS 0.12136f ; **FLOATING
C1378 DELAY_VBIASN.n23 VSS 0.19922f ; **FLOATING
C1379 DELAY_VBIASN.t7 VSS 0.12136f ; **FLOATING
C1380 DELAY_VBIASN.n24 VSS 0.19922f ; **FLOATING
C1381 DELAY_VBIASN.t6 VSS 0.12136f ; **FLOATING
C1382 DELAY_VBIASN.n25 VSS 0.19922f ; **FLOATING
C1383 DELAY_VBIASN.t5 VSS 0.12136f ; **FLOATING
C1384 DELAY_VBIASN.n26 VSS 0.19922f ; **FLOATING
C1385 DELAY_VBIASN.t4 VSS 0.12136f ; **FLOATING
C1386 DELAY_VBIASN.n27 VSS 0.19922f ; **FLOATING
C1387 DELAY_VBIASN.t3 VSS 0.12136f ; **FLOATING
C1388 DELAY_VBIASN.n28 VSS 0.19922f ; **FLOATING
C1389 DELAY_VBIASN.t2 VSS 0.12136f ; **FLOATING
C1390 DELAY_VBIASN.n29 VSS 0.19922f ; **FLOATING
C1391 DELAY_VBIASN.t1 VSS 0.12136f ; **FLOATING
C1392 DELAY_VBIASN.n30 VSS 0.19922f ; **FLOATING
C1393 DELAY_VBIASN.t0 VSS 0.12136f ; **FLOATING
.ends
