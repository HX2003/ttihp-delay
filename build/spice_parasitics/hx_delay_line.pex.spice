* NGSPICE file created from hx_delay_line.ext - technology: ihp-sg13g2

.subckt hx_delay_line DELAY_IN DELAY_OUT_LAST DELAY_OUT_TAP1 DELAY_OUT_TAP2 DELAY_OUT_TAP3
+ DELAY_OUT_TAP4 DELAY_OUT_TAP5 DELAY_OUT_TAP6 DELAY_OUT_TAP7 DELAY_OUT_TAP8 DELAY_OUT_TAP9
+ DELAY_OUT_TAP10 DELAY_OUT_TAP11 DELAY_OUT_TAP12 DELAY_OUT_TAP13 DELAY_OUT_TAP14
+ DELAY_OUT_TAP15 DELAY_OUT_TAP16 DELAY_OUT_TAP17 DELAY_OUT_TAP18 DELAY_OUT_TAP19
+ DELAY_OUT_TAP20 DELAY_OUT_TAP21 DELAY_OUT_TAP22 DELAY_OUT_TAP23 DELAY_OUT_TAP24
+ DELAY_OUT_TAP25 DELAY_OUT_TAP26 DELAY_OUT_TAP27 DELAY_OUT_TAP28 DELAY_OUT_TAP29
+ DELAY_OUT_TAP30 DELAY_OUT_TAP31 VDD VSS DELAY_VBIASN DELAY_VBIASP
X0 VDD.t17 a_4003_1842# DELAY_OUT_TAP1 VDD.t0 sg13_lv_pmos ad=0.2128p pd=1.5u as=0.3808p ps=2.92u w=1.12u l=0.13u
X1 a_10951_2470# a_10713_1842# a_10843_1842# VDD.t0 sg13_lv_pmos ad=0.2128p pd=1.5u as=0.3808p ps=2.92u w=1.12u l=0.2u
X2 a_25153_1842# DELAY_OUT_TAP28 VSS.t77 VSS.t133 sg13_lv_nmos ad=0.2516p pd=2.16u as=0.1406p ps=1.12u w=0.74u l=0.13u
X3 VDD.t63 DELAY_VBIASP.t11 a_19311_2470# VDD.t0 sg13_lv_pmos ad=0.3808p pd=2.92u as=0.2128p ps=1.5u w=1.12u l=0.6u
X4 VDD.t0 DELAY_VBIASP.t24 a_9431_2470# VDD.t0 sg13_lv_pmos ad=0.3808p pd=2.92u as=0.2128p ps=1.5u w=1.12u l=0.6u
X5 VDD.t70 DELAY_VBIASP.t6 a_23111_2470# VDD.t0 sg13_lv_pmos ad=0.3808p pd=2.92u as=0.2128p ps=1.5u w=1.12u l=0.6u
X6 a_17791_1842# a_17553_1842# a_17683_1842# VSS.t58 sg13_lv_nmos ad=0.1406p pd=1.12u as=0.2516p ps=2.16u w=0.74u l=0.2u
X7 a_6153_1842# DELAY_OUT_TAP3 VSS.t36 VSS.t84 sg13_lv_nmos ad=0.2516p pd=2.16u as=0.1406p ps=1.12u w=0.74u l=0.13u
X8 a_21591_1842# a_21353_1842# a_21483_1842# VSS.t18 sg13_lv_nmos ad=0.1406p pd=1.12u as=0.2516p ps=2.16u w=0.74u l=0.2u
X9 VSS.t33 a_16163_1842# DELAY_OUT_TAP17 VSS.t32 sg13_lv_nmos ad=0.1406p pd=1.12u as=0.2516p ps=2.16u w=0.74u l=0.13u
X10 VDD.t15 a_11603_1842# DELAY_OUT_TAP11 VDD.t0 sg13_lv_pmos ad=0.2128p pd=1.5u as=0.3808p ps=2.92u w=1.12u l=0.13u
X11 VDD.t49 DELAY_VBIASP.t17 a_14751_2470# VDD.t0 sg13_lv_pmos ad=0.3808p pd=2.92u as=0.2128p ps=1.5u w=1.12u l=0.6u
X12 a_24393_1842# DELAY_OUT_TAP27 VDD.t82 VDD.t0 sg13_lv_pmos ad=0.3808p pd=2.92u as=0.2128p ps=1.5u w=1.12u l=0.13u
X13 VSS.t145 DELAY_VBIASN.t23 a_10191_1842# VSS.t144 sg13_lv_nmos ad=0.2516p pd=2.16u as=0.1406p ps=1.12u w=0.74u l=0.6u
X14 VDD.t17 DELAY_VBIASP.t31 a_4111_2470# VDD.t0 sg13_lv_pmos ad=0.3808p pd=2.92u as=0.2128p ps=1.5u w=1.12u l=0.6u
X15 VSS.t75 a_19963_1842# DELAY_OUT_TAP22 VSS.t74 sg13_lv_nmos ad=0.1406p pd=1.12u as=0.2516p ps=2.16u w=0.74u l=0.13u
X16 a_17031_2470# a_16793_1842# a_16923_1842# VDD.t0 sg13_lv_pmos ad=0.2128p pd=1.5u as=0.3808p ps=2.92u w=1.12u l=0.2u
X17 a_11473_1842# DELAY_OUT_TAP10 VSS.t57 VSS.t92 sg13_lv_nmos ad=0.2516p pd=2.16u as=0.1406p ps=1.12u w=0.74u l=0.13u
X18 a_5393_1842# DELAY_OUT_TAP2 VDD.t20 VDD.t0 sg13_lv_pmos ad=0.3808p pd=2.92u as=0.2128p ps=1.5u w=1.12u l=0.13u
X19 VDD.t62 DELAY_VBIASP.t14 a_17031_2470# VDD.t0 sg13_lv_pmos ad=0.3808p pd=2.92u as=0.2128p ps=1.5u w=1.12u l=0.6u
X20 a_20831_2470# a_20593_1842# a_20723_1842# VDD.t0 sg13_lv_pmos ad=0.2128p pd=1.5u as=0.3808p ps=2.92u w=1.12u l=0.2u
X21 VDD.t85 a_26803_1842# DELAY_OUT_TAP31 VDD.t0 sg13_lv_pmos ad=0.2128p pd=1.5u as=0.3808p ps=2.92u w=1.12u l=0.13u
X22 VSS.t151 DELAY_VBIASN.t3 a_25391_1842# VSS.t150 sg13_lv_nmos ad=0.2516p pd=2.16u as=0.1406p ps=1.12u w=0.74u l=0.6u
X23 a_19311_2470# a_19073_1842# a_19203_1842# VDD.t0 sg13_lv_pmos ad=0.2128p pd=1.5u as=0.3808p ps=2.92u w=1.12u l=0.2u
X24 a_10713_1842# DELAY_OUT_TAP9 VDD.t12 VDD.t0 sg13_lv_pmos ad=0.3808p pd=2.92u as=0.2128p ps=1.5u w=1.12u l=0.13u
X25 VDD.t18 a_17683_1842# DELAY_OUT_TAP19 VDD.t0 sg13_lv_pmos ad=0.2128p pd=1.5u as=0.3808p ps=2.92u w=1.12u l=0.13u
X26 a_23111_2470# a_22873_1842# a_23003_1842# VDD.t0 sg13_lv_pmos ad=0.2128p pd=1.5u as=0.3808p ps=2.92u w=1.12u l=0.2u
X27 VDD.t9 a_7803_1842# DELAY_OUT_TAP6 VDD.t0 sg13_lv_pmos ad=0.2128p pd=1.5u as=0.3808p ps=2.92u w=1.12u l=0.13u
X28 a_26673_1842# DELAY_OUT_TAP30 VSS.t111 VSS.t140 sg13_lv_nmos ad=0.2516p pd=2.16u as=0.1406p ps=1.12u w=0.74u l=0.13u
X29 VSS.t161 DELAY_VBIASN.t28 a_6391_1842# VSS.t160 sg13_lv_nmos ad=0.2516p pd=2.16u as=0.1406p ps=1.12u w=0.74u l=0.6u
X30 VSS.t203 DELAY_VBIASN.t9 a_20831_1842# VSS.t202 sg13_lv_nmos ad=0.2516p pd=2.16u as=0.1406p ps=1.12u w=0.74u l=0.6u
X31 a_14751_2470# a_14513_1842# a_14643_1842# VDD.t0 sg13_lv_pmos ad=0.2128p pd=1.5u as=0.3808p ps=2.92u w=1.12u l=0.2u
X32 a_10191_1842# a_9953_1842# a_10083_1842# VSS.t59 sg13_lv_nmos ad=0.1406p pd=1.12u as=0.2516p ps=2.16u w=0.74u l=0.2u
X33 VDD.t17 VDD.t17 VDD.t17 VDD.t0 sg13_lv_pmos ad=0.2128p pd=1.5u as=0 ps=0 w=1.12u l=0.13u
X34 a_4111_2470# DELAY_IN a_4003_1842# VDD.t0 sg13_lv_pmos ad=0.2128p pd=1.5u as=0.3808p ps=2.92u w=1.12u l=0.2u
X35 VDD.t23 a_13123_1842# DELAY_OUT_TAP13 VDD.t0 sg13_lv_pmos ad=0.2128p pd=1.5u as=0.3808p ps=2.92u w=1.12u l=0.13u
X36 a_25913_1842# DELAY_OUT_TAP29 VDD.t25 VDD.t0 sg13_lv_pmos ad=0.3808p pd=2.92u as=0.2128p ps=1.5u w=1.12u l=0.13u
X37 a_7673_1842# DELAY_OUT_TAP5 VSS.t20 VSS.t82 sg13_lv_nmos ad=0.2516p pd=2.16u as=0.1406p ps=1.12u w=0.74u l=0.13u
X38 VSS.t53 a_21483_1842# DELAY_OUT_TAP24 VSS.t52 sg13_lv_nmos ad=0.1406p pd=1.12u as=0.2516p ps=2.16u w=0.74u l=0.13u
X39 VSS.t187 DELAY_VBIASN.t21 a_11711_1842# VSS.t186 sg13_lv_nmos ad=0.2516p pd=2.16u as=0.1406p ps=1.12u w=0.74u l=0.6u
X40 a_25391_1842# a_25153_1842# a_25283_1842# VSS.t95 sg13_lv_nmos ad=0.1406p pd=1.12u as=0.2516p ps=2.16u w=0.74u l=0.2u
X41 a_12993_1842# DELAY_OUT_TAP12 VSS.t5 VSS.t90 sg13_lv_nmos ad=0.2516p pd=2.16u as=0.1406p ps=1.12u w=0.74u l=0.13u
X42 a_6913_1842# DELAY_OUT_TAP4 VDD.t28 VDD.t0 sg13_lv_pmos ad=0.3808p pd=2.92u as=0.2128p ps=1.5u w=1.12u l=0.13u
X43 VDD.t64 DELAY_VBIASP.t12 a_18551_2470# VDD.t0 sg13_lv_pmos ad=0.3808p pd=2.92u as=0.2128p ps=1.5u w=1.12u l=0.6u
X44 DELAY_OUT_LAST a_27997_1842# VDD.t83 VDD.t0 sg13_lv_pmos ad=0.3808p pd=2.92u as=0.2128p ps=1.5u w=1.12u l=0.13u
X45 VSS.t97 a_23763_1842# DELAY_OUT_TAP27 VSS.t96 sg13_lv_nmos ad=0.1406p pd=1.12u as=0.2516p ps=2.16u w=0.74u l=0.13u
X46 VSS.t181 DELAY_VBIASN.t18 a_13991_1842# VSS.t180 sg13_lv_nmos ad=0.2516p pd=2.16u as=0.1406p ps=1.12u w=0.74u l=0.6u
X47 VDD.t66 DELAY_VBIASP.t7 a_22351_2470# VDD.t0 sg13_lv_pmos ad=0.3808p pd=2.92u as=0.2128p ps=1.5u w=1.12u l=0.6u
X48 VSS.t147 DELAY_VBIASN.t1 a_26911_1842# VSS.t146 sg13_lv_nmos ad=0.2516p pd=2.16u as=0.1406p ps=1.12u w=0.74u l=0.6u
X49 a_9193_1842# DELAY_OUT_TAP7 VDD.t0 VDD.t0 sg13_lv_pmos ad=0.3808p pd=2.92u as=0.2128p ps=1.5u w=1.12u l=0.13u
X50 a_19833_1842# DELAY_OUT_TAP21 VDD.t1 VDD.t0 sg13_lv_pmos ad=0.3808p pd=2.92u as=0.2128p ps=1.5u w=1.12u l=0.13u
X51 a_24631_2470# a_24393_1842# a_24523_1842# VDD.t0 sg13_lv_pmos ad=0.2128p pd=1.5u as=0.3808p ps=2.92u w=1.12u l=0.2u
X52 a_6391_1842# a_6153_1842# a_6283_1842# VSS.t26 sg13_lv_nmos ad=0.1406p pd=1.12u as=0.2516p ps=2.16u w=0.74u l=0.2u
X53 a_15273_1842# DELAY_OUT_TAP15 VSS.t17 VSS.t109 sg13_lv_nmos ad=0.2516p pd=2.16u as=0.1406p ps=1.12u w=0.74u l=0.13u
X54 VDD.t0 a_9323_1842# DELAY_OUT_TAP8 VDD.t0 sg13_lv_pmos ad=0.2128p pd=1.5u as=0.3808p ps=2.92u w=1.12u l=0.13u
X55 a_23633_1842# DELAY_OUT_TAP26 VDD.t3 VDD.t0 sg13_lv_pmos ad=0.3808p pd=2.92u as=0.2128p ps=1.5u w=1.12u l=0.13u
X56 VSS.t55 a_4763_1842# DELAY_OUT_TAP2 VSS.t54 sg13_lv_nmos ad=0.1406p pd=1.12u as=0.2516p ps=2.16u w=0.74u l=0.13u
X57 VSS.t12 a_15403_1842# DELAY_OUT_TAP16 VSS.t11 sg13_lv_nmos ad=0.1406p pd=1.12u as=0.2516p ps=2.16u w=0.74u l=0.13u
X58 VSS.t153 DELAY_VBIASN.t26 a_7911_1842# VSS.t152 sg13_lv_nmos ad=0.2516p pd=2.16u as=0.1406p ps=1.12u w=0.74u l=0.6u
X59 a_11711_1842# a_11473_1842# a_11603_1842# VSS.t47 sg13_lv_nmos ad=0.1406p pd=1.12u as=0.2516p ps=2.16u w=0.74u l=0.2u
X60 a_5631_2470# a_5393_1842# a_5523_1842# VDD.t0 sg13_lv_pmos ad=0.2128p pd=1.5u as=0.3808p ps=2.92u w=1.12u l=0.2u
X61 a_14513_1842# DELAY_OUT_TAP14 VDD.t10 VDD.t0 sg13_lv_pmos ad=0.3808p pd=2.92u as=0.2128p ps=1.5u w=1.12u l=0.13u
X62 a_4633_1842# DELAY_OUT_TAP1 VDD.t17 VDD.t0 sg13_lv_pmos ad=0.3808p pd=2.92u as=0.2128p ps=1.5u w=1.12u l=0.13u
X63 VSS.t31 a_10083_1842# DELAY_OUT_TAP9 VSS.t30 sg13_lv_nmos ad=0.1406p pd=1.12u as=0.2516p ps=2.16u w=0.74u l=0.13u
X64 VSS.t155 DELAY_VBIASN.t4 a_24631_1842# VSS.t154 sg13_lv_nmos ad=0.2516p pd=2.16u as=0.1406p ps=1.12u w=0.74u l=0.6u
X65 a_18551_2470# a_18313_1842# a_18443_1842# VDD.t0 sg13_lv_pmos ad=0.2128p pd=1.5u as=0.3808p ps=2.92u w=1.12u l=0.2u
X66 VDD.t16 a_16923_1842# DELAY_OUT_TAP18 VDD.t0 sg13_lv_pmos ad=0.2128p pd=1.5u as=0.3808p ps=2.92u w=1.12u l=0.13u
X67 a_22351_2470# a_22113_1842# a_22243_1842# VDD.t0 sg13_lv_pmos ad=0.2128p pd=1.5u as=0.3808p ps=2.92u w=1.12u l=0.2u
X68 VSS.t115 VSS.t112 VSS.t114 VSS.t113 sg13_lv_nmos ad=0.2516p pd=2.16u as=0 ps=0 w=0.74u l=0.13u
X69 a_26911_1842# a_26673_1842# a_26803_1842# VSS.t105 sg13_lv_nmos ad=0.1406p pd=1.12u as=0.2516p ps=2.16u w=0.74u l=0.2u
X70 VDD.t46 DELAY_VBIASP.t22 a_10951_2470# VDD.t0 sg13_lv_pmos ad=0.3808p pd=2.92u as=0.2128p ps=1.5u w=1.12u l=0.6u
X71 VSS.t177 DELAY_VBIASN.t16 a_15511_1842# VSS.t176 sg13_lv_nmos ad=0.2516p pd=2.16u as=0.1406p ps=1.12u w=0.74u l=0.6u
X72 VDD.t24 a_20723_1842# DELAY_OUT_TAP23 VDD.t0 sg13_lv_pmos ad=0.2128p pd=1.5u as=0.3808p ps=2.92u w=1.12u l=0.13u
X73 VSS.t163 DELAY_VBIASN.t29 a_5631_1842# VSS.t162 sg13_lv_nmos ad=0.2516p pd=2.16u as=0.1406p ps=1.12u w=0.74u l=0.6u
X74 VSS.t68 a_25283_1842# DELAY_OUT_TAP29 VSS.t67 sg13_lv_nmos ad=0.1406p pd=1.12u as=0.2516p ps=2.16u w=0.74u l=0.13u
X75 a_13231_2470# a_12993_1842# a_13123_1842# VDD.t0 sg13_lv_pmos ad=0.2128p pd=1.5u as=0.3808p ps=2.92u w=1.12u l=0.2u
X76 VDD.t73 DELAY_VBIASP.t5 a_23871_2470# VDD.t0 sg13_lv_pmos ad=0.3808p pd=2.92u as=0.2128p ps=1.5u w=1.12u l=0.6u
X77 a_12233_1842# DELAY_OUT_TAP11 VDD.t15 VDD.t0 sg13_lv_pmos ad=0.3808p pd=2.92u as=0.2128p ps=1.5u w=1.12u l=0.13u
X78 a_7911_1842# a_7673_1842# a_7803_1842# VSS.t40 sg13_lv_nmos ad=0.1406p pd=1.12u as=0.2516p ps=2.16u w=0.74u l=0.2u
X79 a_16793_1842# DELAY_OUT_TAP17 VSS.t33 VSS.t134 sg13_lv_nmos ad=0.2516p pd=2.16u as=0.1406p ps=1.12u w=0.74u l=0.13u
X80 VSS.t81 a_6283_1842# DELAY_OUT_TAP4 VSS.t80 sg13_lv_nmos ad=0.1406p pd=1.12u as=0.2516p ps=2.16u w=0.74u l=0.13u
X81 VSS.t100 a_27563_1842# a_27997_1842# VSS.t99 sg13_lv_nmos ad=0.1406p pd=1.12u as=0.2516p ps=2.16u w=0.74u l=0.13u
X82 a_20593_1842# DELAY_OUT_TAP22 VSS.t75 VSS.t137 sg13_lv_nmos ad=0.2516p pd=2.16u as=0.1406p ps=1.12u w=0.74u l=0.13u
X83 VDD.t20 DELAY_VBIASP.t30 a_4871_2470# VDD.t0 sg13_lv_pmos ad=0.3808p pd=2.92u as=0.2128p ps=1.5u w=1.12u l=0.6u
X84 VDD.t75 DELAY_VBIASP.t2 a_26151_2470# VDD.t0 sg13_lv_pmos ad=0.3808p pd=2.92u as=0.2128p ps=1.5u w=1.12u l=0.6u
X85 a_19073_1842# DELAY_OUT_TAP20 VSS.t29 VSS.t129 sg13_lv_nmos ad=0.2516p pd=2.16u as=0.1406p ps=1.12u w=0.74u l=0.13u
X86 VDD.t35 VDD.t33 VDD.t34 VDD.t0 sg13_lv_pmos ad=0.3808p pd=2.92u as=0 ps=0 w=1.12u l=0.6u
X87 VSS.t2 a_19203_1842# DELAY_OUT_TAP21 VSS.t1 sg13_lv_nmos ad=0.1406p pd=1.12u as=0.2516p ps=2.16u w=0.74u l=0.13u
X88 a_27433_1842# DELAY_OUT_TAP31 VDD.t85 VDD.t0 sg13_lv_pmos ad=0.3808p pd=2.92u as=0.2128p ps=1.5u w=1.12u l=0.13u
X89 VSS.t15 a_8563_1842# DELAY_OUT_TAP7 VSS.t14 sg13_lv_nmos ad=0.1406p pd=1.12u as=0.2516p ps=2.16u w=0.74u l=0.13u
X90 VSS.t8 a_23003_1842# DELAY_OUT_TAP26 VSS.t7 sg13_lv_nmos ad=0.1406p pd=1.12u as=0.2516p ps=2.16u w=0.74u l=0.13u
X91 VSS.t183 DELAY_VBIASN.t19 a_13231_1842# VSS.t182 sg13_lv_nmos ad=0.2516p pd=2.16u as=0.1406p ps=1.12u w=0.74u l=0.6u
X92 VDD.t8 DELAY_VBIASP.t27 a_7151_2470# VDD.t0 sg13_lv_pmos ad=0.3808p pd=2.92u as=0.2128p ps=1.5u w=1.12u l=0.6u
X93 a_15511_1842# a_15273_1842# a_15403_1842# VSS.t51 sg13_lv_nmos ad=0.1406p pd=1.12u as=0.2516p ps=2.16u w=0.74u l=0.2u
X94 a_9431_2470# a_9193_1842# a_9323_1842# VDD.t0 sg13_lv_pmos ad=0.2128p pd=1.5u as=0.3808p ps=2.92u w=1.12u l=0.2u
X95 a_18313_1842# DELAY_OUT_TAP19 VDD.t18 VDD.t0 sg13_lv_pmos ad=0.3808p pd=2.92u as=0.2128p ps=1.5u w=1.12u l=0.13u
X96 a_23871_2470# a_23633_1842# a_23763_1842# VDD.t0 sg13_lv_pmos ad=0.2128p pd=1.5u as=0.3808p ps=2.92u w=1.12u l=0.2u
X97 VSS.t24 a_13883_1842# DELAY_OUT_TAP14 VSS.t23 sg13_lv_nmos ad=0.1406p pd=1.12u as=0.2516p ps=2.16u w=0.74u l=0.13u
X98 a_8433_1842# DELAY_OUT_TAP6 VDD.t9 VDD.t0 sg13_lv_pmos ad=0.3808p pd=2.92u as=0.2128p ps=1.5u w=1.12u l=0.13u
X99 VDD.t52 DELAY_VBIASP.t20 a_12471_2470# VDD.t0 sg13_lv_pmos ad=0.3808p pd=2.92u as=0.2128p ps=1.5u w=1.12u l=0.6u
X100 VDD.t11 a_18443_1842# DELAY_OUT_TAP20 VDD.t0 sg13_lv_pmos ad=0.2128p pd=1.5u as=0.3808p ps=2.92u w=1.12u l=0.13u
X101 a_22113_1842# DELAY_OUT_TAP24 VDD.t19 VDD.t0 sg13_lv_pmos ad=0.3808p pd=2.92u as=0.2128p ps=1.5u w=1.12u l=0.13u
X102 VSS.t45 a_4003_1842# DELAY_OUT_TAP1 VSS.t44 sg13_lv_nmos ad=0.1406p pd=1.12u as=0.2516p ps=2.16u w=0.74u l=0.13u
X103 VDD.t22 a_22243_1842# DELAY_OUT_TAP25 VDD.t0 sg13_lv_pmos ad=0.2128p pd=1.5u as=0.3808p ps=2.92u w=1.12u l=0.13u
X104 a_4871_2470# a_4633_1842# a_4763_1842# VDD.t0 sg13_lv_pmos ad=0.2128p pd=1.5u as=0.3808p ps=2.92u w=1.12u l=0.2u
X105 a_13753_1842# DELAY_OUT_TAP13 VDD.t23 VDD.t0 sg13_lv_pmos ad=0.3808p pd=2.92u as=0.2128p ps=1.5u w=1.12u l=0.13u
X106 a_26151_2470# a_25913_1842# a_26043_1842# VDD.t0 sg13_lv_pmos ad=0.2128p pd=1.5u as=0.3808p ps=2.92u w=1.12u l=0.2u
X107 a_10951_1842# a_10713_1842# a_10843_1842# VSS.t71 sg13_lv_nmos ad=0.1406p pd=1.12u as=0.2516p ps=2.16u w=0.74u l=0.2u
X108 VDD.t27 a_24523_1842# DELAY_OUT_TAP28 VDD.t0 sg13_lv_pmos ad=0.2128p pd=1.5u as=0.3808p ps=2.92u w=1.12u l=0.13u
X109 VSS.t195 DELAY_VBIASN.t11 a_19311_1842# VSS.t194 sg13_lv_nmos ad=0.2516p pd=2.16u as=0.1406p ps=1.12u w=0.74u l=0.6u
X110 VDD.t71 DELAY_VBIASP.t0 a_27671_2470# VDD.t0 sg13_lv_pmos ad=0.3808p pd=2.92u as=0.2128p ps=1.5u w=1.12u l=0.6u
X111 VSS.t173 DELAY_VBIASN.t24 a_9431_1842# VSS.t172 sg13_lv_nmos ad=0.2516p pd=2.16u as=0.1406p ps=1.12u w=0.74u l=0.6u
X112 VSS.t191 DELAY_VBIASN.t6 a_23111_1842# VSS.t190 sg13_lv_nmos ad=0.2516p pd=2.16u as=0.1406p ps=1.12u w=0.74u l=0.6u
X113 a_7151_2470# a_6913_1842# a_7043_1842# VDD.t0 sg13_lv_pmos ad=0.2128p pd=1.5u as=0.3808p ps=2.92u w=1.12u l=0.2u
X114 a_16033_1842# DELAY_OUT_TAP16 VDD.t5 VDD.t0 sg13_lv_pmos ad=0.3808p pd=2.92u as=0.2128p ps=1.5u w=1.12u l=0.13u
X115 VSS.t38 a_11603_1842# DELAY_OUT_TAP11 VSS.t37 sg13_lv_nmos ad=0.1406p pd=1.12u as=0.2516p ps=2.16u w=0.74u l=0.13u
X116 VDD.t14 a_5523_1842# DELAY_OUT_TAP3 VDD.t0 sg13_lv_pmos ad=0.2128p pd=1.5u as=0.3808p ps=2.92u w=1.12u l=0.13u
X117 a_24393_1842# DELAY_OUT_TAP27 VSS.t97 VSS.t135 sg13_lv_nmos ad=0.2516p pd=2.16u as=0.1406p ps=1.12u w=0.74u l=0.13u
X118 VSS.t179 DELAY_VBIASN.t17 a_14751_1842# VSS.t178 sg13_lv_nmos ad=0.2516p pd=2.16u as=0.1406p ps=1.12u w=0.74u l=0.6u
X119 VDD.t0 DELAY_VBIASP.t25 a_8671_2470# VDD.t0 sg13_lv_pmos ad=0.3808p pd=2.92u as=0.2128p ps=1.5u w=1.12u l=0.6u
X120 VSS.t167 DELAY_VBIASN.t31 a_4111_1842# VSS.t166 sg13_lv_nmos ad=0.2516p pd=2.16u as=0.1406p ps=1.12u w=0.74u l=0.6u
X121 a_12471_2470# a_12233_1842# a_12363_1842# VDD.t0 sg13_lv_pmos ad=0.2128p pd=1.5u as=0.3808p ps=2.92u w=1.12u l=0.2u
X122 a_17031_1842# a_16793_1842# a_16923_1842# VSS.t73 sg13_lv_nmos ad=0.1406p pd=1.12u as=0.2516p ps=2.16u w=0.74u l=0.2u
X123 a_20831_1842# a_20593_1842# a_20723_1842# VSS.t94 sg13_lv_nmos ad=0.1406p pd=1.12u as=0.2516p ps=2.16u w=0.74u l=0.2u
X124 a_9953_1842# DELAY_OUT_TAP8 VDD.t0 VDD.t0 sg13_lv_pmos ad=0.3808p pd=2.92u as=0.2128p ps=1.5u w=1.12u l=0.13u
X125 VDD.t21 a_10843_1842# DELAY_OUT_TAP10 VDD.t0 sg13_lv_pmos ad=0.2128p pd=1.5u as=0.3808p ps=2.92u w=1.12u l=0.13u
X126 a_5393_1842# DELAY_OUT_TAP2 VSS.t55 VSS.t85 sg13_lv_nmos ad=0.2516p pd=2.16u as=0.1406p ps=1.12u w=0.74u l=0.13u
X127 VSS.t104 a_26803_1842# DELAY_OUT_TAP31 VSS.t103 sg13_lv_nmos ad=0.1406p pd=1.12u as=0.2516p ps=2.16u w=0.74u l=0.13u
X128 VSS.t189 DELAY_VBIASN.t14 a_17031_1842# VSS.t188 sg13_lv_nmos ad=0.2516p pd=2.16u as=0.1406p ps=1.12u w=0.74u l=0.6u
X129 a_19311_1842# a_19073_1842# a_19203_1842# VSS.t6 sg13_lv_nmos ad=0.1406p pd=1.12u as=0.2516p ps=2.16u w=0.74u l=0.2u
X130 a_27671_2470# a_27433_1842# a_27563_1842# VDD.t0 sg13_lv_pmos ad=0.2128p pd=1.5u as=0.3808p ps=2.92u w=1.12u l=0.2u
X131 a_23111_1842# a_22873_1842# a_23003_1842# VSS.t25 sg13_lv_nmos ad=0.1406p pd=1.12u as=0.2516p ps=2.16u w=0.74u l=0.2u
X132 VSS.t49 a_17683_1842# DELAY_OUT_TAP19 VSS.t48 sg13_lv_nmos ad=0.1406p pd=1.12u as=0.2516p ps=2.16u w=0.74u l=0.13u
X133 a_10713_1842# DELAY_OUT_TAP9 VSS.t31 VSS.t93 sg13_lv_nmos ad=0.2516p pd=2.16u as=0.1406p ps=1.12u w=0.74u l=0.13u
X134 VDD.t47 DELAY_VBIASP.t15 a_16271_2470# VDD.t0 sg13_lv_pmos ad=0.3808p pd=2.92u as=0.2128p ps=1.5u w=1.12u l=0.6u
X135 VSS.t22 a_7803_1842# DELAY_OUT_TAP6 VSS.t21 sg13_lv_nmos ad=0.1406p pd=1.12u as=0.2516p ps=2.16u w=0.74u l=0.13u
X136 VDD.t68 DELAY_VBIASP.t10 a_20071_2470# VDD.t0 sg13_lv_pmos ad=0.3808p pd=2.92u as=0.2128p ps=1.5u w=1.12u l=0.6u
X137 VDD.t90 a_26043_1842# DELAY_OUT_TAP30 VDD.t0 sg13_lv_pmos ad=0.2128p pd=1.5u as=0.3808p ps=2.92u w=1.12u l=0.13u
X138 VSS.t118 VSS.t114 VSS.t114 VSS.t116 sg13_lv_nmos ad=0.1406p pd=1.12u as=0 ps=0 w=0.74u l=0.13u
X139 a_14751_1842# a_14513_1842# a_14643_1842# VSS.t72 sg13_lv_nmos ad=0.1406p pd=1.12u as=0.2516p ps=2.16u w=0.74u l=0.2u
X140 a_8671_2470# a_8433_1842# a_8563_1842# VDD.t0 sg13_lv_pmos ad=0.2128p pd=1.5u as=0.3808p ps=2.92u w=1.12u l=0.2u
X141 a_17553_1842# DELAY_OUT_TAP18 VDD.t16 VDD.t0 sg13_lv_pmos ad=0.3808p pd=2.92u as=0.2128p ps=1.5u w=1.12u l=0.13u
X142 a_4111_1842# DELAY_IN a_4003_1842# VSS.t87 sg13_lv_nmos ad=0.1406p pd=1.12u as=0.2516p ps=2.16u w=0.74u l=0.2u
X143 VDD.t8 a_7043_1842# DELAY_OUT_TAP5 VDD.t0 sg13_lv_pmos ad=0.2128p pd=1.5u as=0.3808p ps=2.92u w=1.12u l=0.13u
X144 a_21353_1842# DELAY_OUT_TAP23 VDD.t24 VDD.t0 sg13_lv_pmos ad=0.3808p pd=2.92u as=0.2128p ps=1.5u w=1.12u l=0.13u
X145 a_25913_1842# DELAY_OUT_TAP29 VSS.t68 VSS.t138 sg13_lv_nmos ad=0.2516p pd=2.16u as=0.1406p ps=1.12u w=0.74u l=0.13u
X146 VSS.t64 a_13123_1842# DELAY_OUT_TAP13 VSS.t63 sg13_lv_nmos ad=0.1406p pd=1.12u as=0.2516p ps=2.16u w=0.74u l=0.13u
X147 a_13991_2470# a_13753_1842# a_13883_1842# VDD.t0 sg13_lv_pmos ad=0.2128p pd=1.5u as=0.3808p ps=2.92u w=1.12u l=0.2u
X148 DELAY_OUT_LAST a_27997_1842# VSS.t100 VSS.t101 sg13_lv_nmos ad=0.2516p pd=2.16u as=0.1406p ps=1.12u w=0.74u l=0.13u
X149 VDD.t2 a_12363_1842# DELAY_OUT_TAP12 VDD.t0 sg13_lv_pmos ad=0.2128p pd=1.5u as=0.3808p ps=2.92u w=1.12u l=0.13u
X150 a_6913_1842# DELAY_OUT_TAP4 VSS.t81 VSS.t83 sg13_lv_nmos ad=0.2516p pd=2.16u as=0.1406p ps=1.12u w=0.74u l=0.13u
X151 VSS.t143 DELAY_VBIASN.t12 a_18551_1842# VSS.t142 sg13_lv_nmos ad=0.2516p pd=2.16u as=0.1406p ps=1.12u w=0.74u l=0.6u
X152 VSS.t197 DELAY_VBIASN.t7 a_22351_1842# VSS.t196 sg13_lv_nmos ad=0.2516p pd=2.16u as=0.1406p ps=1.12u w=0.74u l=0.6u
X153 a_16271_2470# a_16033_1842# a_16163_1842# VDD.t0 sg13_lv_pmos ad=0.2128p pd=1.5u as=0.3808p ps=2.92u w=1.12u l=0.2u
X154 VDD.t7 a_14643_1842# DELAY_OUT_TAP15 VDD.t0 sg13_lv_pmos ad=0.2128p pd=1.5u as=0.3808p ps=2.92u w=1.12u l=0.13u
X155 a_20071_2470# a_19833_1842# a_19963_1842# VDD.t0 sg13_lv_pmos ad=0.2128p pd=1.5u as=0.3808p ps=2.92u w=1.12u l=0.2u
X156 a_9193_1842# DELAY_OUT_TAP7 VSS.t15 VSS.t107 sg13_lv_nmos ad=0.2516p pd=2.16u as=0.1406p ps=1.12u w=0.74u l=0.13u
X157 a_24631_1842# a_24393_1842# a_24523_1842# VSS.t69 sg13_lv_nmos ad=0.1406p pd=1.12u as=0.2516p ps=2.16u w=0.74u l=0.2u
X158 a_19833_1842# DELAY_OUT_TAP21 VSS.t2 VSS.t128 sg13_lv_nmos ad=0.2516p pd=2.16u as=0.1406p ps=1.12u w=0.74u l=0.13u
X159 VDD.t65 DELAY_VBIASP.t13 a_17791_2470# VDD.t0 sg13_lv_pmos ad=0.3808p pd=2.92u as=0.2128p ps=1.5u w=1.12u l=0.6u
X160 VSS.t10 a_9323_1842# DELAY_OUT_TAP8 VSS.t9 sg13_lv_nmos ad=0.1406p pd=1.12u as=0.2516p ps=2.16u w=0.74u l=0.13u
X161 a_23633_1842# DELAY_OUT_TAP26 VSS.t8 VSS.t136 sg13_lv_nmos ad=0.2516p pd=2.16u as=0.1406p ps=1.12u w=0.74u l=0.13u
X162 VDD.t67 DELAY_VBIASP.t8 a_21591_2470# VDD.t0 sg13_lv_pmos ad=0.3808p pd=2.92u as=0.2128p ps=1.5u w=1.12u l=0.6u
X163 VDD.t38 VDD.t36 VDD.t35 VDD.t0 sg13_lv_pmos ad=0.2128p pd=1.5u as=0 ps=0 w=1.12u l=0.2u
X164 a_5631_1842# a_5393_1842# a_5523_1842# VSS.t46 sg13_lv_nmos ad=0.1406p pd=1.12u as=0.2516p ps=2.16u w=0.74u l=0.2u
X165 a_14513_1842# DELAY_OUT_TAP14 VSS.t24 VSS.t126 sg13_lv_nmos ad=0.2516p pd=2.16u as=0.1406p ps=1.12u w=0.74u l=0.13u
X166 a_22873_1842# DELAY_OUT_TAP25 VDD.t22 VDD.t0 sg13_lv_pmos ad=0.3808p pd=2.92u as=0.2128p ps=1.5u w=1.12u l=0.13u
X167 a_4633_1842# DELAY_OUT_TAP1 VSS.t45 VSS.t86 sg13_lv_nmos ad=0.2516p pd=2.16u as=0.1406p ps=1.12u w=0.74u l=0.13u
X168 a_18551_1842# a_18313_1842# a_18443_1842# VSS.t39 sg13_lv_nmos ad=0.1406p pd=1.12u as=0.2516p ps=2.16u w=0.74u l=0.2u
X169 a_22351_1842# a_22113_1842# a_22243_1842# VSS.t13 sg13_lv_nmos ad=0.1406p pd=1.12u as=0.2516p ps=2.16u w=0.74u l=0.2u
X170 VSS.t43 a_16923_1842# DELAY_OUT_TAP18 VSS.t42 sg13_lv_nmos ad=0.1406p pd=1.12u as=0.2516p ps=2.16u w=0.74u l=0.13u
X171 a_25153_1842# DELAY_OUT_TAP28 VDD.t27 VDD.t0 sg13_lv_pmos ad=0.3808p pd=2.92u as=0.2128p ps=1.5u w=1.12u l=0.13u
X172 VSS.t66 a_20723_1842# DELAY_OUT_TAP23 VSS.t65 sg13_lv_nmos ad=0.1406p pd=1.12u as=0.2516p ps=2.16u w=0.74u l=0.13u
X173 VSS.t175 DELAY_VBIASN.t22 a_10951_1842# VSS.t174 sg13_lv_nmos ad=0.2516p pd=2.16u as=0.1406p ps=1.12u w=0.74u l=0.6u
X174 VSS.t159 DELAY_VBIASN.t5 a_23871_1842# VSS.t158 sg13_lv_nmos ad=0.2516p pd=2.16u as=0.1406p ps=1.12u w=0.74u l=0.6u
X175 a_17791_2470# a_17553_1842# a_17683_1842# VDD.t0 sg13_lv_pmos ad=0.2128p pd=1.5u as=0.3808p ps=2.92u w=1.12u l=0.2u
X176 a_13231_1842# a_12993_1842# a_13123_1842# VSS.t0 sg13_lv_nmos ad=0.1406p pd=1.12u as=0.2516p ps=2.16u w=0.74u l=0.2u
X177 a_21591_2470# a_21353_1842# a_21483_1842# VDD.t0 sg13_lv_pmos ad=0.2128p pd=1.5u as=0.3808p ps=2.92u w=1.12u l=0.2u
X178 a_12233_1842# DELAY_OUT_TAP11 VSS.t38 VSS.t91 sg13_lv_nmos ad=0.2516p pd=2.16u as=0.1406p ps=1.12u w=0.74u l=0.13u
X179 a_6153_1842# DELAY_OUT_TAP3 VDD.t14 VDD.t0 sg13_lv_pmos ad=0.3808p pd=2.92u as=0.2128p ps=1.5u w=1.12u l=0.13u
X180 VDD.t0 DELAY_VBIASP.t23 a_10191_2470# VDD.t0 sg13_lv_pmos ad=0.3808p pd=2.92u as=0.2128p ps=1.5u w=1.12u l=0.6u
X181 VDD.t13 a_16163_1842# DELAY_OUT_TAP17 VDD.t0 sg13_lv_pmos ad=0.2128p pd=1.5u as=0.3808p ps=2.92u w=1.12u l=0.13u
X182 VDD.t26 a_19963_1842# DELAY_OUT_TAP22 VDD.t0 sg13_lv_pmos ad=0.2128p pd=1.5u as=0.3808p ps=2.92u w=1.12u l=0.13u
X183 VSS.t169 DELAY_VBIASN.t30 a_4871_1842# VSS.t168 sg13_lv_nmos ad=0.2516p pd=2.16u as=0.1406p ps=1.12u w=0.74u l=0.6u
X184 VSS.t149 DELAY_VBIASN.t2 a_26151_1842# VSS.t148 sg13_lv_nmos ad=0.2516p pd=2.16u as=0.1406p ps=1.12u w=0.74u l=0.6u
X185 a_11473_1842# DELAY_OUT_TAP10 VDD.t21 VDD.t0 sg13_lv_pmos ad=0.3808p pd=2.92u as=0.2128p ps=1.5u w=1.12u l=0.13u
X186 VSS.t122 VSS.t119 VSS.t121 VSS.t120 sg13_lv_nmos ad=0.2516p pd=2.16u as=0 ps=0 w=0.74u l=0.6u
X187 a_27433_1842# DELAY_OUT_TAP31 VSS.t104 VSS.t131 sg13_lv_nmos ad=0.2516p pd=2.16u as=0.1406p ps=1.12u w=0.74u l=0.13u
X188 VDD.t45 DELAY_VBIASP.t3 a_25391_2470# VDD.t0 sg13_lv_pmos ad=0.3808p pd=2.92u as=0.2128p ps=1.5u w=1.12u l=0.6u
X189 VSS.t157 DELAY_VBIASN.t27 a_7151_1842# VSS.t156 sg13_lv_nmos ad=0.2516p pd=2.16u as=0.1406p ps=1.12u w=0.74u l=0.6u
X190 a_8433_1842# DELAY_OUT_TAP6 VSS.t22 VSS.t88 sg13_lv_nmos ad=0.2516p pd=2.16u as=0.1406p ps=1.12u w=0.74u l=0.13u
X191 a_9431_1842# a_9193_1842# a_9323_1842# VSS.t50 sg13_lv_nmos ad=0.1406p pd=1.12u as=0.2516p ps=2.16u w=0.74u l=0.2u
X192 a_23871_1842# a_23633_1842# a_23763_1842# VSS.t3 sg13_lv_nmos ad=0.1406p pd=1.12u as=0.2516p ps=2.16u w=0.74u l=0.2u
X193 VSS.t29 a_18443_1842# DELAY_OUT_TAP20 VSS.t28 sg13_lv_nmos ad=0.1406p pd=1.12u as=0.2516p ps=2.16u w=0.74u l=0.13u
X194 a_18313_1842# DELAY_OUT_TAP19 VSS.t49 VSS.t108 sg13_lv_nmos ad=0.2516p pd=2.16u as=0.1406p ps=1.12u w=0.74u l=0.13u
X195 a_26673_1842# DELAY_OUT_TAP30 VDD.t90 VDD.t0 sg13_lv_pmos ad=0.3808p pd=2.92u as=0.2128p ps=1.5u w=1.12u l=0.13u
X196 a_22113_1842# DELAY_OUT_TAP24 VSS.t53 VSS.t139 sg13_lv_nmos ad=0.2516p pd=2.16u as=0.1406p ps=1.12u w=0.74u l=0.13u
X197 VSS.t185 DELAY_VBIASN.t20 a_12471_1842# VSS.t184 sg13_lv_nmos ad=0.2516p pd=2.16u as=0.1406p ps=1.12u w=0.74u l=0.6u
X198 VDD.t28 DELAY_VBIASP.t28 a_6391_2470# VDD.t0 sg13_lv_pmos ad=0.3808p pd=2.92u as=0.2128p ps=1.5u w=1.12u l=0.6u
X199 VSS.t62 a_22243_1842# DELAY_OUT_TAP25 VSS.t61 sg13_lv_nmos ad=0.1406p pd=1.12u as=0.2516p ps=2.16u w=0.74u l=0.13u
X200 a_10191_2470# a_9953_1842# a_10083_1842# VDD.t0 sg13_lv_pmos ad=0.2128p pd=1.5u as=0.3808p ps=2.92u w=1.12u l=0.2u
X201 VDD.t69 DELAY_VBIASP.t9 a_20831_2470# VDD.t0 sg13_lv_pmos ad=0.3808p pd=2.92u as=0.2128p ps=1.5u w=1.12u l=0.6u
X202 a_4871_1842# a_4633_1842# a_4763_1842# VSS.t78 sg13_lv_nmos ad=0.1406p pd=1.12u as=0.2516p ps=2.16u w=0.74u l=0.2u
X203 a_26151_1842# a_25913_1842# a_26043_1842# VSS.t98 sg13_lv_nmos ad=0.1406p pd=1.12u as=0.2516p ps=2.16u w=0.74u l=0.2u
X204 a_13753_1842# DELAY_OUT_TAP13 VSS.t64 VSS.t89 sg13_lv_nmos ad=0.2516p pd=2.16u as=0.1406p ps=1.12u w=0.74u l=0.13u
X205 a_7673_1842# DELAY_OUT_TAP5 VDD.t8 VDD.t0 sg13_lv_pmos ad=0.3808p pd=2.92u as=0.2128p ps=1.5u w=1.12u l=0.13u
X206 VSS.t77 a_24523_1842# DELAY_OUT_TAP28 VSS.t76 sg13_lv_nmos ad=0.1406p pd=1.12u as=0.2516p ps=2.16u w=0.74u l=0.13u
X207 VDD.t53 DELAY_VBIASP.t21 a_11711_2470# VDD.t0 sg13_lv_pmos ad=0.3808p pd=2.92u as=0.2128p ps=1.5u w=1.12u l=0.6u
X208 VDD.t19 a_21483_1842# DELAY_OUT_TAP24 VDD.t0 sg13_lv_pmos ad=0.2128p pd=1.5u as=0.3808p ps=2.92u w=1.12u l=0.13u
X209 VSS.t205 DELAY_VBIASN.t0 a_27671_1842# VSS.t204 sg13_lv_nmos ad=0.2516p pd=2.16u as=0.1406p ps=1.12u w=0.74u l=0.6u
X210 a_7151_1842# a_6913_1842# a_7043_1842# VSS.t79 sg13_lv_nmos ad=0.1406p pd=1.12u as=0.2516p ps=2.16u w=0.74u l=0.2u
X211 a_16033_1842# DELAY_OUT_TAP16 VSS.t12 VSS.t127 sg13_lv_nmos ad=0.2516p pd=2.16u as=0.1406p ps=1.12u w=0.74u l=0.13u
X212 a_12993_1842# DELAY_OUT_TAP12 VDD.t2 VDD.t0 sg13_lv_pmos ad=0.3808p pd=2.92u as=0.2128p ps=1.5u w=1.12u l=0.13u
X213 a_25391_2470# a_25153_1842# a_25283_1842# VDD.t0 sg13_lv_pmos ad=0.2128p pd=1.5u as=0.3808p ps=2.92u w=1.12u l=0.2u
X214 VDD.t50 DELAY_VBIASP.t18 a_13991_2470# VDD.t0 sg13_lv_pmos ad=0.3808p pd=2.92u as=0.2128p ps=1.5u w=1.12u l=0.6u
X215 VSS.t36 a_5523_1842# DELAY_OUT_TAP3 VSS.t35 sg13_lv_nmos ad=0.1406p pd=1.12u as=0.2516p ps=2.16u w=0.74u l=0.13u
X216 VDD.t82 a_23763_1842# DELAY_OUT_TAP27 VDD.t0 sg13_lv_pmos ad=0.2128p pd=1.5u as=0.3808p ps=2.92u w=1.12u l=0.13u
X217 VDD.t74 DELAY_VBIASP.t1 a_26911_2470# VDD.t0 sg13_lv_pmos ad=0.3808p pd=2.92u as=0.2128p ps=1.5u w=1.12u l=0.6u
X218 VSS.t171 DELAY_VBIASN.t25 a_8671_1842# VSS.t170 sg13_lv_nmos ad=0.2516p pd=2.16u as=0.1406p ps=1.12u w=0.74u l=0.6u
X219 a_12471_1842# a_12233_1842# a_12363_1842# VSS.t27 sg13_lv_nmos ad=0.1406p pd=1.12u as=0.2516p ps=2.16u w=0.74u l=0.2u
X220 a_6391_2470# a_6153_1842# a_6283_1842# VDD.t0 sg13_lv_pmos ad=0.2128p pd=1.5u as=0.3808p ps=2.92u w=1.12u l=0.2u
X221 a_15273_1842# DELAY_OUT_TAP15 VDD.t7 VDD.t0 sg13_lv_pmos ad=0.3808p pd=2.92u as=0.2128p ps=1.5u w=1.12u l=0.13u
X222 VDD.t20 a_4763_1842# DELAY_OUT_TAP2 VDD.t0 sg13_lv_pmos ad=0.2128p pd=1.5u as=0.3808p ps=2.92u w=1.12u l=0.13u
X223 VDD.t5 a_15403_1842# DELAY_OUT_TAP16 VDD.t0 sg13_lv_pmos ad=0.2128p pd=1.5u as=0.3808p ps=2.92u w=1.12u l=0.13u
X224 a_9953_1842# DELAY_OUT_TAP8 VSS.t10 VSS.t106 sg13_lv_nmos ad=0.2516p pd=2.16u as=0.1406p ps=1.12u w=0.74u l=0.13u
X225 VSS.t57 a_10843_1842# DELAY_OUT_TAP10 VSS.t56 sg13_lv_nmos ad=0.1406p pd=1.12u as=0.2516p ps=2.16u w=0.74u l=0.13u
X226 VDD.t9 DELAY_VBIASP.t26 a_7911_2470# VDD.t0 sg13_lv_pmos ad=0.3808p pd=2.92u as=0.2128p ps=1.5u w=1.12u l=0.6u
X227 a_11711_2470# a_11473_1842# a_11603_1842# VDD.t0 sg13_lv_pmos ad=0.2128p pd=1.5u as=0.3808p ps=2.92u w=1.12u l=0.2u
X228 a_27671_1842# a_27433_1842# a_27563_1842# VSS.t102 sg13_lv_nmos ad=0.1406p pd=1.12u as=0.2516p ps=2.16u w=0.74u l=0.2u
X229 VDD.t12 a_10083_1842# DELAY_OUT_TAP9 VDD.t0 sg13_lv_pmos ad=0.2128p pd=1.5u as=0.3808p ps=2.92u w=1.12u l=0.13u
X230 VSS.t111 a_26043_1842# DELAY_OUT_TAP30 VSS.t110 sg13_lv_nmos ad=0.1406p pd=1.12u as=0.2516p ps=2.16u w=0.74u l=0.13u
X231 VSS.t165 DELAY_VBIASN.t15 a_16271_1842# VSS.t164 sg13_lv_nmos ad=0.2516p pd=2.16u as=0.1406p ps=1.12u w=0.74u l=0.6u
X232 VDD.t72 DELAY_VBIASP.t4 a_24631_2470# VDD.t0 sg13_lv_pmos ad=0.3808p pd=2.92u as=0.2128p ps=1.5u w=1.12u l=0.6u
X233 VSS.t201 DELAY_VBIASN.t10 a_20071_1842# VSS.t200 sg13_lv_nmos ad=0.2516p pd=2.16u as=0.1406p ps=1.12u w=0.74u l=0.6u
X234 VDD.t17 VDD.t17 VDD.t17 VDD.t0 sg13_lv_pmos ad=0.3808p pd=2.92u as=0 ps=0 w=1.12u l=0.13u
X235 a_26911_2470# a_26673_1842# a_26803_1842# VDD.t0 sg13_lv_pmos ad=0.2128p pd=1.5u as=0.3808p ps=2.92u w=1.12u l=0.2u
X236 a_8671_1842# a_8433_1842# a_8563_1842# VSS.t70 sg13_lv_nmos ad=0.1406p pd=1.12u as=0.2516p ps=2.16u w=0.74u l=0.2u
X237 a_17553_1842# DELAY_OUT_TAP18 VSS.t43 VSS.t130 sg13_lv_nmos ad=0.2516p pd=2.16u as=0.1406p ps=1.12u w=0.74u l=0.13u
X238 VDD.t48 DELAY_VBIASP.t16 a_15511_2470# VDD.t0 sg13_lv_pmos ad=0.3808p pd=2.92u as=0.2128p ps=1.5u w=1.12u l=0.6u
X239 VSS.t20 a_7043_1842# DELAY_OUT_TAP5 VSS.t19 sg13_lv_nmos ad=0.1406p pd=1.12u as=0.2516p ps=2.16u w=0.74u l=0.13u
X240 a_21353_1842# DELAY_OUT_TAP23 VSS.t66 VSS.t132 sg13_lv_nmos ad=0.2516p pd=2.16u as=0.1406p ps=1.12u w=0.74u l=0.13u
X241 VDD.t14 DELAY_VBIASP.t29 a_5631_2470# VDD.t0 sg13_lv_pmos ad=0.3808p pd=2.92u as=0.2128p ps=1.5u w=1.12u l=0.6u
X242 VDD.t25 a_25283_1842# DELAY_OUT_TAP29 VDD.t0 sg13_lv_pmos ad=0.2128p pd=1.5u as=0.3808p ps=2.92u w=1.12u l=0.13u
X243 a_13991_1842# a_13753_1842# a_13883_1842# VSS.t41 sg13_lv_nmos ad=0.1406p pd=1.12u as=0.2516p ps=2.16u w=0.74u l=0.2u
X244 a_7911_2470# a_7673_1842# a_7803_1842# VDD.t0 sg13_lv_pmos ad=0.2128p pd=1.5u as=0.3808p ps=2.92u w=1.12u l=0.2u
X245 a_16793_1842# DELAY_OUT_TAP17 VDD.t13 VDD.t0 sg13_lv_pmos ad=0.3808p pd=2.92u as=0.2128p ps=1.5u w=1.12u l=0.13u
X246 a_20593_1842# DELAY_OUT_TAP22 VDD.t26 VDD.t0 sg13_lv_pmos ad=0.3808p pd=2.92u as=0.2128p ps=1.5u w=1.12u l=0.13u
X247 VDD.t83 a_27563_1842# a_27997_1842# VDD.t0 sg13_lv_pmos ad=0.2128p pd=1.5u as=0.3808p ps=2.92u w=1.12u l=0.13u
X248 VSS.t5 a_12363_1842# DELAY_OUT_TAP12 VSS.t4 sg13_lv_nmos ad=0.1406p pd=1.12u as=0.2516p ps=2.16u w=0.74u l=0.13u
X249 VDD.t28 a_6283_1842# DELAY_OUT_TAP4 VDD.t0 sg13_lv_pmos ad=0.2128p pd=1.5u as=0.3808p ps=2.92u w=1.12u l=0.13u
X250 a_16271_1842# a_16033_1842# a_16163_1842# VSS.t60 sg13_lv_nmos ad=0.1406p pd=1.12u as=0.2516p ps=2.16u w=0.74u l=0.2u
X251 a_19073_1842# DELAY_OUT_TAP20 VDD.t11 VDD.t0 sg13_lv_pmos ad=0.3808p pd=2.92u as=0.2128p ps=1.5u w=1.12u l=0.13u
X252 VDD.t1 a_19203_1842# DELAY_OUT_TAP21 VDD.t0 sg13_lv_pmos ad=0.2128p pd=1.5u as=0.3808p ps=2.92u w=1.12u l=0.13u
X253 a_20071_1842# a_19833_1842# a_19963_1842# VSS.t34 sg13_lv_nmos ad=0.1406p pd=1.12u as=0.2516p ps=2.16u w=0.74u l=0.2u
X254 VSS.t17 a_14643_1842# DELAY_OUT_TAP15 VSS.t16 sg13_lv_nmos ad=0.1406p pd=1.12u as=0.2516p ps=2.16u w=0.74u l=0.13u
X255 VDD.t0 a_8563_1842# DELAY_OUT_TAP7 VDD.t0 sg13_lv_pmos ad=0.2128p pd=1.5u as=0.3808p ps=2.92u w=1.12u l=0.13u
X256 VDD.t51 DELAY_VBIASP.t19 a_13231_2470# VDD.t0 sg13_lv_pmos ad=0.3808p pd=2.92u as=0.2128p ps=1.5u w=1.12u l=0.6u
X257 VSS.t193 DELAY_VBIASN.t13 a_17791_1842# VSS.t192 sg13_lv_nmos ad=0.2516p pd=2.16u as=0.1406p ps=1.12u w=0.74u l=0.6u
X258 VDD.t3 a_23003_1842# DELAY_OUT_TAP26 VDD.t0 sg13_lv_pmos ad=0.2128p pd=1.5u as=0.3808p ps=2.92u w=1.12u l=0.13u
X259 VSS.t199 DELAY_VBIASN.t8 a_21591_1842# VSS.t198 sg13_lv_nmos ad=0.2516p pd=2.16u as=0.1406p ps=1.12u w=0.74u l=0.6u
X260 a_15511_2470# a_15273_1842# a_15403_1842# VDD.t0 sg13_lv_pmos ad=0.2128p pd=1.5u as=0.3808p ps=2.92u w=1.12u l=0.2u
X261 VSS.t121 VSS.t123 VSS.t125 VSS.t124 sg13_lv_nmos ad=0.1406p pd=1.12u as=0 ps=0 w=0.74u l=0.2u
X262 VDD.t10 a_13883_1842# DELAY_OUT_TAP14 VDD.t0 sg13_lv_pmos ad=0.2128p pd=1.5u as=0.3808p ps=2.92u w=1.12u l=0.13u
X263 a_22873_1842# DELAY_OUT_TAP25 VSS.t62 VSS.t141 sg13_lv_nmos ad=0.2516p pd=2.16u as=0.1406p ps=1.12u w=0.74u l=0.13u
C0 a_11473_1842# DELAY_OUT_TAP11 0.0114f
C1 a_4633_1842# DELAY_VBIASN 0.10296f
C2 a_10083_1842# DELAY_VBIASP 0.06316f
C3 a_24523_1842# DELAY_VBIASP 0.06316f
C4 a_19963_1842# a_20071_1842# 0.01163f
C5 a_25283_1842# DELAY_VBIASN 0.06812f
C6 DELAY_OUT_TAP5 a_7043_1842# 0.69646f
C7 a_15273_1842# a_15403_1842# 0.69911f
C8 a_16923_1842# DELAY_VBIASN 0.06812f
C9 DELAY_VBIASP a_27433_1842# 0.11005f
C10 DELAY_OUT_TAP4 a_6283_1842# 0.69646f
C11 VDD DELAY_OUT_LAST 0.5592f
C12 DELAY_OUT_TAP20 DELAY_VBIASN 0.04023f
C13 VDD a_13123_1842# 0.85896f
C14 a_13753_1842# a_13883_1842# 0.69911f
C15 DELAY_OUT_TAP4 DELAY_VBIASP 0.03913f
C16 a_4633_1842# a_4763_1842# 0.69911f
C17 a_12471_1842# a_12363_1842# 0.01163f
C18 a_15403_1842# DELAY_VBIASN 0.06812f
C19 VDD DELAY_OUT_TAP23 0.7981f
C20 a_12233_1842# a_12363_1842# 0.69911f
C21 VDD a_7673_1842# 0.70781f
C22 DELAY_OUT_TAP30 DELAY_VBIASN 0.04023f
C23 a_12363_1842# DELAY_VBIASN 0.06812f
C24 a_7911_1842# a_7803_1842# 0.01163f
C25 VDD a_7043_1842# 0.85896f
C26 VDD a_22113_1842# 0.70781f
C27 DELAY_VBIASP DELAY_OUT_TAP16 0.03913f
C28 VDD a_4871_2470# 0.02372f
C29 a_17791_2470# VDD 0.02372f
C30 VDD a_12471_2470# 0.02372f
C31 VDD a_6153_1842# 0.70781f
C32 a_19833_1842# DELAY_OUT_TAP22 0.0114f
C33 a_20593_1842# DELAY_VBIASN 0.10296f
C34 a_23003_1842# a_23111_2470# 0.01697f
C35 DELAY_OUT_TAP25 a_22243_1842# 0.69646f
C36 DELAY_OUT_TAP13 VDD 0.7981f
C37 DELAY_OUT_TAP14 a_13883_1842# 0.69646f
C38 VDD DELAY_IN 0.64793f
C39 DELAY_VBIASP a_13883_1842# 0.06316f
C40 a_23633_1842# VDD 0.70781f
C41 a_21353_1842# DELAY_VBIASN 0.10296f
C42 DELAY_OUT_TAP11 a_12233_1842# 0.70708f
C43 DELAY_VBIASP DELAY_OUT_TAP25 0.03913f
C44 a_7911_2470# a_7803_1842# 0.01697f
C45 a_27563_1842# DELAY_VBIASN 0.06813f
C46 DELAY_VBIASP a_8433_1842# 0.11005f
C47 a_5393_1842# DELAY_VBIASN 0.10296f
C48 a_9953_1842# DELAY_OUT_TAP9 0.0114f
C49 a_11473_1842# DELAY_VBIASN 0.10296f
C50 a_23633_1842# DELAY_OUT_TAP26 0.70708f
C51 a_23633_1842# DELAY_OUT_TAP27 0.0114f
C52 a_11473_1842# a_11603_1842# 0.69911f
C53 VDD a_26043_1842# 0.85896f
C54 DELAY_OUT_TAP11 DELAY_VBIASN 0.04023f
C55 DELAY_OUT_TAP11 a_11603_1842# 0.69646f
C56 a_20723_1842# DELAY_VBIASN 0.06812f
C57 a_6391_2470# a_6283_1842# 0.01697f
C58 a_16923_1842# DELAY_OUT_TAP18 0.69646f
C59 a_19073_1842# DELAY_VBIASP 0.11005f
C60 DELAY_VBIASP a_22873_1842# 0.11005f
C61 DELAY_OUT_TAP8 a_9193_1842# 0.0114f
C62 a_10843_1842# a_10951_2470# 0.01697f
C63 DELAY_VBIASP a_6913_1842# 0.11005f
C64 a_27997_1842# a_27563_1842# 0.69646f
C65 a_17553_1842# VDD 0.70781f
C66 DELAY_OUT_TAP7 DELAY_VBIASN 0.04023f
C67 DELAY_VBIASP DELAY_OUT_TAP1 0.03913f
C68 a_16033_1842# DELAY_OUT_TAP17 0.0114f
C69 a_11473_1842# DELAY_OUT_TAP10 0.70708f
C70 a_4003_1842# DELAY_VBIASN 0.06133f
C71 a_9953_1842# DELAY_VBIASP 0.11005f
C72 a_24393_1842# DELAY_VBIASP 0.11005f
C73 VDD a_16033_1842# 0.70781f
C74 a_22351_1842# a_22243_1842# 0.01163f
C75 a_16793_1842# DELAY_VBIASN 0.10296f
C76 DELAY_VBIASP a_26803_1842# 0.06316f
C77 DELAY_OUT_TAP4 a_6153_1842# 0.0114f
C78 a_18313_1842# a_18443_1842# 0.69911f
C79 VDD DELAY_OUT_TAP31 0.7981f
C80 DELAY_OUT_TAP19 DELAY_VBIASN 0.04023f
C81 VDD a_12993_1842# 0.70781f
C82 DELAY_OUT_TAP3 DELAY_VBIASP 0.03913f
C83 a_4871_1842# a_4763_1842# 0.01163f
C84 a_16163_1842# DELAY_VBIASN 0.06812f
C85 a_15273_1842# DELAY_VBIASN 0.10296f
C86 VDD DELAY_OUT_TAP22 0.7981f
C87 a_18313_1842# DELAY_VBIASP 0.11005f
C88 a_26673_1842# a_26803_1842# 0.69911f
C89 a_25153_1842# a_25283_1842# 0.69911f
C90 DELAY_OUT_TAP29 DELAY_VBIASN 0.04023f
C91 a_15511_2470# a_15403_1842# 0.01697f
C92 a_12233_1842# DELAY_VBIASN 0.10296f
C93 VDD a_21483_1842# 0.85896f
C94 DELAY_VBIASP DELAY_OUT_TAP15 0.03913f
C95 VDD a_4111_2470# 0.02431f
C96 a_11603_1842# DELAY_VBIASN 0.06812f
C97 VDD a_11711_2470# 0.02372f
C98 a_17031_2470# VDD 0.02372f
C99 VDD a_5523_1842# 0.85896f
C100 a_19963_1842# DELAY_VBIASN 0.06812f
C101 a_4003_1842# a_4111_1842# 0.01163f
C102 DELAY_OUT_TAP25 a_22113_1842# 0.0114f
C103 DELAY_OUT_TAP14 a_13753_1842# 0.0114f
C104 a_16271_1842# a_16163_1842# 0.01163f
C105 DELAY_OUT_TAP12 VDD 0.7981f
C106 DELAY_VBIASP a_13753_1842# 0.11005f
C107 a_15511_1842# a_15403_1842# 0.01163f
C108 a_16271_2470# VDD 0.02372f
C109 a_23003_1842# VDD 0.85896f
C110 DELAY_OUT_TAP9 DELAY_VBIASP 0.03913f
C111 DELAY_VBIASP DELAY_OUT_TAP24 0.03913f
C112 a_27997_1842# DELAY_VBIASN 0.03845f
C113 a_6391_1842# a_6283_1842# 0.01163f
C114 DELAY_VBIASP a_7803_1842# 0.06316f
C115 DELAY_OUT_TAP8 VDD 0.7981f
C116 a_4763_1842# DELAY_VBIASN 0.06812f
C117 DELAY_OUT_TAP31 a_27433_1842# 0.70708f
C118 a_10843_1842# DELAY_VBIASN 0.06812f
C119 a_18551_2470# a_18443_1842# 0.01697f
C120 a_23003_1842# DELAY_OUT_TAP26 0.69646f
C121 DELAY_OUT_TAP10 DELAY_VBIASN 0.04023f
C122 VDD a_25913_1842# 0.70781f
C123 a_7043_1842# a_6913_1842# 0.69911f
C124 a_4633_1842# VDD 0.70781f
C125 a_18443_1842# DELAY_VBIASP 0.06316f
C126 a_16793_1842# DELAY_OUT_TAP18 0.0114f
C127 a_24523_1842# a_24631_1842# 0.01163f
C128 DELAY_VBIASP a_22243_1842# 0.06316f
C129 DELAY_OUT_TAP7 a_9193_1842# 0.70708f
C130 VDD a_25283_1842# 0.85896f
C131 a_7151_2470# a_7043_1842# 0.01697f
C132 DELAY_VBIASP a_6283_1842# 0.06316f
C133 a_16923_1842# VDD 0.85896f
C134 DELAY_OUT_TAP6 DELAY_VBIASN 0.04023f
C135 DELAY_OUT_TAP14 DELAY_VBIASP 0.03913f
C136 DELAY_IN DELAY_OUT_TAP1 0.01139f
C137 a_16033_1842# DELAY_OUT_TAP16 0.70708f
C138 VDD a_24631_2470# 0.02372f
C139 VDD DELAY_OUT_TAP20 0.7981f
C140 a_10843_1842# DELAY_OUT_TAP10 0.69646f
C141 a_9323_1842# DELAY_VBIASP 0.06316f
C142 a_23763_1842# DELAY_VBIASP 0.06316f
C143 VDD a_15403_1842# 0.85896f
C144 a_13991_1842# a_13883_1842# 0.01163f
C145 DELAY_VBIASP a_26673_1842# 0.11005f
C146 DELAY_OUT_TAP3 a_6153_1842# 0.70708f
C147 VDD DELAY_OUT_TAP30 0.7981f
C148 DELAY_OUT_TAP18 DELAY_VBIASN 0.04023f
C149 VDD a_12363_1842# 0.85896f
C150 a_4633_1842# DELAY_OUT_TAP2 0.0114f
C151 a_27671_2470# a_27563_1842# 0.01697f
C152 a_23003_1842# a_23111_1842# 0.01163f
C153 a_14643_1842# DELAY_VBIASN 0.06812f
C154 a_17683_1842# DELAY_VBIASP 0.06316f
C155 a_20593_1842# VDD 0.70781f
C156 a_21591_2470# a_21483_1842# 0.01697f
C157 a_11711_1842# a_11603_1842# 0.01163f
C158 DELAY_OUT_TAP28 DELAY_VBIASN 0.04023f
C159 VDD a_10951_2470# 0.02372f
C160 a_24523_1842# a_24631_2470# 0.01697f
C161 a_9193_1842# DELAY_VBIASN 0.10296f
C162 VDD a_21353_1842# 0.70781f
C163 a_7673_1842# a_7803_1842# 0.69911f
C164 a_26151_2470# a_26043_1842# 0.01697f
C165 VDD a_27563_1842# 0.85978f
C166 a_13231_2470# a_13123_1842# 0.01697f
C167 VDD a_5393_1842# 0.70781f
C168 a_19833_1842# DELAY_VBIASN 0.10296f
C169 a_11473_1842# VDD 0.70781f
C170 a_7151_1842# a_7043_1842# 0.01163f
C171 a_19833_1842# a_19963_1842# 0.69911f
C172 DELAY_OUT_TAP24 a_22113_1842# 0.70708f
C173 DELAY_OUT_TAP13 a_13753_1842# 0.70708f
C174 DELAY_OUT_TAP11 VDD 0.7981f
C175 VDD a_20723_1842# 0.85896f
C176 DELAY_VBIASP DELAY_OUT_LAST 0.21025f
C177 DELAY_VBIASP a_13123_1842# 0.06316f
C178 a_25153_1842# DELAY_OUT_TAP29 0.0114f
C179 a_27563_1842# a_27671_1842# 0.01163f
C180 DELAY_VBIASP DELAY_OUT_TAP23 0.03913f
C181 a_22113_1842# a_22243_1842# 0.69911f
C182 DELAY_VBIASP a_7673_1842# 0.11005f
C183 DELAY_OUT_TAP7 VDD 0.7981f
C184 DELAY_OUT_TAP31 a_26803_1842# 0.69646f
C185 a_10713_1842# DELAY_VBIASN 0.10296f
C186 a_25153_1842# DELAY_VBIASN 0.10296f
C187 a_16793_1842# DELAY_OUT_TAP17 0.70708f
C188 a_4003_1842# VDD 0.97904f
C189 a_6153_1842# a_6283_1842# 0.69911f
C190 DELAY_VBIASP a_7043_1842# 0.06316f
C191 DELAY_VBIASP a_22113_1842# 0.11005f
C192 a_18551_1842# a_18443_1842# 0.01163f
C193 DELAY_OUT_TAP7 a_8563_1842# 0.69646f
C194 DELAY_VBIASP a_6153_1842# 0.11005f
C195 DELAY_OUT_TAP2 a_5393_1842# 0.70708f
C196 a_23003_1842# a_22873_1842# 0.69911f
C197 a_16793_1842# VDD 0.70781f
C198 a_16163_1842# DELAY_OUT_TAP17 0.69646f
C199 a_26151_1842# a_26043_1842# 0.01163f
C200 DELAY_OUT_TAP5 DELAY_VBIASN 0.04023f
C201 DELAY_OUT_TAP13 DELAY_VBIASP 0.03913f
C202 DELAY_IN DELAY_VBIASP 0.07311f
C203 a_10713_1842# a_10843_1842# 0.69911f
C204 VDD a_23871_2470# 0.02372f
C205 VDD DELAY_OUT_TAP19 0.7981f
C206 a_15403_1842# DELAY_OUT_TAP16 0.69646f
C207 a_10713_1842# DELAY_OUT_TAP10 0.0114f
C208 a_23633_1842# DELAY_VBIASP 0.11005f
C209 a_16163_1842# VDD 0.85896f
C210 a_27563_1842# a_27433_1842# 0.69911f
C211 VDD a_15273_1842# 0.70781f
C212 a_23633_1842# a_23763_1842# 0.69911f
C213 DELAY_OUT_TAP21 DELAY_VBIASN 0.04023f
C214 DELAY_VBIASP a_26043_1842# 0.06316f
C215 DELAY_OUT_TAP3 a_5523_1842# 0.69646f
C216 DELAY_OUT_TAP8 a_9953_1842# 0.70708f
C217 VDD DELAY_OUT_TAP29 0.7981f
C218 DELAY_OUT_TAP17 DELAY_VBIASN 0.04023f
C219 VDD a_12233_1842# 0.70781f
C220 a_4633_1842# DELAY_OUT_TAP1 0.70708f
C221 a_19073_1842# DELAY_OUT_TAP20 0.70708f
C222 a_17683_1842# a_17791_2470# 0.01697f
C223 a_14513_1842# DELAY_VBIASN 0.10296f
C224 VDD DELAY_VBIASN 0.34192f
C225 VDD a_11603_1842# 0.85896f
C226 a_17553_1842# DELAY_VBIASP 0.11005f
C227 a_19963_1842# VDD 0.85896f
C228 DELAY_OUT_TAP27 DELAY_VBIASN 0.04023f
C229 DELAY_OUT_TAP26 DELAY_VBIASN 0.04023f
C230 a_8563_1842# DELAY_VBIASN 0.06812f
C231 VDD a_10191_2470# 0.02372f
C232 DELAY_VBIASP a_16033_1842# 0.11005f
C233 VDD a_27997_1842# 0.82658f
C234 VDD a_4763_1842# 0.85896f
C235 a_19203_1842# DELAY_VBIASN 0.06812f
C236 a_10843_1842# VDD 0.85896f
C237 DELAY_OUT_TAP13 a_13123_1842# 0.69646f
C238 DELAY_OUT_TAP24 a_21483_1842# 0.69646f
C239 DELAY_OUT_TAP10 VDD 0.7981f
C240 DELAY_VBIASP DELAY_OUT_TAP31 0.03913f
C241 DELAY_VBIASP a_12993_1842# 0.11005f
C242 a_10843_1842# a_10951_1842# 0.01163f
C243 a_20071_2470# a_19963_1842# 0.01697f
C244 a_25153_1842# DELAY_OUT_TAP28 0.70708f
C245 a_17553_1842# a_17683_1842# 0.69911f
C246 DELAY_VBIASP DELAY_OUT_TAP22 0.03913f
C247 DELAY_OUT_TAP2 DELAY_VBIASN 0.04023f
C248 a_18313_1842# DELAY_OUT_TAP20 0.0114f
C249 a_25391_2470# a_25283_1842# 0.01697f
C250 a_14751_1842# a_14643_1842# 0.01163f
C251 DELAY_OUT_TAP6 VDD 0.7981f
C252 a_10083_1842# DELAY_VBIASN 0.06812f
C253 DELAY_OUT_TAP31 a_26673_1842# 0.0114f
C254 a_24523_1842# DELAY_VBIASN 0.06812f
C255 a_5631_2470# a_5523_1842# 0.01697f
C256 a_5631_1842# a_5523_1842# 0.01163f
C257 DELAY_VBIASP a_21483_1842# 0.06316f
C258 a_27433_1842# DELAY_VBIASN 0.10297f
C259 DELAY_OUT_TAP7 a_8433_1842# 0.0114f
C260 a_10083_1842# a_10191_2470# 0.01697f
C261 DELAY_VBIASP a_5523_1842# 0.06316f
C262 DELAY_OUT_TAP2 a_4763_1842# 0.69646f
C263 DELAY_OUT_TAP4 DELAY_VBIASN 0.04023f
C264 DELAY_OUT_TAP12 DELAY_VBIASP 0.03913f
C265 VDD a_23111_2470# 0.02372f
C266 a_15273_1842# DELAY_OUT_TAP16 0.0114f
C267 VDD DELAY_OUT_TAP18 0.7981f
C268 a_23003_1842# DELAY_VBIASP 0.06316f
C269 a_27997_1842# a_27433_1842# 0.0114f
C270 a_14513_1842# a_14643_1842# 0.69911f
C271 a_21591_1842# a_21483_1842# 0.01163f
C272 VDD a_14643_1842# 0.85896f
C273 DELAY_OUT_TAP8 DELAY_VBIASP 0.03913f
C274 a_19833_1842# DELAY_OUT_TAP21 0.70708f
C275 DELAY_VBIASP a_25913_1842# 0.11005f
C276 DELAY_OUT_TAP3 a_5393_1842# 0.0114f
C277 VDD DELAY_OUT_TAP28 0.7981f
C278 DELAY_OUT_TAP8 a_9323_1842# 0.69646f
C279 a_12993_1842# a_13123_1842# 0.69911f
C280 DELAY_OUT_TAP16 DELAY_VBIASN 0.04023f
C281 a_4003_1842# DELAY_OUT_TAP1 0.69646f
C282 a_4633_1842# DELAY_VBIASP 0.11005f
C283 a_18443_1842# DELAY_OUT_TAP20 0.69646f
C284 VDD a_9193_1842# 0.70781f
C285 DELAY_VBIASP a_25283_1842# 0.06316f
C286 a_13883_1842# DELAY_VBIASN 0.06812f
C287 a_16923_1842# DELAY_VBIASP 0.06316f
C288 a_19833_1842# VDD 0.70781f
C289 a_17791_1842# a_17683_1842# 0.01163f
C290 DELAY_VBIASP DELAY_OUT_TAP20 0.03913f
C291 DELAY_OUT_TAP25 DELAY_VBIASN 0.04023f
C292 a_14751_2470# a_14643_1842# 0.01697f
C293 VDD a_15511_2470# 0.02372f
C294 VDD a_9431_2470# 0.02372f
C295 a_8433_1842# DELAY_VBIASN 0.10296f
C296 a_20831_2470# a_20723_1842# 0.01697f
C297 DELAY_VBIASP a_15403_1842# 0.06316f
C298 a_19073_1842# DELAY_VBIASN 0.10296f
C299 a_10713_1842# VDD 0.70781f
C300 a_25153_1842# VDD 0.70781f
C301 a_22873_1842# DELAY_VBIASN 0.10296f
C302 DELAY_OUT_TAP13 a_12993_1842# 0.0114f
C303 DELAY_OUT_TAP24 a_21353_1842# 0.0114f
C304 DELAY_VBIASP DELAY_OUT_TAP30 0.03913f
C305 DELAY_VBIASP a_12363_1842# 0.06316f
C306 a_6913_1842# DELAY_VBIASN 0.10296f
C307 a_24523_1842# DELAY_OUT_TAP28 0.69646f
C308 DELAY_OUT_TAP1 DELAY_VBIASN 0.04023f
C309 a_18313_1842# DELAY_OUT_TAP19 0.70708f
C310 a_20593_1842# DELAY_VBIASP 0.11005f
C311 DELAY_OUT_TAP5 VDD 0.7981f
C312 DELAY_OUT_TAP30 a_26673_1842# 0.70708f
C313 a_9953_1842# DELAY_VBIASN 0.10296f
C314 a_24393_1842# DELAY_VBIASN 0.10296f
C315 a_19203_1842# a_19311_1842# 0.01163f
C316 a_27671_2470# VDD 0.02372f
C317 DELAY_VBIASP a_21353_1842# 0.11005f
C318 a_26803_1842# DELAY_VBIASN 0.06812f
C319 DELAY_OUT_TAP6 a_8433_1842# 0.70708f
C320 DELAY_VBIASP a_27563_1842# 0.06318f
C321 VDD DELAY_OUT_TAP21 0.7981f
C322 DELAY_VBIASP a_5393_1842# 0.11005f
C323 a_11473_1842# DELAY_VBIASP 0.11005f
C324 DELAY_OUT_TAP3 DELAY_VBIASN 0.04023f
C325 DELAY_OUT_TAP11 DELAY_VBIASP 0.03913f
C326 DELAY_VBIASP a_20723_1842# 0.06316f
C327 VDD a_22351_2470# 0.02372f
C328 a_15273_1842# DELAY_OUT_TAP15 0.70708f
C329 VDD DELAY_OUT_TAP17 0.7981f
C330 a_18313_1842# DELAY_VBIASN 0.10296f
C331 a_25391_1842# a_25283_1842# 0.01163f
C332 VDD a_14513_1842# 0.70781f
C333 DELAY_OUT_TAP7 DELAY_VBIASP 0.03913f
C334 a_19203_1842# DELAY_OUT_TAP21 0.69646f
C335 a_13231_1842# a_13123_1842# 0.01163f
C336 VDD DELAY_OUT_TAP27 0.7981f
C337 VDD DELAY_OUT_TAP26 0.7981f
C338 DELAY_OUT_TAP15 DELAY_VBIASN 0.04023f
C339 a_4003_1842# DELAY_VBIASP 0.05735f
C340 VDD a_8563_1842# 0.85896f
C341 a_13753_1842# DELAY_VBIASN 0.10296f
C342 a_16793_1842# DELAY_VBIASP 0.11005f
C343 a_8671_1842# a_8563_1842# 0.01163f
C344 a_19203_1842# VDD 0.85896f
C345 a_25913_1842# a_26043_1842# 0.69911f
C346 DELAY_VBIASP DELAY_OUT_TAP19 0.03913f
C347 DELAY_OUT_TAP9 DELAY_VBIASN 0.04023f
C348 DELAY_OUT_TAP24 DELAY_VBIASN 0.04023f
C349 VDD a_14751_2470# 0.02372f
C350 a_20071_2470# VDD 0.02372f
C351 a_20593_1842# DELAY_OUT_TAP23 0.0114f
C352 a_16163_1842# DELAY_VBIASP 0.06316f
C353 VDD a_8671_2470# 0.02372f
C354 a_7803_1842# DELAY_VBIASN 0.06812f
C355 a_23763_1842# a_23871_2470# 0.01697f
C356 DELAY_VBIASP a_15273_1842# 0.11005f
C357 VDD DELAY_OUT_TAP2 0.7981f
C358 a_12471_2470# a_12363_1842# 0.01697f
C359 a_18443_1842# DELAY_VBIASN 0.06812f
C360 a_10083_1842# VDD 0.85896f
C361 a_24523_1842# VDD 0.85896f
C362 DELAY_OUT_TAP12 a_12993_1842# 0.70708f
C363 DELAY_OUT_TAP23 a_21353_1842# 0.70708f
C364 a_22243_1842# DELAY_VBIASN 0.06812f
C365 DELAY_VBIASP DELAY_OUT_TAP29 0.03913f
C366 a_8671_2470# a_8563_1842# 0.01697f
C367 DELAY_VBIASP a_12233_1842# 0.11005f
C368 a_6283_1842# DELAY_VBIASN 0.06812f
C369 a_24393_1842# DELAY_OUT_TAP28 0.0114f
C370 DELAY_OUT_TAP14 DELAY_VBIASN 0.04023f
C371 VDD a_27433_1842# 0.70781f
C372 DELAY_OUT_TAP23 a_20723_1842# 0.69646f
C373 DELAY_VBIASP DELAY_VBIASN 2.36634f
C374 DELAY_VBIASP a_11603_1842# 0.06316f
C375 a_17683_1842# DELAY_OUT_TAP19 0.69646f
C376 a_19963_1842# DELAY_VBIASP 0.06316f
C377 DELAY_OUT_TAP4 VDD 0.7981f
C378 a_9323_1842# DELAY_VBIASN 0.06812f
C379 DELAY_OUT_TAP30 a_26043_1842# 0.69646f
C380 a_23763_1842# DELAY_VBIASN 0.06812f
C381 a_26911_2470# VDD 0.02372f
C382 a_26673_1842# DELAY_VBIASN 0.10296f
C383 DELAY_OUT_TAP6 a_7803_1842# 0.69646f
C384 DELAY_VBIASP a_27997_1842# 0.03776f
C385 DELAY_VBIASP a_4763_1842# 0.06316f
C386 a_10843_1842# DELAY_VBIASP 0.06316f
C387 DELAY_OUT_TAP10 DELAY_VBIASP 0.03913f
C388 VDD a_21591_2470# 0.02372f
C389 a_14643_1842# DELAY_OUT_TAP15 0.69646f
C390 VDD DELAY_OUT_TAP16 0.7981f
C391 a_17683_1842# DELAY_VBIASN 0.06812f
C392 DELAY_OUT_TAP5 a_6913_1842# 0.0114f
C393 VDD a_13883_1842# 0.85896f
C394 DELAY_OUT_TAP6 DELAY_VBIASP 0.03913f
C395 a_19073_1842# DELAY_OUT_TAP21 0.0114f
C396 VDD DELAY_OUT_TAP25 0.7981f
C397 a_4003_1842# DELAY_IN 0.52007f
C398 a_20831_1842# a_20723_1842# 0.01163f
C399 VDD a_8433_1842# 0.70781f
C400 a_16923_1842# a_17031_2470# 0.01697f
C401 DELAY_OUT_LAST DELAY_VBIASN 0.04506f
C402 a_13123_1842# DELAY_VBIASN 0.06812f
C403 a_19073_1842# VDD 0.70781f
C404 VDD a_22873_1842# 0.70781f
C405 a_8433_1842# a_8563_1842# 0.69911f
C406 DELAY_VBIASP DELAY_OUT_TAP18 0.03913f
C407 VDD a_6391_2470# 0.02372f
C408 DELAY_OUT_TAP23 DELAY_VBIASN 0.04023f
C409 a_19311_2470# VDD 0.02372f
C410 VDD a_13991_2470# 0.02372f
C411 VDD a_6913_1842# 0.70781f
C412 a_20593_1842# DELAY_OUT_TAP22 0.70708f
C413 a_7673_1842# DELAY_VBIASN 0.10296f
C414 DELAY_OUT_TAP26 a_22873_1842# 0.0114f
C415 VDD a_7911_2470# 0.02372f
C416 a_27997_1842# DELAY_OUT_LAST 0.70955f
C417 DELAY_VBIASP a_14643_1842# 0.06316f
C418 VDD DELAY_OUT_TAP1 0.79811f
C419 a_9953_1842# VDD 0.70781f
C420 a_24393_1842# VDD 0.70781f
C421 a_7043_1842# DELAY_VBIASN 0.06812f
C422 VDD a_7151_2470# 0.02372f
C423 a_22113_1842# DELAY_VBIASN 0.10296f
C424 DELAY_OUT_TAP12 a_12363_1842# 0.69646f
C425 a_19073_1842# a_19203_1842# 0.69911f
C426 DELAY_VBIASP DELAY_OUT_TAP28 0.03913f
C427 a_10083_1842# a_10191_1842# 0.01163f
C428 a_6153_1842# DELAY_VBIASN 0.10296f
C429 DELAY_VBIASP a_9193_1842# 0.11005f
C430 a_9323_1842# a_9431_1842# 0.01163f
C431 a_10713_1842# DELAY_OUT_TAP9 0.70708f
C432 a_24393_1842# DELAY_OUT_TAP27 0.70708f
C433 a_19311_2470# a_19203_1842# 0.01697f
C434 VDD a_26803_1842# 0.85896f
C435 DELAY_OUT_TAP13 DELAY_VBIASN 0.04023f
C436 a_9323_1842# a_9193_1842# 0.69911f
C437 DELAY_IN DELAY_VBIASN 0.06896f
C438 a_17553_1842# DELAY_OUT_TAP19 0.0114f
C439 a_21353_1842# a_21483_1842# 0.69911f
C440 a_19833_1842# DELAY_VBIASP 0.11005f
C441 DELAY_OUT_TAP3 VDD 0.7981f
C442 DELAY_OUT_TAP30 a_25913_1842# 0.0114f
C443 a_23633_1842# DELAY_VBIASN 0.10296f
C444 a_18313_1842# VDD 0.70781f
C445 a_4871_2470# a_4763_1842# 0.01697f
C446 a_26151_2470# VDD 0.02372f
C447 a_5393_1842# a_5523_1842# 0.69911f
C448 a_26043_1842# DELAY_VBIASN 0.06812f
C449 DELAY_OUT_TAP6 a_7673_1842# 0.0114f
C450 a_9323_1842# a_9431_2470# 0.01697f
C451 a_16163_1842# a_16033_1842# 0.69911f
C452 a_25153_1842# DELAY_VBIASP 0.11005f
C453 a_25391_2470# VDD 0.02372f
C454 a_10713_1842# DELAY_VBIASP 0.11005f
C455 VDD a_20831_2470# 0.02372f
C456 VDD DELAY_OUT_TAP15 0.7981f
C457 a_9953_1842# a_10083_1842# 0.69911f
C458 a_14513_1842# DELAY_OUT_TAP15 0.0114f
C459 a_24393_1842# a_24523_1842# 0.69911f
C460 a_17553_1842# DELAY_VBIASN 0.10296f
C461 DELAY_OUT_TAP4 a_6913_1842# 0.70708f
C462 VDD a_13753_1842# 0.70781f
C463 a_4003_1842# a_4111_2470# 0.01697f
C464 DELAY_OUT_TAP5 DELAY_VBIASP 0.03913f
C465 DELAY_OUT_TAP9 VDD 0.7981f
C466 a_16033_1842# DELAY_VBIASN 0.10296f
C467 VDD DELAY_OUT_TAP24 0.7981f
C468 VDD a_7803_1842# 0.85896f
C469 a_22351_2470# a_22243_1842# 0.01697f
C470 DELAY_OUT_TAP31 DELAY_VBIASN 0.04023f
C471 a_12993_1842# DELAY_VBIASN 0.10296f
C472 DELAY_VBIASP DELAY_OUT_TAP21 0.03913f
C473 a_18443_1842# VDD 0.85896f
C474 a_17031_1842# a_16923_1842# 0.01163f
C475 VDD a_22243_1842# 0.85896f
C476 DELAY_VBIASP DELAY_OUT_TAP17 0.03913f
C477 a_26911_2470# a_26803_1842# 0.01697f
C478 VDD a_5631_2470# 0.02372f
C479 DELAY_OUT_TAP22 DELAY_VBIASN 0.04023f
C480 a_18551_2470# VDD 0.02372f
C481 VDD a_13231_2470# 0.02372f
C482 VDD a_6283_1842# 0.85896f
C483 a_13991_2470# a_13883_1842# 0.01697f
C484 a_19963_1842# DELAY_OUT_TAP22 0.69646f
C485 a_23763_1842# a_23871_1842# 0.01163f
C486 DELAY_OUT_TAP25 a_22873_1842# 0.70708f
C487 DELAY_OUT_TAP14 VDD 0.7981f
C488 DELAY_OUT_TAP14 a_14513_1842# 0.70708f
C489 a_16163_1842# a_16271_2470# 0.01697f
C490 VDD DELAY_VBIASP 35.8265f
C491 DELAY_VBIASP a_14513_1842# 0.11005f
C492 a_9323_1842# VDD 0.85896f
C493 a_23763_1842# VDD 0.85896f
C494 a_21483_1842# DELAY_VBIASN 0.06812f
C495 DELAY_OUT_TAP12 a_12233_1842# 0.0114f
C496 DELAY_VBIASP DELAY_OUT_TAP27 0.03913f
C497 DELAY_VBIASP DELAY_OUT_TAP26 0.03913f
C498 DELAY_VBIASP a_8563_1842# 0.06316f
C499 a_5523_1842# DELAY_VBIASN 0.06812f
C500 a_10083_1842# DELAY_OUT_TAP9 0.69646f
C501 a_11711_2470# a_11603_1842# 0.01697f
C502 a_23763_1842# DELAY_OUT_TAP27 0.69646f
C503 a_16793_1842# a_16923_1842# 0.69911f
C504 VDD a_26673_1842# 0.70781f
C505 DELAY_OUT_TAP12 DELAY_VBIASN 0.04023f
C506 a_20593_1842# a_20723_1842# 0.69911f
C507 a_17553_1842# DELAY_OUT_TAP18 0.70708f
C508 a_19203_1842# DELAY_VBIASP 0.06316f
C509 a_23003_1842# DELAY_VBIASN 0.06812f
C510 DELAY_OUT_TAP29 a_25913_1842# 0.70708f
C511 a_17683_1842# VDD 0.85896f
C512 a_26911_1842# a_26803_1842# 0.01163f
C513 DELAY_OUT_TAP8 DELAY_VBIASN 0.04023f
C514 DELAY_OUT_TAP29 a_25283_1842# 0.69646f
C515 a_25913_1842# DELAY_VBIASN 0.10296f
C516 DELAY_VBIASP DELAY_OUT_TAP2 0.03913f
C517 DELAY_OUT_TAP5 a_7673_1842# 0.70708f
R0 DELAY_VBIASN.n1 DELAY_VBIASN.t31 34.3755
R1 DELAY_VBIASN.n1 DELAY_VBIASN.t30 33.0005
R2 DELAY_VBIASN.n2 DELAY_VBIASN.t29 33.0005
R3 DELAY_VBIASN.n3 DELAY_VBIASN.t28 33.0005
R4 DELAY_VBIASN.n4 DELAY_VBIASN.t27 33.0005
R5 DELAY_VBIASN.n5 DELAY_VBIASN.t26 33.0005
R6 DELAY_VBIASN.n6 DELAY_VBIASN.t25 33.0005
R7 DELAY_VBIASN.n7 DELAY_VBIASN.t24 33.0005
R8 DELAY_VBIASN.n8 DELAY_VBIASN.t23 33.0005
R9 DELAY_VBIASN.n9 DELAY_VBIASN.t22 33.0005
R10 DELAY_VBIASN.n10 DELAY_VBIASN.t21 33.0005
R11 DELAY_VBIASN.n11 DELAY_VBIASN.t20 33.0005
R12 DELAY_VBIASN.n12 DELAY_VBIASN.t19 33.0005
R13 DELAY_VBIASN.n13 DELAY_VBIASN.t18 33.0005
R14 DELAY_VBIASN.n14 DELAY_VBIASN.t17 33.0005
R15 DELAY_VBIASN.n15 DELAY_VBIASN.t16 33.0005
R16 DELAY_VBIASN.n16 DELAY_VBIASN.t15 33.0005
R17 DELAY_VBIASN.n17 DELAY_VBIASN.t14 33.0005
R18 DELAY_VBIASN.n18 DELAY_VBIASN.t13 33.0005
R19 DELAY_VBIASN.n19 DELAY_VBIASN.t12 33.0005
R20 DELAY_VBIASN.n20 DELAY_VBIASN.t11 33.0005
R21 DELAY_VBIASN.n21 DELAY_VBIASN.t10 33.0005
R22 DELAY_VBIASN.n22 DELAY_VBIASN.t9 33.0005
R23 DELAY_VBIASN.n23 DELAY_VBIASN.t8 33.0005
R24 DELAY_VBIASN.n24 DELAY_VBIASN.t7 33.0005
R25 DELAY_VBIASN.n25 DELAY_VBIASN.t6 33.0005
R26 DELAY_VBIASN.n26 DELAY_VBIASN.t5 33.0005
R27 DELAY_VBIASN.n27 DELAY_VBIASN.t4 33.0005
R28 DELAY_VBIASN.n28 DELAY_VBIASN.t3 33.0005
R29 DELAY_VBIASN.n29 DELAY_VBIASN.t2 33.0005
R30 DELAY_VBIASN.n30 DELAY_VBIASN.t1 33.0005
R31 DELAY_VBIASN.n0 DELAY_VBIASN.t0 33.0005
R32 DELAY_VBIASN DELAY_VBIASN.n0 1.55517
R33 DELAY_VBIASN.n0 DELAY_VBIASN.n30 1.3755
R34 DELAY_VBIASN.n30 DELAY_VBIASN.n29 1.3755
R35 DELAY_VBIASN.n29 DELAY_VBIASN.n28 1.3755
R36 DELAY_VBIASN.n28 DELAY_VBIASN.n27 1.3755
R37 DELAY_VBIASN.n27 DELAY_VBIASN.n26 1.3755
R38 DELAY_VBIASN.n26 DELAY_VBIASN.n25 1.3755
R39 DELAY_VBIASN.n25 DELAY_VBIASN.n24 1.3755
R40 DELAY_VBIASN.n24 DELAY_VBIASN.n23 1.3755
R41 DELAY_VBIASN.n23 DELAY_VBIASN.n22 1.3755
R42 DELAY_VBIASN.n22 DELAY_VBIASN.n21 1.3755
R43 DELAY_VBIASN.n21 DELAY_VBIASN.n20 1.3755
R44 DELAY_VBIASN.n20 DELAY_VBIASN.n19 1.3755
R45 DELAY_VBIASN.n19 DELAY_VBIASN.n18 1.3755
R46 DELAY_VBIASN.n18 DELAY_VBIASN.n17 1.3755
R47 DELAY_VBIASN.n17 DELAY_VBIASN.n16 1.3755
R48 DELAY_VBIASN.n16 DELAY_VBIASN.n15 1.3755
R49 DELAY_VBIASN.n15 DELAY_VBIASN.n14 1.3755
R50 DELAY_VBIASN.n14 DELAY_VBIASN.n13 1.3755
R51 DELAY_VBIASN.n13 DELAY_VBIASN.n12 1.3755
R52 DELAY_VBIASN.n12 DELAY_VBIASN.n11 1.3755
R53 DELAY_VBIASN.n11 DELAY_VBIASN.n10 1.3755
R54 DELAY_VBIASN.n10 DELAY_VBIASN.n9 1.3755
R55 DELAY_VBIASN.n9 DELAY_VBIASN.n8 1.3755
R56 DELAY_VBIASN.n8 DELAY_VBIASN.n7 1.3755
R57 DELAY_VBIASN.n7 DELAY_VBIASN.n6 1.3755
R58 DELAY_VBIASN.n6 DELAY_VBIASN.n5 1.3755
R59 DELAY_VBIASN.n5 DELAY_VBIASN.n4 1.3755
R60 DELAY_VBIASN.n4 DELAY_VBIASN.n3 1.3755
R61 DELAY_VBIASN.n3 DELAY_VBIASN.n2 1.3755
R62 DELAY_VBIASN.n2 DELAY_VBIASN.n1 1.3755
R63 DELAY_VBIASP.n1 DELAY_VBIASP.t31 34.3685
R64 DELAY_VBIASP.n1 DELAY_VBIASP.t30 33.0005
R65 DELAY_VBIASP.n2 DELAY_VBIASP.t29 33.0005
R66 DELAY_VBIASP.n3 DELAY_VBIASP.t28 33.0005
R67 DELAY_VBIASP.n4 DELAY_VBIASP.t27 33.0005
R68 DELAY_VBIASP.n5 DELAY_VBIASP.t26 33.0005
R69 DELAY_VBIASP.n6 DELAY_VBIASP.t25 33.0005
R70 DELAY_VBIASP.n7 DELAY_VBIASP.t24 33.0005
R71 DELAY_VBIASP.n8 DELAY_VBIASP.t23 33.0005
R72 DELAY_VBIASP.n9 DELAY_VBIASP.t22 33.0005
R73 DELAY_VBIASP.n10 DELAY_VBIASP.t21 33.0005
R74 DELAY_VBIASP.n11 DELAY_VBIASP.t20 33.0005
R75 DELAY_VBIASP.n12 DELAY_VBIASP.t19 33.0005
R76 DELAY_VBIASP.n13 DELAY_VBIASP.t18 33.0005
R77 DELAY_VBIASP.n14 DELAY_VBIASP.t17 33.0005
R78 DELAY_VBIASP.n15 DELAY_VBIASP.t16 33.0005
R79 DELAY_VBIASP.n16 DELAY_VBIASP.t15 33.0005
R80 DELAY_VBIASP.n17 DELAY_VBIASP.t14 33.0005
R81 DELAY_VBIASP.n18 DELAY_VBIASP.t13 33.0005
R82 DELAY_VBIASP.n19 DELAY_VBIASP.t12 33.0005
R83 DELAY_VBIASP.n20 DELAY_VBIASP.t11 33.0005
R84 DELAY_VBIASP.n21 DELAY_VBIASP.t10 33.0005
R85 DELAY_VBIASP.n22 DELAY_VBIASP.t9 33.0005
R86 DELAY_VBIASP.n23 DELAY_VBIASP.t8 33.0005
R87 DELAY_VBIASP.n24 DELAY_VBIASP.t7 33.0005
R88 DELAY_VBIASP.n25 DELAY_VBIASP.t6 33.0005
R89 DELAY_VBIASP.n26 DELAY_VBIASP.t5 33.0005
R90 DELAY_VBIASP.n27 DELAY_VBIASP.t4 33.0005
R91 DELAY_VBIASP.n28 DELAY_VBIASP.t3 33.0005
R92 DELAY_VBIASP.n29 DELAY_VBIASP.t2 33.0005
R93 DELAY_VBIASP.n30 DELAY_VBIASP.t1 33.0005
R94 DELAY_VBIASP.n0 DELAY_VBIASP.t0 33.0005
R95 DELAY_VBIASP DELAY_VBIASP.n0 1.70586
R96 DELAY_VBIASP.n0 DELAY_VBIASP.n30 1.36852
R97 DELAY_VBIASP.n30 DELAY_VBIASP.n29 1.36852
R98 DELAY_VBIASP.n29 DELAY_VBIASP.n28 1.36852
R99 DELAY_VBIASP.n28 DELAY_VBIASP.n27 1.36852
R100 DELAY_VBIASP.n27 DELAY_VBIASP.n26 1.36852
R101 DELAY_VBIASP.n26 DELAY_VBIASP.n25 1.36852
R102 DELAY_VBIASP.n25 DELAY_VBIASP.n24 1.36852
R103 DELAY_VBIASP.n24 DELAY_VBIASP.n23 1.36852
R104 DELAY_VBIASP.n23 DELAY_VBIASP.n22 1.36852
R105 DELAY_VBIASP.n22 DELAY_VBIASP.n21 1.36852
R106 DELAY_VBIASP.n21 DELAY_VBIASP.n20 1.36852
R107 DELAY_VBIASP.n20 DELAY_VBIASP.n19 1.36852
R108 DELAY_VBIASP.n19 DELAY_VBIASP.n18 1.36852
R109 DELAY_VBIASP.n18 DELAY_VBIASP.n17 1.36852
R110 DELAY_VBIASP.n17 DELAY_VBIASP.n16 1.36852
R111 DELAY_VBIASP.n16 DELAY_VBIASP.n15 1.36852
R112 DELAY_VBIASP.n15 DELAY_VBIASP.n14 1.36852
R113 DELAY_VBIASP.n14 DELAY_VBIASP.n13 1.36852
R114 DELAY_VBIASP.n13 DELAY_VBIASP.n12 1.36852
R115 DELAY_VBIASP.n12 DELAY_VBIASP.n11 1.36852
R116 DELAY_VBIASP.n11 DELAY_VBIASP.n10 1.36852
R117 DELAY_VBIASP.n10 DELAY_VBIASP.n9 1.36852
R118 DELAY_VBIASP.n9 DELAY_VBIASP.n8 1.36852
R119 DELAY_VBIASP.n8 DELAY_VBIASP.n7 1.36852
R120 DELAY_VBIASP.n7 DELAY_VBIASP.n6 1.36852
R121 DELAY_VBIASP.n6 DELAY_VBIASP.n5 1.36852
R122 DELAY_VBIASP.n5 DELAY_VBIASP.n4 1.36852
R123 DELAY_VBIASP.n4 DELAY_VBIASP.n3 1.36852
R124 DELAY_VBIASP.n3 DELAY_VBIASP.n2 1.36852
R125 DELAY_VBIASP.n2 DELAY_VBIASP.n1 1.36852
R126 VDD.t0 VDD.n28 0.290909
R127 VDD.t0 VDD.n50 1.07225
R128 VDD.n49 VDD.t33 15.1333
R129 VDD.n257 VDD.t36 15.0005
R130 VDD.n725 VDD.n724 9.0005
R131 VDD.n723 VDD.n254 9.0005
R132 VDD.n722 VDD.n721 9.0005
R133 VDD.n720 VDD.n258 9.0005
R134 VDD.n719 VDD.n718 9.0005
R135 VDD.n717 VDD.n259 9.0005
R136 VDD.n716 VDD.n715 9.0005
R137 VDD.n714 VDD.n260 9.0005
R138 VDD.n713 VDD.n712 9.0005
R139 VDD.n711 VDD.n233 9.0005
R140 VDD.n710 VDD.n709 9.0005
R141 VDD.n708 VDD.n261 9.0005
R142 VDD.n707 VDD.n706 9.0005
R143 VDD.n705 VDD.n262 9.0005
R144 VDD.n704 VDD.n703 9.0005
R145 VDD.n264 VDD.n263 9.0005
R146 VDD.n364 VDD.n363 9.0005
R147 VDD.n366 VDD.n365 9.0005
R148 VDD.n367 VDD.n362 9.0005
R149 VDD.n369 VDD.n368 9.0005
R150 VDD.n370 VDD.n361 9.0005
R151 VDD.n372 VDD.n371 9.0005
R152 VDD.n373 VDD.n360 9.0005
R153 VDD.n375 VDD.n374 9.0005
R154 VDD.n376 VDD.n359 9.0005
R155 VDD.n378 VDD.n377 9.0005
R156 VDD.n379 VDD.n358 9.0005
R157 VDD.n381 VDD.n380 9.0005
R158 VDD.n382 VDD.n357 9.0005
R159 VDD.n384 VDD.n383 9.0005
R160 VDD.n385 VDD.n356 9.0005
R161 VDD.n387 VDD.n386 9.0005
R162 VDD.n388 VDD.n355 9.0005
R163 VDD.n390 VDD.n389 9.0005
R164 VDD.n391 VDD.n354 9.0005
R165 VDD.n393 VDD.n392 9.0005
R166 VDD.n394 VDD.n353 9.0005
R167 VDD.n396 VDD.n395 9.0005
R168 VDD.n397 VDD.n352 9.0005
R169 VDD.n399 VDD.n398 9.0005
R170 VDD.n400 VDD.n351 9.0005
R171 VDD.n402 VDD.n401 9.0005
R172 VDD.n403 VDD.n350 9.0005
R173 VDD.n405 VDD.n404 9.0005
R174 VDD.n406 VDD.n349 9.0005
R175 VDD.n408 VDD.n407 9.0005
R176 VDD.n409 VDD.n348 9.0005
R177 VDD.n411 VDD.n410 9.0005
R178 VDD.n412 VDD.n347 9.0005
R179 VDD.n414 VDD.n413 9.0005
R180 VDD.n415 VDD.n346 9.0005
R181 VDD.n417 VDD.n416 9.0005
R182 VDD.n418 VDD.n345 9.0005
R183 VDD.n420 VDD.n419 9.0005
R184 VDD.n421 VDD.n344 9.0005
R185 VDD.n423 VDD.n422 9.0005
R186 VDD.n424 VDD.n343 9.0005
R187 VDD.n426 VDD.n425 9.0005
R188 VDD.n427 VDD.n342 9.0005
R189 VDD.n429 VDD.n428 9.0005
R190 VDD.n430 VDD.n341 9.0005
R191 VDD.n432 VDD.n431 9.0005
R192 VDD.n433 VDD.n340 9.0005
R193 VDD.n435 VDD.n434 9.0005
R194 VDD.n436 VDD.n339 9.0005
R195 VDD.n438 VDD.n437 9.0005
R196 VDD.n439 VDD.n338 9.0005
R197 VDD.n441 VDD.n440 9.0005
R198 VDD.n442 VDD.n337 9.0005
R199 VDD.n444 VDD.n443 9.0005
R200 VDD.n445 VDD.n336 9.0005
R201 VDD.n447 VDD.n446 9.0005
R202 VDD.n448 VDD.n335 9.0005
R203 VDD.n450 VDD.n449 9.0005
R204 VDD.n451 VDD.n334 9.0005
R205 VDD.n453 VDD.n452 9.0005
R206 VDD.n454 VDD.n333 9.0005
R207 VDD.n456 VDD.n455 9.0005
R208 VDD.n457 VDD.n332 9.0005
R209 VDD.n459 VDD.n458 9.0005
R210 VDD.n460 VDD.n331 9.0005
R211 VDD.n462 VDD.n461 9.0005
R212 VDD.n463 VDD.n330 9.0005
R213 VDD.n465 VDD.n464 9.0005
R214 VDD.n466 VDD.n329 9.0005
R215 VDD.n468 VDD.n467 9.0005
R216 VDD.n469 VDD.n328 9.0005
R217 VDD.n471 VDD.n470 9.0005
R218 VDD.n472 VDD.n327 9.0005
R219 VDD.n474 VDD.n473 9.0005
R220 VDD.n475 VDD.n326 9.0005
R221 VDD.n477 VDD.n476 9.0005
R222 VDD.n478 VDD.n325 9.0005
R223 VDD.n480 VDD.n479 9.0005
R224 VDD.n481 VDD.n324 9.0005
R225 VDD.n483 VDD.n482 9.0005
R226 VDD.n484 VDD.n323 9.0005
R227 VDD.n486 VDD.n485 9.0005
R228 VDD.n487 VDD.n322 9.0005
R229 VDD.n489 VDD.n488 9.0005
R230 VDD.n490 VDD.n321 9.0005
R231 VDD.n492 VDD.n491 9.0005
R232 VDD.n493 VDD.n320 9.0005
R233 VDD.n495 VDD.n494 9.0005
R234 VDD.n496 VDD.n319 9.0005
R235 VDD.n498 VDD.n497 9.0005
R236 VDD.n499 VDD.n318 9.0005
R237 VDD.n501 VDD.n500 9.0005
R238 VDD.n502 VDD.n317 9.0005
R239 VDD.n504 VDD.n503 9.0005
R240 VDD.n505 VDD.n316 9.0005
R241 VDD.n507 VDD.n506 9.0005
R242 VDD.n508 VDD.n315 9.0005
R243 VDD.n510 VDD.n509 9.0005
R244 VDD.n511 VDD.n314 9.0005
R245 VDD.n513 VDD.n512 9.0005
R246 VDD.n514 VDD.n313 9.0005
R247 VDD.n516 VDD.n515 9.0005
R248 VDD.n517 VDD.n312 9.0005
R249 VDD.n519 VDD.n518 9.0005
R250 VDD.n520 VDD.n311 9.0005
R251 VDD.n522 VDD.n521 9.0005
R252 VDD.n523 VDD.n310 9.0005
R253 VDD.n525 VDD.n524 9.0005
R254 VDD.n526 VDD.n309 9.0005
R255 VDD.n528 VDD.n527 9.0005
R256 VDD.n529 VDD.n308 9.0005
R257 VDD.n531 VDD.n530 9.0005
R258 VDD.n532 VDD.n307 9.0005
R259 VDD.n534 VDD.n533 9.0005
R260 VDD.n535 VDD.n306 9.0005
R261 VDD.n537 VDD.n536 9.0005
R262 VDD.n538 VDD.n305 9.0005
R263 VDD.n540 VDD.n539 9.0005
R264 VDD.n541 VDD.n304 9.0005
R265 VDD.n543 VDD.n542 9.0005
R266 VDD.n544 VDD.n303 9.0005
R267 VDD.n546 VDD.n545 9.0005
R268 VDD.n547 VDD.n302 9.0005
R269 VDD.n549 VDD.n548 9.0005
R270 VDD.n550 VDD.n301 9.0005
R271 VDD.n552 VDD.n551 9.0005
R272 VDD.n553 VDD.n300 9.0005
R273 VDD.n555 VDD.n554 9.0005
R274 VDD.n556 VDD.n299 9.0005
R275 VDD.n558 VDD.n557 9.0005
R276 VDD.n559 VDD.n298 9.0005
R277 VDD.n561 VDD.n560 9.0005
R278 VDD.n562 VDD.n297 9.0005
R279 VDD.n564 VDD.n563 9.0005
R280 VDD.n565 VDD.n296 9.0005
R281 VDD.n567 VDD.n566 9.0005
R282 VDD.n568 VDD.n295 9.0005
R283 VDD.n570 VDD.n569 9.0005
R284 VDD.n571 VDD.n294 9.0005
R285 VDD.n573 VDD.n572 9.0005
R286 VDD.n574 VDD.n48 0.360403
R287 VDD.n231 VDD.n725 9.0005
R288 VDD.n721 VDD.t17 9.0005
R289 VDD.n719 VDD.n222 0.114852
R290 VDD.n715 VDD.n59 9.0005
R291 VDD.n713 VDD.n53 0.114852
R292 VDD.n208 VDD.n6 4.44407
R293 VDD.n707 VDD.n168 0.114852
R294 VDD.n182 VDD.n6 4.44407
R295 VDD.n364 VDD.n58 0.114852
R296 VDD.n362 VDD.n156 0.114852
R297 VDD.n370 VDD.n8 9.0005
R298 VDD.n56 VDD.n8 4.44407
R299 VDD.n376 VDD.n221 0.114852
R300 VDD.n358 VDD.n169 0.114852
R301 VDD.n382 VDD.n51 9.0005
R302 VDD.n356 VDD.n186 0.114852
R303 VDD.n388 VDD.n55 0.114852
R304 VDD.n354 VDD.n200 0.114852
R305 VDD.n394 VDD.t0 9.0005
R306 VDD.n198 VDD.t0 4.44407
R307 VDD.n220 VDD.t0 4.44407
R308 VDD.n57 VDD.t0 4.44407
R309 VDD.n406 VDD.n207 0.114852
R310 VDD.n348 VDD.t0 9.0005
R311 VDD.n412 VDD.n54 0.114852
R312 VDD.n219 VDD.n25 4.44407
R313 VDD.n176 VDD.n47 4.44407
R314 VDD.n218 VDD.n178 4.44407
R315 VDD.n175 VDD.n173 4.44407
R316 VDD.n342 VDD.n172 9.0005
R317 VDD.n430 VDD.n189 0.114852
R318 VDD.n340 VDD.n197 0.114852
R319 VDD.n217 VDD.n41 4.44407
R320 VDD.n338 VDD.n167 0.114852
R321 VDD.n442 VDD.n22 9.0005
R322 VDD.n201 VDD.n22 4.44407
R323 VDD.n193 VDD.n22 4.44407
R324 VDD.n334 VDD.n153 0.114852
R325 VDD.n454 VDD.n192 0.114852
R326 VDD.n332 VDD.n28 9.0005
R327 VDD.n460 VDD.n224 0.114852
R328 VDD.n330 VDD.n196 0.114852
R329 VDD.n466 VDD.n216 0.114852
R330 VDD.n328 VDD.n31 9.0005
R331 VDD.n155 VDD.n31 4.44407
R332 VDD.n184 VDD.n31 4.44407
R333 VDD.n478 VDD.n199 0.114852
R334 VDD.n324 VDD.n206 0.114852
R335 VDD.n484 VDD.n2 9.0005
R336 VDD.n60 VDD.n2 4.44407
R337 VDD.n490 VDD.n190 0.114852
R338 VDD.n320 VDD.n195 0.114852
R339 VDD.n215 VDD.n5 4.44407
R340 VDD.n318 VDD.n165 0.114852
R341 VDD.n502 VDD.n5 9.0005
R342 VDD.n214 VDD.n5 4.44407
R343 VDD.n61 VDD.n5 4.44407
R344 VDD.n314 VDD.n223 0.114852
R345 VDD.n514 VDD.n5 9.0005
R346 VDD.n191 VDD.n44 4.44407
R347 VDD.n213 VDD.n44 4.44407
R348 VDD.n170 VDD.n44 4.44407
R349 VDD.n212 VDD.n181 4.44407
R350 VDD.n308 VDD.n232 9.0005
R351 VDD.n36 VDD.n35 4.44407
R352 VDD.n202 VDD.n35 4.44407
R353 VDD.n538 VDD.n194 0.114852
R354 VDD.n304 VDD.n185 0.114852
R355 VDD.n544 VDD.t0 9.0005
R356 VDD.n62 VDD.t0 4.44407
R357 VDD.n183 VDD.t0 4.44407
R358 VDD.n300 VDD.n154 0.114852
R359 VDD.n556 VDD.n211 0.114852
R360 VDD.n298 VDD.n16 9.0005
R361 VDD.n562 VDD.n63 0.114852
R362 VDD.n210 VDD.n16 4.44407
R363 VDD.n171 VDD.n16 4.44407
R364 VDD.n209 VDD.n205 4.44407
R365 VDD.n574 VDD.n203 9.0005
R366 VDD.n573 VDD.n209 0.114852
R367 VDD.n569 VDD.n16 9.0005
R368 VDD.n567 VDD.n171 0.114852
R369 VDD.n563 VDD.n210 0.114852
R370 VDD.n63 VDD.n16 4.44407
R371 VDD.n211 VDD.n16 4.44407
R372 VDD.n555 VDD.n10 9.0005
R373 VDD.n154 VDD.t0 4.44407
R374 VDD.n549 VDD.n183 0.114852
R375 VDD.n545 VDD.n62 0.114852
R376 VDD.n185 VDD.t0 4.44407
R377 VDD.n194 VDD.t0 4.44407
R378 VDD.n537 VDD.n35 9.0005
R379 VDD.n533 VDD.n202 0.114852
R380 VDD.n531 VDD.n36 0.114852
R381 VDD.n527 VDD.n212 0.114852
R382 VDD.n525 VDD.n44 9.0005
R383 VDD.n521 VDD.n170 0.114852
R384 VDD.n519 VDD.n213 0.114852
R385 VDD.n515 VDD.n191 0.114852
R386 VDD.n223 VDD.n5 4.44407
R387 VDD.n509 VDD.n61 0.114852
R388 VDD.n507 VDD.n5 9.0005
R389 VDD.n503 VDD.n214 0.114852
R390 VDD.n165 VDD.n5 4.44407
R391 VDD.n497 VDD.n215 0.114852
R392 VDD.n495 VDD.n5 9.0005
R393 VDD.n195 VDD.n5 4.44407
R394 VDD.n190 VDD.n2 4.44407
R395 VDD.n485 VDD.n60 0.114852
R396 VDD.n206 VDD.n2 4.44407
R397 VDD.n199 VDD.n2 4.44407
R398 VDD.n477 VDD.n31 9.0005
R399 VDD.n473 VDD.n184 0.114852
R400 VDD.n471 VDD.n155 0.114852
R401 VDD.n216 VDD.n31 4.44407
R402 VDD.n196 VDD.n31 4.44407
R403 VDD.n461 VDD.n31 9.0005
R404 VDD.n224 VDD.n28 4.44407
R405 VDD.n192 VDD.n28 4.44407
R406 VDD.n153 VDD.n26 4.44407
R407 VDD.n449 VDD.n193 0.114852
R408 VDD.n447 VDD.n22 9.0005
R409 VDD.n443 VDD.n201 0.114852
R410 VDD.n167 VDD.n166 4.44407
R411 VDD.n437 VDD.n217 0.114852
R412 VDD.n435 VDD.n41 9.0005
R413 VDD.n197 VDD.n41 4.44407
R414 VDD.n189 VDD.n188 4.44407
R415 VDD.n425 VDD.n175 0.114852
R416 VDD.n423 VDD.n218 0.114852
R417 VDD.n419 VDD.n47 9.0005
R418 VDD.n417 VDD.n176 0.114852
R419 VDD.n413 VDD.n219 0.114852
R420 VDD.n54 VDD.n25 4.44407
R421 VDD.n207 VDD.t0 4.44407
R422 VDD.n405 VDD.t0 9.0005
R423 VDD.n401 VDD.n57 0.114852
R424 VDD.n399 VDD.n220 0.114852
R425 VDD.n395 VDD.n198 0.114852
R426 VDD.n200 VDD.t0 4.44407
R427 VDD.n389 VDD.t0 9.0005
R428 VDD.n55 VDD.t0 4.44407
R429 VDD.n186 VDD.t0 4.44407
R430 VDD.n169 VDD.n51 4.44407
R431 VDD.n221 VDD.n8 4.44407
R432 VDD.n375 VDD.n8 9.0005
R433 VDD.n371 VDD.n56 0.114852
R434 VDD.n156 VDD.n8 4.44407
R435 VDD.n58 VDD.n6 4.44407
R436 VDD.n264 VDD.n182 0.114852
R437 VDD.n168 VDD.n6 4.44407
R438 VDD.n708 VDD.n6 9.0005
R439 VDD.n208 VDD.n233 0.114852
R440 VDD.n53 VDD.n6 4.44407
R441 VDD.n222 VDD.n59 4.44407
R442 VDD.t17 VDD.n254 9.0005
R443 VDD.n229 VDD.n256 9.0005
R444 VDD.n689 VDD.t17 9.0005
R445 VDD.n64 VDD.t17 4.44407
R446 VDD.n693 VDD.t17 9.0005
R447 VDD.n164 VDD.t20 4.44407
R448 VDD.n697 VDD.t20 9.0005
R449 VDD.n163 VDD.t14 4.44407
R450 VDD.t14 VDD.n702 9.0005
R451 VDD.n162 VDD.t28 4.44407
R452 VDD.n684 VDD.t28 9.0005
R453 VDD.n161 VDD.t8 4.44407
R454 VDD.n680 VDD.t8 9.0005
R455 VDD.n160 VDD.t9 4.44407
R456 VDD.n676 VDD.t9 9.0005
R457 VDD.n159 VDD.t0 4.44407
R458 VDD.n672 VDD.t0 9.0005
R459 VDD.n158 VDD.t0 4.44407
R460 VDD.n668 VDD.t0 9.0005
R461 VDD.n157 VDD.t0 4.44407
R462 VDD.n664 VDD.t0 9.0005
R463 VDD.n66 VDD.n65 4.44407
R464 VDD.n661 VDD.n66 0.114852
R465 VDD.n660 VDD.n234 9.0005
R466 VDD.n69 VDD.n67 4.44407
R467 VDD.n657 VDD.n69 0.114852
R468 VDD.n656 VDD.n235 9.0005
R469 VDD.n72 VDD.n70 4.44407
R470 VDD.n653 VDD.n72 0.114852
R471 VDD.n652 VDD.n236 9.0005
R472 VDD.n75 VDD.n73 4.44407
R473 VDD.n649 VDD.n75 0.114852
R474 VDD.n648 VDD.n237 9.0005
R475 VDD.n78 VDD.n76 4.44407
R476 VDD.n645 VDD.n78 0.114852
R477 VDD.n644 VDD.n238 9.0005
R478 VDD.n81 VDD.n79 4.44407
R479 VDD.n641 VDD.n81 0.114852
R480 VDD.n640 VDD.n239 9.0005
R481 VDD.n84 VDD.n82 4.44407
R482 VDD.n637 VDD.n84 0.114852
R483 VDD.n636 VDD.n240 9.0005
R484 VDD.n87 VDD.n85 4.44407
R485 VDD.n633 VDD.n87 0.114852
R486 VDD.n632 VDD.n241 9.0005
R487 VDD.n90 VDD.n88 4.44407
R488 VDD.n629 VDD.n90 0.114852
R489 VDD.n628 VDD.n242 9.0005
R490 VDD.n93 VDD.n91 4.44407
R491 VDD.n625 VDD.n93 0.114852
R492 VDD.n624 VDD.n243 9.0005
R493 VDD.n96 VDD.n94 4.44407
R494 VDD.n621 VDD.n96 0.114852
R495 VDD.n620 VDD.n244 9.0005
R496 VDD.n99 VDD.n97 4.44407
R497 VDD.n617 VDD.n99 0.114852
R498 VDD.n616 VDD.n245 9.0005
R499 VDD.n102 VDD.n100 4.44407
R500 VDD.n613 VDD.n102 0.114852
R501 VDD.n612 VDD.n3 9.0005
R502 VDD.n105 VDD.n103 4.44407
R503 VDD.n609 VDD.n105 0.114852
R504 VDD.n608 VDD.n246 9.0005
R505 VDD.n108 VDD.n106 4.44407
R506 VDD.n605 VDD.n108 0.114852
R507 VDD.n604 VDD.n247 9.0005
R508 VDD.n111 VDD.n109 4.44407
R509 VDD.n601 VDD.n111 0.114852
R510 VDD.n600 VDD.n248 9.0005
R511 VDD.n114 VDD.n112 4.44407
R512 VDD.n597 VDD.n114 0.114852
R513 VDD.n596 VDD.n249 9.0005
R514 VDD.n117 VDD.n115 4.44407
R515 VDD.n593 VDD.n117 0.114852
R516 VDD.n592 VDD.n250 9.0005
R517 VDD.n120 VDD.n118 4.44407
R518 VDD.n589 VDD.n120 0.114852
R519 VDD.n588 VDD.n251 9.0005
R520 VDD.n123 VDD.n121 4.44407
R521 VDD.n585 VDD.n123 0.114852
R522 VDD.n584 VDD.n33 9.0005
R523 VDD.n126 VDD.n124 4.44407
R524 VDD.n581 VDD.n126 0.114852
R525 VDD.n580 VDD.n252 9.0005
R526 VDD.n129 VDD.n127 4.44407
R527 VDD.n577 VDD.n129 0.114852
R528 VDD.n576 VDD.n253 9.0005
R529 VDD.n256 VDD.n255 9.0005
R530 VDD.n690 VDD.n689 9.0005
R531 VDD.n64 VDD.n691 9.11485
R532 VDD.n692 VDD.n688 9.0005
R533 VDD.n694 VDD.n693 9.0005
R534 VDD.n164 VDD.n695 9.11485
R535 VDD.n696 VDD.n687 9.0005
R536 VDD.n698 VDD.n697 9.0005
R537 VDD.n699 VDD.n163 9.11485
R538 VDD.n700 VDD.n265 9.0005
R539 VDD.n702 VDD.n701 9.0005
R540 VDD.n686 VDD.n162 9.11485
R541 VDD.n685 VDD.n266 9.0005
R542 VDD.n684 VDD.n683 9.0005
R543 VDD.n682 VDD.n161 9.11485
R544 VDD.n681 VDD.n267 9.0005
R545 VDD.n680 VDD.n679 9.0005
R546 VDD.n678 VDD.n160 9.11485
R547 VDD.n677 VDD.n268 9.0005
R548 VDD.n676 VDD.n675 9.0005
R549 VDD.n674 VDD.n159 9.11485
R550 VDD.n673 VDD.n269 9.0005
R551 VDD.n672 VDD.n671 9.0005
R552 VDD.n670 VDD.n158 9.11485
R553 VDD.n669 VDD.n270 9.0005
R554 VDD.n668 VDD.n667 9.0005
R555 VDD.n666 VDD.n157 9.11485
R556 VDD.n665 VDD.n271 9.0005
R557 VDD.n664 VDD.n663 9.0005
R558 VDD.n661 VDD.n272 9.0005
R559 VDD.n660 VDD.n659 9.0005
R560 VDD.n657 VDD.n273 9.0005
R561 VDD.n656 VDD.n655 9.0005
R562 VDD.n653 VDD.n274 9.0005
R563 VDD.n652 VDD.n651 9.0005
R564 VDD.n649 VDD.n275 9.0005
R565 VDD.n648 VDD.n647 9.0005
R566 VDD.n645 VDD.n276 9.0005
R567 VDD.n644 VDD.n643 9.0005
R568 VDD.n641 VDD.n277 9.0005
R569 VDD.n640 VDD.n639 9.0005
R570 VDD.n637 VDD.n278 9.0005
R571 VDD.n636 VDD.n635 9.0005
R572 VDD.n633 VDD.n279 9.0005
R573 VDD.n632 VDD.n631 9.0005
R574 VDD.n629 VDD.n280 9.0005
R575 VDD.n628 VDD.n627 9.0005
R576 VDD.n625 VDD.n281 9.0005
R577 VDD.n624 VDD.n623 9.0005
R578 VDD.n621 VDD.n282 9.0005
R579 VDD.n620 VDD.n619 9.0005
R580 VDD.n617 VDD.n283 9.0005
R581 VDD.n616 VDD.n615 9.0005
R582 VDD.n613 VDD.n284 9.0005
R583 VDD.n612 VDD.n611 9.0005
R584 VDD.n609 VDD.n285 9.0005
R585 VDD.n608 VDD.n607 9.0005
R586 VDD.n605 VDD.n286 9.0005
R587 VDD.n604 VDD.n603 9.0005
R588 VDD.n601 VDD.n287 9.0005
R589 VDD.n600 VDD.n599 9.0005
R590 VDD.n597 VDD.n288 9.0005
R591 VDD.n596 VDD.n595 9.0005
R592 VDD.n593 VDD.n289 9.0005
R593 VDD.n592 VDD.n591 9.0005
R594 VDD.n589 VDD.n290 9.0005
R595 VDD.n588 VDD.n587 9.0005
R596 VDD.n585 VDD.n291 9.0005
R597 VDD.n584 VDD.n583 9.0005
R598 VDD.n581 VDD.n292 9.0005
R599 VDD.n580 VDD.n579 9.0005
R600 VDD.n577 VDD.n293 9.0005
R601 VDD.n576 VDD.n575 9.0005
R602 VDD.n230 VDD.n231 0.273104
R603 VDD.t0 VDD.n1 0.23979
R604 VDD.n14 VDD.n47 0.709484
R605 VDD.n174 VDD.n178 0.112979
R606 VDD.t0 VDD.n174 1.59972
R607 VDD.n42 VDD.n41 0.423868
R608 VDD.t0 VDD.n22 0.776647
R609 VDD.n32 VDD.n44 0.376307
R610 VDD.t0 VDD.n179 1.4532
R611 VDD.n179 VDD.n232 0.162881
R612 VDD.t0 VDD.n35 0.48697
R613 VDD.n16 VDD.n10 0.498569
R614 VDD.n17 VDD.n205 0.662147
R615 VDD.n228 VDD.n49 0.291571
R616 VDD.t0 VDD.n230 1.29141
R617 VDD.n1 VDD.t20 0.496458
R618 VDD.t0 VDD.n45 0.608151
R619 VDD.n45 VDD.t28 0.359111
R620 VDD.n13 VDD.t8 0.499356
R621 VDD.n13 VDD.t9 0.137361
R622 VDD.n20 VDD.n227 0.285322
R623 VDD.n52 VDD.n229 6.31594
R624 VDD.n231 VDD.n52 6.31494
R625 VDD.t0 VDD.t12 6.09901
R626 VDD.n151 VDD.t21 6.09901
R627 VDD.n130 VDD.t15 6.09901
R628 VDD.n131 VDD.t2 6.09901
R629 VDD.n132 VDD.t23 6.09901
R630 VDD.n150 VDD.t10 6.09901
R631 VDD.n133 VDD.t7 6.09901
R632 VDD.n134 VDD.t5 6.09901
R633 VDD.n149 VDD.t13 6.09901
R634 VDD.n135 VDD.t16 6.09901
R635 VDD.n148 VDD.t18 6.09901
R636 VDD.n147 VDD.t11 6.09901
R637 VDD.n146 VDD.t1 6.09901
R638 VDD.n136 VDD.t26 6.09901
R639 VDD.n145 VDD.t24 6.09901
R640 VDD.n137 VDD.t19 6.09901
R641 VDD.n144 VDD.t22 6.09901
R642 VDD.n143 VDD.t3 6.09901
R643 VDD.n138 VDD.t82 6.09901
R644 VDD.n139 VDD.t27 6.09901
R645 VDD.n142 VDD.t25 6.09901
R646 VDD.n140 VDD.t90 6.09901
R647 VDD.n141 VDD.t85 6.09901
R648 VDD.n20 VDD.t83 6.09901
R649 VDD.t0 VDD.n12 0.414998
R650 VDD.t0 VDD.n42 0.712649
R651 VDD.t0 VDD.n17 0.394948
R652 VDD.t0 VDD.n65 0.650826
R653 VDD.n68 VDD.n151 0.0882776
R654 VDD.t0 VDD.n68 1.5973
R655 VDD.n71 VDD.n130 0.0882776
R656 VDD.t0 VDD.n71 1.5973
R657 VDD.n74 VDD.n131 0.0882776
R658 VDD.t0 VDD.n74 1.5973
R659 VDD.n77 VDD.n132 0.0882776
R660 VDD.t0 VDD.n77 1.5973
R661 VDD.n80 VDD.n150 0.0882776
R662 VDD.t0 VDD.n80 1.5973
R663 VDD.n83 VDD.n133 0.0882776
R664 VDD.t0 VDD.n83 1.5973
R665 VDD.n86 VDD.n134 0.0882776
R666 VDD.t0 VDD.n86 1.5973
R667 VDD.n89 VDD.n149 0.0882776
R668 VDD.t0 VDD.n89 1.5973
R669 VDD.n92 VDD.n135 0.0882776
R670 VDD.t0 VDD.n92 1.5973
R671 VDD.n95 VDD.n148 0.0882776
R672 VDD.t0 VDD.n95 1.5973
R673 VDD.n98 VDD.n147 0.0882776
R674 VDD.t0 VDD.n98 1.5973
R675 VDD.n101 VDD.n146 0.0882776
R676 VDD.t0 VDD.n101 1.5973
R677 VDD.n104 VDD.n136 0.0882776
R678 VDD.t0 VDD.n104 1.5973
R679 VDD.n107 VDD.n145 0.0882776
R680 VDD.t0 VDD.n107 1.5973
R681 VDD.n110 VDD.n137 0.0882776
R682 VDD.t0 VDD.n110 1.5973
R683 VDD.n113 VDD.n144 0.0882776
R684 VDD.t0 VDD.n113 1.5973
R685 VDD.n116 VDD.n143 0.0882776
R686 VDD.t0 VDD.n116 1.5973
R687 VDD.n119 VDD.n138 0.0882776
R688 VDD.t0 VDD.n119 1.5973
R689 VDD.n122 VDD.n139 0.0882776
R690 VDD.t0 VDD.n122 1.5973
R691 VDD.n125 VDD.n142 0.0882776
R692 VDD.t0 VDD.n125 1.5973
R693 VDD.n128 VDD.n140 0.0882776
R694 VDD.t0 VDD.n128 1.5973
R695 VDD.n39 VDD.n141 0.25683
R696 VDD.t0 VDD.n39 0.71334
R697 VDD.n225 VDD.t38 5.60347
R698 VDD.n226 VDD.t35 5.60347
R699 VDD.n24 VDD.t46 5.59675
R700 VDD.n177 VDD.t53 5.59675
R701 VDD.n187 VDD.t52 5.59675
R702 VDD.n40 VDD.t51 5.59675
R703 VDD.n21 VDD.t50 5.59675
R704 VDD.n152 VDD.t49 5.59675
R705 VDD.n27 VDD.t48 5.59675
R706 VDD.n30 VDD.t47 5.59675
R707 VDD.n29 VDD.t62 5.59675
R708 VDD.n38 VDD.t65 5.59675
R709 VDD.n37 VDD.t64 5.59675
R710 VDD.n4 VDD.t63 5.59675
R711 VDD.n5 VDD.t68 5.59675
R712 VDD.n46 VDD.t69 5.59675
R713 VDD.n43 VDD.t67 5.59675
R714 VDD.n180 VDD.t66 5.59675
R715 VDD.n34 VDD.t70 5.59675
R716 VDD.n9 VDD.t73 5.59675
R717 VDD.n11 VDD.t72 5.59675
R718 VDD.n16 VDD.t45 5.59675
R719 VDD.n15 VDD.t75 5.59675
R720 VDD.n204 VDD.t74 5.59675
R721 VDD.n19 VDD.t71 5.59675
R722 VDD.n18 VDD.t34 5.59675
R723 VDD VDD.n255 4.16843
R724 VDD.n724 VDD 4.16808
R725 VDD.n230 VDD.n229 0.27313
R726 VDD.t0 VDD.n228 1.0646
R727 VDD.n6 VDD.n23 0.330482
R728 VDD.t17 VDD.n0 0.292623
R729 VDD.t20 VDD.n23 0.315074
R730 VDD.n8 VDD.n7 0.330507
R731 VDD.n7 VDD.t8 0.315025
R732 VDD.n695 VDD.n694 0.692362
R733 VDD.n699 VDD.n698 0.692362
R734 VDD.n701 VDD.n686 0.692362
R735 VDD.n683 VDD.n682 0.692362
R736 VDD.n679 VDD.n678 0.692362
R737 VDD.n675 VDD.n674 0.692362
R738 VDD.n671 VDD.n670 0.692362
R739 VDD.n667 VDD.n666 0.692362
R740 VDD.n663 VDD.n662 0.692362
R741 VDD.n659 VDD.n658 0.692362
R742 VDD.n655 VDD.n654 0.692362
R743 VDD.n651 VDD.n650 0.692362
R744 VDD.n647 VDD.n646 0.692362
R745 VDD.n643 VDD.n642 0.692362
R746 VDD.n639 VDD.n638 0.692362
R747 VDD.n635 VDD.n634 0.692362
R748 VDD.n631 VDD.n630 0.692362
R749 VDD.n627 VDD.n626 0.692362
R750 VDD.n623 VDD.n622 0.692362
R751 VDD.n619 VDD.n618 0.692362
R752 VDD.n615 VDD.n614 0.692362
R753 VDD.n611 VDD.n610 0.692362
R754 VDD.n607 VDD.n606 0.692362
R755 VDD.n603 VDD.n602 0.692362
R756 VDD.n599 VDD.n598 0.692362
R757 VDD.n595 VDD.n594 0.692362
R758 VDD.n591 VDD.n590 0.692362
R759 VDD.n587 VDD.n586 0.692362
R760 VDD.n583 VDD.n582 0.692362
R761 VDD.n579 VDD.n578 0.692362
R762 VDD.n575 VDD.n20 6.7288
R763 VDD.n25 VDD.n24 0.495398
R764 VDD.n178 VDD.n177 0.495398
R765 VDD.n188 VDD.n187 0.495398
R766 VDD.n41 VDD.n40 0.495398
R767 VDD.n22 VDD.n21 0.495398
R768 VDD.n26 VDD.n152 0.495398
R769 VDD.n28 VDD.n27 0.495398
R770 VDD.n31 VDD.n30 0.495398
R771 VDD.n31 VDD.n29 0.495398
R772 VDD.n2 VDD.n38 0.495398
R773 VDD.n2 VDD.n37 0.495398
R774 VDD.n5 VDD.n4 0.495398
R775 VDD.n44 VDD.n43 0.495398
R776 VDD.n181 VDD.n180 0.495398
R777 VDD.n35 VDD.n34 0.495398
R778 VDD.t0 VDD.n9 0.495398
R779 VDD.t0 VDD.n11 0.495398
R780 VDD.n16 VDD.n15 0.495398
R781 VDD.n205 VDD.n204 0.495398
R782 VDD.n19 VDD.n50 0.495398
R783 VDD.n18 VDD.n49 0.495398
R784 VDD.n24 VDD.n234 0.478641
R785 VDD.n177 VDD.n235 0.478641
R786 VDD.n187 VDD.n236 0.478641
R787 VDD.n40 VDD.n237 0.478641
R788 VDD.n21 VDD.n238 0.478641
R789 VDD.n152 VDD.n239 0.478641
R790 VDD.n27 VDD.n240 0.478641
R791 VDD.n30 VDD.n241 0.478641
R792 VDD.n29 VDD.n242 0.478641
R793 VDD.n38 VDD.n243 0.478641
R794 VDD.n37 VDD.n244 0.478641
R795 VDD.n4 VDD.n245 0.478641
R796 VDD.n46 VDD.n246 0.478641
R797 VDD.n43 VDD.n247 0.478641
R798 VDD.n180 VDD.n248 0.478641
R799 VDD.n34 VDD.n249 0.478641
R800 VDD.n9 VDD.n250 0.478641
R801 VDD.n11 VDD.n251 0.478641
R802 VDD.n15 VDD.n252 0.478641
R803 VDD.n204 VDD.n253 0.478641
R804 VDD.n20 VDD.n19 0.478641
R805 VDD.n20 VDD.n18 0.478641
R806 VDD.n226 VDD.n49 0.446112
R807 VDD.n228 VDD.n227 0.535684
R808 VDD.n227 VDD.n225 0.426806
R809 VDD.n227 VDD.n226 0.426806
R810 VDD.n231 VDD.t17 0.409807
R811 VDD.n0 VDD.n59 0.125133
R812 VDD.n723 VDD.n722 0.346431
R813 VDD.n691 VDD.n690 0.346431
R814 VDD.n181 VDD.n44 0.468716
R815 VDD.n178 VDD.n47 0.46712
R816 VDD.n50 VDD.n203 0.429703
R817 VDD.n173 VDD.n172 0.380849
R818 VDD.n41 VDD.n166 0.371398
R819 VDD.n253 VDD.n127 0.363056
R820 VDD.n225 VDD.n257 0.313353
R821 VDD.n68 VDD.n67 0.209865
R822 VDD.n80 VDD.n79 0.209865
R823 VDD.n89 VDD.n88 0.209865
R824 VDD.n95 VDD.n94 0.209865
R825 VDD.n98 VDD.n97 0.209865
R826 VDD.n101 VDD.n100 0.209865
R827 VDD.n107 VDD.n106 0.209865
R828 VDD.n113 VDD.n112 0.209865
R829 VDD.n116 VDD.n115 0.209865
R830 VDD.n125 VDD.n124 0.209865
R831 VDD.n128 VDD.n127 0.209865
R832 VDD.n122 VDD.n121 0.209865
R833 VDD.n119 VDD.n118 0.209865
R834 VDD.n110 VDD.n109 0.209865
R835 VDD.n104 VDD.n103 0.209865
R836 VDD.n92 VDD.n91 0.209865
R837 VDD.n86 VDD.n85 0.209865
R838 VDD.n83 VDD.n82 0.209865
R839 VDD.n77 VDD.n76 0.209865
R840 VDD.n74 VDD.n73 0.209865
R841 VDD.n71 VDD.n70 0.209865
R842 VDD.n174 VDD.n173 0.170735
R843 VDD.n205 VDD.n203 0.294103
R844 VDD.n22 VDD.n26 0.46184
R845 VDD.n257 VDD.n49 0.278994
R846 VDD.n252 VDD.n140 0.278939
R847 VDD.n33 VDD.n142 0.278939
R848 VDD.n251 VDD.n139 0.278939
R849 VDD.n250 VDD.n138 0.278939
R850 VDD.n249 VDD.n143 0.278939
R851 VDD.n247 VDD.n137 0.278939
R852 VDD.n3 VDD.n136 0.278939
R853 VDD.n245 VDD.n146 0.278939
R854 VDD.n244 VDD.n147 0.278939
R855 VDD.n242 VDD.n135 0.278939
R856 VDD.n241 VDD.n149 0.278939
R857 VDD.n238 VDD.n150 0.278939
R858 VDD.n237 VDD.n132 0.278939
R859 VDD.n236 VDD.n131 0.278939
R860 VDD.n234 VDD.n151 0.278939
R861 VDD.n253 VDD.n141 0.278939
R862 VDD.n248 VDD.n144 0.278939
R863 VDD.n246 VDD.n145 0.278939
R864 VDD.n243 VDD.n148 0.278939
R865 VDD.n240 VDD.n134 0.278939
R866 VDD.n239 VDD.n133 0.278939
R867 VDD.n235 VDD.n130 0.278939
R868 VDD.n188 VDD.n172 0.277981
R869 VDD.n181 VDD.n179 0.168125
R870 VDD.n724 VDD.n723 0.231121
R871 VDD.n722 VDD.n258 0.231121
R872 VDD.n718 VDD.n258 0.231121
R873 VDD.n718 VDD.n717 0.231121
R874 VDD.n717 VDD.n716 0.231121
R875 VDD.n716 VDD.n260 0.231121
R876 VDD.n712 VDD.n260 0.231121
R877 VDD.n712 VDD.n711 0.231121
R878 VDD.n711 VDD.n710 0.231121
R879 VDD.n710 VDD.n261 0.231121
R880 VDD.n706 VDD.n261 0.231121
R881 VDD.n706 VDD.n705 0.231121
R882 VDD.n705 VDD.n704 0.231121
R883 VDD.n704 VDD.n263 0.231121
R884 VDD.n363 VDD.n263 0.231121
R885 VDD.n366 VDD.n363 0.231121
R886 VDD.n367 VDD.n366 0.231121
R887 VDD.n368 VDD.n367 0.231121
R888 VDD.n368 VDD.n361 0.231121
R889 VDD.n372 VDD.n361 0.231121
R890 VDD.n373 VDD.n372 0.231121
R891 VDD.n374 VDD.n373 0.231121
R892 VDD.n374 VDD.n359 0.231121
R893 VDD.n378 VDD.n359 0.231121
R894 VDD.n379 VDD.n378 0.231121
R895 VDD.n380 VDD.n379 0.231121
R896 VDD.n380 VDD.n357 0.231121
R897 VDD.n384 VDD.n357 0.231121
R898 VDD.n385 VDD.n384 0.231121
R899 VDD.n386 VDD.n385 0.231121
R900 VDD.n386 VDD.n355 0.231121
R901 VDD.n390 VDD.n355 0.231121
R902 VDD.n391 VDD.n390 0.231121
R903 VDD.n392 VDD.n391 0.231121
R904 VDD.n392 VDD.n353 0.231121
R905 VDD.n396 VDD.n353 0.231121
R906 VDD.n397 VDD.n396 0.231121
R907 VDD.n398 VDD.n397 0.231121
R908 VDD.n398 VDD.n351 0.231121
R909 VDD.n402 VDD.n351 0.231121
R910 VDD.n403 VDD.n402 0.231121
R911 VDD.n404 VDD.n403 0.231121
R912 VDD.n404 VDD.n349 0.231121
R913 VDD.n408 VDD.n349 0.231121
R914 VDD.n409 VDD.n408 0.231121
R915 VDD.n410 VDD.n409 0.231121
R916 VDD.n410 VDD.n347 0.231121
R917 VDD.n414 VDD.n347 0.231121
R918 VDD.n415 VDD.n414 0.231121
R919 VDD.n416 VDD.n415 0.231121
R920 VDD.n416 VDD.n345 0.231121
R921 VDD.n420 VDD.n345 0.231121
R922 VDD.n421 VDD.n420 0.231121
R923 VDD.n422 VDD.n421 0.231121
R924 VDD.n422 VDD.n343 0.231121
R925 VDD.n426 VDD.n343 0.231121
R926 VDD.n427 VDD.n426 0.231121
R927 VDD.n428 VDD.n427 0.231121
R928 VDD.n428 VDD.n341 0.231121
R929 VDD.n432 VDD.n341 0.231121
R930 VDD.n433 VDD.n432 0.231121
R931 VDD.n434 VDD.n433 0.231121
R932 VDD.n434 VDD.n339 0.231121
R933 VDD.n438 VDD.n339 0.231121
R934 VDD.n439 VDD.n438 0.231121
R935 VDD.n440 VDD.n439 0.231121
R936 VDD.n440 VDD.n337 0.231121
R937 VDD.n444 VDD.n337 0.231121
R938 VDD.n445 VDD.n444 0.231121
R939 VDD.n446 VDD.n445 0.231121
R940 VDD.n446 VDD.n335 0.231121
R941 VDD.n450 VDD.n335 0.231121
R942 VDD.n451 VDD.n450 0.231121
R943 VDD.n452 VDD.n451 0.231121
R944 VDD.n452 VDD.n333 0.231121
R945 VDD.n456 VDD.n333 0.231121
R946 VDD.n457 VDD.n456 0.231121
R947 VDD.n458 VDD.n457 0.231121
R948 VDD.n458 VDD.n331 0.231121
R949 VDD.n462 VDD.n331 0.231121
R950 VDD.n463 VDD.n462 0.231121
R951 VDD.n464 VDD.n463 0.231121
R952 VDD.n464 VDD.n329 0.231121
R953 VDD.n468 VDD.n329 0.231121
R954 VDD.n469 VDD.n468 0.231121
R955 VDD.n470 VDD.n469 0.231121
R956 VDD.n470 VDD.n327 0.231121
R957 VDD.n474 VDD.n327 0.231121
R958 VDD.n475 VDD.n474 0.231121
R959 VDD.n476 VDD.n475 0.231121
R960 VDD.n476 VDD.n325 0.231121
R961 VDD.n480 VDD.n325 0.231121
R962 VDD.n481 VDD.n480 0.231121
R963 VDD.n482 VDD.n481 0.231121
R964 VDD.n482 VDD.n323 0.231121
R965 VDD.n486 VDD.n323 0.231121
R966 VDD.n487 VDD.n486 0.231121
R967 VDD.n488 VDD.n487 0.231121
R968 VDD.n488 VDD.n321 0.231121
R969 VDD.n492 VDD.n321 0.231121
R970 VDD.n493 VDD.n492 0.231121
R971 VDD.n494 VDD.n493 0.231121
R972 VDD.n494 VDD.n319 0.231121
R973 VDD.n498 VDD.n319 0.231121
R974 VDD.n499 VDD.n498 0.231121
R975 VDD.n500 VDD.n499 0.231121
R976 VDD.n500 VDD.n317 0.231121
R977 VDD.n504 VDD.n317 0.231121
R978 VDD.n505 VDD.n504 0.231121
R979 VDD.n506 VDD.n505 0.231121
R980 VDD.n506 VDD.n315 0.231121
R981 VDD.n510 VDD.n315 0.231121
R982 VDD.n511 VDD.n510 0.231121
R983 VDD.n512 VDD.n511 0.231121
R984 VDD.n512 VDD.n313 0.231121
R985 VDD.n516 VDD.n313 0.231121
R986 VDD.n517 VDD.n516 0.231121
R987 VDD.n518 VDD.n517 0.231121
R988 VDD.n518 VDD.n311 0.231121
R989 VDD.n522 VDD.n311 0.231121
R990 VDD.n523 VDD.n522 0.231121
R991 VDD.n524 VDD.n523 0.231121
R992 VDD.n524 VDD.n309 0.231121
R993 VDD.n528 VDD.n309 0.231121
R994 VDD.n529 VDD.n528 0.231121
R995 VDD.n530 VDD.n529 0.231121
R996 VDD.n530 VDD.n307 0.231121
R997 VDD.n534 VDD.n307 0.231121
R998 VDD.n535 VDD.n534 0.231121
R999 VDD.n536 VDD.n535 0.231121
R1000 VDD.n536 VDD.n305 0.231121
R1001 VDD.n540 VDD.n305 0.231121
R1002 VDD.n541 VDD.n540 0.231121
R1003 VDD.n542 VDD.n541 0.231121
R1004 VDD.n542 VDD.n303 0.231121
R1005 VDD.n546 VDD.n303 0.231121
R1006 VDD.n547 VDD.n546 0.231121
R1007 VDD.n548 VDD.n547 0.231121
R1008 VDD.n548 VDD.n301 0.231121
R1009 VDD.n552 VDD.n301 0.231121
R1010 VDD.n553 VDD.n552 0.231121
R1011 VDD.n554 VDD.n553 0.231121
R1012 VDD.n554 VDD.n299 0.231121
R1013 VDD.n558 VDD.n299 0.231121
R1014 VDD.n559 VDD.n558 0.231121
R1015 VDD.n560 VDD.n559 0.231121
R1016 VDD.n560 VDD.n297 0.231121
R1017 VDD.n564 VDD.n297 0.231121
R1018 VDD.n565 VDD.n564 0.231121
R1019 VDD.n566 VDD.n565 0.231121
R1020 VDD.n566 VDD.n295 0.231121
R1021 VDD.n570 VDD.n295 0.231121
R1022 VDD.n571 VDD.n570 0.231121
R1023 VDD.n572 VDD.n571 0.231121
R1024 VDD.n690 VDD.n255 0.231121
R1025 VDD.n691 VDD.n688 0.231121
R1026 VDD.n694 VDD.n688 0.231121
R1027 VDD.n695 VDD.n687 0.231121
R1028 VDD.n698 VDD.n687 0.231121
R1029 VDD.n700 VDD.n699 0.231121
R1030 VDD.n701 VDD.n700 0.231121
R1031 VDD.n686 VDD.n266 0.231121
R1032 VDD.n683 VDD.n266 0.231121
R1033 VDD.n682 VDD.n267 0.231121
R1034 VDD.n679 VDD.n267 0.231121
R1035 VDD.n678 VDD.n268 0.231121
R1036 VDD.n675 VDD.n268 0.231121
R1037 VDD.n674 VDD.n269 0.231121
R1038 VDD.n671 VDD.n269 0.231121
R1039 VDD.n670 VDD.n270 0.231121
R1040 VDD.n667 VDD.n270 0.231121
R1041 VDD.n666 VDD.n271 0.231121
R1042 VDD.n663 VDD.n271 0.231121
R1043 VDD.n662 VDD.n272 0.231121
R1044 VDD.n659 VDD.n272 0.231121
R1045 VDD.n658 VDD.n273 0.231121
R1046 VDD.n655 VDD.n273 0.231121
R1047 VDD.n654 VDD.n274 0.231121
R1048 VDD.n651 VDD.n274 0.231121
R1049 VDD.n650 VDD.n275 0.231121
R1050 VDD.n647 VDD.n275 0.231121
R1051 VDD.n646 VDD.n276 0.231121
R1052 VDD.n643 VDD.n276 0.231121
R1053 VDD.n642 VDD.n277 0.231121
R1054 VDD.n639 VDD.n277 0.231121
R1055 VDD.n638 VDD.n278 0.231121
R1056 VDD.n635 VDD.n278 0.231121
R1057 VDD.n634 VDD.n279 0.231121
R1058 VDD.n631 VDD.n279 0.231121
R1059 VDD.n630 VDD.n280 0.231121
R1060 VDD.n627 VDD.n280 0.231121
R1061 VDD.n626 VDD.n281 0.231121
R1062 VDD.n623 VDD.n281 0.231121
R1063 VDD.n622 VDD.n282 0.231121
R1064 VDD.n619 VDD.n282 0.231121
R1065 VDD.n618 VDD.n283 0.231121
R1066 VDD.n615 VDD.n283 0.231121
R1067 VDD.n614 VDD.n284 0.231121
R1068 VDD.n611 VDD.n284 0.231121
R1069 VDD.n610 VDD.n285 0.231121
R1070 VDD.n607 VDD.n285 0.231121
R1071 VDD.n606 VDD.n286 0.231121
R1072 VDD.n603 VDD.n286 0.231121
R1073 VDD.n602 VDD.n287 0.231121
R1074 VDD.n599 VDD.n287 0.231121
R1075 VDD.n598 VDD.n288 0.231121
R1076 VDD.n595 VDD.n288 0.231121
R1077 VDD.n594 VDD.n289 0.231121
R1078 VDD.n591 VDD.n289 0.231121
R1079 VDD.n590 VDD.n290 0.231121
R1080 VDD.n587 VDD.n290 0.231121
R1081 VDD.n586 VDD.n291 0.231121
R1082 VDD.n583 VDD.n291 0.231121
R1083 VDD.n582 VDD.n292 0.231121
R1084 VDD.n579 VDD.n292 0.231121
R1085 VDD.n578 VDD.n293 0.231121
R1086 VDD.n575 VDD.n293 0.231121
R1087 VDD.n578 VDD.n129 9.11485
R1088 VDD.n252 VDD.n124 0.363056
R1089 VDD.n577 VDD.n576 0.231121
R1090 VDD.n582 VDD.n126 9.11485
R1091 VDD.n33 VDD.n121 0.363056
R1092 VDD.n581 VDD.n580 0.231121
R1093 VDD.n586 VDD.n123 9.11485
R1094 VDD.n251 VDD.n118 0.363056
R1095 VDD.n585 VDD.n584 0.231121
R1096 VDD.n590 VDD.n120 9.11485
R1097 VDD.n250 VDD.n115 0.363056
R1098 VDD.n589 VDD.n588 0.231121
R1099 VDD.n594 VDD.n117 9.11485
R1100 VDD.n249 VDD.n112 0.363056
R1101 VDD.n593 VDD.n592 0.231121
R1102 VDD.n598 VDD.n114 9.11485
R1103 VDD.n248 VDD.n109 0.363056
R1104 VDD.n597 VDD.n596 0.231121
R1105 VDD.n602 VDD.n111 9.11485
R1106 VDD.n247 VDD.n106 0.363056
R1107 VDD.n601 VDD.n600 0.231121
R1108 VDD.n606 VDD.n108 9.11485
R1109 VDD.n246 VDD.n103 0.363056
R1110 VDD.n605 VDD.n604 0.231121
R1111 VDD.n610 VDD.n105 9.11485
R1112 VDD.n3 VDD.n100 0.363056
R1113 VDD.n609 VDD.n608 0.231121
R1114 VDD.n614 VDD.n102 9.11485
R1115 VDD.n245 VDD.n97 0.363056
R1116 VDD.n613 VDD.n612 0.231121
R1117 VDD.n618 VDD.n99 9.11485
R1118 VDD.n244 VDD.n94 0.363056
R1119 VDD.n617 VDD.n616 0.231121
R1120 VDD.n622 VDD.n96 9.11485
R1121 VDD.n243 VDD.n91 0.363056
R1122 VDD.n621 VDD.n620 0.231121
R1123 VDD.n626 VDD.n93 9.11485
R1124 VDD.n242 VDD.n88 0.363056
R1125 VDD.n625 VDD.n624 0.231121
R1126 VDD.n630 VDD.n90 9.11485
R1127 VDD.n241 VDD.n85 0.363056
R1128 VDD.n629 VDD.n628 0.231121
R1129 VDD.n634 VDD.n87 9.11485
R1130 VDD.n240 VDD.n82 0.363056
R1131 VDD.n633 VDD.n632 0.231121
R1132 VDD.n638 VDD.n84 9.11485
R1133 VDD.n239 VDD.n79 0.363056
R1134 VDD.n637 VDD.n636 0.231121
R1135 VDD.n642 VDD.n81 9.11485
R1136 VDD.n238 VDD.n76 0.363056
R1137 VDD.n641 VDD.n640 0.231121
R1138 VDD.n646 VDD.n78 9.11485
R1139 VDD.n237 VDD.n73 0.363056
R1140 VDD.n645 VDD.n644 0.231121
R1141 VDD.n650 VDD.n75 9.11485
R1142 VDD.n236 VDD.n70 0.363056
R1143 VDD.n649 VDD.n648 0.231121
R1144 VDD.n654 VDD.n72 9.11485
R1145 VDD.n235 VDD.n67 0.363056
R1146 VDD.n653 VDD.n652 0.231121
R1147 VDD.n658 VDD.n69 9.11485
R1148 VDD.n234 VDD.n65 0.363056
R1149 VDD.n657 VDD.n656 0.231121
R1150 VDD.n662 VDD.n66 9.11485
R1151 VDD.n661 VDD.n660 0.231121
R1152 VDD.n157 VDD.n665 0.114852
R1153 VDD.n665 VDD.n664 0.231121
R1154 VDD.n158 VDD.n669 0.114852
R1155 VDD.n669 VDD.n668 0.231121
R1156 VDD.n159 VDD.n673 0.114852
R1157 VDD.n673 VDD.n672 0.231121
R1158 VDD.n160 VDD.n677 0.114852
R1159 VDD.n677 VDD.n676 0.231121
R1160 VDD.n161 VDD.n681 0.114852
R1161 VDD.n681 VDD.n680 0.231121
R1162 VDD.n162 VDD.n685 0.114852
R1163 VDD.n685 VDD.n684 0.231121
R1164 VDD.n163 VDD.n265 0.114852
R1165 VDD.n702 VDD.n265 0.231121
R1166 VDD.n696 VDD.n164 0.114852
R1167 VDD.n697 VDD.n696 0.231121
R1168 VDD.n692 VDD.n64 0.114852
R1169 VDD.n693 VDD.n692 0.231121
R1170 VDD.n689 VDD.n256 0.231121
R1171 VDD.n725 VDD.n254 0.231121
R1172 VDD.n721 VDD.n720 0.231121
R1173 VDD.n720 VDD.n719 0.231121
R1174 VDD.n222 VDD.n259 0.114852
R1175 VDD.n715 VDD.n259 0.231121
R1176 VDD.n715 VDD.n714 0.231121
R1177 VDD.n714 VDD.n53 0.114852
R1178 VDD.n713 VDD.n233 0.231121
R1179 VDD.n709 VDD.n208 0.114852
R1180 VDD.n709 VDD.n708 0.231121
R1181 VDD.n708 VDD.n707 0.231121
R1182 VDD.n168 VDD.n262 0.114852
R1183 VDD.n703 VDD.n262 0.231121
R1184 VDD.n703 VDD.n182 0.114852
R1185 VDD.n364 VDD.n264 0.231121
R1186 VDD.n365 VDD.n58 0.114852
R1187 VDD.n365 VDD.n362 0.231121
R1188 VDD.n369 VDD.n156 0.114852
R1189 VDD.n370 VDD.n369 0.231121
R1190 VDD.n371 VDD.n370 0.231121
R1191 VDD.n56 VDD.n360 0.114852
R1192 VDD.n375 VDD.n360 0.231121
R1193 VDD.n376 VDD.n375 0.231121
R1194 VDD.n377 VDD.n221 0.114852
R1195 VDD.n377 VDD.n358 0.231121
R1196 VDD.n381 VDD.n169 0.114852
R1197 VDD.n382 VDD.n381 0.231121
R1198 VDD.n383 VDD.n382 0.231121
R1199 VDD.n383 VDD.n186 0.114852
R1200 VDD.n387 VDD.n356 0.231121
R1201 VDD.n55 VDD.n387 0.114852
R1202 VDD.n389 VDD.n388 0.231121
R1203 VDD.n389 VDD.n354 0.231121
R1204 VDD.n393 VDD.n200 0.114852
R1205 VDD.n394 VDD.n393 0.231121
R1206 VDD.n395 VDD.n394 0.231121
R1207 VDD.n198 VDD.n352 0.114852
R1208 VDD.n399 VDD.n352 0.231121
R1209 VDD.n400 VDD.n220 0.114852
R1210 VDD.n401 VDD.n400 0.231121
R1211 VDD.n57 VDD.n350 0.114852
R1212 VDD.n405 VDD.n350 0.231121
R1213 VDD.n406 VDD.n405 0.231121
R1214 VDD.n407 VDD.n207 0.114852
R1215 VDD.n407 VDD.n348 0.231121
R1216 VDD.n411 VDD.n348 0.231121
R1217 VDD.n54 VDD.n411 0.114852
R1218 VDD.n413 VDD.n412 0.231121
R1219 VDD.n219 VDD.n346 0.114852
R1220 VDD.n417 VDD.n346 0.231121
R1221 VDD.n418 VDD.n176 0.114852
R1222 VDD.n419 VDD.n418 0.231121
R1223 VDD.n419 VDD.n344 0.231121
R1224 VDD.n218 VDD.n344 0.114852
R1225 VDD.n424 VDD.n423 0.231121
R1226 VDD.n175 VDD.n424 0.114852
R1227 VDD.n425 VDD.n342 0.231121
R1228 VDD.n429 VDD.n342 0.231121
R1229 VDD.n189 VDD.n429 0.114852
R1230 VDD.n431 VDD.n430 0.231121
R1231 VDD.n431 VDD.n197 0.114852
R1232 VDD.n435 VDD.n340 0.231121
R1233 VDD.n436 VDD.n435 0.231121
R1234 VDD.n217 VDD.n436 0.114852
R1235 VDD.n437 VDD.n338 0.231121
R1236 VDD.n441 VDD.n167 0.114852
R1237 VDD.n442 VDD.n441 0.231121
R1238 VDD.n443 VDD.n442 0.231121
R1239 VDD.n201 VDD.n336 0.114852
R1240 VDD.n447 VDD.n336 0.231121
R1241 VDD.n448 VDD.n447 0.231121
R1242 VDD.n193 VDD.n448 0.114852
R1243 VDD.n449 VDD.n334 0.231121
R1244 VDD.n453 VDD.n153 0.114852
R1245 VDD.n454 VDD.n453 0.231121
R1246 VDD.n455 VDD.n192 0.114852
R1247 VDD.n455 VDD.n332 0.231121
R1248 VDD.n459 VDD.n332 0.231121
R1249 VDD.n224 VDD.n459 0.114852
R1250 VDD.n461 VDD.n460 0.231121
R1251 VDD.n461 VDD.n330 0.231121
R1252 VDD.n465 VDD.n196 0.114852
R1253 VDD.n466 VDD.n465 0.231121
R1254 VDD.n467 VDD.n216 0.114852
R1255 VDD.n467 VDD.n328 0.231121
R1256 VDD.n471 VDD.n328 0.231121
R1257 VDD.n472 VDD.n155 0.114852
R1258 VDD.n473 VDD.n472 0.231121
R1259 VDD.n184 VDD.n326 0.114852
R1260 VDD.n477 VDD.n326 0.231121
R1261 VDD.n478 VDD.n477 0.231121
R1262 VDD.n479 VDD.n199 0.114852
R1263 VDD.n479 VDD.n324 0.231121
R1264 VDD.n483 VDD.n206 0.114852
R1265 VDD.n484 VDD.n483 0.231121
R1266 VDD.n485 VDD.n484 0.231121
R1267 VDD.n60 VDD.n322 0.114852
R1268 VDD.n489 VDD.n322 0.231121
R1269 VDD.n190 VDD.n489 0.114852
R1270 VDD.n491 VDD.n490 0.231121
R1271 VDD.n491 VDD.n195 0.114852
R1272 VDD.n495 VDD.n320 0.231121
R1273 VDD.n496 VDD.n495 0.231121
R1274 VDD.n215 VDD.n496 0.114852
R1275 VDD.n497 VDD.n318 0.231121
R1276 VDD.n501 VDD.n165 0.114852
R1277 VDD.n502 VDD.n501 0.231121
R1278 VDD.n503 VDD.n502 0.231121
R1279 VDD.n214 VDD.n316 0.114852
R1280 VDD.n507 VDD.n316 0.231121
R1281 VDD.n508 VDD.n507 0.231121
R1282 VDD.n61 VDD.n508 0.114852
R1283 VDD.n509 VDD.n314 0.231121
R1284 VDD.n513 VDD.n223 0.114852
R1285 VDD.n514 VDD.n513 0.231121
R1286 VDD.n515 VDD.n514 0.231121
R1287 VDD.n191 VDD.n312 0.114852
R1288 VDD.n519 VDD.n312 0.231121
R1289 VDD.n520 VDD.n213 0.114852
R1290 VDD.n521 VDD.n520 0.231121
R1291 VDD.n170 VDD.n310 0.114852
R1292 VDD.n525 VDD.n310 0.231121
R1293 VDD.n526 VDD.n525 0.231121
R1294 VDD.n212 VDD.n526 0.114852
R1295 VDD.n527 VDD.n308 0.231121
R1296 VDD.n531 VDD.n308 0.231121
R1297 VDD.n532 VDD.n36 0.114852
R1298 VDD.n533 VDD.n532 0.231121
R1299 VDD.n202 VDD.n306 0.114852
R1300 VDD.n537 VDD.n306 0.231121
R1301 VDD.n538 VDD.n537 0.231121
R1302 VDD.n539 VDD.n194 0.114852
R1303 VDD.n539 VDD.n304 0.231121
R1304 VDD.n543 VDD.n185 0.114852
R1305 VDD.n544 VDD.n543 0.231121
R1306 VDD.n545 VDD.n544 0.231121
R1307 VDD.n62 VDD.n302 0.114852
R1308 VDD.n549 VDD.n302 0.231121
R1309 VDD.n550 VDD.n183 0.114852
R1310 VDD.n551 VDD.n550 0.231121
R1311 VDD.n551 VDD.n154 0.114852
R1312 VDD.n555 VDD.n300 0.231121
R1313 VDD.n556 VDD.n555 0.231121
R1314 VDD.n557 VDD.n211 0.114852
R1315 VDD.n557 VDD.n298 0.231121
R1316 VDD.n561 VDD.n298 0.231121
R1317 VDD.n63 VDD.n561 0.114852
R1318 VDD.n563 VDD.n562 0.231121
R1319 VDD.n210 VDD.n296 0.114852
R1320 VDD.n567 VDD.n296 0.231121
R1321 VDD.n568 VDD.n171 0.114852
R1322 VDD.n569 VDD.n568 0.231121
R1323 VDD.n569 VDD.n294 0.231121
R1324 VDD.n209 VDD.n294 0.114852
R1325 VDD.n574 VDD.n573 0.231121
R1326 VDD.n50 VDD.n48 1.90713
R1327 VDD.n572 VDD.n48 1.97919
R1328 VDD VDD.n52 3.09434
R1329 VDD VDD.n52 2.93359
R1330 VDD.n5 VDD.n3 1.35578
R1331 VDD.t0 VDD.n6 1.28518
R1332 VDD.n16 VDD.n33 1.26091
R1333 VDD.n32 VDD.n5 1.20344
R1334 VDD.n229 VDD.t17 1.15938
R1335 VDD.t0 VDD.n31 0.413776
R1336 VDD.t0 VDD.n32 0.456987
R1337 VDD.n12 VDD.n51 0.13495
R1338 VDD.n8 VDD.n6 1.1341
R1339 VDD.n17 VDD.n16 0.282544
R1340 VDD.n22 VDD.n166 1.11301
R1341 VDD.n5 VDD.n46 1.10515
R1342 VDD.n13 VDD.t0 1.09124
R1343 VDD.t0 VDD.n2 1.07042
R1344 VDD.n8 VDD.n12 1.02523
R1345 VDD.n39 VDD.n20 1.00962
R1346 VDD.n232 VDD.n35 0.992938
R1347 VDD.n5 VDD.n2 0.985153
R1348 VDD.n50 VDD.n49 0.976447
R1349 VDD.n28 VDD.n26 0.963295
R1350 VDD.n42 VDD.n188 0.428414
R1351 VDD.n59 VDD.n6 0.943878
R1352 VDD.n25 VDD.n14 0.0765708
R1353 VDD.n23 VDD.t14 0.315074
R1354 VDD.t14 VDD.n45 0.359111
R1355 VDD.t17 VDD.n1 0.141905
R1356 VDD.t28 VDD.n7 0.315025
R1357 VDD.t0 VDD.n10 0.906377
R1358 VDD.n14 VDD.t0 0.336264
R1359 VDD.n720 VDD.n0 9.17835
R1360 VSS.t156 VSS.n25 108.746
R1361 VSS.n357 VSS.t186 108.746
R1362 VSS.t192 VSS.n70 108.746
R1363 VSS.t194 VSS.n343 108.746
R1364 VSS.t202 VSS.n83 108.746
R1365 VSS.n333 VSS.t158 108.746
R1366 VSS.t166 VSS.n11 108.746
R1367 VSS.t168 VSS.n372 108.746
R1368 VSS.t162 VSS.n18 108.746
R1369 VSS.n368 VSS.t160 108.746
R1370 VSS.n363 VSS.t170 108.746
R1371 VSS.n164 VSS.t172 108.746
R1372 VSS.n177 VSS.t174 108.746
R1373 VSS.t184 VSS.n355 108.746
R1374 VSS.t182 VSS.n50 108.746
R1375 VSS.t180 VSS.n353 108.746
R1376 VSS.t178 VSS.n57 108.746
R1377 VSS.n350 VSS.t176 108.746
R1378 VSS.n229 VSS.t188 108.746
R1379 VSS.t200 VSS.n341 108.746
R1380 VSS.t198 VSS.n336 108.746
R1381 VSS.n335 VSS.t196 108.746
R1382 VSS.n291 VSS.t154 108.746
R1383 VSS.t150 VSS.n330 108.746
R1384 VSS.t148 VSS.n327 108.746
R1385 VSS.t146 VSS.n108 108.746
R1386 VSS.t204 VSS.n325 108.746
R1387 VSS.t144 VSS.n170 108.746
R1388 VSS.n222 VSS.t164 108.746
R1389 VSS.t152 VSS.n365 108.746
R1390 VSS.n346 VSS.t142 108.746
R1391 VSS.n334 VSS.t190 108.746
R1392 VSS.n371 VSS.t46 106.056
R1393 VSS.n364 VSS.t70 106.056
R1394 VSS.n361 VSS.t59 106.056
R1395 VSS.n359 VSS.t71 106.056
R1396 VSS.n358 VSS.t47 106.056
R1397 VSS.n349 VSS.t73 106.056
R1398 VSS.n348 VSS.t58 106.056
R1399 VSS.n340 VSS.t94 106.056
R1400 VSS.n332 VSS.t95 106.056
R1401 VSS.n329 VSS.t98 106.056
R1402 VSS.n1050 VSS.t87 106.056
R1403 VSS.t78 VSS.n125 106.056
R1404 VSS.n369 VSS.t26 106.056
R1405 VSS.t79 VSS.n142 106.056
R1406 VSS.t40 VSS.n148 106.056
R1407 VSS.n362 VSS.t50 106.056
R1408 VSS.t27 VSS.n186 106.056
R1409 VSS.t0 VSS.n192 106.056
R1410 VSS.t41 VSS.n199 106.056
R1411 VSS.n352 VSS.t72 106.056
R1412 VSS.t51 VSS.n210 106.056
R1413 VSS.t60 VSS.n217 106.056
R1414 VSS.n347 VSS.t39 106.056
R1415 VSS.n345 VSS.t6 106.056
R1416 VSS.t34 VSS.n249 106.056
R1417 VSS.n338 VSS.t18 106.056
R1418 VSS.t13 VSS.n265 106.056
R1419 VSS.t25 VSS.n272 106.056
R1420 VSS.t3 VSS.n279 106.056
R1421 VSS.t69 VSS.n286 106.056
R1422 VSS.t105 VSS.n304 106.056
R1423 VSS.t102 VSS.n311 106.056
R1424 VSS.t113 VSS.t116 99.7537
R1425 VSS.t86 VSS.n124 94.1709
R1426 VSS.t85 VSS.n130 94.1709
R1427 VSS.t84 VSS.n135 94.1709
R1428 VSS.t83 VSS.n141 94.1709
R1429 VSS.t82 VSS.n147 94.1709
R1430 VSS.t88 VSS.n153 94.1709
R1431 VSS.t107 VSS.n159 94.1709
R1432 VSS.t106 VSS.n166 94.1709
R1433 VSS.t93 VSS.n172 94.1709
R1434 VSS.t92 VSS.n179 94.1709
R1435 VSS.t91 VSS.n185 94.1709
R1436 VSS.t90 VSS.n191 94.1709
R1437 VSS.t89 VSS.n198 94.1709
R1438 VSS.t126 VSS.n204 94.1709
R1439 VSS.t109 VSS.n209 94.1709
R1440 VSS.t127 VSS.n216 94.1709
R1441 VSS.t134 VSS.n224 94.1709
R1442 VSS.t130 VSS.n231 94.1709
R1443 VSS.t108 VSS.n237 94.1709
R1444 VSS.t129 VSS.n243 94.1709
R1445 VSS.t128 VSS.n248 94.1709
R1446 VSS.t137 VSS.n254 94.1709
R1447 VSS.t132 VSS.n259 94.1709
R1448 VSS.t139 VSS.n264 94.1709
R1449 VSS.t141 VSS.n271 94.1709
R1450 VSS.t136 VSS.n278 94.1709
R1451 VSS.t135 VSS.n285 94.1709
R1452 VSS.t133 VSS.n293 94.1709
R1453 VSS.t138 VSS.n298 94.1709
R1454 VSS.t140 VSS.n303 94.1709
R1455 VSS.t131 VSS.n310 94.1709
R1456 VSS.t101 VSS.n316 94.1709
R1457 VSS.n365 VSS.t21 67.0429
R1458 VSS.n346 VSS.t28 67.0429
R1459 VSS.n334 VSS.t7 67.0429
R1460 VSS.n372 VSS.t54 67.0426
R1461 VSS.n368 VSS.t80 67.0426
R1462 VSS.n363 VSS.t14 67.0426
R1463 VSS.t9 VSS.n164 67.0426
R1464 VSS.t56 VSS.n177 67.0426
R1465 VSS.n357 VSS.t37 67.0426
R1466 VSS.n355 VSS.t4 67.0426
R1467 VSS.n353 VSS.t23 67.0426
R1468 VSS.n350 VSS.t11 67.0426
R1469 VSS.t42 VSS.n229 67.0426
R1470 VSS.n343 VSS.t1 67.0426
R1471 VSS.n341 VSS.t74 67.0426
R1472 VSS.n336 VSS.t52 67.0426
R1473 VSS.n335 VSS.t61 67.0426
R1474 VSS.n333 VSS.t96 67.0426
R1475 VSS.t76 VSS.n291 67.0426
R1476 VSS.n330 VSS.t67 67.0426
R1477 VSS.n327 VSS.t110 67.0426
R1478 VSS.n325 VSS.t99 67.0426
R1479 VSS.t44 VSS.n11 67.0426
R1480 VSS.t35 VSS.n18 67.0426
R1481 VSS.t19 VSS.n25 67.0426
R1482 VSS.t63 VSS.n50 67.0426
R1483 VSS.t16 VSS.n57 67.0426
R1484 VSS.t48 VSS.n70 67.0426
R1485 VSS.t65 VSS.n83 67.0426
R1486 VSS.t103 VSS.n108 67.0426
R1487 VSS.t30 VSS.n170 67.042
R1488 VSS.t32 VSS.n222 67.042
R1489 VSS.t124 VSS.n320 62.447
R1490 VSS.t120 VSS.n320 59.7557
R1491 VSS.n324 VSS.t120 57.6672
R1492 VSS.n124 VSS.t44 43.0498
R1493 VSS.t54 VSS.n130 43.0498
R1494 VSS.n135 VSS.t35 43.0498
R1495 VSS.t80 VSS.n141 43.0498
R1496 VSS.n147 VSS.t19 43.0498
R1497 VSS.t21 VSS.n153 43.0498
R1498 VSS.t14 VSS.n159 43.0498
R1499 VSS.n166 VSS.t9 43.0498
R1500 VSS.n172 VSS.t30 43.0498
R1501 VSS.n179 VSS.t56 43.0498
R1502 VSS.t37 VSS.n185 43.0498
R1503 VSS.t4 VSS.n191 43.0498
R1504 VSS.n198 VSS.t63 43.0498
R1505 VSS.t23 VSS.n204 43.0498
R1506 VSS.n209 VSS.t16 43.0498
R1507 VSS.t11 VSS.n216 43.0498
R1508 VSS.n224 VSS.t32 43.0498
R1509 VSS.n231 VSS.t42 43.0498
R1510 VSS.n237 VSS.t48 43.0498
R1511 VSS.t28 VSS.n243 43.0498
R1512 VSS.t1 VSS.n248 43.0498
R1513 VSS.t74 VSS.n254 43.0498
R1514 VSS.n259 VSS.t65 43.0498
R1515 VSS.t52 VSS.n264 43.0498
R1516 VSS.t61 VSS.n271 43.0498
R1517 VSS.t7 VSS.n278 43.0498
R1518 VSS.t96 VSS.n285 43.0498
R1519 VSS.n293 VSS.t76 43.0498
R1520 VSS.t67 VSS.n298 43.0498
R1521 VSS.t110 VSS.n303 43.0498
R1522 VSS.n310 VSS.t103 43.0498
R1523 VSS.t99 VSS.n316 43.0498
R1524 VSS.n740 VSS.n739 18.4617
R1525 VSS.n1053 VSS.n1052 18.0005
R1526 VSS.n7 VSS.n1051 17.0005
R1527 VSS.n1051 VSS.n1049 17.0005
R1528 VSS.n1051 VSS.n117 17.0005
R1529 VSS.n1051 VSS.n8 17.0005
R1530 VSS.n1051 VSS.n116 17.0005
R1531 VSS.n324 VSS.t101 15.9618
R1532 VSS.n125 VSS.t86 15.9213
R1533 VSS.n369 VSS.t84 15.9213
R1534 VSS.n142 VSS.t83 15.9213
R1535 VSS.n148 VSS.t82 15.9213
R1536 VSS.n362 VSS.t107 15.9213
R1537 VSS.n186 VSS.t91 15.9213
R1538 VSS.n192 VSS.t90 15.9213
R1539 VSS.n199 VSS.t89 15.9213
R1540 VSS.n352 VSS.t126 15.9213
R1541 VSS.n210 VSS.t109 15.9213
R1542 VSS.n217 VSS.t127 15.9213
R1543 VSS.n347 VSS.t108 15.9213
R1544 VSS.n345 VSS.t129 15.9213
R1545 VSS.n249 VSS.t128 15.9213
R1546 VSS.n338 VSS.t132 15.9213
R1547 VSS.n265 VSS.t139 15.9213
R1548 VSS.n272 VSS.t141 15.9213
R1549 VSS.n279 VSS.t136 15.9213
R1550 VSS.n286 VSS.t135 15.9213
R1551 VSS.n304 VSS.t140 15.9213
R1552 VSS.n311 VSS.t131 15.9213
R1553 VSS.n371 VSS.t85 15.9203
R1554 VSS.n364 VSS.t88 15.9203
R1555 VSS.n361 VSS.t106 15.9203
R1556 VSS.n359 VSS.t93 15.9203
R1557 VSS.n358 VSS.t92 15.9203
R1558 VSS.n349 VSS.t134 15.9203
R1559 VSS.n348 VSS.t130 15.9203
R1560 VSS.n340 VSS.t137 15.9203
R1561 VSS.n332 VSS.t133 15.9203
R1562 VSS.n329 VSS.t138 15.9203
R1563 VSS.t116 VSS.n1050 13.2307
R1564 VSS.n373 VSS.t78 11.8854
R1565 VSS.t46 VSS.n370 11.8854
R1566 VSS.n367 VSS.t79 11.8854
R1567 VSS.n366 VSS.t40 11.8854
R1568 VSS.t70 VSS.n155 11.8854
R1569 VSS.t50 VSS.n161 11.8854
R1570 VSS.t59 VSS.n360 11.8854
R1571 VSS.t71 VSS.n174 11.8854
R1572 VSS.t47 VSS.n181 11.8854
R1573 VSS.n356 VSS.t27 11.8854
R1574 VSS.n194 VSS.t0 11.8854
R1575 VSS.n354 VSS.t41 11.8854
R1576 VSS.t72 VSS.n351 11.8854
R1577 VSS.n212 VSS.t51 11.8854
R1578 VSS.n219 VSS.t60 11.8854
R1579 VSS.t58 VSS.n233 11.8854
R1580 VSS.t39 VSS.n239 11.8854
R1581 VSS.t6 VSS.n344 11.8854
R1582 VSS.n342 VSS.t34 11.8854
R1583 VSS.t94 VSS.n339 11.8854
R1584 VSS.t18 VSS.n337 11.8854
R1585 VSS.n267 VSS.t13 11.8854
R1586 VSS.n288 VSS.t69 11.8854
R1587 VSS.t95 VSS.n331 11.8854
R1588 VSS.t98 VSS.n328 11.8854
R1589 VSS.n326 VSS.t102 11.8854
R1590 VSS.t87 VSS.n120 11.8844
R1591 VSS.t26 VSS.n137 11.8844
R1592 VSS.t73 VSS.n226 11.8844
R1593 VSS.n274 VSS.t25 11.8844
R1594 VSS.n281 VSS.t3 11.8844
R1595 VSS.n306 VSS.t105 11.8844
R1596 VSS.n120 VSS.t166 9.19536
R1597 VSS.t160 VSS.n137 9.19536
R1598 VSS.t188 VSS.n226 9.19536
R1599 VSS.t190 VSS.n274 9.19536
R1600 VSS.t158 VSS.n281 9.19536
R1601 VSS.n306 VSS.t146 9.19536
R1602 VSS.n373 VSS.t168 9.19506
R1603 VSS.n370 VSS.t162 9.19506
R1604 VSS.n367 VSS.t156 9.19506
R1605 VSS.n366 VSS.t152 9.19506
R1606 VSS.t170 VSS.n155 9.19506
R1607 VSS.t172 VSS.n161 9.19506
R1608 VSS.n360 VSS.t144 9.19506
R1609 VSS.t174 VSS.n174 9.19506
R1610 VSS.t186 VSS.n181 9.19506
R1611 VSS.n356 VSS.t184 9.19506
R1612 VSS.n194 VSS.t182 9.19506
R1613 VSS.n354 VSS.t180 9.19506
R1614 VSS.n351 VSS.t178 9.19506
R1615 VSS.t176 VSS.n212 9.19506
R1616 VSS.t164 VSS.n219 9.19506
R1617 VSS.n233 VSS.t192 9.19506
R1618 VSS.t142 VSS.n239 9.19506
R1619 VSS.n344 VSS.t194 9.19506
R1620 VSS.n342 VSS.t200 9.19506
R1621 VSS.n339 VSS.t202 9.19506
R1622 VSS.n337 VSS.t198 9.19506
R1623 VSS.t196 VSS.n267 9.19506
R1624 VSS.t154 VSS.n288 9.19506
R1625 VSS.n331 VSS.t150 9.19506
R1626 VSS.n328 VSS.t148 9.19506
R1627 VSS.n326 VSS.t204 9.19506
R1628 VSS.n115 VSS.n735 9.11631
R1629 VSS.n1013 VSS.n4 9.0005
R1630 VSS.n1014 VSS.n1010 9.0005
R1631 VSS.n1018 VSS.n1017 9.0005
R1632 VSS.n1022 VSS.n1019 9.0005
R1633 VSS.n1027 VSS.n1026 9.0005
R1634 VSS.n1024 VSS.n1023 9.0005
R1635 VSS.n1025 VSS.n381 9.0005
R1636 VSS.n1009 VSS.n1008 9.0005
R1637 VSS.n1001 VSS.n383 9.0005
R1638 VSS.n1006 VSS.n382 9.0005
R1639 VSS.n1004 VSS.n1002 9.0005
R1640 VSS.n1000 VSS.n999 9.0005
R1641 VSS.n992 VSS.n385 9.0005
R1642 VSS.n997 VSS.n384 9.0005
R1643 VSS.n995 VSS.n993 9.0005
R1644 VSS.n991 VSS.n990 9.0005
R1645 VSS.n983 VSS.n387 9.0005
R1646 VSS.n988 VSS.n386 9.0005
R1647 VSS.n986 VSS.n984 9.0005
R1648 VSS.n982 VSS.n981 9.0005
R1649 VSS.n974 VSS.n389 9.0005
R1650 VSS.n979 VSS.n388 9.0005
R1651 VSS.n977 VSS.n975 9.0005
R1652 VSS.n973 VSS.n972 9.0005
R1653 VSS.n965 VSS.n391 9.0005
R1654 VSS.n970 VSS.n390 9.0005
R1655 VSS.n968 VSS.n966 9.0005
R1656 VSS.n964 VSS.n963 9.0005
R1657 VSS.n956 VSS.n393 9.0005
R1658 VSS.n961 VSS.n392 9.0005
R1659 VSS.n959 VSS.n957 9.0005
R1660 VSS.n955 VSS.n954 9.0005
R1661 VSS.n947 VSS.n395 9.0005
R1662 VSS.n952 VSS.n394 9.0005
R1663 VSS.n950 VSS.n948 9.0005
R1664 VSS.n946 VSS.n945 9.0005
R1665 VSS.n938 VSS.n397 9.0005
R1666 VSS.n943 VSS.n396 9.0005
R1667 VSS.n941 VSS.n939 9.0005
R1668 VSS.n937 VSS.n936 9.0005
R1669 VSS.n929 VSS.n399 9.0005
R1670 VSS.n934 VSS.n398 9.0005
R1671 VSS.n932 VSS.n930 9.0005
R1672 VSS.n928 VSS.n927 9.0005
R1673 VSS.n920 VSS.n401 9.0005
R1674 VSS.n925 VSS.n400 9.0005
R1675 VSS.n923 VSS.n921 9.0005
R1676 VSS.n919 VSS.n918 9.0005
R1677 VSS.n911 VSS.n403 9.0005
R1678 VSS.n916 VSS.n402 9.0005
R1679 VSS.n914 VSS.n912 9.0005
R1680 VSS.n910 VSS.n909 9.0005
R1681 VSS.n902 VSS.n405 9.0005
R1682 VSS.n907 VSS.n404 9.0005
R1683 VSS.n905 VSS.n903 9.0005
R1684 VSS.n901 VSS.n900 9.0005
R1685 VSS.n893 VSS.n407 9.0005
R1686 VSS.n898 VSS.n406 9.0005
R1687 VSS.n896 VSS.n894 9.0005
R1688 VSS.n892 VSS.n891 9.0005
R1689 VSS.n884 VSS.n409 9.0005
R1690 VSS.n889 VSS.n408 9.0005
R1691 VSS.n887 VSS.n885 9.0005
R1692 VSS.n883 VSS.n882 9.0005
R1693 VSS.n875 VSS.n411 9.0005
R1694 VSS.n880 VSS.n410 9.0005
R1695 VSS.n878 VSS.n876 9.0005
R1696 VSS.n874 VSS.n873 9.0005
R1697 VSS.n866 VSS.n413 9.0005
R1698 VSS.n871 VSS.n412 9.0005
R1699 VSS.n869 VSS.n867 9.0005
R1700 VSS.n865 VSS.n864 9.0005
R1701 VSS.n857 VSS.n415 9.0005
R1702 VSS.n862 VSS.n414 9.0005
R1703 VSS.n860 VSS.n858 9.0005
R1704 VSS.n856 VSS.n855 9.0005
R1705 VSS.n848 VSS.n417 9.0005
R1706 VSS.n853 VSS.n416 9.0005
R1707 VSS.n851 VSS.n849 9.0005
R1708 VSS.n847 VSS.n846 9.0005
R1709 VSS.n839 VSS.n419 9.0005
R1710 VSS.n844 VSS.n418 9.0005
R1711 VSS.n842 VSS.n840 9.0005
R1712 VSS.n838 VSS.n837 9.0005
R1713 VSS.n830 VSS.n421 9.0005
R1714 VSS.n835 VSS.n420 9.0005
R1715 VSS.n833 VSS.n831 9.0005
R1716 VSS.n829 VSS.n828 9.0005
R1717 VSS.n821 VSS.n423 9.0005
R1718 VSS.n826 VSS.n422 9.0005
R1719 VSS.n824 VSS.n822 9.0005
R1720 VSS.n820 VSS.n819 9.0005
R1721 VSS.n812 VSS.n425 9.0005
R1722 VSS.n817 VSS.n424 9.0005
R1723 VSS.n815 VSS.n813 9.0005
R1724 VSS.n811 VSS.n810 9.0005
R1725 VSS.n803 VSS.n427 9.0005
R1726 VSS.n808 VSS.n426 9.0005
R1727 VSS.n806 VSS.n804 9.0005
R1728 VSS.n802 VSS.n801 9.0005
R1729 VSS.n794 VSS.n429 9.0005
R1730 VSS.n799 VSS.n428 9.0005
R1731 VSS.n797 VSS.n795 9.0005
R1732 VSS.n793 VSS.n792 9.0005
R1733 VSS.n785 VSS.n431 9.0005
R1734 VSS.n790 VSS.n430 9.0005
R1735 VSS.n788 VSS.n786 9.0005
R1736 VSS.n784 VSS.n783 9.0005
R1737 VSS.n776 VSS.n433 9.0005
R1738 VSS.n781 VSS.n432 9.0005
R1739 VSS.n779 VSS.n777 9.0005
R1740 VSS.n775 VSS.n774 9.0005
R1741 VSS.n767 VSS.n435 9.0005
R1742 VSS.n772 VSS.n434 9.0005
R1743 VSS.n770 VSS.n768 9.0005
R1744 VSS.n766 VSS.n765 9.0005
R1745 VSS.n758 VSS.n437 9.0005
R1746 VSS.n763 VSS.n436 9.0005
R1747 VSS.n761 VSS.n759 9.0005
R1748 VSS.n757 VSS.n756 9.0005
R1749 VSS.n749 VSS.n439 9.0005
R1750 VSS.n754 VSS.n438 9.0005
R1751 VSS.n752 VSS.n750 9.0005
R1752 VSS.n748 VSS.n747 9.0005
R1753 VSS.n740 VSS.n738 9.0005
R1754 VSS.n745 VSS.n440 9.0005
R1755 VSS.n743 VSS.n741 9.0005
R1756 VSS.n1013 VSS.n1012 9.0005
R1757 VSS.n1014 VSS.n1011 9.0005
R1758 VSS.n1017 VSS.n1016 9.0005
R1759 VSS.n1022 VSS.n1021 9.0005
R1760 VSS.n1028 VSS.n1027 9.0005
R1761 VSS.n1008 VSS.n1007 9.0005
R1762 VSS.n514 VSS.n383 9.0005
R1763 VSS.n999 VSS.n998 9.0005
R1764 VSS.n527 VSS.n385 9.0005
R1765 VSS.n990 VSS.n989 9.0005
R1766 VSS.n509 VSS.n387 9.0005
R1767 VSS.n981 VSS.n980 9.0005
R1768 VSS.n542 VSS.n389 9.0005
R1769 VSS.n972 VSS.n971 9.0005
R1770 VSS.n504 VSS.n391 9.0005
R1771 VSS.n963 VSS.n962 9.0005
R1772 VSS.n557 VSS.n393 9.0005
R1773 VSS.n954 VSS.n953 9.0005
R1774 VSS.n499 VSS.n395 9.0005
R1775 VSS.n945 VSS.n944 9.0005
R1776 VSS.n572 VSS.n397 9.0005
R1777 VSS.n936 VSS.n935 9.0005
R1778 VSS.n494 VSS.n399 9.0005
R1779 VSS.n927 VSS.n926 9.0005
R1780 VSS.n587 VSS.n401 9.0005
R1781 VSS.n918 VSS.n917 9.0005
R1782 VSS.n489 VSS.n403 9.0005
R1783 VSS.n909 VSS.n908 9.0005
R1784 VSS.n602 VSS.n405 9.0005
R1785 VSS.n900 VSS.n899 9.0005
R1786 VSS.n484 VSS.n407 9.0005
R1787 VSS.n891 VSS.n890 9.0005
R1788 VSS.n617 VSS.n409 9.0005
R1789 VSS.n882 VSS.n881 9.0005
R1790 VSS.n479 VSS.n411 9.0005
R1791 VSS.n873 VSS.n872 9.0005
R1792 VSS.n632 VSS.n413 9.0005
R1793 VSS.n864 VSS.n863 9.0005
R1794 VSS.n474 VSS.n415 9.0005
R1795 VSS.n855 VSS.n854 9.0005
R1796 VSS.n647 VSS.n417 9.0005
R1797 VSS.n846 VSS.n845 9.0005
R1798 VSS.n469 VSS.n419 9.0005
R1799 VSS.n837 VSS.n836 9.0005
R1800 VSS.n662 VSS.n421 9.0005
R1801 VSS.n828 VSS.n827 9.0005
R1802 VSS.n464 VSS.n423 9.0005
R1803 VSS.n819 VSS.n818 9.0005
R1804 VSS.n677 VSS.n425 9.0005
R1805 VSS.n810 VSS.n809 9.0005
R1806 VSS.n459 VSS.n427 9.0005
R1807 VSS.n801 VSS.n800 9.0005
R1808 VSS.n692 VSS.n429 9.0005
R1809 VSS.n792 VSS.n791 9.0005
R1810 VSS.n454 VSS.n431 9.0005
R1811 VSS.n783 VSS.n782 9.0005
R1812 VSS.n707 VSS.n433 9.0005
R1813 VSS.n774 VSS.n773 9.0005
R1814 VSS.n449 VSS.n435 9.0005
R1815 VSS.n765 VSS.n764 9.0005
R1816 VSS.n722 VSS.n437 9.0005
R1817 VSS.n756 VSS.n755 9.0005
R1818 VSS.n444 VSS.n439 9.0005
R1819 VSS.n747 VSS.n746 9.0005
R1820 VSS.n738 VSS.n737 9.0005
R1821 VSS.n745 VSS.n744 9.0005
R1822 VSS.n743 VSS.n742 9.0005
R1823 VSS.n754 VSS.n753 9.0005
R1824 VSS.n752 VSS.n751 9.0005
R1825 VSS.n763 VSS.n762 9.0005
R1826 VSS.n761 VSS.n760 9.0005
R1827 VSS.n772 VSS.n771 9.0005
R1828 VSS.n770 VSS.n769 9.0005
R1829 VSS.n781 VSS.n780 9.0005
R1830 VSS.n779 VSS.n778 9.0005
R1831 VSS.n790 VSS.n789 9.0005
R1832 VSS.n788 VSS.n787 9.0005
R1833 VSS.n799 VSS.n798 9.0005
R1834 VSS.n797 VSS.n796 9.0005
R1835 VSS.n808 VSS.n807 9.0005
R1836 VSS.n806 VSS.n805 9.0005
R1837 VSS.n817 VSS.n816 9.0005
R1838 VSS.n815 VSS.n814 9.0005
R1839 VSS.n826 VSS.n825 9.0005
R1840 VSS.n824 VSS.n823 9.0005
R1841 VSS.n835 VSS.n834 9.0005
R1842 VSS.n833 VSS.n832 9.0005
R1843 VSS.n844 VSS.n843 9.0005
R1844 VSS.n842 VSS.n841 9.0005
R1845 VSS.n853 VSS.n852 9.0005
R1846 VSS.n851 VSS.n850 9.0005
R1847 VSS.n862 VSS.n861 9.0005
R1848 VSS.n860 VSS.n859 9.0005
R1849 VSS.n871 VSS.n870 9.0005
R1850 VSS.n869 VSS.n868 9.0005
R1851 VSS.n880 VSS.n879 9.0005
R1852 VSS.n878 VSS.n877 9.0005
R1853 VSS.n889 VSS.n888 9.0005
R1854 VSS.n887 VSS.n886 9.0005
R1855 VSS.n898 VSS.n897 9.0005
R1856 VSS.n896 VSS.n895 9.0005
R1857 VSS.n907 VSS.n906 9.0005
R1858 VSS.n905 VSS.n904 9.0005
R1859 VSS.n916 VSS.n915 9.0005
R1860 VSS.n914 VSS.n913 9.0005
R1861 VSS.n925 VSS.n924 9.0005
R1862 VSS.n923 VSS.n922 9.0005
R1863 VSS.n934 VSS.n933 9.0005
R1864 VSS.n932 VSS.n931 9.0005
R1865 VSS.n943 VSS.n942 9.0005
R1866 VSS.n941 VSS.n940 9.0005
R1867 VSS.n952 VSS.n951 9.0005
R1868 VSS.n950 VSS.n949 9.0005
R1869 VSS.n961 VSS.n960 9.0005
R1870 VSS.n959 VSS.n958 9.0005
R1871 VSS.n970 VSS.n969 9.0005
R1872 VSS.n968 VSS.n967 9.0005
R1873 VSS.n979 VSS.n978 9.0005
R1874 VSS.n977 VSS.n976 9.0005
R1875 VSS.n988 VSS.n987 9.0005
R1876 VSS.n986 VSS.n985 9.0005
R1877 VSS.n997 VSS.n996 9.0005
R1878 VSS.n995 VSS.n994 9.0005
R1879 VSS.n1006 VSS.n1005 9.0005
R1880 VSS.n1004 VSS.n1003 9.0005
R1881 VSS.n1023 VSS.n1020 9.0005
R1882 VSS.n381 VSS.n380 9.0005
R1883 VSS.n1044 VSS.n117 9.0005
R1884 VSS.n1041 VSS.n1040 9.0005
R1885 VSS.n1037 VSS.n12 9.0005
R1886 VSS.n1032 VSS.n1031 9.0005
R1887 VSS.n517 VSS.n16 9.0005
R1888 VSS.n520 VSS.n515 9.0005
R1889 VSS.n525 VSS.n524 9.0005
R1890 VSS.n532 VSS.n23 9.0005
R1891 VSS.n535 VSS.n510 9.0005
R1892 VSS.n540 VSS.n539 9.0005
R1893 VSS.n547 VSS.n30 9.0005
R1894 VSS.n550 VSS.n505 9.0005
R1895 VSS.n555 VSS.n554 9.0005
R1896 VSS.n562 VSS.n36 9.0005
R1897 VSS.n565 VSS.n500 9.0005
R1898 VSS.n570 VSS.n569 9.0005
R1899 VSS.n577 VSS.n42 9.0005
R1900 VSS.n580 VSS.n495 9.0005
R1901 VSS.n585 VSS.n584 9.0005
R1902 VSS.n592 VSS.n48 9.0005
R1903 VSS.n595 VSS.n490 9.0005
R1904 VSS.n600 VSS.n599 9.0005
R1905 VSS.n607 VSS.n55 9.0005
R1906 VSS.n610 VSS.n485 9.0005
R1907 VSS.n615 VSS.n614 9.0005
R1908 VSS.n622 VSS.n62 9.0005
R1909 VSS.n625 VSS.n480 9.0005
R1910 VSS.n630 VSS.n629 9.0005
R1911 VSS.n637 VSS.n68 9.0005
R1912 VSS.n640 VSS.n475 9.0005
R1913 VSS.n645 VSS.n644 9.0005
R1914 VSS.n652 VSS.n75 9.0005
R1915 VSS.n655 VSS.n470 9.0005
R1916 VSS.n660 VSS.n659 9.0005
R1917 VSS.n667 VSS.n81 9.0005
R1918 VSS.n670 VSS.n465 9.0005
R1919 VSS.n675 VSS.n674 9.0005
R1920 VSS.n682 VSS.n88 9.0005
R1921 VSS.n685 VSS.n460 9.0005
R1922 VSS.n690 VSS.n689 9.0005
R1923 VSS.n697 VSS.n94 9.0005
R1924 VSS.n700 VSS.n455 9.0005
R1925 VSS.n705 VSS.n704 9.0005
R1926 VSS.n712 VSS.n100 9.0005
R1927 VSS.n715 VSS.n450 9.0005
R1928 VSS.n720 VSS.n719 9.0005
R1929 VSS.n727 VSS.n106 9.0005
R1930 VSS.n730 VSS.n445 9.0005
R1931 VSS.n442 VSS.n441 9.0005
R1932 VSS.n733 VSS.n732 9.0005
R1933 VSS.n729 VSS.n728 9.0005
R1934 VSS.n724 VSS.n723 9.0005
R1935 VSS.n718 VSS.n447 9.0005
R1936 VSS.n714 VSS.n713 9.0005
R1937 VSS.n709 VSS.n708 9.0005
R1938 VSS.n703 VSS.n452 9.0005
R1939 VSS.n699 VSS.n698 9.0005
R1940 VSS.n694 VSS.n693 9.0005
R1941 VSS.n688 VSS.n457 9.0005
R1942 VSS.n684 VSS.n683 9.0005
R1943 VSS.n679 VSS.n678 9.0005
R1944 VSS.n673 VSS.n462 9.0005
R1945 VSS.n669 VSS.n668 9.0005
R1946 VSS.n664 VSS.n663 9.0005
R1947 VSS.n658 VSS.n467 9.0005
R1948 VSS.n654 VSS.n653 9.0005
R1949 VSS.n649 VSS.n648 9.0005
R1950 VSS.n643 VSS.n472 9.0005
R1951 VSS.n639 VSS.n638 9.0005
R1952 VSS.n634 VSS.n633 9.0005
R1953 VSS.n628 VSS.n477 9.0005
R1954 VSS.n624 VSS.n623 9.0005
R1955 VSS.n619 VSS.n618 9.0005
R1956 VSS.n613 VSS.n482 9.0005
R1957 VSS.n609 VSS.n608 9.0005
R1958 VSS.n604 VSS.n603 9.0005
R1959 VSS.n598 VSS.n487 9.0005
R1960 VSS.n594 VSS.n593 9.0005
R1961 VSS.n589 VSS.n588 9.0005
R1962 VSS.n583 VSS.n492 9.0005
R1963 VSS.n579 VSS.n578 9.0005
R1964 VSS.n574 VSS.n573 9.0005
R1965 VSS.n568 VSS.n497 9.0005
R1966 VSS.n564 VSS.n563 9.0005
R1967 VSS.n559 VSS.n558 9.0005
R1968 VSS.n553 VSS.n502 9.0005
R1969 VSS.n549 VSS.n548 9.0005
R1970 VSS.n544 VSS.n543 9.0005
R1971 VSS.n538 VSS.n507 9.0005
R1972 VSS.n534 VSS.n533 9.0005
R1973 VSS.n529 VSS.n528 9.0005
R1974 VSS.n523 VSS.n512 9.0005
R1975 VSS.n519 VSS.n518 9.0005
R1976 VSS.n1030 VSS.n1029 9.0005
R1977 VSS.n1034 VSS.n1033 9.0005
R1978 VSS.n1039 VSS.n1038 9.0005
R1979 VSS.n1046 VSS.n1045 9.0005
R1980 VSS.n1044 VSS.n1 9.0005
R1981 VSS.n1045 VSS.n1043 9.0005
R1982 VSS.n1042 VSS.n1041 9.0005
R1983 VSS.n1039 VSS.n376 9.0005
R1984 VSS.n1037 VSS.n1036 9.0005
R1985 VSS.n1032 VSS.n377 9.0005
R1986 VSS.n1030 VSS.n378 9.0005
R1987 VSS.n1035 VSS.n1034 9.0005
R1988 VSS.n517 VSS.n516 9.0005
R1989 VSS.n519 VSS.n513 9.0005
R1990 VSS.n521 VSS.n520 9.0005
R1991 VSS.n525 VSS.n511 9.0005
R1992 VSS.n530 VSS.n529 9.0005
R1993 VSS.n523 VSS.n522 9.0005
R1994 VSS.n532 VSS.n531 9.0005
R1995 VSS.n534 VSS.n508 9.0005
R1996 VSS.n536 VSS.n535 9.0005
R1997 VSS.n540 VSS.n506 9.0005
R1998 VSS.n545 VSS.n544 9.0005
R1999 VSS.n538 VSS.n537 9.0005
R2000 VSS.n547 VSS.n546 9.0005
R2001 VSS.n549 VSS.n503 9.0005
R2002 VSS.n551 VSS.n550 9.0005
R2003 VSS.n555 VSS.n501 9.0005
R2004 VSS.n560 VSS.n559 9.0005
R2005 VSS.n553 VSS.n552 9.0005
R2006 VSS.n562 VSS.n561 9.0005
R2007 VSS.n564 VSS.n498 9.0005
R2008 VSS.n566 VSS.n565 9.0005
R2009 VSS.n570 VSS.n496 9.0005
R2010 VSS.n575 VSS.n574 9.0005
R2011 VSS.n568 VSS.n567 9.0005
R2012 VSS.n577 VSS.n576 9.0005
R2013 VSS.n579 VSS.n493 9.0005
R2014 VSS.n581 VSS.n580 9.0005
R2015 VSS.n585 VSS.n491 9.0005
R2016 VSS.n590 VSS.n589 9.0005
R2017 VSS.n583 VSS.n582 9.0005
R2018 VSS.n592 VSS.n591 9.0005
R2019 VSS.n594 VSS.n488 9.0005
R2020 VSS.n596 VSS.n595 9.0005
R2021 VSS.n600 VSS.n486 9.0005
R2022 VSS.n605 VSS.n604 9.0005
R2023 VSS.n598 VSS.n597 9.0005
R2024 VSS.n607 VSS.n606 9.0005
R2025 VSS.n609 VSS.n483 9.0005
R2026 VSS.n611 VSS.n610 9.0005
R2027 VSS.n615 VSS.n481 9.0005
R2028 VSS.n620 VSS.n619 9.0005
R2029 VSS.n613 VSS.n612 9.0005
R2030 VSS.n622 VSS.n621 9.0005
R2031 VSS.n624 VSS.n478 9.0005
R2032 VSS.n626 VSS.n625 9.0005
R2033 VSS.n630 VSS.n476 9.0005
R2034 VSS.n635 VSS.n634 9.0005
R2035 VSS.n628 VSS.n627 9.0005
R2036 VSS.n637 VSS.n636 9.0005
R2037 VSS.n639 VSS.n473 9.0005
R2038 VSS.n641 VSS.n640 9.0005
R2039 VSS.n645 VSS.n471 9.0005
R2040 VSS.n650 VSS.n649 9.0005
R2041 VSS.n643 VSS.n642 9.0005
R2042 VSS.n652 VSS.n651 9.0005
R2043 VSS.n654 VSS.n468 9.0005
R2044 VSS.n656 VSS.n655 9.0005
R2045 VSS.n660 VSS.n466 9.0005
R2046 VSS.n665 VSS.n664 9.0005
R2047 VSS.n658 VSS.n657 9.0005
R2048 VSS.n667 VSS.n666 9.0005
R2049 VSS.n669 VSS.n463 9.0005
R2050 VSS.n671 VSS.n670 9.0005
R2051 VSS.n675 VSS.n461 9.0005
R2052 VSS.n680 VSS.n679 9.0005
R2053 VSS.n673 VSS.n672 9.0005
R2054 VSS.n682 VSS.n681 9.0005
R2055 VSS.n684 VSS.n458 9.0005
R2056 VSS.n686 VSS.n685 9.0005
R2057 VSS.n690 VSS.n456 9.0005
R2058 VSS.n695 VSS.n694 9.0005
R2059 VSS.n688 VSS.n687 9.0005
R2060 VSS.n697 VSS.n696 9.0005
R2061 VSS.n699 VSS.n453 9.0005
R2062 VSS.n701 VSS.n700 9.0005
R2063 VSS.n705 VSS.n451 9.0005
R2064 VSS.n710 VSS.n709 9.0005
R2065 VSS.n703 VSS.n702 9.0005
R2066 VSS.n712 VSS.n711 9.0005
R2067 VSS.n714 VSS.n448 9.0005
R2068 VSS.n716 VSS.n715 9.0005
R2069 VSS.n720 VSS.n446 9.0005
R2070 VSS.n725 VSS.n724 9.0005
R2071 VSS.n718 VSS.n717 9.0005
R2072 VSS.n727 VSS.n726 9.0005
R2073 VSS.n729 VSS.n443 9.0005
R2074 VSS.n731 VSS.n730 9.0005
R2075 VSS.n734 VSS.n733 9.0005
R2076 VSS.n1051 VSS.n124 8.5005
R2077 VSS.n1051 VSS.n130 8.5005
R2078 VSS.n1051 VSS.n135 8.5005
R2079 VSS.n1051 VSS.n141 8.5005
R2080 VSS.n1051 VSS.n147 8.5005
R2081 VSS.n1051 VSS.n153 8.5005
R2082 VSS.n1051 VSS.n159 8.5005
R2083 VSS.n1051 VSS.n166 8.5005
R2084 VSS.n1051 VSS.n172 8.5005
R2085 VSS.n1051 VSS.n179 8.5005
R2086 VSS.n1051 VSS.n185 8.5005
R2087 VSS.n1051 VSS.n191 8.5005
R2088 VSS.n1051 VSS.n198 8.5005
R2089 VSS.n1051 VSS.n204 8.5005
R2090 VSS.n1051 VSS.n209 8.5005
R2091 VSS.n1051 VSS.n216 8.5005
R2092 VSS.n1051 VSS.n224 8.5005
R2093 VSS.n1051 VSS.n231 8.5005
R2094 VSS.n1051 VSS.n237 8.5005
R2095 VSS.n1051 VSS.n243 8.5005
R2096 VSS.n1051 VSS.n248 8.5005
R2097 VSS.n1051 VSS.n254 8.5005
R2098 VSS.n1051 VSS.n259 8.5005
R2099 VSS.n1051 VSS.n264 8.5005
R2100 VSS.n1051 VSS.n271 8.5005
R2101 VSS.n1051 VSS.n278 8.5005
R2102 VSS.n1051 VSS.n285 8.5005
R2103 VSS.n1051 VSS.n293 8.5005
R2104 VSS.n1051 VSS.n298 8.5005
R2105 VSS.n1051 VSS.n303 8.5005
R2106 VSS.n1051 VSS.n310 8.5005
R2107 VSS.n1051 VSS.n316 8.5005
R2108 VSS.n1051 VSS.n5 8.47732
R2109 VSS.n1051 VSS.n119 8.47732
R2110 VSS.n1051 VSS.n121 8.47732
R2111 VSS.n1051 VSS.n122 8.47732
R2112 VSS.n1051 VSS.n126 8.47732
R2113 VSS.n1051 VSS.n127 8.47732
R2114 VSS.n1051 VSS.n128 8.47732
R2115 VSS.n1051 VSS.n131 8.47732
R2116 VSS.n1051 VSS.n132 8.47732
R2117 VSS.n1051 VSS.n133 8.47732
R2118 VSS.n1051 VSS.n136 8.47732
R2119 VSS.n1051 VSS.n138 8.47732
R2120 VSS.n1051 VSS.n139 8.47732
R2121 VSS.n1051 VSS.n143 8.47732
R2122 VSS.n1051 VSS.n144 8.47732
R2123 VSS.n1051 VSS.n145 8.47732
R2124 VSS.n1051 VSS.n149 8.47732
R2125 VSS.n1051 VSS.n150 8.47732
R2126 VSS.n1051 VSS.n151 8.47732
R2127 VSS.n1051 VSS.n154 8.47732
R2128 VSS.n1051 VSS.n156 8.47732
R2129 VSS.n1051 VSS.n157 8.47732
R2130 VSS.n1051 VSS.n160 8.47732
R2131 VSS.n1051 VSS.n162 8.47732
R2132 VSS.n1051 VSS.n163 8.47732
R2133 VSS.n1051 VSS.n167 8.47732
R2134 VSS.n1051 VSS.n168 8.47732
R2135 VSS.n1051 VSS.n169 8.47732
R2136 VSS.n1051 VSS.n173 8.47732
R2137 VSS.n1051 VSS.n175 8.47732
R2138 VSS.n1051 VSS.n176 8.47732
R2139 VSS.n1051 VSS.n180 8.47732
R2140 VSS.n1051 VSS.n182 8.47732
R2141 VSS.n1051 VSS.n183 8.47732
R2142 VSS.n1051 VSS.n187 8.47732
R2143 VSS.n1051 VSS.n188 8.47732
R2144 VSS.n1051 VSS.n189 8.47732
R2145 VSS.n1051 VSS.n193 8.47732
R2146 VSS.n1051 VSS.n195 8.47732
R2147 VSS.n1051 VSS.n196 8.47732
R2148 VSS.n1051 VSS.n200 8.47732
R2149 VSS.n1051 VSS.n201 8.47732
R2150 VSS.n1051 VSS.n202 8.47732
R2151 VSS.n1051 VSS.n205 8.47732
R2152 VSS.n1051 VSS.n206 8.47732
R2153 VSS.n1051 VSS.n207 8.47732
R2154 VSS.n1051 VSS.n211 8.47732
R2155 VSS.n1051 VSS.n213 8.47732
R2156 VSS.n1051 VSS.n214 8.47732
R2157 VSS.n1051 VSS.n218 8.47732
R2158 VSS.n1051 VSS.n220 8.47732
R2159 VSS.n1051 VSS.n221 8.47732
R2160 VSS.n1051 VSS.n225 8.47732
R2161 VSS.n1051 VSS.n227 8.47732
R2162 VSS.n1051 VSS.n228 8.47732
R2163 VSS.n1051 VSS.n232 8.47732
R2164 VSS.n1051 VSS.n234 8.47732
R2165 VSS.n1051 VSS.n235 8.47732
R2166 VSS.n1051 VSS.n238 8.47732
R2167 VSS.n1051 VSS.n240 8.47732
R2168 VSS.n1051 VSS.n241 8.47732
R2169 VSS.n1051 VSS.n244 8.47732
R2170 VSS.n1051 VSS.n245 8.47732
R2171 VSS.n1051 VSS.n246 8.47732
R2172 VSS.n1051 VSS.n250 8.47732
R2173 VSS.n1051 VSS.n251 8.47732
R2174 VSS.n1051 VSS.n252 8.47732
R2175 VSS.n1051 VSS.n255 8.47732
R2176 VSS.n1051 VSS.n256 8.47732
R2177 VSS.n1051 VSS.n257 8.47732
R2178 VSS.n1051 VSS.n260 8.47732
R2179 VSS.n1051 VSS.n261 8.47732
R2180 VSS.n1051 VSS.n262 8.47732
R2181 VSS.n1051 VSS.n266 8.47732
R2182 VSS.n1051 VSS.n268 8.47732
R2183 VSS.n1051 VSS.n269 8.47732
R2184 VSS.n1051 VSS.n273 8.47732
R2185 VSS.n1051 VSS.n275 8.47732
R2186 VSS.n1051 VSS.n276 8.47732
R2187 VSS.n1051 VSS.n280 8.47732
R2188 VSS.n1051 VSS.n282 8.47732
R2189 VSS.n1051 VSS.n283 8.47732
R2190 VSS.n1051 VSS.n287 8.47732
R2191 VSS.n1051 VSS.n289 8.47732
R2192 VSS.n1051 VSS.n290 8.47732
R2193 VSS.n1051 VSS.n294 8.47732
R2194 VSS.n1051 VSS.n295 8.47732
R2195 VSS.n1051 VSS.n296 8.47732
R2196 VSS.n1051 VSS.n299 8.47732
R2197 VSS.n1051 VSS.n300 8.47732
R2198 VSS.n1051 VSS.n301 8.47732
R2199 VSS.n1051 VSS.n305 8.47732
R2200 VSS.n1051 VSS.n307 8.47732
R2201 VSS.n1051 VSS.n308 8.47732
R2202 VSS.n1051 VSS.n312 8.47732
R2203 VSS.n1051 VSS.n313 8.47732
R2204 VSS.n1051 VSS.n314 8.47732
R2205 VSS.n1051 VSS.n317 8.47732
R2206 VSS.n1051 VSS.t119 8.47732
R2207 VSS.n1051 VSS.n321 8.47732
R2208 VSS.n1051 VSS.n6 8.47732
R2209 VSS.n1051 VSS.n9 8.47732
R2210 VSS.n1051 VSS.n13 8.47732
R2211 VSS.n1051 VSS.n15 8.47732
R2212 VSS.n1051 VSS.n20 8.47732
R2213 VSS.n1051 VSS.n22 8.47732
R2214 VSS.n1051 VSS.n27 8.47732
R2215 VSS.n1051 VSS.n29 8.47732
R2216 VSS.n1051 VSS.n33 8.47732
R2217 VSS.n1051 VSS.n35 8.47732
R2218 VSS.n1051 VSS.n39 8.47732
R2219 VSS.n1051 VSS.n41 8.47732
R2220 VSS.n1051 VSS.n45 8.47732
R2221 VSS.n1051 VSS.n47 8.47732
R2222 VSS.n1051 VSS.n52 8.47732
R2223 VSS.n1051 VSS.n54 8.47732
R2224 VSS.n1051 VSS.n59 8.47732
R2225 VSS.n1051 VSS.n61 8.47732
R2226 VSS.n1051 VSS.n65 8.47732
R2227 VSS.n1051 VSS.n67 8.47732
R2228 VSS.n1051 VSS.n72 8.47732
R2229 VSS.n1051 VSS.n74 8.47732
R2230 VSS.n1051 VSS.n78 8.47732
R2231 VSS.n1051 VSS.n80 8.47732
R2232 VSS.n1051 VSS.n85 8.47732
R2233 VSS.n1051 VSS.n87 8.47732
R2234 VSS.n1051 VSS.n91 8.47732
R2235 VSS.n1051 VSS.n93 8.47732
R2236 VSS.n1051 VSS.n97 8.47732
R2237 VSS.n1051 VSS.n99 8.47732
R2238 VSS.n1051 VSS.n103 8.47732
R2239 VSS.n1051 VSS.n105 8.47732
R2240 VSS.n1051 VSS.n110 8.47732
R2241 VSS.n1051 VSS.n114 8.47732
R2242 VSS.n1051 VSS.n113 8.47732
R2243 VSS.n1055 VSS.n3 6.85994
R2244 VSS.n1056 VSS.n2 6.85994
R2245 VSS.n1051 VSS.n322 5.63777
R2246 VSS.n1051 VSS.n10 5.62581
R2247 VSS.n1051 VSS.n14 5.62581
R2248 VSS.n1051 VSS.n17 5.62581
R2249 VSS.n1051 VSS.n21 5.62581
R2250 VSS.n1051 VSS.n24 5.62581
R2251 VSS.n1051 VSS.n28 5.62581
R2252 VSS.n1051 VSS.n31 5.62581
R2253 VSS.n1051 VSS.n34 5.62581
R2254 VSS.n1051 VSS.n37 5.62581
R2255 VSS.n1051 VSS.n40 5.62581
R2256 VSS.n1051 VSS.n43 5.62581
R2257 VSS.n1051 VSS.n46 5.62581
R2258 VSS.n1051 VSS.n49 5.62581
R2259 VSS.n1051 VSS.n53 5.62581
R2260 VSS.n1051 VSS.n56 5.62581
R2261 VSS.n1051 VSS.n60 5.62581
R2262 VSS.n1051 VSS.n63 5.62581
R2263 VSS.n1051 VSS.n66 5.62581
R2264 VSS.n1051 VSS.n69 5.62581
R2265 VSS.n1051 VSS.n73 5.62581
R2266 VSS.n1051 VSS.n76 5.62581
R2267 VSS.n1051 VSS.n79 5.62581
R2268 VSS.n1051 VSS.n82 5.62581
R2269 VSS.n1051 VSS.n86 5.62581
R2270 VSS.n1051 VSS.n89 5.62581
R2271 VSS.n1051 VSS.n92 5.62581
R2272 VSS.n1051 VSS.n95 5.62581
R2273 VSS.n1051 VSS.n98 5.62581
R2274 VSS.n1051 VSS.n101 5.62581
R2275 VSS.n1051 VSS.n104 5.62581
R2276 VSS.n1051 VSS.n107 5.62581
R2277 VSS.n1051 VSS.n111 5.62581
R2278 VSS.n1054 VSS.n1053 5.01167
R2279 VSS.n1051 VSS.t113 5.00029
R2280 VSS.n1057 VSS.n1 4.8967
R2281 VSS.n735 VSS.n734 4.73162
R2282 VSS.t124 VSS.n0 54.9783
R2283 VSS.n1051 VSS.n112 4.20662
R2284 VSS.n1051 VSS.n123 4.19244
R2285 VSS.n1051 VSS.n129 4.19244
R2286 VSS.n1051 VSS.n134 4.19244
R2287 VSS.n1051 VSS.n140 4.19244
R2288 VSS.n1051 VSS.n146 4.19244
R2289 VSS.n1051 VSS.n152 4.19244
R2290 VSS.n1051 VSS.n158 4.19244
R2291 VSS.n1051 VSS.n165 4.19244
R2292 VSS.n1051 VSS.n171 4.19244
R2293 VSS.n1051 VSS.n178 4.19244
R2294 VSS.n1051 VSS.n184 4.19244
R2295 VSS.n1051 VSS.n190 4.19244
R2296 VSS.n1051 VSS.n197 4.19244
R2297 VSS.n1051 VSS.n203 4.19244
R2298 VSS.n1051 VSS.n208 4.19244
R2299 VSS.n1051 VSS.n215 4.19244
R2300 VSS.n1051 VSS.n223 4.19244
R2301 VSS.n1051 VSS.n230 4.19244
R2302 VSS.n1051 VSS.n236 4.19244
R2303 VSS.n1051 VSS.n242 4.19244
R2304 VSS.n1051 VSS.n247 4.19244
R2305 VSS.n1051 VSS.n253 4.19244
R2306 VSS.n1051 VSS.n258 4.19244
R2307 VSS.n1051 VSS.n263 4.19244
R2308 VSS.n1051 VSS.n270 4.19244
R2309 VSS.n1051 VSS.n277 4.19244
R2310 VSS.n1051 VSS.n284 4.19244
R2311 VSS.n1051 VSS.n292 4.19244
R2312 VSS.n1051 VSS.n297 4.19244
R2313 VSS.n1051 VSS.n302 4.19244
R2314 VSS.n1051 VSS.n309 4.19244
R2315 VSS.n1051 VSS.n315 4.19244
R2316 VSS.n1051 VSS.n118 3.32778
R2317 VSS.n1051 VSS.t36 3.32623
R2318 VSS.n1051 VSS.t15 3.32623
R2319 VSS.n1051 VSS.t31 3.32623
R2320 VSS.n1051 VSS.t33 3.32623
R2321 VSS.n1051 VSS.t49 3.32623
R2322 VSS.n1051 VSS.t2 3.32623
R2323 VSS.n1051 VSS.t68 3.32623
R2324 VSS.n1051 VSS.t104 3.32623
R2325 VSS.n1051 VSS.t97 3.32623
R2326 VSS.n1051 VSS.t62 3.32623
R2327 VSS.n1051 VSS.t66 3.32623
R2328 VSS.n1051 VSS.t17 3.32623
R2329 VSS.n1051 VSS.t64 3.32623
R2330 VSS.n1051 VSS.t38 3.32623
R2331 VSS.n1051 VSS.t20 3.32623
R2332 VSS.n1051 VSS.t45 3.32623
R2333 VSS.n1051 VSS.t55 3.32615
R2334 VSS.n1051 VSS.t81 3.32615
R2335 VSS.n1051 VSS.t22 3.32615
R2336 VSS.n1051 VSS.t10 3.32615
R2337 VSS.n1051 VSS.t57 3.32615
R2338 VSS.n1051 VSS.t5 3.32615
R2339 VSS.n1051 VSS.t24 3.32615
R2340 VSS.n1051 VSS.t12 3.32615
R2341 VSS.n1051 VSS.t43 3.32615
R2342 VSS.n1051 VSS.t29 3.32615
R2343 VSS.n1051 VSS.t75 3.32615
R2344 VSS.n1051 VSS.t53 3.32615
R2345 VSS.n1051 VSS.t8 3.32615
R2346 VSS.n1051 VSS.t77 3.32615
R2347 VSS.n1051 VSS.t111 3.32615
R2348 VSS.n1055 VSS.n1054 2.93359
R2349 VSS.n1057 VSS.n1056 2.93359
R2350 VSS.n1051 VSS.t100 2.74394
R2351 VSS.t112 VSS.t115 0.806856
R2352 VSS.t169 VSS.n379 0.802775
R2353 VSS.n1015 VSS.t167 0.802775
R2354 VSS.n736 VSS.t205 0.802775
R2355 VSS.t149 VSS.n721 0.802775
R2356 VSS.t155 VSS.n706 0.802775
R2357 VSS.t191 VSS.n691 0.802775
R2358 VSS.t199 VSS.n676 0.802775
R2359 VSS.t201 VSS.n661 0.802775
R2360 VSS.t143 VSS.n646 0.802775
R2361 VSS.t189 VSS.n631 0.802775
R2362 VSS.t177 VSS.n616 0.802775
R2363 VSS.t181 VSS.n601 0.802775
R2364 VSS.t185 VSS.n586 0.802775
R2365 VSS.t175 VSS.n571 0.802775
R2366 VSS.t173 VSS.n556 0.802775
R2367 VSS.t153 VSS.n541 0.802775
R2368 VSS.t161 VSS.n526 0.802775
R2369 VSS.t163 VSS.n19 0.802775
R2370 VSS.t157 VSS.n26 0.802775
R2371 VSS.t171 VSS.n32 0.802775
R2372 VSS.t145 VSS.n38 0.802775
R2373 VSS.t187 VSS.n44 0.802775
R2374 VSS.t183 VSS.n51 0.802775
R2375 VSS.t179 VSS.n58 0.802775
R2376 VSS.t165 VSS.n64 0.802775
R2377 VSS.t193 VSS.n71 0.802775
R2378 VSS.t195 VSS.n77 0.802775
R2379 VSS.t203 VSS.n84 0.802775
R2380 VSS.t197 VSS.n90 0.802775
R2381 VSS.t159 VSS.n96 0.802775
R2382 VSS.t151 VSS.n102 0.802775
R2383 VSS.t147 VSS.n109 0.802775
R2384 VSS.n318 VSS.t122 0.802775
R2385 VSS.n319 VSS.t121 0.723599
R2386 VSS.t123 VSS.t125 0.723599
R2387 VSS.n1036 VSS.n1035 0.692362
R2388 VSS.n516 VSS.n378 0.692362
R2389 VSS.n522 VSS.n521 0.692362
R2390 VSS.n531 VSS.n530 0.692362
R2391 VSS.n537 VSS.n536 0.692362
R2392 VSS.n546 VSS.n545 0.692362
R2393 VSS.n552 VSS.n551 0.692362
R2394 VSS.n561 VSS.n560 0.692362
R2395 VSS.n567 VSS.n566 0.692362
R2396 VSS.n576 VSS.n575 0.692362
R2397 VSS.n582 VSS.n581 0.692362
R2398 VSS.n591 VSS.n590 0.692362
R2399 VSS.n597 VSS.n596 0.692362
R2400 VSS.n606 VSS.n605 0.692362
R2401 VSS.n612 VSS.n611 0.692362
R2402 VSS.n621 VSS.n620 0.692362
R2403 VSS.n627 VSS.n626 0.692362
R2404 VSS.n636 VSS.n635 0.692362
R2405 VSS.n642 VSS.n641 0.692362
R2406 VSS.n651 VSS.n650 0.692362
R2407 VSS.n657 VSS.n656 0.692362
R2408 VSS.n666 VSS.n665 0.692362
R2409 VSS.n672 VSS.n671 0.692362
R2410 VSS.n681 VSS.n680 0.692362
R2411 VSS.n687 VSS.n686 0.692362
R2412 VSS.n696 VSS.n695 0.692362
R2413 VSS.n702 VSS.n701 0.692362
R2414 VSS.n711 VSS.n710 0.692362
R2415 VSS.n717 VSS.n716 0.692362
R2416 VSS.n726 VSS.n725 0.692362
R2417 VSS.n734 VSS.n731 0.692362
R2418 VSS.n1051 VSS.n320 0.607264
R2419 VSS.t118 VSS.n1047 0.595317
R2420 VSS.t114 VSS.n375 0.595317
R2421 VSS.n1053 VSS.n4 0.461741
R2422 VSS.n1019 VSS.n1018 0.461741
R2423 VSS.n1026 VSS.n1009 0.461741
R2424 VSS.n1001 VSS.n1000 0.461741
R2425 VSS.n992 VSS.n991 0.461741
R2426 VSS.n983 VSS.n982 0.461741
R2427 VSS.n974 VSS.n973 0.461741
R2428 VSS.n965 VSS.n964 0.461741
R2429 VSS.n956 VSS.n955 0.461741
R2430 VSS.n947 VSS.n946 0.461741
R2431 VSS.n938 VSS.n937 0.461741
R2432 VSS.n929 VSS.n928 0.461741
R2433 VSS.n920 VSS.n919 0.461741
R2434 VSS.n911 VSS.n910 0.461741
R2435 VSS.n902 VSS.n901 0.461741
R2436 VSS.n893 VSS.n892 0.461741
R2437 VSS.n884 VSS.n883 0.461741
R2438 VSS.n875 VSS.n874 0.461741
R2439 VSS.n866 VSS.n865 0.461741
R2440 VSS.n857 VSS.n856 0.461741
R2441 VSS.n848 VSS.n847 0.461741
R2442 VSS.n839 VSS.n838 0.461741
R2443 VSS.n830 VSS.n829 0.461741
R2444 VSS.n821 VSS.n820 0.461741
R2445 VSS.n812 VSS.n811 0.461741
R2446 VSS.n803 VSS.n802 0.461741
R2447 VSS.n794 VSS.n793 0.461741
R2448 VSS.n785 VSS.n784 0.461741
R2449 VSS.n776 VSS.n775 0.461741
R2450 VSS.n767 VSS.n766 0.461741
R2451 VSS.n758 VSS.n757 0.461741
R2452 VSS.n749 VSS.n748 0.461741
R2453 VSS.n1043 VSS.n1042 0.346431
R2454 VSS.t205 VSS.t100 0.301976
R2455 VSS.n118 VSS.n3 0.289639
R2456 VSS.n106 VSS.t111 0.28485
R2457 VSS.n100 VSS.t77 0.28485
R2458 VSS.n94 VSS.t8 0.28485
R2459 VSS.n88 VSS.t53 0.28485
R2460 VSS.n81 VSS.t75 0.28485
R2461 VSS.n75 VSS.t29 0.28485
R2462 VSS.n68 VSS.t43 0.28485
R2463 VSS.n62 VSS.t12 0.28485
R2464 VSS.n55 VSS.t24 0.28485
R2465 VSS.n48 VSS.t5 0.28485
R2466 VSS.n42 VSS.t57 0.28485
R2467 VSS.n36 VSS.t10 0.28485
R2468 VSS.n30 VSS.t22 0.28485
R2469 VSS.n23 VSS.t81 0.28485
R2470 VSS.n16 VSS.t55 0.28485
R2471 VSS.n512 VSS.t36 0.284653
R2472 VSS.n502 VSS.t15 0.284653
R2473 VSS.n497 VSS.t31 0.284653
R2474 VSS.n477 VSS.t33 0.284653
R2475 VSS.n472 VSS.t49 0.284653
R2476 VSS.n467 VSS.t2 0.284653
R2477 VSS.n447 VSS.t68 0.284653
R2478 VSS.n732 VSS.t104 0.284653
R2479 VSS.n452 VSS.t97 0.284653
R2480 VSS.n457 VSS.t62 0.284653
R2481 VSS.n462 VSS.t66 0.284653
R2482 VSS.n482 VSS.t17 0.284653
R2483 VSS.n487 VSS.t64 0.284653
R2484 VSS.n492 VSS.t38 0.284653
R2485 VSS.n507 VSS.t20 0.284653
R2486 VSS.n1033 VSS.t45 0.284653
R2487 VSS.n118 VSS.n2 0.28352
R2488 VSS.n323 VSS.n112 0.259448
R2489 VSS.t147 VSS.t104 0.256315
R2490 VSS.t151 VSS.t68 0.256315
R2491 VSS.t159 VSS.t97 0.256315
R2492 VSS.t197 VSS.t62 0.256315
R2493 VSS.t203 VSS.t66 0.256315
R2494 VSS.t195 VSS.t2 0.256315
R2495 VSS.t193 VSS.t49 0.256315
R2496 VSS.t165 VSS.t33 0.256315
R2497 VSS.t179 VSS.t17 0.256315
R2498 VSS.t183 VSS.t64 0.256315
R2499 VSS.t187 VSS.t38 0.256315
R2500 VSS.t145 VSS.t31 0.256315
R2501 VSS.t171 VSS.t15 0.256315
R2502 VSS.t157 VSS.t20 0.256315
R2503 VSS.t163 VSS.t36 0.256315
R2504 VSS.t167 VSS.t45 0.256315
R2505 VSS.t169 VSS.t55 0.256107
R2506 VSS.t161 VSS.t81 0.256107
R2507 VSS.t153 VSS.t22 0.256107
R2508 VSS.t173 VSS.t10 0.256107
R2509 VSS.t175 VSS.t57 0.256107
R2510 VSS.t185 VSS.t5 0.256107
R2511 VSS.t181 VSS.t24 0.256107
R2512 VSS.t177 VSS.t12 0.256107
R2513 VSS.t189 VSS.t43 0.256107
R2514 VSS.t143 VSS.t29 0.256107
R2515 VSS.t201 VSS.t75 0.256107
R2516 VSS.t199 VSS.t53 0.256107
R2517 VSS.t191 VSS.t8 0.256107
R2518 VSS.t155 VSS.t77 0.256107
R2519 VSS.t149 VSS.t111 0.256107
R2520 VSS.t122 VSS.t100 0.254814
R2521 VSS.n1010 VSS.n4 0.231121
R2522 VSS.n1018 VSS.n1010 0.231121
R2523 VSS.n1024 VSS.n1019 0.231121
R2524 VSS.n1025 VSS.n1024 0.231121
R2525 VSS.n1026 VSS.n1025 0.231121
R2526 VSS.n1009 VSS.n382 0.231121
R2527 VSS.n1002 VSS.n382 0.231121
R2528 VSS.n1002 VSS.n1001 0.231121
R2529 VSS.n1000 VSS.n384 0.231121
R2530 VSS.n993 VSS.n384 0.231121
R2531 VSS.n993 VSS.n992 0.231121
R2532 VSS.n991 VSS.n386 0.231121
R2533 VSS.n984 VSS.n386 0.231121
R2534 VSS.n984 VSS.n983 0.231121
R2535 VSS.n982 VSS.n388 0.231121
R2536 VSS.n975 VSS.n388 0.231121
R2537 VSS.n975 VSS.n974 0.231121
R2538 VSS.n973 VSS.n390 0.231121
R2539 VSS.n966 VSS.n390 0.231121
R2540 VSS.n966 VSS.n965 0.231121
R2541 VSS.n964 VSS.n392 0.231121
R2542 VSS.n957 VSS.n392 0.231121
R2543 VSS.n957 VSS.n956 0.231121
R2544 VSS.n955 VSS.n394 0.231121
R2545 VSS.n948 VSS.n394 0.231121
R2546 VSS.n948 VSS.n947 0.231121
R2547 VSS.n946 VSS.n396 0.231121
R2548 VSS.n939 VSS.n396 0.231121
R2549 VSS.n939 VSS.n938 0.231121
R2550 VSS.n937 VSS.n398 0.231121
R2551 VSS.n930 VSS.n398 0.231121
R2552 VSS.n930 VSS.n929 0.231121
R2553 VSS.n928 VSS.n400 0.231121
R2554 VSS.n921 VSS.n400 0.231121
R2555 VSS.n921 VSS.n920 0.231121
R2556 VSS.n919 VSS.n402 0.231121
R2557 VSS.n912 VSS.n402 0.231121
R2558 VSS.n912 VSS.n911 0.231121
R2559 VSS.n910 VSS.n404 0.231121
R2560 VSS.n903 VSS.n404 0.231121
R2561 VSS.n903 VSS.n902 0.231121
R2562 VSS.n901 VSS.n406 0.231121
R2563 VSS.n894 VSS.n406 0.231121
R2564 VSS.n894 VSS.n893 0.231121
R2565 VSS.n892 VSS.n408 0.231121
R2566 VSS.n885 VSS.n408 0.231121
R2567 VSS.n885 VSS.n884 0.231121
R2568 VSS.n883 VSS.n410 0.231121
R2569 VSS.n876 VSS.n410 0.231121
R2570 VSS.n876 VSS.n875 0.231121
R2571 VSS.n874 VSS.n412 0.231121
R2572 VSS.n867 VSS.n412 0.231121
R2573 VSS.n867 VSS.n866 0.231121
R2574 VSS.n865 VSS.n414 0.231121
R2575 VSS.n858 VSS.n414 0.231121
R2576 VSS.n858 VSS.n857 0.231121
R2577 VSS.n856 VSS.n416 0.231121
R2578 VSS.n849 VSS.n416 0.231121
R2579 VSS.n849 VSS.n848 0.231121
R2580 VSS.n847 VSS.n418 0.231121
R2581 VSS.n840 VSS.n418 0.231121
R2582 VSS.n840 VSS.n839 0.231121
R2583 VSS.n838 VSS.n420 0.231121
R2584 VSS.n831 VSS.n420 0.231121
R2585 VSS.n831 VSS.n830 0.231121
R2586 VSS.n829 VSS.n422 0.231121
R2587 VSS.n822 VSS.n422 0.231121
R2588 VSS.n822 VSS.n821 0.231121
R2589 VSS.n820 VSS.n424 0.231121
R2590 VSS.n813 VSS.n424 0.231121
R2591 VSS.n813 VSS.n812 0.231121
R2592 VSS.n811 VSS.n426 0.231121
R2593 VSS.n804 VSS.n426 0.231121
R2594 VSS.n804 VSS.n803 0.231121
R2595 VSS.n802 VSS.n428 0.231121
R2596 VSS.n795 VSS.n428 0.231121
R2597 VSS.n795 VSS.n794 0.231121
R2598 VSS.n793 VSS.n430 0.231121
R2599 VSS.n786 VSS.n430 0.231121
R2600 VSS.n786 VSS.n785 0.231121
R2601 VSS.n784 VSS.n432 0.231121
R2602 VSS.n777 VSS.n432 0.231121
R2603 VSS.n777 VSS.n776 0.231121
R2604 VSS.n775 VSS.n434 0.231121
R2605 VSS.n768 VSS.n434 0.231121
R2606 VSS.n768 VSS.n767 0.231121
R2607 VSS.n766 VSS.n436 0.231121
R2608 VSS.n759 VSS.n436 0.231121
R2609 VSS.n759 VSS.n758 0.231121
R2610 VSS.n757 VSS.n438 0.231121
R2611 VSS.n750 VSS.n438 0.231121
R2612 VSS.n750 VSS.n749 0.231121
R2613 VSS.n748 VSS.n440 0.231121
R2614 VSS.n741 VSS.n440 0.231121
R2615 VSS.n741 VSS.n740 0.231121
R2616 VSS.n1045 VSS.n1044 0.231121
R2617 VSS.n1043 VSS.n1 0.231121
R2618 VSS.n1042 VSS.n376 0.231121
R2619 VSS.n1036 VSS.n376 0.231121
R2620 VSS.n1035 VSS.n377 0.231121
R2621 VSS.n378 VSS.n377 0.231121
R2622 VSS.n516 VSS.n513 0.231121
R2623 VSS.n521 VSS.n513 0.231121
R2624 VSS.n522 VSS.n511 0.231121
R2625 VSS.n530 VSS.n511 0.231121
R2626 VSS.n531 VSS.n508 0.231121
R2627 VSS.n536 VSS.n508 0.231121
R2628 VSS.n537 VSS.n506 0.231121
R2629 VSS.n545 VSS.n506 0.231121
R2630 VSS.n546 VSS.n503 0.231121
R2631 VSS.n551 VSS.n503 0.231121
R2632 VSS.n552 VSS.n501 0.231121
R2633 VSS.n560 VSS.n501 0.231121
R2634 VSS.n561 VSS.n498 0.231121
R2635 VSS.n566 VSS.n498 0.231121
R2636 VSS.n567 VSS.n496 0.231121
R2637 VSS.n575 VSS.n496 0.231121
R2638 VSS.n576 VSS.n493 0.231121
R2639 VSS.n581 VSS.n493 0.231121
R2640 VSS.n582 VSS.n491 0.231121
R2641 VSS.n590 VSS.n491 0.231121
R2642 VSS.n591 VSS.n488 0.231121
R2643 VSS.n596 VSS.n488 0.231121
R2644 VSS.n597 VSS.n486 0.231121
R2645 VSS.n605 VSS.n486 0.231121
R2646 VSS.n606 VSS.n483 0.231121
R2647 VSS.n611 VSS.n483 0.231121
R2648 VSS.n612 VSS.n481 0.231121
R2649 VSS.n620 VSS.n481 0.231121
R2650 VSS.n621 VSS.n478 0.231121
R2651 VSS.n626 VSS.n478 0.231121
R2652 VSS.n627 VSS.n476 0.231121
R2653 VSS.n635 VSS.n476 0.231121
R2654 VSS.n636 VSS.n473 0.231121
R2655 VSS.n641 VSS.n473 0.231121
R2656 VSS.n642 VSS.n471 0.231121
R2657 VSS.n650 VSS.n471 0.231121
R2658 VSS.n651 VSS.n468 0.231121
R2659 VSS.n656 VSS.n468 0.231121
R2660 VSS.n657 VSS.n466 0.231121
R2661 VSS.n665 VSS.n466 0.231121
R2662 VSS.n666 VSS.n463 0.231121
R2663 VSS.n671 VSS.n463 0.231121
R2664 VSS.n672 VSS.n461 0.231121
R2665 VSS.n680 VSS.n461 0.231121
R2666 VSS.n681 VSS.n458 0.231121
R2667 VSS.n686 VSS.n458 0.231121
R2668 VSS.n687 VSS.n456 0.231121
R2669 VSS.n695 VSS.n456 0.231121
R2670 VSS.n696 VSS.n453 0.231121
R2671 VSS.n701 VSS.n453 0.231121
R2672 VSS.n702 VSS.n451 0.231121
R2673 VSS.n710 VSS.n451 0.231121
R2674 VSS.n711 VSS.n448 0.231121
R2675 VSS.n716 VSS.n448 0.231121
R2676 VSS.n717 VSS.n446 0.231121
R2677 VSS.n725 VSS.n446 0.231121
R2678 VSS.n726 VSS.n443 0.231121
R2679 VSS.n731 VSS.n443 0.231121
R2680 VSS.n733 VSS.n442 0.231121
R2681 VSS.n729 VSS.n727 0.231121
R2682 VSS.n730 VSS.n729 0.231121
R2683 VSS.n720 VSS.n718 0.231121
R2684 VSS.n724 VSS.n720 0.231121
R2685 VSS.n714 VSS.n712 0.231121
R2686 VSS.n715 VSS.n714 0.231121
R2687 VSS.n705 VSS.n703 0.231121
R2688 VSS.n709 VSS.n705 0.231121
R2689 VSS.n699 VSS.n697 0.231121
R2690 VSS.n700 VSS.n699 0.231121
R2691 VSS.n690 VSS.n688 0.231121
R2692 VSS.n694 VSS.n690 0.231121
R2693 VSS.n684 VSS.n682 0.231121
R2694 VSS.n685 VSS.n684 0.231121
R2695 VSS.n675 VSS.n673 0.231121
R2696 VSS.n679 VSS.n675 0.231121
R2697 VSS.n669 VSS.n667 0.231121
R2698 VSS.n670 VSS.n669 0.231121
R2699 VSS.n660 VSS.n658 0.231121
R2700 VSS.n664 VSS.n660 0.231121
R2701 VSS.n654 VSS.n652 0.231121
R2702 VSS.n655 VSS.n654 0.231121
R2703 VSS.n645 VSS.n643 0.231121
R2704 VSS.n649 VSS.n645 0.231121
R2705 VSS.n639 VSS.n637 0.231121
R2706 VSS.n640 VSS.n639 0.231121
R2707 VSS.n630 VSS.n628 0.231121
R2708 VSS.n634 VSS.n630 0.231121
R2709 VSS.n624 VSS.n622 0.231121
R2710 VSS.n625 VSS.n624 0.231121
R2711 VSS.n615 VSS.n613 0.231121
R2712 VSS.n619 VSS.n615 0.231121
R2713 VSS.n609 VSS.n607 0.231121
R2714 VSS.n610 VSS.n609 0.231121
R2715 VSS.n600 VSS.n598 0.231121
R2716 VSS.n604 VSS.n600 0.231121
R2717 VSS.n594 VSS.n592 0.231121
R2718 VSS.n595 VSS.n594 0.231121
R2719 VSS.n585 VSS.n583 0.231121
R2720 VSS.n589 VSS.n585 0.231121
R2721 VSS.n579 VSS.n577 0.231121
R2722 VSS.n580 VSS.n579 0.231121
R2723 VSS.n570 VSS.n568 0.231121
R2724 VSS.n574 VSS.n570 0.231121
R2725 VSS.n564 VSS.n562 0.231121
R2726 VSS.n565 VSS.n564 0.231121
R2727 VSS.n555 VSS.n553 0.231121
R2728 VSS.n559 VSS.n555 0.231121
R2729 VSS.n549 VSS.n547 0.231121
R2730 VSS.n550 VSS.n549 0.231121
R2731 VSS.n540 VSS.n538 0.231121
R2732 VSS.n544 VSS.n540 0.231121
R2733 VSS.n534 VSS.n532 0.231121
R2734 VSS.n535 VSS.n534 0.231121
R2735 VSS.n525 VSS.n523 0.231121
R2736 VSS.n529 VSS.n525 0.231121
R2737 VSS.n519 VSS.n517 0.231121
R2738 VSS.n520 VSS.n519 0.231121
R2739 VSS.n1034 VSS.n1032 0.231121
R2740 VSS.n1032 VSS.n1030 0.231121
R2741 VSS.n1041 VSS.n1039 0.231121
R2742 VSS.n1039 VSS.n1037 0.231121
R2743 VSS.n1023 VSS.n1022 0.231121
R2744 VSS.n1023 VSS.n381 0.231121
R2745 VSS.n1027 VSS.n381 0.231121
R2746 VSS.n1008 VSS.n1006 0.231121
R2747 VSS.n1006 VSS.n1004 0.231121
R2748 VSS.n1004 VSS.n383 0.231121
R2749 VSS.n999 VSS.n997 0.231121
R2750 VSS.n997 VSS.n995 0.231121
R2751 VSS.n995 VSS.n385 0.231121
R2752 VSS.n990 VSS.n988 0.231121
R2753 VSS.n988 VSS.n986 0.231121
R2754 VSS.n986 VSS.n387 0.231121
R2755 VSS.n981 VSS.n979 0.231121
R2756 VSS.n979 VSS.n977 0.231121
R2757 VSS.n977 VSS.n389 0.231121
R2758 VSS.n972 VSS.n970 0.231121
R2759 VSS.n970 VSS.n968 0.231121
R2760 VSS.n968 VSS.n391 0.231121
R2761 VSS.n963 VSS.n961 0.231121
R2762 VSS.n961 VSS.n959 0.231121
R2763 VSS.n959 VSS.n393 0.231121
R2764 VSS.n954 VSS.n952 0.231121
R2765 VSS.n952 VSS.n950 0.231121
R2766 VSS.n950 VSS.n395 0.231121
R2767 VSS.n945 VSS.n943 0.231121
R2768 VSS.n943 VSS.n941 0.231121
R2769 VSS.n941 VSS.n397 0.231121
R2770 VSS.n936 VSS.n934 0.231121
R2771 VSS.n934 VSS.n932 0.231121
R2772 VSS.n932 VSS.n399 0.231121
R2773 VSS.n927 VSS.n925 0.231121
R2774 VSS.n925 VSS.n923 0.231121
R2775 VSS.n923 VSS.n401 0.231121
R2776 VSS.n918 VSS.n916 0.231121
R2777 VSS.n916 VSS.n914 0.231121
R2778 VSS.n914 VSS.n403 0.231121
R2779 VSS.n909 VSS.n907 0.231121
R2780 VSS.n907 VSS.n905 0.231121
R2781 VSS.n905 VSS.n405 0.231121
R2782 VSS.n900 VSS.n898 0.231121
R2783 VSS.n898 VSS.n896 0.231121
R2784 VSS.n896 VSS.n407 0.231121
R2785 VSS.n891 VSS.n889 0.231121
R2786 VSS.n889 VSS.n887 0.231121
R2787 VSS.n887 VSS.n409 0.231121
R2788 VSS.n882 VSS.n880 0.231121
R2789 VSS.n880 VSS.n878 0.231121
R2790 VSS.n878 VSS.n411 0.231121
R2791 VSS.n873 VSS.n871 0.231121
R2792 VSS.n871 VSS.n869 0.231121
R2793 VSS.n869 VSS.n413 0.231121
R2794 VSS.n864 VSS.n862 0.231121
R2795 VSS.n862 VSS.n860 0.231121
R2796 VSS.n860 VSS.n415 0.231121
R2797 VSS.n855 VSS.n853 0.231121
R2798 VSS.n853 VSS.n851 0.231121
R2799 VSS.n851 VSS.n417 0.231121
R2800 VSS.n846 VSS.n844 0.231121
R2801 VSS.n844 VSS.n842 0.231121
R2802 VSS.n842 VSS.n419 0.231121
R2803 VSS.n837 VSS.n835 0.231121
R2804 VSS.n835 VSS.n833 0.231121
R2805 VSS.n833 VSS.n421 0.231121
R2806 VSS.n828 VSS.n826 0.231121
R2807 VSS.n826 VSS.n824 0.231121
R2808 VSS.n824 VSS.n423 0.231121
R2809 VSS.n819 VSS.n817 0.231121
R2810 VSS.n817 VSS.n815 0.231121
R2811 VSS.n815 VSS.n425 0.231121
R2812 VSS.n810 VSS.n808 0.231121
R2813 VSS.n808 VSS.n806 0.231121
R2814 VSS.n806 VSS.n427 0.231121
R2815 VSS.n801 VSS.n799 0.231121
R2816 VSS.n799 VSS.n797 0.231121
R2817 VSS.n797 VSS.n429 0.231121
R2818 VSS.n792 VSS.n790 0.231121
R2819 VSS.n790 VSS.n788 0.231121
R2820 VSS.n788 VSS.n431 0.231121
R2821 VSS.n783 VSS.n781 0.231121
R2822 VSS.n781 VSS.n779 0.231121
R2823 VSS.n779 VSS.n433 0.231121
R2824 VSS.n774 VSS.n772 0.231121
R2825 VSS.n772 VSS.n770 0.231121
R2826 VSS.n770 VSS.n435 0.231121
R2827 VSS.n765 VSS.n763 0.231121
R2828 VSS.n763 VSS.n761 0.231121
R2829 VSS.n761 VSS.n437 0.231121
R2830 VSS.n756 VSS.n754 0.231121
R2831 VSS.n754 VSS.n752 0.231121
R2832 VSS.n752 VSS.n439 0.231121
R2833 VSS.n747 VSS.n745 0.231121
R2834 VSS.n745 VSS.n743 0.231121
R2835 VSS.n743 VSS.n738 0.231121
R2836 VSS.n1014 VSS.n1013 0.231121
R2837 VSS.n1017 VSS.n1014 0.231121
R2838 VSS.n1054 VSS 0.226636
R2839 VSS VSS.n1057 0.226288
R2840 VSS.n323 VSS.n322 0.206787
R2841 VSS.n1015 VSS.n123 0.197793
R2842 VSS.n379 VSS.n129 0.197793
R2843 VSS.n19 VSS.n134 0.197793
R2844 VSS.n526 VSS.n140 0.197793
R2845 VSS.n26 VSS.n146 0.197793
R2846 VSS.n541 VSS.n152 0.197793
R2847 VSS.n32 VSS.n158 0.197793
R2848 VSS.n556 VSS.n165 0.197793
R2849 VSS.n38 VSS.n171 0.197793
R2850 VSS.n571 VSS.n178 0.197793
R2851 VSS.n44 VSS.n184 0.197793
R2852 VSS.n586 VSS.n190 0.197793
R2853 VSS.n51 VSS.n197 0.197793
R2854 VSS.n601 VSS.n203 0.197793
R2855 VSS.n58 VSS.n208 0.197793
R2856 VSS.n616 VSS.n215 0.197793
R2857 VSS.n64 VSS.n223 0.197793
R2858 VSS.n631 VSS.n230 0.197793
R2859 VSS.n71 VSS.n236 0.197793
R2860 VSS.n646 VSS.n242 0.197793
R2861 VSS.n77 VSS.n247 0.197793
R2862 VSS.n661 VSS.n253 0.197793
R2863 VSS.n84 VSS.n258 0.197793
R2864 VSS.n676 VSS.n263 0.197793
R2865 VSS.n90 VSS.n270 0.197793
R2866 VSS.n691 VSS.n277 0.197793
R2867 VSS.n96 VSS.n284 0.197793
R2868 VSS.n706 VSS.n292 0.197793
R2869 VSS.n102 VSS.n297 0.197793
R2870 VSS.n721 VSS.n302 0.197793
R2871 VSS.n109 VSS.n309 0.197793
R2872 VSS.n736 VSS.n315 0.197793
R2873 VSS.t114 VSS.t118 0.1875
R2874 VSS.t125 VSS.n112 0.177116
R2875 VSS.n1021 VSS.n123 0.143558
R2876 VSS.n1007 VSS.n129 0.143558
R2877 VSS.n998 VSS.n134 0.143558
R2878 VSS.n989 VSS.n140 0.143558
R2879 VSS.n980 VSS.n146 0.143558
R2880 VSS.n971 VSS.n152 0.143558
R2881 VSS.n962 VSS.n158 0.143558
R2882 VSS.n953 VSS.n165 0.143558
R2883 VSS.n944 VSS.n171 0.143558
R2884 VSS.n935 VSS.n178 0.143558
R2885 VSS.n926 VSS.n184 0.143558
R2886 VSS.n917 VSS.n190 0.143558
R2887 VSS.n908 VSS.n197 0.143558
R2888 VSS.n899 VSS.n203 0.143558
R2889 VSS.n890 VSS.n208 0.143558
R2890 VSS.n881 VSS.n215 0.143558
R2891 VSS.n872 VSS.n223 0.143558
R2892 VSS.n863 VSS.n230 0.143558
R2893 VSS.n854 VSS.n236 0.143558
R2894 VSS.n845 VSS.n242 0.143558
R2895 VSS.n836 VSS.n247 0.143558
R2896 VSS.n827 VSS.n253 0.143558
R2897 VSS.n818 VSS.n258 0.143558
R2898 VSS.n809 VSS.n263 0.143558
R2899 VSS.n800 VSS.n270 0.143558
R2900 VSS.n791 VSS.n277 0.143558
R2901 VSS.n782 VSS.n284 0.143558
R2902 VSS.n773 VSS.n292 0.143558
R2903 VSS.n764 VSS.n297 0.143558
R2904 VSS.n755 VSS.n302 0.143558
R2905 VSS.n746 VSS.n309 0.143558
R2906 VSS.n739 VSS.n315 0.143558
R2907 VSS.n1012 VSS.n121 0.143368
R2908 VSS.n1011 VSS.n122 0.143368
R2909 VSS.n1021 VSS.n126 0.143368
R2910 VSS.n1020 VSS.n127 0.143368
R2911 VSS.n380 VSS.n128 0.143368
R2912 VSS.n1007 VSS.n131 0.143368
R2913 VSS.n1005 VSS.n132 0.143368
R2914 VSS.n1003 VSS.n133 0.143368
R2915 VSS.n998 VSS.n136 0.143368
R2916 VSS.n996 VSS.n138 0.143368
R2917 VSS.n994 VSS.n139 0.143368
R2918 VSS.n989 VSS.n143 0.143368
R2919 VSS.n987 VSS.n144 0.143368
R2920 VSS.n985 VSS.n145 0.143368
R2921 VSS.n980 VSS.n149 0.143368
R2922 VSS.n978 VSS.n150 0.143368
R2923 VSS.n976 VSS.n151 0.143368
R2924 VSS.n971 VSS.n154 0.143368
R2925 VSS.n969 VSS.n156 0.143368
R2926 VSS.n967 VSS.n157 0.143368
R2927 VSS.n962 VSS.n160 0.143368
R2928 VSS.n960 VSS.n162 0.143368
R2929 VSS.n958 VSS.n163 0.143368
R2930 VSS.n953 VSS.n167 0.143368
R2931 VSS.n951 VSS.n168 0.143368
R2932 VSS.n949 VSS.n169 0.143368
R2933 VSS.n944 VSS.n173 0.143368
R2934 VSS.n942 VSS.n175 0.143368
R2935 VSS.n940 VSS.n176 0.143368
R2936 VSS.n935 VSS.n180 0.143368
R2937 VSS.n933 VSS.n182 0.143368
R2938 VSS.n931 VSS.n183 0.143368
R2939 VSS.n926 VSS.n187 0.143368
R2940 VSS.n924 VSS.n188 0.143368
R2941 VSS.n922 VSS.n189 0.143368
R2942 VSS.n917 VSS.n193 0.143368
R2943 VSS.n915 VSS.n195 0.143368
R2944 VSS.n913 VSS.n196 0.143368
R2945 VSS.n908 VSS.n200 0.143368
R2946 VSS.n906 VSS.n201 0.143368
R2947 VSS.n904 VSS.n202 0.143368
R2948 VSS.n899 VSS.n205 0.143368
R2949 VSS.n897 VSS.n206 0.143368
R2950 VSS.n895 VSS.n207 0.143368
R2951 VSS.n890 VSS.n211 0.143368
R2952 VSS.n888 VSS.n213 0.143368
R2953 VSS.n886 VSS.n214 0.143368
R2954 VSS.n881 VSS.n218 0.143368
R2955 VSS.n879 VSS.n220 0.143368
R2956 VSS.n877 VSS.n221 0.143368
R2957 VSS.n872 VSS.n225 0.143368
R2958 VSS.n870 VSS.n227 0.143368
R2959 VSS.n868 VSS.n228 0.143368
R2960 VSS.n863 VSS.n232 0.143368
R2961 VSS.n861 VSS.n234 0.143368
R2962 VSS.n859 VSS.n235 0.143368
R2963 VSS.n854 VSS.n238 0.143368
R2964 VSS.n852 VSS.n240 0.143368
R2965 VSS.n850 VSS.n241 0.143368
R2966 VSS.n845 VSS.n244 0.143368
R2967 VSS.n843 VSS.n245 0.143368
R2968 VSS.n841 VSS.n246 0.143368
R2969 VSS.n836 VSS.n250 0.143368
R2970 VSS.n834 VSS.n251 0.143368
R2971 VSS.n832 VSS.n252 0.143368
R2972 VSS.n827 VSS.n255 0.143368
R2973 VSS.n825 VSS.n256 0.143368
R2974 VSS.n823 VSS.n257 0.143368
R2975 VSS.n818 VSS.n260 0.143368
R2976 VSS.n816 VSS.n261 0.143368
R2977 VSS.n814 VSS.n262 0.143368
R2978 VSS.n809 VSS.n266 0.143368
R2979 VSS.n807 VSS.n268 0.143368
R2980 VSS.n805 VSS.n269 0.143368
R2981 VSS.n800 VSS.n273 0.143368
R2982 VSS.n798 VSS.n275 0.143368
R2983 VSS.n796 VSS.n276 0.143368
R2984 VSS.n791 VSS.n280 0.143368
R2985 VSS.n789 VSS.n282 0.143368
R2986 VSS.n787 VSS.n283 0.143368
R2987 VSS.n782 VSS.n287 0.143368
R2988 VSS.n780 VSS.n289 0.143368
R2989 VSS.n778 VSS.n290 0.143368
R2990 VSS.n773 VSS.n294 0.143368
R2991 VSS.n771 VSS.n295 0.143368
R2992 VSS.n769 VSS.n296 0.143368
R2993 VSS.n764 VSS.n299 0.143368
R2994 VSS.n762 VSS.n300 0.143368
R2995 VSS.n760 VSS.n301 0.143368
R2996 VSS.n755 VSS.n305 0.143368
R2997 VSS.n753 VSS.n307 0.143368
R2998 VSS.n751 VSS.n308 0.143368
R2999 VSS.n746 VSS.n312 0.143368
R3000 VSS.n744 VSS.n313 0.143368
R3001 VSS.n742 VSS.n314 0.143368
R3002 VSS.n739 VSS.n317 0.143368
R3003 VSS.n1038 VSS.n9 0.143368
R3004 VSS.n1031 VSS.n13 0.143368
R3005 VSS.n518 VSS.n15 0.143368
R3006 VSS.n524 VSS.n20 0.143368
R3007 VSS.n533 VSS.n22 0.143368
R3008 VSS.n539 VSS.n27 0.143368
R3009 VSS.n548 VSS.n29 0.143368
R3010 VSS.n554 VSS.n33 0.143368
R3011 VSS.n563 VSS.n35 0.143368
R3012 VSS.n569 VSS.n39 0.143368
R3013 VSS.n578 VSS.n41 0.143368
R3014 VSS.n584 VSS.n45 0.143368
R3015 VSS.n593 VSS.n47 0.143368
R3016 VSS.n599 VSS.n52 0.143368
R3017 VSS.n608 VSS.n54 0.143368
R3018 VSS.n614 VSS.n59 0.143368
R3019 VSS.n623 VSS.n61 0.143368
R3020 VSS.n629 VSS.n65 0.143368
R3021 VSS.n638 VSS.n67 0.143368
R3022 VSS.n644 VSS.n72 0.143368
R3023 VSS.n653 VSS.n74 0.143368
R3024 VSS.n659 VSS.n78 0.143368
R3025 VSS.n668 VSS.n80 0.143368
R3026 VSS.n674 VSS.n85 0.143368
R3027 VSS.n683 VSS.n87 0.143368
R3028 VSS.n689 VSS.n91 0.143368
R3029 VSS.n698 VSS.n93 0.143368
R3030 VSS.n704 VSS.n97 0.143368
R3031 VSS.n713 VSS.n99 0.143368
R3032 VSS.n719 VSS.n103 0.143368
R3033 VSS.n728 VSS.n105 0.143368
R3034 VSS.n441 VSS.n110 0.143368
R3035 VSS.n322 VSS.t123 0.141022
R3036 VSS.n1056 VSS.n1055 0.138073
R3037 VSS.t119 VSS.n318 0.135868
R3038 VSS.t122 VSS.n114 0.124618
R3039 VSS.t119 VSS.n319 0.122118
R3040 VSS.t121 VSS.n114 0.122118
R3041 VSS.n735 VSS.n442 0.113429
R3042 VSS.n12 VSS.n10 0.0961384
R3043 VSS.n1029 VSS.n14 0.0961384
R3044 VSS.n515 VSS.n17 0.0961384
R3045 VSS.n528 VSS.n21 0.0961384
R3046 VSS.n510 VSS.n24 0.0961384
R3047 VSS.n543 VSS.n28 0.0961384
R3048 VSS.n505 VSS.n31 0.0961384
R3049 VSS.n558 VSS.n34 0.0961384
R3050 VSS.n500 VSS.n37 0.0961384
R3051 VSS.n573 VSS.n40 0.0961384
R3052 VSS.n495 VSS.n43 0.0961384
R3053 VSS.n588 VSS.n46 0.0961384
R3054 VSS.n490 VSS.n49 0.0961384
R3055 VSS.n603 VSS.n53 0.0961384
R3056 VSS.n485 VSS.n56 0.0961384
R3057 VSS.n618 VSS.n60 0.0961384
R3058 VSS.n480 VSS.n63 0.0961384
R3059 VSS.n633 VSS.n66 0.0961384
R3060 VSS.n475 VSS.n69 0.0961384
R3061 VSS.n648 VSS.n73 0.0961384
R3062 VSS.n470 VSS.n76 0.0961384
R3063 VSS.n663 VSS.n79 0.0961384
R3064 VSS.n465 VSS.n82 0.0961384
R3065 VSS.n678 VSS.n86 0.0961384
R3066 VSS.n460 VSS.n89 0.0961384
R3067 VSS.n693 VSS.n92 0.0961384
R3068 VSS.n455 VSS.n95 0.0961384
R3069 VSS.n708 VSS.n98 0.0961384
R3070 VSS.n450 VSS.n101 0.0961384
R3071 VSS.n723 VSS.n104 0.0961384
R3072 VSS.n445 VSS.n107 0.0961384
R3073 VSS.n115 VSS.n111 0.0961384
R3074 VSS.n1038 VSS.n10 0.0958002
R3075 VSS.n1031 VSS.n14 0.0958002
R3076 VSS.n518 VSS.n17 0.0958002
R3077 VSS.n524 VSS.n21 0.0958002
R3078 VSS.n533 VSS.n24 0.0958002
R3079 VSS.n539 VSS.n28 0.0958002
R3080 VSS.n548 VSS.n31 0.0958002
R3081 VSS.n554 VSS.n34 0.0958002
R3082 VSS.n563 VSS.n37 0.0958002
R3083 VSS.n569 VSS.n40 0.0958002
R3084 VSS.n578 VSS.n43 0.0958002
R3085 VSS.n584 VSS.n46 0.0958002
R3086 VSS.n593 VSS.n49 0.0958002
R3087 VSS.n599 VSS.n53 0.0958002
R3088 VSS.n608 VSS.n56 0.0958002
R3089 VSS.n614 VSS.n60 0.0958002
R3090 VSS.n623 VSS.n63 0.0958002
R3091 VSS.n629 VSS.n66 0.0958002
R3092 VSS.n638 VSS.n69 0.0958002
R3093 VSS.n644 VSS.n73 0.0958002
R3094 VSS.n653 VSS.n76 0.0958002
R3095 VSS.n659 VSS.n79 0.0958002
R3096 VSS.n668 VSS.n82 0.0958002
R3097 VSS.n674 VSS.n86 0.0958002
R3098 VSS.n683 VSS.n89 0.0958002
R3099 VSS.n689 VSS.n92 0.0958002
R3100 VSS.n698 VSS.n95 0.0958002
R3101 VSS.n704 VSS.n98 0.0958002
R3102 VSS.n713 VSS.n101 0.0958002
R3103 VSS.n719 VSS.n104 0.0958002
R3104 VSS.n728 VSS.n107 0.0958002
R3105 VSS.n441 VSS.n111 0.0958002
R3106 VSS.n1040 VSS.n116 0.0955
R3107 VSS.t115 VSS.n7 0.08925
R3108 VSS.n117 VSS.t112 0.08925
R3109 VSS.n1051 VSS.n0 0.0010079
R3110 VSS.n1048 VSS.t114 0.0851154
R3111 VSS.t118 VSS.n374 0.0851154
R3112 VSS.n374 VSS.n119 0.0846176
R3113 VSS.t123 VSS.n321 0.0771176
R3114 VSS.t125 VSS.n113 0.0771176
R3115 VSS.n1048 VSS.n5 0.0746176
R3116 VSS.n319 VSS.n321 0.0696176
R3117 VSS.t121 VSS.n113 0.0696176
R3118 VSS.n1049 VSS.n1048 0.06925
R3119 VSS.n375 VSS.n8 0.06925
R3120 VSS.n1049 VSS.n374 0.05925
R3121 VSS.n1047 VSS.n8 0.05925
R3122 VSS.n318 VSS.n317 0.0558676
R3123 VSS.t112 VSS.n6 0.0546176
R3124 VSS.n1012 VSS.n119 0.0483676
R3125 VSS.n1011 VSS.n121 0.0483676
R3126 VSS.n1016 VSS.n122 0.0483676
R3127 VSS.n1020 VSS.n126 0.0483676
R3128 VSS.n380 VSS.n127 0.0483676
R3129 VSS.n1028 VSS.n128 0.0483676
R3130 VSS.n1005 VSS.n131 0.0483676
R3131 VSS.n1003 VSS.n132 0.0483676
R3132 VSS.n514 VSS.n133 0.0483676
R3133 VSS.n996 VSS.n136 0.0483676
R3134 VSS.n994 VSS.n138 0.0483676
R3135 VSS.n527 VSS.n139 0.0483676
R3136 VSS.n987 VSS.n143 0.0483676
R3137 VSS.n985 VSS.n144 0.0483676
R3138 VSS.n509 VSS.n145 0.0483676
R3139 VSS.n978 VSS.n149 0.0483676
R3140 VSS.n976 VSS.n150 0.0483676
R3141 VSS.n542 VSS.n151 0.0483676
R3142 VSS.n969 VSS.n154 0.0483676
R3143 VSS.n967 VSS.n156 0.0483676
R3144 VSS.n504 VSS.n157 0.0483676
R3145 VSS.n960 VSS.n160 0.0483676
R3146 VSS.n958 VSS.n162 0.0483676
R3147 VSS.n557 VSS.n163 0.0483676
R3148 VSS.n951 VSS.n167 0.0483676
R3149 VSS.n949 VSS.n168 0.0483676
R3150 VSS.n499 VSS.n169 0.0483676
R3151 VSS.n942 VSS.n173 0.0483676
R3152 VSS.n940 VSS.n175 0.0483676
R3153 VSS.n572 VSS.n176 0.0483676
R3154 VSS.n933 VSS.n180 0.0483676
R3155 VSS.n931 VSS.n182 0.0483676
R3156 VSS.n494 VSS.n183 0.0483676
R3157 VSS.n924 VSS.n187 0.0483676
R3158 VSS.n922 VSS.n188 0.0483676
R3159 VSS.n587 VSS.n189 0.0483676
R3160 VSS.n915 VSS.n193 0.0483676
R3161 VSS.n913 VSS.n195 0.0483676
R3162 VSS.n489 VSS.n196 0.0483676
R3163 VSS.n906 VSS.n200 0.0483676
R3164 VSS.n904 VSS.n201 0.0483676
R3165 VSS.n602 VSS.n202 0.0483676
R3166 VSS.n897 VSS.n205 0.0483676
R3167 VSS.n895 VSS.n206 0.0483676
R3168 VSS.n484 VSS.n207 0.0483676
R3169 VSS.n888 VSS.n211 0.0483676
R3170 VSS.n886 VSS.n213 0.0483676
R3171 VSS.n617 VSS.n214 0.0483676
R3172 VSS.n879 VSS.n218 0.0483676
R3173 VSS.n877 VSS.n220 0.0483676
R3174 VSS.n479 VSS.n221 0.0483676
R3175 VSS.n870 VSS.n225 0.0483676
R3176 VSS.n868 VSS.n227 0.0483676
R3177 VSS.n632 VSS.n228 0.0483676
R3178 VSS.n861 VSS.n232 0.0483676
R3179 VSS.n859 VSS.n234 0.0483676
R3180 VSS.n474 VSS.n235 0.0483676
R3181 VSS.n852 VSS.n238 0.0483676
R3182 VSS.n850 VSS.n240 0.0483676
R3183 VSS.n647 VSS.n241 0.0483676
R3184 VSS.n843 VSS.n244 0.0483676
R3185 VSS.n841 VSS.n245 0.0483676
R3186 VSS.n469 VSS.n246 0.0483676
R3187 VSS.n834 VSS.n250 0.0483676
R3188 VSS.n832 VSS.n251 0.0483676
R3189 VSS.n662 VSS.n252 0.0483676
R3190 VSS.n825 VSS.n255 0.0483676
R3191 VSS.n823 VSS.n256 0.0483676
R3192 VSS.n464 VSS.n257 0.0483676
R3193 VSS.n816 VSS.n260 0.0483676
R3194 VSS.n814 VSS.n261 0.0483676
R3195 VSS.n677 VSS.n262 0.0483676
R3196 VSS.n807 VSS.n266 0.0483676
R3197 VSS.n805 VSS.n268 0.0483676
R3198 VSS.n459 VSS.n269 0.0483676
R3199 VSS.n798 VSS.n273 0.0483676
R3200 VSS.n796 VSS.n275 0.0483676
R3201 VSS.n692 VSS.n276 0.0483676
R3202 VSS.n789 VSS.n280 0.0483676
R3203 VSS.n787 VSS.n282 0.0483676
R3204 VSS.n454 VSS.n283 0.0483676
R3205 VSS.n780 VSS.n287 0.0483676
R3206 VSS.n778 VSS.n289 0.0483676
R3207 VSS.n707 VSS.n290 0.0483676
R3208 VSS.n771 VSS.n294 0.0483676
R3209 VSS.n769 VSS.n295 0.0483676
R3210 VSS.n449 VSS.n296 0.0483676
R3211 VSS.n762 VSS.n299 0.0483676
R3212 VSS.n760 VSS.n300 0.0483676
R3213 VSS.n722 VSS.n301 0.0483676
R3214 VSS.n753 VSS.n305 0.0483676
R3215 VSS.n751 VSS.n307 0.0483676
R3216 VSS.n444 VSS.n308 0.0483676
R3217 VSS.n744 VSS.n312 0.0483676
R3218 VSS.n742 VSS.n313 0.0483676
R3219 VSS.n737 VSS.n314 0.0483676
R3220 VSS.n1052 VSS.n5 0.0483676
R3221 VSS.n1046 VSS.n6 0.0483676
R3222 VSS.n1040 VSS.n9 0.0483676
R3223 VSS.n1033 VSS.n13 0.0483676
R3224 VSS.n16 VSS.n15 0.0483676
R3225 VSS.n512 VSS.n20 0.0483676
R3226 VSS.n23 VSS.n22 0.0483676
R3227 VSS.n507 VSS.n27 0.0483676
R3228 VSS.n30 VSS.n29 0.0483676
R3229 VSS.n502 VSS.n33 0.0483676
R3230 VSS.n36 VSS.n35 0.0483676
R3231 VSS.n497 VSS.n39 0.0483676
R3232 VSS.n42 VSS.n41 0.0483676
R3233 VSS.n492 VSS.n45 0.0483676
R3234 VSS.n48 VSS.n47 0.0483676
R3235 VSS.n487 VSS.n52 0.0483676
R3236 VSS.n55 VSS.n54 0.0483676
R3237 VSS.n482 VSS.n59 0.0483676
R3238 VSS.n62 VSS.n61 0.0483676
R3239 VSS.n477 VSS.n65 0.0483676
R3240 VSS.n68 VSS.n67 0.0483676
R3241 VSS.n472 VSS.n72 0.0483676
R3242 VSS.n75 VSS.n74 0.0483676
R3243 VSS.n467 VSS.n78 0.0483676
R3244 VSS.n81 VSS.n80 0.0483676
R3245 VSS.n462 VSS.n85 0.0483676
R3246 VSS.n88 VSS.n87 0.0483676
R3247 VSS.n457 VSS.n91 0.0483676
R3248 VSS.n94 VSS.n93 0.0483676
R3249 VSS.n452 VSS.n97 0.0483676
R3250 VSS.n100 VSS.n99 0.0483676
R3251 VSS.n447 VSS.n103 0.0483676
R3252 VSS.n106 VSS.n105 0.0483676
R3253 VSS.n732 VSS.n110 0.0483676
R3254 VSS.n1051 VSS.n170 0.0447034
R3255 VSS.n1051 VSS.n222 0.0447034
R3256 VSS.n1051 VSS.n120 0.0444724
R3257 VSS.n1051 VSS.n371 0.0444724
R3258 VSS.n1051 VSS.n137 0.0444724
R3259 VSS.n1051 VSS.n365 0.0444724
R3260 VSS.n1051 VSS.n364 0.0444724
R3261 VSS.n1051 VSS.n361 0.0444724
R3262 VSS.n1051 VSS.n359 0.0444724
R3263 VSS.n1051 VSS.n358 0.0444724
R3264 VSS.n1051 VSS.n349 0.0444724
R3265 VSS.n1051 VSS.n226 0.0444724
R3266 VSS.n1051 VSS.n348 0.0444724
R3267 VSS.n1051 VSS.n346 0.0444724
R3268 VSS.n1051 VSS.n340 0.0444724
R3269 VSS.n1051 VSS.n274 0.0444724
R3270 VSS.n1051 VSS.n334 0.0444724
R3271 VSS.n1051 VSS.n281 0.0444724
R3272 VSS.n1051 VSS.n332 0.0444724
R3273 VSS.n1051 VSS.n329 0.0444724
R3274 VSS.n1051 VSS.n306 0.0444724
R3275 VSS.n1051 VSS.n1050 0.0444549
R3276 VSS.n1051 VSS.n125 0.0444549
R3277 VSS.n1051 VSS.n373 0.0444549
R3278 VSS.n1051 VSS.n372 0.0444549
R3279 VSS.n1051 VSS.n370 0.0444549
R3280 VSS.n1051 VSS.n369 0.0444549
R3281 VSS.n1051 VSS.n368 0.0444549
R3282 VSS.n1051 VSS.n142 0.0444549
R3283 VSS.n1051 VSS.n367 0.0444549
R3284 VSS.n1051 VSS.n148 0.0444549
R3285 VSS.n1051 VSS.n366 0.0444549
R3286 VSS.n1051 VSS.n155 0.0444549
R3287 VSS.n1051 VSS.n363 0.0444549
R3288 VSS.n1051 VSS.n362 0.0444549
R3289 VSS.n1051 VSS.n161 0.0444549
R3290 VSS.n1051 VSS.n164 0.0444549
R3291 VSS.n1051 VSS.n360 0.0444549
R3292 VSS.n1051 VSS.n174 0.0444549
R3293 VSS.n1051 VSS.n177 0.0444549
R3294 VSS.n1051 VSS.n181 0.0444549
R3295 VSS.n1051 VSS.n357 0.0444549
R3296 VSS.n1051 VSS.n186 0.0444549
R3297 VSS.n1051 VSS.n356 0.0444549
R3298 VSS.n1051 VSS.n355 0.0444549
R3299 VSS.n1051 VSS.n192 0.0444549
R3300 VSS.n1051 VSS.n194 0.0444549
R3301 VSS.n1051 VSS.n199 0.0444549
R3302 VSS.n1051 VSS.n354 0.0444549
R3303 VSS.n1051 VSS.n353 0.0444549
R3304 VSS.n1051 VSS.n352 0.0444549
R3305 VSS.n1051 VSS.n351 0.0444549
R3306 VSS.n1051 VSS.n210 0.0444549
R3307 VSS.n1051 VSS.n212 0.0444549
R3308 VSS.n1051 VSS.n350 0.0444549
R3309 VSS.n1051 VSS.n217 0.0444549
R3310 VSS.n1051 VSS.n219 0.0444549
R3311 VSS.n1051 VSS.n229 0.0444549
R3312 VSS.n1051 VSS.n233 0.0444549
R3313 VSS.n1051 VSS.n347 0.0444549
R3314 VSS.n1051 VSS.n239 0.0444549
R3315 VSS.n1051 VSS.n345 0.0444549
R3316 VSS.n1051 VSS.n344 0.0444549
R3317 VSS.n1051 VSS.n343 0.0444549
R3318 VSS.n1051 VSS.n249 0.0444549
R3319 VSS.n1051 VSS.n342 0.0444549
R3320 VSS.n1051 VSS.n341 0.0444549
R3321 VSS.n1051 VSS.n339 0.0444549
R3322 VSS.n1051 VSS.n338 0.0444549
R3323 VSS.n1051 VSS.n337 0.0444549
R3324 VSS.n1051 VSS.n336 0.0444549
R3325 VSS.n1051 VSS.n265 0.0444549
R3326 VSS.n1051 VSS.n267 0.0444549
R3327 VSS.n1051 VSS.n335 0.0444549
R3328 VSS.n1051 VSS.n272 0.0444549
R3329 VSS.n1051 VSS.n279 0.0444549
R3330 VSS.n1051 VSS.n333 0.0444549
R3331 VSS.n1051 VSS.n286 0.0444549
R3332 VSS.n1051 VSS.n288 0.0444549
R3333 VSS.n1051 VSS.n291 0.0444549
R3334 VSS.n1051 VSS.n331 0.0444549
R3335 VSS.n1051 VSS.n330 0.0444549
R3336 VSS.n1051 VSS.n328 0.0444549
R3337 VSS.n1051 VSS.n327 0.0444549
R3338 VSS.n1051 VSS.n304 0.0444549
R3339 VSS.n1051 VSS.n311 0.0444549
R3340 VSS.n1051 VSS.n326 0.0444549
R3341 VSS.n1051 VSS.n325 0.0444549
R3342 VSS.n1051 VSS.n108 0.0444549
R3343 VSS.n1051 VSS.n83 0.0444549
R3344 VSS.n1051 VSS.n70 0.0444549
R3345 VSS.n1051 VSS.n57 0.0444549
R3346 VSS.n1051 VSS.n50 0.0444549
R3347 VSS.n1051 VSS.n25 0.0444549
R3348 VSS.n1051 VSS.n18 0.0444549
R3349 VSS.n1051 VSS.n11 0.0444549
R3350 VSS.n1016 VSS.n1015 0.0405
R3351 VSS.n379 VSS.n1028 0.0405
R3352 VSS.n19 VSS.n514 0.0405
R3353 VSS.n526 VSS.n527 0.0405
R3354 VSS.n26 VSS.n509 0.0405
R3355 VSS.n541 VSS.n542 0.0405
R3356 VSS.n32 VSS.n504 0.0405
R3357 VSS.n556 VSS.n557 0.0405
R3358 VSS.n38 VSS.n499 0.0405
R3359 VSS.n571 VSS.n572 0.0405
R3360 VSS.n44 VSS.n494 0.0405
R3361 VSS.n586 VSS.n587 0.0405
R3362 VSS.n51 VSS.n489 0.0405
R3363 VSS.n601 VSS.n602 0.0405
R3364 VSS.n58 VSS.n484 0.0405
R3365 VSS.n616 VSS.n617 0.0405
R3366 VSS.n64 VSS.n479 0.0405
R3367 VSS.n631 VSS.n632 0.0405
R3368 VSS.n71 VSS.n474 0.0405
R3369 VSS.n646 VSS.n647 0.0405
R3370 VSS.n77 VSS.n469 0.0405
R3371 VSS.n661 VSS.n662 0.0405
R3372 VSS.n84 VSS.n464 0.0405
R3373 VSS.n676 VSS.n677 0.0405
R3374 VSS.n90 VSS.n459 0.0405
R3375 VSS.n691 VSS.n692 0.0405
R3376 VSS.n96 VSS.n454 0.0405
R3377 VSS.n706 VSS.n707 0.0405
R3378 VSS.n102 VSS.n449 0.0405
R3379 VSS.n721 VSS.n722 0.0405
R3380 VSS.n109 VSS.n444 0.0405
R3381 VSS.n737 VSS.n736 0.0405
R3382 VSS.n1047 VSS.n116 0.03675
R3383 VSS.t167 VSS.n12 0.02925
R3384 VSS.n1029 VSS.t169 0.02925
R3385 VSS.n515 VSS.t163 0.02925
R3386 VSS.n528 VSS.t161 0.02925
R3387 VSS.n510 VSS.t157 0.02925
R3388 VSS.n543 VSS.t153 0.02925
R3389 VSS.n505 VSS.t171 0.02925
R3390 VSS.n558 VSS.t173 0.02925
R3391 VSS.n500 VSS.t145 0.02925
R3392 VSS.n573 VSS.t175 0.02925
R3393 VSS.n495 VSS.t187 0.02925
R3394 VSS.n588 VSS.t185 0.02925
R3395 VSS.n490 VSS.t183 0.02925
R3396 VSS.n603 VSS.t181 0.02925
R3397 VSS.n485 VSS.t179 0.02925
R3398 VSS.n618 VSS.t177 0.02925
R3399 VSS.n480 VSS.t165 0.02925
R3400 VSS.n633 VSS.t189 0.02925
R3401 VSS.n475 VSS.t193 0.02925
R3402 VSS.n648 VSS.t143 0.02925
R3403 VSS.n470 VSS.t195 0.02925
R3404 VSS.n663 VSS.t201 0.02925
R3405 VSS.n465 VSS.t203 0.02925
R3406 VSS.n678 VSS.t199 0.02925
R3407 VSS.n460 VSS.t197 0.02925
R3408 VSS.n693 VSS.t191 0.02925
R3409 VSS.n455 VSS.t159 0.02925
R3410 VSS.n708 VSS.t155 0.02925
R3411 VSS.n450 VSS.t151 0.02925
R3412 VSS.n723 VSS.t149 0.02925
R3413 VSS.n445 VSS.t147 0.02925
R3414 VSS.t205 VSS.n115 0.02925
R3415 VSS.n375 VSS.n1046 0.02675
R3416 VSS.n7 VSS.n3 0.00675
R3417 VSS.n1052 VSS.t115 0.00675
R3418 VSS.n117 VSS.n2 0.00675
R3419 VSS.n1051 VSS.n324 0.00413568
R3420 VSS.n0 VSS.n323 8.48048
C518 DELAY_VBIASN VSS 36.86696f
C519 DELAY_OUT_LAST VSS 0.48296f
C520 DELAY_OUT_TAP31 VSS 0.66256f
C521 DELAY_OUT_TAP30 VSS 0.66256f
C522 DELAY_OUT_TAP29 VSS 0.66256f
C523 DELAY_OUT_TAP28 VSS 0.66256f
C524 DELAY_OUT_TAP27 VSS 0.66256f
C525 DELAY_OUT_TAP26 VSS 0.66256f
C526 DELAY_OUT_TAP25 VSS 0.66256f
C527 DELAY_OUT_TAP24 VSS 0.66256f
C528 DELAY_OUT_TAP23 VSS 0.66256f
C529 DELAY_OUT_TAP22 VSS 0.66256f
C530 DELAY_OUT_TAP21 VSS 0.66256f
C531 DELAY_OUT_TAP20 VSS 0.66256f
C532 DELAY_OUT_TAP19 VSS 0.66256f
C533 DELAY_OUT_TAP18 VSS 0.66256f
C534 DELAY_OUT_TAP17 VSS 0.66256f
C535 DELAY_OUT_TAP16 VSS 0.66256f
C536 DELAY_OUT_TAP15 VSS 0.66256f
C537 DELAY_OUT_TAP14 VSS 0.66256f
C538 DELAY_OUT_TAP13 VSS 0.66256f
C539 DELAY_OUT_TAP12 VSS 0.66256f
C540 DELAY_OUT_TAP11 VSS 0.66256f
C541 DELAY_OUT_TAP10 VSS 0.66256f
C542 DELAY_OUT_TAP9 VSS 0.66256f
C543 DELAY_OUT_TAP8 VSS 0.66256f
C544 DELAY_OUT_TAP7 VSS 0.66256f
C545 DELAY_OUT_TAP6 VSS 0.66256f
C546 DELAY_OUT_TAP5 VSS 0.66256f
C547 DELAY_OUT_TAP4 VSS 0.66256f
C548 DELAY_OUT_TAP3 VSS 0.66256f
C549 DELAY_OUT_TAP2 VSS 0.66256f
C550 DELAY_OUT_TAP1 VSS 0.66256f
C551 DELAY_IN VSS 0.73859f
C552 VDD VSS 46.32329f
C553 a_27671_1842# VSS 0.01732f ; **FLOATING
C554 a_26911_1842# VSS 0.01732f ; **FLOATING
C555 a_26151_1842# VSS 0.01732f ; **FLOATING
C556 a_25391_1842# VSS 0.01732f ; **FLOATING
C557 a_24631_1842# VSS 0.01732f ; **FLOATING
C558 a_23871_1842# VSS 0.01732f ; **FLOATING
C559 a_23111_1842# VSS 0.01732f ; **FLOATING
C560 a_22351_1842# VSS 0.01732f ; **FLOATING
C561 a_21591_1842# VSS 0.01732f ; **FLOATING
C562 a_20831_1842# VSS 0.01732f ; **FLOATING
C563 a_20071_1842# VSS 0.01732f ; **FLOATING
C564 a_19311_1842# VSS 0.01732f ; **FLOATING
C565 a_18551_1842# VSS 0.01732f ; **FLOATING
C566 a_17791_1842# VSS 0.01732f ; **FLOATING
C567 a_17031_1842# VSS 0.01732f ; **FLOATING
C568 a_16271_1842# VSS 0.01732f ; **FLOATING
C569 a_15511_1842# VSS 0.01732f ; **FLOATING
C570 a_14751_1842# VSS 0.01732f ; **FLOATING
C571 a_13991_1842# VSS 0.01732f ; **FLOATING
C572 a_13231_1842# VSS 0.01732f ; **FLOATING
C573 a_12471_1842# VSS 0.01732f ; **FLOATING
C574 a_11711_1842# VSS 0.01732f ; **FLOATING
C575 a_10951_1842# VSS 0.01732f ; **FLOATING
C576 a_10191_1842# VSS 0.01732f ; **FLOATING
C577 a_9431_1842# VSS 0.01732f ; **FLOATING
C578 a_8671_1842# VSS 0.01732f ; **FLOATING
C579 a_7911_1842# VSS 0.01732f ; **FLOATING
C580 a_7151_1842# VSS 0.01732f ; **FLOATING
C581 a_6391_1842# VSS 0.01732f ; **FLOATING
C582 a_5631_1842# VSS 0.01732f ; **FLOATING
C583 a_4871_1842# VSS 0.01732f ; **FLOATING
C584 a_4111_1842# VSS 0.01786f ; **FLOATING
C585 a_27563_1842# VSS 0.85349f ; **FLOATING
C586 a_27997_1842# VSS 0.69075f ; **FLOATING
C587 a_27433_1842# VSS 0.66121f ; **FLOATING
C588 a_26803_1842# VSS 0.85106f ; **FLOATING
C589 a_26673_1842# VSS 0.66121f ; **FLOATING
C590 a_26043_1842# VSS 0.85106f ; **FLOATING
C591 a_25913_1842# VSS 0.66121f ; **FLOATING
C592 a_25283_1842# VSS 0.85106f ; **FLOATING
C593 a_25153_1842# VSS 0.66121f ; **FLOATING
C594 a_24523_1842# VSS 0.85106f ; **FLOATING
C595 a_24393_1842# VSS 0.66121f ; **FLOATING
C596 a_23763_1842# VSS 0.85106f ; **FLOATING
C597 a_23633_1842# VSS 0.66121f ; **FLOATING
C598 a_23003_1842# VSS 0.85106f ; **FLOATING
C599 a_22873_1842# VSS 0.66121f ; **FLOATING
C600 a_22243_1842# VSS 0.85106f ; **FLOATING
C601 a_22113_1842# VSS 0.66121f ; **FLOATING
C602 a_21483_1842# VSS 0.85106f ; **FLOATING
C603 a_21353_1842# VSS 0.66121f ; **FLOATING
C604 a_20723_1842# VSS 0.85106f ; **FLOATING
C605 a_20593_1842# VSS 0.66121f ; **FLOATING
C606 a_19963_1842# VSS 0.85106f ; **FLOATING
C607 a_19833_1842# VSS 0.66121f ; **FLOATING
C608 a_19203_1842# VSS 0.85106f ; **FLOATING
C609 a_19073_1842# VSS 0.66121f ; **FLOATING
C610 a_18443_1842# VSS 0.85106f ; **FLOATING
C611 a_18313_1842# VSS 0.66121f ; **FLOATING
C612 a_17683_1842# VSS 0.85106f ; **FLOATING
C613 a_17553_1842# VSS 0.66121f ; **FLOATING
C614 a_16923_1842# VSS 0.85106f ; **FLOATING
C615 a_16793_1842# VSS 0.66121f ; **FLOATING
C616 a_16163_1842# VSS 0.85106f ; **FLOATING
C617 a_16033_1842# VSS 0.66121f ; **FLOATING
C618 a_15403_1842# VSS 0.85106f ; **FLOATING
C619 a_15273_1842# VSS 0.66121f ; **FLOATING
C620 a_14643_1842# VSS 0.85106f ; **FLOATING
C621 a_14513_1842# VSS 0.66121f ; **FLOATING
C622 a_13883_1842# VSS 0.85106f ; **FLOATING
C623 a_13753_1842# VSS 0.66121f ; **FLOATING
C624 a_13123_1842# VSS 0.85106f ; **FLOATING
C625 a_12993_1842# VSS 0.66121f ; **FLOATING
C626 a_12363_1842# VSS 0.85106f ; **FLOATING
C627 a_12233_1842# VSS 0.66121f ; **FLOATING
C628 a_11603_1842# VSS 0.85106f ; **FLOATING
C629 a_11473_1842# VSS 0.66121f ; **FLOATING
C630 a_10843_1842# VSS 0.85106f ; **FLOATING
C631 a_10713_1842# VSS 0.66121f ; **FLOATING
C632 a_10083_1842# VSS 0.85106f ; **FLOATING
C633 a_9953_1842# VSS 0.66121f ; **FLOATING
C634 a_9323_1842# VSS 0.85106f ; **FLOATING
C635 a_9193_1842# VSS 0.66121f ; **FLOATING
C636 a_8563_1842# VSS 0.85106f ; **FLOATING
C637 a_8433_1842# VSS 0.66121f ; **FLOATING
C638 a_7803_1842# VSS 0.85106f ; **FLOATING
C639 a_7673_1842# VSS 0.66121f ; **FLOATING
C640 a_7043_1842# VSS 0.85106f ; **FLOATING
C641 a_6913_1842# VSS 0.66121f ; **FLOATING
C642 a_6283_1842# VSS 0.85106f ; **FLOATING
C643 a_6153_1842# VSS 0.66121f ; **FLOATING
C644 a_5523_1842# VSS 0.85106f ; **FLOATING
C645 a_5393_1842# VSS 0.66121f ; **FLOATING
C646 a_4763_1842# VSS 0.85106f ; **FLOATING
C647 a_4633_1842# VSS 0.66121f ; **FLOATING
C648 a_4003_1842# VSS 0.93266f ; **FLOATING
C649 VDD.n0 VSS 0.04308f ; **FLOATING
C650 VDD.t17 VSS 1.03077f ; **FLOATING
C651 VDD.n2 VSS 0.43625f ; **FLOATING
C652 VDD.n3 VSS 0.06859f ; **FLOATING
C653 VDD.n4 VSS 0.03705f ; **FLOATING
C654 VDD.n5 VSS 0.80121f ; **FLOATING
C655 VDD.n6 VSS 0.60893f ; **FLOATING
C656 VDD.t8 VSS 0.39283f ; **FLOATING
C657 VDD.n8 VSS 0.47072f ; **FLOATING
C658 VDD.n9 VSS 0.03705f ; **FLOATING
C659 VDD.n10 VSS 0.04955f ; **FLOATING
C660 VDD.n11 VSS 0.03705f ; **FLOATING
C661 VDD.t0 VSS 71.4999f ; **FLOATING
C662 VDD.n15 VSS 0.03705f ; **FLOATING
C663 VDD.n16 VSS 0.51428f ; **FLOATING
C664 VDD.n18 VSS 0.03705f ; **FLOATING
C665 VDD.n19 VSS 0.03705f ; **FLOATING
C666 VDD.n20 VSS 0.402f ; **FLOATING
C667 VDD.n21 VSS 0.03705f ; **FLOATING
C668 VDD.n22 VSS 0.29526f ; **FLOATING
C669 VDD.t14 VSS 0.39298f ; **FLOATING
C670 VDD.n24 VSS 0.03705f ; **FLOATING
C671 VDD.n25 VSS 0.19622f ; **FLOATING
C672 VDD.n26 VSS 0.11177f ; **FLOATING
C673 VDD.n27 VSS 0.03705f ; **FLOATING
C674 VDD.n28 VSS 0.23644f ; **FLOATING
C675 VDD.n29 VSS 0.03705f ; **FLOATING
C676 VDD.n30 VSS 0.03705f ; **FLOATING
C677 VDD.n31 VSS 0.52778f ; **FLOATING
C678 VDD.n33 VSS 0.06859f ; **FLOATING
C679 VDD.n34 VSS 0.03705f ; **FLOATING
C680 VDD.n35 VSS 0.2401f ; **FLOATING
C681 VDD.n37 VSS 0.03705f ; **FLOATING
C682 VDD.n38 VSS 0.03705f ; **FLOATING
C683 VDD.n39 VSS 0.01444f ; **FLOATING
C684 VDD.n40 VSS 0.03705f ; **FLOATING
C685 VDD.n41 VSS 0.23286f ; **FLOATING
C686 VDD.n43 VSS 0.03705f ; **FLOATING
C687 VDD.n44 VSS 0.3206f ; **FLOATING
C688 VDD.t28 VSS 0.3929f ; **FLOATING
C689 VDD.t9 VSS 0.3929f ; **FLOATING
C690 VDD.t20 VSS 0.39283f ; **FLOATING
C691 VDD.n46 VSS 0.03705f ; **FLOATING
C692 VDD.n47 VSS 0.13434f ; **FLOATING
C693 VDD.n48 VSS 0.15689f ; **FLOATING
C694 VDD.n49 VSS 0.25856f ; **FLOATING
C695 VDD.n50 VSS 0.2695f ; **FLOATING
C696 VDD.n51 VSS 0.13161f ; **FLOATING
C697 VDD.n52 VSS 1.75529f ; **FLOATING
C698 VDD.n59 VSS 0.19569f ; **FLOATING
C699 VDD.n64 VSS 0.02141f ; **FLOATING
C700 VDD.n65 VSS 0.09507f ; **FLOATING
C701 VDD.n66 VSS 0.02141f ; **FLOATING
C702 VDD.n67 VSS 0.09507f ; **FLOATING
C703 VDD.n69 VSS 0.02141f ; **FLOATING
C704 VDD.n70 VSS 0.09507f ; **FLOATING
C705 VDD.n72 VSS 0.02141f ; **FLOATING
C706 VDD.n73 VSS 0.09507f ; **FLOATING
C707 VDD.n75 VSS 0.02141f ; **FLOATING
C708 VDD.n76 VSS 0.09507f ; **FLOATING
C709 VDD.n78 VSS 0.02141f ; **FLOATING
C710 VDD.n79 VSS 0.09507f ; **FLOATING
C711 VDD.n81 VSS 0.02141f ; **FLOATING
C712 VDD.n82 VSS 0.09507f ; **FLOATING
C713 VDD.n84 VSS 0.02141f ; **FLOATING
C714 VDD.n85 VSS 0.09507f ; **FLOATING
C715 VDD.n87 VSS 0.02141f ; **FLOATING
C716 VDD.n88 VSS 0.09507f ; **FLOATING
C717 VDD.n90 VSS 0.02141f ; **FLOATING
C718 VDD.n91 VSS 0.09507f ; **FLOATING
C719 VDD.n93 VSS 0.02141f ; **FLOATING
C720 VDD.n94 VSS 0.09507f ; **FLOATING
C721 VDD.n96 VSS 0.02141f ; **FLOATING
C722 VDD.n97 VSS 0.09507f ; **FLOATING
C723 VDD.n99 VSS 0.02141f ; **FLOATING
C724 VDD.n100 VSS 0.09507f ; **FLOATING
C725 VDD.n102 VSS 0.02141f ; **FLOATING
C726 VDD.n103 VSS 0.09507f ; **FLOATING
C727 VDD.n105 VSS 0.02141f ; **FLOATING
C728 VDD.n106 VSS 0.09507f ; **FLOATING
C729 VDD.n108 VSS 0.02141f ; **FLOATING
C730 VDD.n109 VSS 0.09507f ; **FLOATING
C731 VDD.n111 VSS 0.02141f ; **FLOATING
C732 VDD.n112 VSS 0.09507f ; **FLOATING
C733 VDD.n114 VSS 0.02141f ; **FLOATING
C734 VDD.n115 VSS 0.09507f ; **FLOATING
C735 VDD.n117 VSS 0.02141f ; **FLOATING
C736 VDD.n118 VSS 0.09507f ; **FLOATING
C737 VDD.n120 VSS 0.02141f ; **FLOATING
C738 VDD.n121 VSS 0.09507f ; **FLOATING
C739 VDD.n123 VSS 0.02141f ; **FLOATING
C740 VDD.n124 VSS 0.09507f ; **FLOATING
C741 VDD.n126 VSS 0.02141f ; **FLOATING
C742 VDD.n127 VSS 0.09507f ; **FLOATING
C743 VDD.n129 VSS 0.02141f ; **FLOATING
C744 VDD.n130 VSS 0.12639f ; **FLOATING
C745 VDD.n131 VSS 0.1264f ; **FLOATING
C746 VDD.n132 VSS 0.1264f ; **FLOATING
C747 VDD.n133 VSS 0.12639f ; **FLOATING
C748 VDD.n134 VSS 0.12639f ; **FLOATING
C749 VDD.n135 VSS 0.1264f ; **FLOATING
C750 VDD.n136 VSS 0.1264f ; **FLOATING
C751 VDD.n137 VSS 0.1264f ; **FLOATING
C752 VDD.n138 VSS 0.1264f ; **FLOATING
C753 VDD.n139 VSS 0.1264f ; **FLOATING
C754 VDD.n140 VSS 0.1264f ; **FLOATING
C755 VDD.n141 VSS 0.15411f ; **FLOATING
C756 VDD.n142 VSS 0.1264f ; **FLOATING
C757 VDD.n143 VSS 0.1264f ; **FLOATING
C758 VDD.n144 VSS 0.12639f ; **FLOATING
C759 VDD.n145 VSS 0.12639f ; **FLOATING
C760 VDD.n146 VSS 0.1264f ; **FLOATING
C761 VDD.n147 VSS 0.1264f ; **FLOATING
C762 VDD.n148 VSS 0.12639f ; **FLOATING
C763 VDD.n149 VSS 0.1264f ; **FLOATING
C764 VDD.n150 VSS 0.1264f ; **FLOATING
C765 VDD.n151 VSS 0.1264f ; **FLOATING
C766 VDD.n152 VSS 0.03705f ; **FLOATING
C767 VDD.n157 VSS 0.02141f ; **FLOATING
C768 VDD.n158 VSS 0.02141f ; **FLOATING
C769 VDD.n159 VSS 0.02141f ; **FLOATING
C770 VDD.n160 VSS 0.02141f ; **FLOATING
C771 VDD.n161 VSS 0.02141f ; **FLOATING
C772 VDD.n162 VSS 0.02141f ; **FLOATING
C773 VDD.n163 VSS 0.02141f ; **FLOATING
C774 VDD.n164 VSS 0.02141f ; **FLOATING
C775 VDD.n166 VSS 0.08039f ; **FLOATING
C776 VDD.n172 VSS 0.04387f ; **FLOATING
C777 VDD.n173 VSS 0.08774f ; **FLOATING
C778 VDD.n177 VSS 0.03705f ; **FLOATING
C779 VDD.n178 VSS 0.10576f ; **FLOATING
C780 VDD.n180 VSS 0.03705f ; **FLOATING
C781 VDD.n181 VSS 0.11091f ; **FLOATING
C782 VDD.n187 VSS 0.03705f ; **FLOATING
C783 VDD.n188 VSS 0.11572f ; **FLOATING
C784 VDD.n203 VSS 0.03652f ; **FLOATING
C785 VDD.n204 VSS 0.03705f ; **FLOATING
C786 VDD.n205 VSS 0.10576f ; **FLOATING
C787 VDD.n225 VSS 0.03317f ; **FLOATING
C788 VDD.n226 VSS 0.04051f ; **FLOATING
C789 VDD.n227 VSS 0.19086f ; **FLOATING
C790 VDD.n228 VSS 0.06358f ; **FLOATING
C791 VDD.n229 VSS 0.67057f ; **FLOATING
C792 VDD.n230 VSS 0.02359f ; **FLOATING
C793 VDD.n231 VSS 0.6706f ; **FLOATING
C794 VDD.n232 VSS 0.04724f ; **FLOATING
C795 VDD.n233 VSS 0.02892f ; **FLOATING
C796 VDD.n234 VSS 0.06859f ; **FLOATING
C797 VDD.n235 VSS 0.0686f ; **FLOATING
C798 VDD.n236 VSS 0.06859f ; **FLOATING
C799 VDD.n237 VSS 0.06859f ; **FLOATING
C800 VDD.n238 VSS 0.06859f ; **FLOATING
C801 VDD.n239 VSS 0.0686f ; **FLOATING
C802 VDD.n240 VSS 0.0686f ; **FLOATING
C803 VDD.n241 VSS 0.06859f ; **FLOATING
C804 VDD.n242 VSS 0.06859f ; **FLOATING
C805 VDD.n243 VSS 0.0686f ; **FLOATING
C806 VDD.n244 VSS 0.06859f ; **FLOATING
C807 VDD.n245 VSS 0.06859f ; **FLOATING
C808 VDD.n246 VSS 0.0686f ; **FLOATING
C809 VDD.n247 VSS 0.06859f ; **FLOATING
C810 VDD.n248 VSS 0.0686f ; **FLOATING
C811 VDD.n249 VSS 0.06859f ; **FLOATING
C812 VDD.n250 VSS 0.06859f ; **FLOATING
C813 VDD.n251 VSS 0.06859f ; **FLOATING
C814 VDD.n252 VSS 0.06859f ; **FLOATING
C815 VDD.n253 VSS 0.0686f ; **FLOATING
C816 VDD.n254 VSS 0.02055f ; **FLOATING
C817 VDD.n255 VSS 0.27598f ; **FLOATING
C818 VDD.n256 VSS 0.03253f ; **FLOATING
C819 VDD.t33 VSS 0.1048f ; **FLOATING
C820 VDD.t36 VSS 0.04828f ; **FLOATING
C821 VDD.n257 VSS 0.02462f ; **FLOATING
C822 VDD.t38 VSS 0.04996f ; **FLOATING
C823 VDD.t35 VSS 0.05584f ; **FLOATING
C824 VDD.t34 VSS 0.04996f ; **FLOATING
C825 VDD.t83 VSS 0.05859f ; **FLOATING
C826 VDD.t85 VSS 0.05859f ; **FLOATING
C827 VDD.t90 VSS 0.05859f ; **FLOATING
C828 VDD.t25 VSS 0.05859f ; **FLOATING
C829 VDD.t27 VSS 0.05859f ; **FLOATING
C830 VDD.t82 VSS 0.05859f ; **FLOATING
C831 VDD.t3 VSS 0.05859f ; **FLOATING
C832 VDD.t22 VSS 0.05859f ; **FLOATING
C833 VDD.t19 VSS 0.05859f ; **FLOATING
C834 VDD.t24 VSS 0.05859f ; **FLOATING
C835 VDD.t26 VSS 0.05859f ; **FLOATING
C836 VDD.t1 VSS 0.05859f ; **FLOATING
C837 VDD.t11 VSS 0.05859f ; **FLOATING
C838 VDD.t18 VSS 0.05859f ; **FLOATING
C839 VDD.t16 VSS 0.05859f ; **FLOATING
C840 VDD.t13 VSS 0.05859f ; **FLOATING
C841 VDD.t5 VSS 0.05859f ; **FLOATING
C842 VDD.t7 VSS 0.05859f ; **FLOATING
C843 VDD.t10 VSS 0.05859f ; **FLOATING
C844 VDD.t23 VSS 0.05859f ; **FLOATING
C845 VDD.t2 VSS 0.05859f ; **FLOATING
C846 VDD.t15 VSS 0.05859f ; **FLOATING
C847 VDD.t21 VSS 0.05859f ; **FLOATING
C848 VDD.t12 VSS 0.05859f ; **FLOATING
C849 VDD.n258 VSS 0.02892f ; **FLOATING
C850 VDD.n259 VSS 0.02892f ; **FLOATING
C851 VDD.n260 VSS 0.02892f ; **FLOATING
C852 VDD.n261 VSS 0.02892f ; **FLOATING
C853 VDD.n262 VSS 0.02892f ; **FLOATING
C854 VDD.n263 VSS 0.02892f ; **FLOATING
C855 VDD.n264 VSS 0.02892f ; **FLOATING
C856 VDD.n265 VSS 0.02892f ; **FLOATING
C857 VDD.n266 VSS 0.02892f ; **FLOATING
C858 VDD.n267 VSS 0.02892f ; **FLOATING
C859 VDD.n268 VSS 0.02892f ; **FLOATING
C860 VDD.n269 VSS 0.02892f ; **FLOATING
C861 VDD.n270 VSS 0.02892f ; **FLOATING
C862 VDD.n271 VSS 0.02892f ; **FLOATING
C863 VDD.n272 VSS 0.02892f ; **FLOATING
C864 VDD.n273 VSS 0.02892f ; **FLOATING
C865 VDD.n274 VSS 0.02892f ; **FLOATING
C866 VDD.n275 VSS 0.02892f ; **FLOATING
C867 VDD.n276 VSS 0.02892f ; **FLOATING
C868 VDD.n277 VSS 0.02892f ; **FLOATING
C869 VDD.n278 VSS 0.02892f ; **FLOATING
C870 VDD.n279 VSS 0.02892f ; **FLOATING
C871 VDD.n280 VSS 0.02892f ; **FLOATING
C872 VDD.n281 VSS 0.02892f ; **FLOATING
C873 VDD.n282 VSS 0.02892f ; **FLOATING
C874 VDD.n283 VSS 0.02892f ; **FLOATING
C875 VDD.n284 VSS 0.02892f ; **FLOATING
C876 VDD.n285 VSS 0.02892f ; **FLOATING
C877 VDD.n286 VSS 0.02892f ; **FLOATING
C878 VDD.n287 VSS 0.02892f ; **FLOATING
C879 VDD.n288 VSS 0.02892f ; **FLOATING
C880 VDD.n289 VSS 0.02892f ; **FLOATING
C881 VDD.n290 VSS 0.02892f ; **FLOATING
C882 VDD.n291 VSS 0.02892f ; **FLOATING
C883 VDD.n292 VSS 0.02892f ; **FLOATING
C884 VDD.n293 VSS 0.02892f ; **FLOATING
C885 VDD.t71 VSS 0.04996f ; **FLOATING
C886 VDD.t74 VSS 0.04996f ; **FLOATING
C887 VDD.n294 VSS 0.02892f ; **FLOATING
C888 VDD.n295 VSS 0.02892f ; **FLOATING
C889 VDD.n296 VSS 0.02892f ; **FLOATING
C890 VDD.n297 VSS 0.02892f ; **FLOATING
C891 VDD.t75 VSS 0.04996f ; **FLOATING
C892 VDD.n298 VSS 0.02892f ; **FLOATING
C893 VDD.n299 VSS 0.02892f ; **FLOATING
C894 VDD.t45 VSS 0.04996f ; **FLOATING
C895 VDD.n300 VSS 0.02892f ; **FLOATING
C896 VDD.n301 VSS 0.02892f ; **FLOATING
C897 VDD.t72 VSS 0.04996f ; **FLOATING
C898 VDD.n302 VSS 0.02892f ; **FLOATING
C899 VDD.n303 VSS 0.02892f ; **FLOATING
C900 VDD.t73 VSS 0.04996f ; **FLOATING
C901 VDD.n304 VSS 0.02892f ; **FLOATING
C902 VDD.n305 VSS 0.02892f ; **FLOATING
C903 VDD.n306 VSS 0.02892f ; **FLOATING
C904 VDD.n307 VSS 0.02892f ; **FLOATING
C905 VDD.t70 VSS 0.04996f ; **FLOATING
C906 VDD.n308 VSS 0.02892f ; **FLOATING
C907 VDD.n309 VSS 0.02892f ; **FLOATING
C908 VDD.t66 VSS 0.04996f ; **FLOATING
C909 VDD.n310 VSS 0.02892f ; **FLOATING
C910 VDD.n311 VSS 0.02892f ; **FLOATING
C911 VDD.t67 VSS 0.04996f ; **FLOATING
C912 VDD.n312 VSS 0.02892f ; **FLOATING
C913 VDD.n313 VSS 0.02892f ; **FLOATING
C914 VDD.t69 VSS 0.04996f ; **FLOATING
C915 VDD.n314 VSS 0.02892f ; **FLOATING
C916 VDD.n315 VSS 0.02892f ; **FLOATING
C917 VDD.n316 VSS 0.02892f ; **FLOATING
C918 VDD.n317 VSS 0.02892f ; **FLOATING
C919 VDD.t68 VSS 0.04996f ; **FLOATING
C920 VDD.n318 VSS 0.02892f ; **FLOATING
C921 VDD.n319 VSS 0.02892f ; **FLOATING
C922 VDD.t63 VSS 0.04996f ; **FLOATING
C923 VDD.n320 VSS 0.02892f ; **FLOATING
C924 VDD.n321 VSS 0.02892f ; **FLOATING
C925 VDD.t64 VSS 0.04996f ; **FLOATING
C926 VDD.n322 VSS 0.02892f ; **FLOATING
C927 VDD.n323 VSS 0.02892f ; **FLOATING
C928 VDD.t65 VSS 0.04996f ; **FLOATING
C929 VDD.n324 VSS 0.02892f ; **FLOATING
C930 VDD.n325 VSS 0.02892f ; **FLOATING
C931 VDD.n326 VSS 0.02892f ; **FLOATING
C932 VDD.n327 VSS 0.02892f ; **FLOATING
C933 VDD.t62 VSS 0.04996f ; **FLOATING
C934 VDD.n328 VSS 0.02892f ; **FLOATING
C935 VDD.n329 VSS 0.02892f ; **FLOATING
C936 VDD.t47 VSS 0.04996f ; **FLOATING
C937 VDD.n330 VSS 0.02892f ; **FLOATING
C938 VDD.n331 VSS 0.02892f ; **FLOATING
C939 VDD.t48 VSS 0.04996f ; **FLOATING
C940 VDD.n332 VSS 0.02892f ; **FLOATING
C941 VDD.n333 VSS 0.02892f ; **FLOATING
C942 VDD.t49 VSS 0.04996f ; **FLOATING
C943 VDD.n334 VSS 0.02892f ; **FLOATING
C944 VDD.n335 VSS 0.02892f ; **FLOATING
C945 VDD.n336 VSS 0.02892f ; **FLOATING
C946 VDD.n337 VSS 0.02892f ; **FLOATING
C947 VDD.t50 VSS 0.04996f ; **FLOATING
C948 VDD.n338 VSS 0.02892f ; **FLOATING
C949 VDD.n339 VSS 0.02892f ; **FLOATING
C950 VDD.t51 VSS 0.04996f ; **FLOATING
C951 VDD.n340 VSS 0.02892f ; **FLOATING
C952 VDD.n341 VSS 0.02892f ; **FLOATING
C953 VDD.t52 VSS 0.04996f ; **FLOATING
C954 VDD.n342 VSS 0.02892f ; **FLOATING
C955 VDD.n343 VSS 0.02892f ; **FLOATING
C956 VDD.t53 VSS 0.04996f ; **FLOATING
C957 VDD.n344 VSS 0.02892f ; **FLOATING
C958 VDD.n345 VSS 0.02892f ; **FLOATING
C959 VDD.n346 VSS 0.02892f ; **FLOATING
C960 VDD.n347 VSS 0.02892f ; **FLOATING
C961 VDD.t46 VSS 0.04996f ; **FLOATING
C962 VDD.n348 VSS 0.02892f ; **FLOATING
C963 VDD.n349 VSS 0.02892f ; **FLOATING
C964 VDD.n350 VSS 0.02892f ; **FLOATING
C965 VDD.n351 VSS 0.02892f ; **FLOATING
C966 VDD.n352 VSS 0.02892f ; **FLOATING
C967 VDD.n353 VSS 0.02892f ; **FLOATING
C968 VDD.n354 VSS 0.02892f ; **FLOATING
C969 VDD.n355 VSS 0.02892f ; **FLOATING
C970 VDD.n356 VSS 0.02892f ; **FLOATING
C971 VDD.n357 VSS 0.02892f ; **FLOATING
C972 VDD.n358 VSS 0.02892f ; **FLOATING
C973 VDD.n359 VSS 0.02892f ; **FLOATING
C974 VDD.n360 VSS 0.02892f ; **FLOATING
C975 VDD.n361 VSS 0.02892f ; **FLOATING
C976 VDD.n362 VSS 0.02892f ; **FLOATING
C977 VDD.n363 VSS 0.02892f ; **FLOATING
C978 VDD.n364 VSS 0.02892f ; **FLOATING
C979 VDD.n365 VSS 0.02892f ; **FLOATING
C980 VDD.n366 VSS 0.02892f ; **FLOATING
C981 VDD.n367 VSS 0.02892f ; **FLOATING
C982 VDD.n368 VSS 0.02892f ; **FLOATING
C983 VDD.n369 VSS 0.02892f ; **FLOATING
C984 VDD.n370 VSS 0.02892f ; **FLOATING
C985 VDD.n371 VSS 0.02892f ; **FLOATING
C986 VDD.n372 VSS 0.02892f ; **FLOATING
C987 VDD.n373 VSS 0.02892f ; **FLOATING
C988 VDD.n374 VSS 0.02892f ; **FLOATING
C989 VDD.n375 VSS 0.02892f ; **FLOATING
C990 VDD.n376 VSS 0.02892f ; **FLOATING
C991 VDD.n377 VSS 0.02892f ; **FLOATING
C992 VDD.n378 VSS 0.02892f ; **FLOATING
C993 VDD.n379 VSS 0.02892f ; **FLOATING
C994 VDD.n380 VSS 0.02892f ; **FLOATING
C995 VDD.n381 VSS 0.02892f ; **FLOATING
C996 VDD.n382 VSS 0.02892f ; **FLOATING
C997 VDD.n383 VSS 0.02892f ; **FLOATING
C998 VDD.n384 VSS 0.02892f ; **FLOATING
C999 VDD.n385 VSS 0.02892f ; **FLOATING
C1000 VDD.n386 VSS 0.02892f ; **FLOATING
C1001 VDD.n387 VSS 0.02892f ; **FLOATING
C1002 VDD.n388 VSS 0.02892f ; **FLOATING
C1003 VDD.n389 VSS 0.02892f ; **FLOATING
C1004 VDD.n390 VSS 0.02892f ; **FLOATING
C1005 VDD.n391 VSS 0.02892f ; **FLOATING
C1006 VDD.n392 VSS 0.02892f ; **FLOATING
C1007 VDD.n393 VSS 0.02892f ; **FLOATING
C1008 VDD.n394 VSS 0.02892f ; **FLOATING
C1009 VDD.n395 VSS 0.02892f ; **FLOATING
C1010 VDD.n396 VSS 0.02892f ; **FLOATING
C1011 VDD.n397 VSS 0.02892f ; **FLOATING
C1012 VDD.n398 VSS 0.02892f ; **FLOATING
C1013 VDD.n399 VSS 0.02892f ; **FLOATING
C1014 VDD.n400 VSS 0.02892f ; **FLOATING
C1015 VDD.n401 VSS 0.02892f ; **FLOATING
C1016 VDD.n402 VSS 0.02892f ; **FLOATING
C1017 VDD.n403 VSS 0.02892f ; **FLOATING
C1018 VDD.n404 VSS 0.02892f ; **FLOATING
C1019 VDD.n405 VSS 0.02892f ; **FLOATING
C1020 VDD.n406 VSS 0.02892f ; **FLOATING
C1021 VDD.n407 VSS 0.02892f ; **FLOATING
C1022 VDD.n408 VSS 0.02892f ; **FLOATING
C1023 VDD.n409 VSS 0.02892f ; **FLOATING
C1024 VDD.n410 VSS 0.02892f ; **FLOATING
C1025 VDD.n411 VSS 0.02892f ; **FLOATING
C1026 VDD.n412 VSS 0.02892f ; **FLOATING
C1027 VDD.n413 VSS 0.02892f ; **FLOATING
C1028 VDD.n414 VSS 0.02892f ; **FLOATING
C1029 VDD.n415 VSS 0.02892f ; **FLOATING
C1030 VDD.n416 VSS 0.02892f ; **FLOATING
C1031 VDD.n417 VSS 0.02892f ; **FLOATING
C1032 VDD.n418 VSS 0.02892f ; **FLOATING
C1033 VDD.n419 VSS 0.02892f ; **FLOATING
C1034 VDD.n420 VSS 0.02892f ; **FLOATING
C1035 VDD.n421 VSS 0.02892f ; **FLOATING
C1036 VDD.n422 VSS 0.02892f ; **FLOATING
C1037 VDD.n423 VSS 0.02892f ; **FLOATING
C1038 VDD.n424 VSS 0.02892f ; **FLOATING
C1039 VDD.n425 VSS 0.02892f ; **FLOATING
C1040 VDD.n426 VSS 0.02892f ; **FLOATING
C1041 VDD.n427 VSS 0.02892f ; **FLOATING
C1042 VDD.n428 VSS 0.02892f ; **FLOATING
C1043 VDD.n429 VSS 0.02892f ; **FLOATING
C1044 VDD.n430 VSS 0.02892f ; **FLOATING
C1045 VDD.n431 VSS 0.02892f ; **FLOATING
C1046 VDD.n432 VSS 0.02892f ; **FLOATING
C1047 VDD.n433 VSS 0.02892f ; **FLOATING
C1048 VDD.n434 VSS 0.02892f ; **FLOATING
C1049 VDD.n435 VSS 0.02892f ; **FLOATING
C1050 VDD.n436 VSS 0.02892f ; **FLOATING
C1051 VDD.n437 VSS 0.02892f ; **FLOATING
C1052 VDD.n438 VSS 0.02892f ; **FLOATING
C1053 VDD.n439 VSS 0.02892f ; **FLOATING
C1054 VDD.n440 VSS 0.02892f ; **FLOATING
C1055 VDD.n441 VSS 0.02892f ; **FLOATING
C1056 VDD.n442 VSS 0.02892f ; **FLOATING
C1057 VDD.n443 VSS 0.02892f ; **FLOATING
C1058 VDD.n444 VSS 0.02892f ; **FLOATING
C1059 VDD.n445 VSS 0.02892f ; **FLOATING
C1060 VDD.n446 VSS 0.02892f ; **FLOATING
C1061 VDD.n447 VSS 0.02892f ; **FLOATING
C1062 VDD.n448 VSS 0.02892f ; **FLOATING
C1063 VDD.n449 VSS 0.02892f ; **FLOATING
C1064 VDD.n450 VSS 0.02892f ; **FLOATING
C1065 VDD.n451 VSS 0.02892f ; **FLOATING
C1066 VDD.n452 VSS 0.02892f ; **FLOATING
C1067 VDD.n453 VSS 0.02892f ; **FLOATING
C1068 VDD.n454 VSS 0.02892f ; **FLOATING
C1069 VDD.n455 VSS 0.02892f ; **FLOATING
C1070 VDD.n456 VSS 0.02892f ; **FLOATING
C1071 VDD.n457 VSS 0.02892f ; **FLOATING
C1072 VDD.n458 VSS 0.02892f ; **FLOATING
C1073 VDD.n459 VSS 0.02892f ; **FLOATING
C1074 VDD.n460 VSS 0.02892f ; **FLOATING
C1075 VDD.n461 VSS 0.02892f ; **FLOATING
C1076 VDD.n462 VSS 0.02892f ; **FLOATING
C1077 VDD.n463 VSS 0.02892f ; **FLOATING
C1078 VDD.n464 VSS 0.02892f ; **FLOATING
C1079 VDD.n465 VSS 0.02892f ; **FLOATING
C1080 VDD.n466 VSS 0.02892f ; **FLOATING
C1081 VDD.n467 VSS 0.02892f ; **FLOATING
C1082 VDD.n468 VSS 0.02892f ; **FLOATING
C1083 VDD.n469 VSS 0.02892f ; **FLOATING
C1084 VDD.n470 VSS 0.02892f ; **FLOATING
C1085 VDD.n471 VSS 0.02892f ; **FLOATING
C1086 VDD.n472 VSS 0.02892f ; **FLOATING
C1087 VDD.n473 VSS 0.02892f ; **FLOATING
C1088 VDD.n474 VSS 0.02892f ; **FLOATING
C1089 VDD.n475 VSS 0.02892f ; **FLOATING
C1090 VDD.n476 VSS 0.02892f ; **FLOATING
C1091 VDD.n477 VSS 0.02892f ; **FLOATING
C1092 VDD.n478 VSS 0.02892f ; **FLOATING
C1093 VDD.n479 VSS 0.02892f ; **FLOATING
C1094 VDD.n480 VSS 0.02892f ; **FLOATING
C1095 VDD.n481 VSS 0.02892f ; **FLOATING
C1096 VDD.n482 VSS 0.02892f ; **FLOATING
C1097 VDD.n483 VSS 0.02892f ; **FLOATING
C1098 VDD.n484 VSS 0.02892f ; **FLOATING
C1099 VDD.n485 VSS 0.02892f ; **FLOATING
C1100 VDD.n486 VSS 0.02892f ; **FLOATING
C1101 VDD.n487 VSS 0.02892f ; **FLOATING
C1102 VDD.n488 VSS 0.02892f ; **FLOATING
C1103 VDD.n489 VSS 0.02892f ; **FLOATING
C1104 VDD.n490 VSS 0.02892f ; **FLOATING
C1105 VDD.n491 VSS 0.02892f ; **FLOATING
C1106 VDD.n492 VSS 0.02892f ; **FLOATING
C1107 VDD.n493 VSS 0.02892f ; **FLOATING
C1108 VDD.n494 VSS 0.02892f ; **FLOATING
C1109 VDD.n495 VSS 0.02892f ; **FLOATING
C1110 VDD.n496 VSS 0.02892f ; **FLOATING
C1111 VDD.n497 VSS 0.02892f ; **FLOATING
C1112 VDD.n498 VSS 0.02892f ; **FLOATING
C1113 VDD.n499 VSS 0.02892f ; **FLOATING
C1114 VDD.n500 VSS 0.02892f ; **FLOATING
C1115 VDD.n501 VSS 0.02892f ; **FLOATING
C1116 VDD.n502 VSS 0.02892f ; **FLOATING
C1117 VDD.n503 VSS 0.02892f ; **FLOATING
C1118 VDD.n504 VSS 0.02892f ; **FLOATING
C1119 VDD.n505 VSS 0.02892f ; **FLOATING
C1120 VDD.n506 VSS 0.02892f ; **FLOATING
C1121 VDD.n507 VSS 0.02892f ; **FLOATING
C1122 VDD.n508 VSS 0.02892f ; **FLOATING
C1123 VDD.n509 VSS 0.02892f ; **FLOATING
C1124 VDD.n510 VSS 0.02892f ; **FLOATING
C1125 VDD.n511 VSS 0.02892f ; **FLOATING
C1126 VDD.n512 VSS 0.02892f ; **FLOATING
C1127 VDD.n513 VSS 0.02892f ; **FLOATING
C1128 VDD.n514 VSS 0.02892f ; **FLOATING
C1129 VDD.n515 VSS 0.02892f ; **FLOATING
C1130 VDD.n516 VSS 0.02892f ; **FLOATING
C1131 VDD.n517 VSS 0.02892f ; **FLOATING
C1132 VDD.n518 VSS 0.02892f ; **FLOATING
C1133 VDD.n519 VSS 0.02892f ; **FLOATING
C1134 VDD.n520 VSS 0.02892f ; **FLOATING
C1135 VDD.n521 VSS 0.02892f ; **FLOATING
C1136 VDD.n522 VSS 0.02892f ; **FLOATING
C1137 VDD.n523 VSS 0.02892f ; **FLOATING
C1138 VDD.n524 VSS 0.02892f ; **FLOATING
C1139 VDD.n525 VSS 0.02892f ; **FLOATING
C1140 VDD.n526 VSS 0.02892f ; **FLOATING
C1141 VDD.n527 VSS 0.02892f ; **FLOATING
C1142 VDD.n528 VSS 0.02892f ; **FLOATING
C1143 VDD.n529 VSS 0.02892f ; **FLOATING
C1144 VDD.n530 VSS 0.02892f ; **FLOATING
C1145 VDD.n531 VSS 0.02892f ; **FLOATING
C1146 VDD.n532 VSS 0.02892f ; **FLOATING
C1147 VDD.n533 VSS 0.02892f ; **FLOATING
C1148 VDD.n534 VSS 0.02892f ; **FLOATING
C1149 VDD.n535 VSS 0.02892f ; **FLOATING
C1150 VDD.n536 VSS 0.02892f ; **FLOATING
C1151 VDD.n537 VSS 0.02892f ; **FLOATING
C1152 VDD.n538 VSS 0.02892f ; **FLOATING
C1153 VDD.n539 VSS 0.02892f ; **FLOATING
C1154 VDD.n540 VSS 0.02892f ; **FLOATING
C1155 VDD.n541 VSS 0.02892f ; **FLOATING
C1156 VDD.n542 VSS 0.02892f ; **FLOATING
C1157 VDD.n543 VSS 0.02892f ; **FLOATING
C1158 VDD.n544 VSS 0.02892f ; **FLOATING
C1159 VDD.n545 VSS 0.02892f ; **FLOATING
C1160 VDD.n546 VSS 0.02892f ; **FLOATING
C1161 VDD.n547 VSS 0.02892f ; **FLOATING
C1162 VDD.n548 VSS 0.02892f ; **FLOATING
C1163 VDD.n549 VSS 0.02892f ; **FLOATING
C1164 VDD.n550 VSS 0.02892f ; **FLOATING
C1165 VDD.n551 VSS 0.02892f ; **FLOATING
C1166 VDD.n552 VSS 0.02892f ; **FLOATING
C1167 VDD.n553 VSS 0.02892f ; **FLOATING
C1168 VDD.n554 VSS 0.02892f ; **FLOATING
C1169 VDD.n555 VSS 0.02892f ; **FLOATING
C1170 VDD.n556 VSS 0.02892f ; **FLOATING
C1171 VDD.n557 VSS 0.02892f ; **FLOATING
C1172 VDD.n558 VSS 0.02892f ; **FLOATING
C1173 VDD.n559 VSS 0.02892f ; **FLOATING
C1174 VDD.n560 VSS 0.02892f ; **FLOATING
C1175 VDD.n561 VSS 0.02892f ; **FLOATING
C1176 VDD.n562 VSS 0.02892f ; **FLOATING
C1177 VDD.n563 VSS 0.02892f ; **FLOATING
C1178 VDD.n564 VSS 0.02892f ; **FLOATING
C1179 VDD.n565 VSS 0.02892f ; **FLOATING
C1180 VDD.n566 VSS 0.02892f ; **FLOATING
C1181 VDD.n567 VSS 0.02892f ; **FLOATING
C1182 VDD.n568 VSS 0.02892f ; **FLOATING
C1183 VDD.n569 VSS 0.02892f ; **FLOATING
C1184 VDD.n570 VSS 0.02892f ; **FLOATING
C1185 VDD.n571 VSS 0.02892f ; **FLOATING
C1186 VDD.n572 VSS 0.16463f ; **FLOATING
C1187 VDD.n573 VSS 0.02892f ; **FLOATING
C1188 VDD.n574 VSS 0.05275f ; **FLOATING
C1189 VDD.n575 VSS 0.25078f ; **FLOATING
C1190 VDD.n576 VSS 0.02911f ; **FLOATING
C1191 VDD.n577 VSS 0.02892f ; **FLOATING
C1192 VDD.n578 VSS 0.0581f ; **FLOATING
C1193 VDD.n579 VSS 0.05783f ; **FLOATING
C1194 VDD.n580 VSS 0.02911f ; **FLOATING
C1195 VDD.n581 VSS 0.02892f ; **FLOATING
C1196 VDD.n582 VSS 0.0581f ; **FLOATING
C1197 VDD.n583 VSS 0.05783f ; **FLOATING
C1198 VDD.n584 VSS 0.02911f ; **FLOATING
C1199 VDD.n585 VSS 0.02892f ; **FLOATING
C1200 VDD.n586 VSS 0.0581f ; **FLOATING
C1201 VDD.n587 VSS 0.05783f ; **FLOATING
C1202 VDD.n588 VSS 0.02911f ; **FLOATING
C1203 VDD.n589 VSS 0.02892f ; **FLOATING
C1204 VDD.n590 VSS 0.0581f ; **FLOATING
C1205 VDD.n591 VSS 0.05783f ; **FLOATING
C1206 VDD.n592 VSS 0.02911f ; **FLOATING
C1207 VDD.n593 VSS 0.02892f ; **FLOATING
C1208 VDD.n594 VSS 0.0581f ; **FLOATING
C1209 VDD.n595 VSS 0.05783f ; **FLOATING
C1210 VDD.n596 VSS 0.02911f ; **FLOATING
C1211 VDD.n597 VSS 0.02892f ; **FLOATING
C1212 VDD.n598 VSS 0.0581f ; **FLOATING
C1213 VDD.n599 VSS 0.05783f ; **FLOATING
C1214 VDD.n600 VSS 0.02911f ; **FLOATING
C1215 VDD.n601 VSS 0.02892f ; **FLOATING
C1216 VDD.n602 VSS 0.0581f ; **FLOATING
C1217 VDD.n603 VSS 0.05783f ; **FLOATING
C1218 VDD.n604 VSS 0.02911f ; **FLOATING
C1219 VDD.n605 VSS 0.02892f ; **FLOATING
C1220 VDD.n606 VSS 0.0581f ; **FLOATING
C1221 VDD.n607 VSS 0.05783f ; **FLOATING
C1222 VDD.n608 VSS 0.02911f ; **FLOATING
C1223 VDD.n609 VSS 0.02892f ; **FLOATING
C1224 VDD.n610 VSS 0.0581f ; **FLOATING
C1225 VDD.n611 VSS 0.05783f ; **FLOATING
C1226 VDD.n612 VSS 0.02911f ; **FLOATING
C1227 VDD.n613 VSS 0.02892f ; **FLOATING
C1228 VDD.n614 VSS 0.0581f ; **FLOATING
C1229 VDD.n615 VSS 0.05783f ; **FLOATING
C1230 VDD.n616 VSS 0.02911f ; **FLOATING
C1231 VDD.n617 VSS 0.02892f ; **FLOATING
C1232 VDD.n618 VSS 0.0581f ; **FLOATING
C1233 VDD.n619 VSS 0.05783f ; **FLOATING
C1234 VDD.n620 VSS 0.02911f ; **FLOATING
C1235 VDD.n621 VSS 0.02892f ; **FLOATING
C1236 VDD.n622 VSS 0.0581f ; **FLOATING
C1237 VDD.n623 VSS 0.05783f ; **FLOATING
C1238 VDD.n624 VSS 0.02911f ; **FLOATING
C1239 VDD.n625 VSS 0.02892f ; **FLOATING
C1240 VDD.n626 VSS 0.0581f ; **FLOATING
C1241 VDD.n627 VSS 0.05783f ; **FLOATING
C1242 VDD.n628 VSS 0.02911f ; **FLOATING
C1243 VDD.n629 VSS 0.02892f ; **FLOATING
C1244 VDD.n630 VSS 0.0581f ; **FLOATING
C1245 VDD.n631 VSS 0.05783f ; **FLOATING
C1246 VDD.n632 VSS 0.02911f ; **FLOATING
C1247 VDD.n633 VSS 0.02892f ; **FLOATING
C1248 VDD.n634 VSS 0.0581f ; **FLOATING
C1249 VDD.n635 VSS 0.05783f ; **FLOATING
C1250 VDD.n636 VSS 0.02911f ; **FLOATING
C1251 VDD.n637 VSS 0.02892f ; **FLOATING
C1252 VDD.n638 VSS 0.0581f ; **FLOATING
C1253 VDD.n639 VSS 0.05783f ; **FLOATING
C1254 VDD.n640 VSS 0.02911f ; **FLOATING
C1255 VDD.n641 VSS 0.02892f ; **FLOATING
C1256 VDD.n642 VSS 0.0581f ; **FLOATING
C1257 VDD.n643 VSS 0.05783f ; **FLOATING
C1258 VDD.n644 VSS 0.02911f ; **FLOATING
C1259 VDD.n645 VSS 0.02892f ; **FLOATING
C1260 VDD.n646 VSS 0.0581f ; **FLOATING
C1261 VDD.n647 VSS 0.05783f ; **FLOATING
C1262 VDD.n648 VSS 0.02911f ; **FLOATING
C1263 VDD.n649 VSS 0.02892f ; **FLOATING
C1264 VDD.n650 VSS 0.0581f ; **FLOATING
C1265 VDD.n651 VSS 0.05783f ; **FLOATING
C1266 VDD.n652 VSS 0.02911f ; **FLOATING
C1267 VDD.n653 VSS 0.02892f ; **FLOATING
C1268 VDD.n654 VSS 0.0581f ; **FLOATING
C1269 VDD.n655 VSS 0.05783f ; **FLOATING
C1270 VDD.n656 VSS 0.02911f ; **FLOATING
C1271 VDD.n657 VSS 0.02892f ; **FLOATING
C1272 VDD.n658 VSS 0.0581f ; **FLOATING
C1273 VDD.n659 VSS 0.05783f ; **FLOATING
C1274 VDD.n660 VSS 0.02911f ; **FLOATING
C1275 VDD.n661 VSS 0.02892f ; **FLOATING
C1276 VDD.n662 VSS 0.0581f ; **FLOATING
C1277 VDD.n663 VSS 0.05783f ; **FLOATING
C1278 VDD.n664 VSS 0.02911f ; **FLOATING
C1279 VDD.n665 VSS 0.02892f ; **FLOATING
C1280 VDD.n666 VSS 0.0581f ; **FLOATING
C1281 VDD.n667 VSS 0.05783f ; **FLOATING
C1282 VDD.n668 VSS 0.02911f ; **FLOATING
C1283 VDD.n669 VSS 0.02892f ; **FLOATING
C1284 VDD.n670 VSS 0.0581f ; **FLOATING
C1285 VDD.n671 VSS 0.05783f ; **FLOATING
C1286 VDD.n672 VSS 0.02911f ; **FLOATING
C1287 VDD.n673 VSS 0.02892f ; **FLOATING
C1288 VDD.n674 VSS 0.0581f ; **FLOATING
C1289 VDD.n675 VSS 0.05783f ; **FLOATING
C1290 VDD.n676 VSS 0.02911f ; **FLOATING
C1291 VDD.n677 VSS 0.02892f ; **FLOATING
C1292 VDD.n678 VSS 0.0581f ; **FLOATING
C1293 VDD.n679 VSS 0.05783f ; **FLOATING
C1294 VDD.n680 VSS 0.02911f ; **FLOATING
C1295 VDD.n681 VSS 0.02892f ; **FLOATING
C1296 VDD.n682 VSS 0.0581f ; **FLOATING
C1297 VDD.n683 VSS 0.05783f ; **FLOATING
C1298 VDD.n684 VSS 0.02911f ; **FLOATING
C1299 VDD.n685 VSS 0.02892f ; **FLOATING
C1300 VDD.n686 VSS 0.0581f ; **FLOATING
C1301 VDD.n687 VSS 0.02892f ; **FLOATING
C1302 VDD.n688 VSS 0.02892f ; **FLOATING
C1303 VDD.n689 VSS 0.02245f ; **FLOATING
C1304 VDD.n690 VSS 0.03614f ; **FLOATING
C1305 VDD.n691 VSS 0.03642f ; **FLOATING
C1306 VDD.n692 VSS 0.02892f ; **FLOATING
C1307 VDD.n693 VSS 0.02911f ; **FLOATING
C1308 VDD.n694 VSS 0.05783f ; **FLOATING
C1309 VDD.n695 VSS 0.0581f ; **FLOATING
C1310 VDD.n696 VSS 0.02892f ; **FLOATING
C1311 VDD.n697 VSS 0.02911f ; **FLOATING
C1312 VDD.n698 VSS 0.05783f ; **FLOATING
C1313 VDD.n699 VSS 0.0581f ; **FLOATING
C1314 VDD.n700 VSS 0.02892f ; **FLOATING
C1315 VDD.n701 VSS 0.05783f ; **FLOATING
C1316 VDD.n702 VSS 0.02911f ; **FLOATING
C1317 VDD.n703 VSS 0.02892f ; **FLOATING
C1318 VDD.n704 VSS 0.02892f ; **FLOATING
C1319 VDD.n705 VSS 0.02892f ; **FLOATING
C1320 VDD.n706 VSS 0.02892f ; **FLOATING
C1321 VDD.n707 VSS 0.02892f ; **FLOATING
C1322 VDD.n708 VSS 0.02892f ; **FLOATING
C1323 VDD.n709 VSS 0.02892f ; **FLOATING
C1324 VDD.n710 VSS 0.02892f ; **FLOATING
C1325 VDD.n711 VSS 0.02892f ; **FLOATING
C1326 VDD.n712 VSS 0.02892f ; **FLOATING
C1327 VDD.n713 VSS 0.02892f ; **FLOATING
C1328 VDD.n714 VSS 0.02892f ; **FLOATING
C1329 VDD.n715 VSS 0.02892f ; **FLOATING
C1330 VDD.n716 VSS 0.02892f ; **FLOATING
C1331 VDD.n717 VSS 0.02892f ; **FLOATING
C1332 VDD.n718 VSS 0.02892f ; **FLOATING
C1333 VDD.n719 VSS 0.02892f ; **FLOATING
C1334 VDD.n720 VSS 0.02977f ; **FLOATING
C1335 VDD.n721 VSS 0.02169f ; **FLOATING
C1336 VDD.n722 VSS 0.03614f ; **FLOATING
C1337 VDD.n723 VSS 0.03614f ; **FLOATING
C1338 VDD.n724 VSS 0.27596f ; **FLOATING
C1339 VDD.n725 VSS 0.03253f ; **FLOATING
C1340 DELAY_VBIASP.n0 VSS 0.26973f ; **FLOATING
C1341 DELAY_VBIASP.t31 VSS 0.69071f ; **FLOATING
C1342 DELAY_VBIASP.t30 VSS 0.67526f ; **FLOATING
C1343 DELAY_VBIASP.n1 VSS 1.21008f ; **FLOATING
C1344 DELAY_VBIASP.t29 VSS 0.67526f ; **FLOATING
C1345 DELAY_VBIASP.n2 VSS 0.8374f ; **FLOATING
C1346 DELAY_VBIASP.t28 VSS 0.67526f ; **FLOATING
C1347 DELAY_VBIASP.n3 VSS 0.8374f ; **FLOATING
C1348 DELAY_VBIASP.t27 VSS 0.67526f ; **FLOATING
C1349 DELAY_VBIASP.n4 VSS 0.8374f ; **FLOATING
C1350 DELAY_VBIASP.t26 VSS 0.67526f ; **FLOATING
C1351 DELAY_VBIASP.n5 VSS 0.8374f ; **FLOATING
C1352 DELAY_VBIASP.t25 VSS 0.67526f ; **FLOATING
C1353 DELAY_VBIASP.n6 VSS 0.8374f ; **FLOATING
C1354 DELAY_VBIASP.t24 VSS 0.67526f ; **FLOATING
C1355 DELAY_VBIASP.n7 VSS 0.8374f ; **FLOATING
C1356 DELAY_VBIASP.t23 VSS 0.67526f ; **FLOATING
C1357 DELAY_VBIASP.n8 VSS 0.8374f ; **FLOATING
C1358 DELAY_VBIASP.t22 VSS 0.67526f ; **FLOATING
C1359 DELAY_VBIASP.n9 VSS 0.8374f ; **FLOATING
C1360 DELAY_VBIASP.t21 VSS 0.67526f ; **FLOATING
C1361 DELAY_VBIASP.n10 VSS 0.8374f ; **FLOATING
C1362 DELAY_VBIASP.t20 VSS 0.67526f ; **FLOATING
C1363 DELAY_VBIASP.n11 VSS 0.8374f ; **FLOATING
C1364 DELAY_VBIASP.t19 VSS 0.67526f ; **FLOATING
C1365 DELAY_VBIASP.n12 VSS 0.8374f ; **FLOATING
C1366 DELAY_VBIASP.t18 VSS 0.67526f ; **FLOATING
C1367 DELAY_VBIASP.n13 VSS 0.8374f ; **FLOATING
C1368 DELAY_VBIASP.t17 VSS 0.67526f ; **FLOATING
C1369 DELAY_VBIASP.n14 VSS 0.8374f ; **FLOATING
C1370 DELAY_VBIASP.t16 VSS 0.67526f ; **FLOATING
C1371 DELAY_VBIASP.n15 VSS 0.8374f ; **FLOATING
C1372 DELAY_VBIASP.t15 VSS 0.67526f ; **FLOATING
C1373 DELAY_VBIASP.n16 VSS 0.8374f ; **FLOATING
C1374 DELAY_VBIASP.t14 VSS 0.67526f ; **FLOATING
C1375 DELAY_VBIASP.n17 VSS 0.8374f ; **FLOATING
C1376 DELAY_VBIASP.t13 VSS 0.67526f ; **FLOATING
C1377 DELAY_VBIASP.n18 VSS 0.8374f ; **FLOATING
C1378 DELAY_VBIASP.t12 VSS 0.67526f ; **FLOATING
C1379 DELAY_VBIASP.n19 VSS 0.8374f ; **FLOATING
C1380 DELAY_VBIASP.t11 VSS 0.67526f ; **FLOATING
C1381 DELAY_VBIASP.n20 VSS 0.8374f ; **FLOATING
C1382 DELAY_VBIASP.t10 VSS 0.67526f ; **FLOATING
C1383 DELAY_VBIASP.n21 VSS 0.8374f ; **FLOATING
C1384 DELAY_VBIASP.t9 VSS 0.67526f ; **FLOATING
C1385 DELAY_VBIASP.n22 VSS 0.8374f ; **FLOATING
C1386 DELAY_VBIASP.t8 VSS 0.67526f ; **FLOATING
C1387 DELAY_VBIASP.n23 VSS 0.8374f ; **FLOATING
C1388 DELAY_VBIASP.t7 VSS 0.67526f ; **FLOATING
C1389 DELAY_VBIASP.n24 VSS 0.8374f ; **FLOATING
C1390 DELAY_VBIASP.t6 VSS 0.67526f ; **FLOATING
C1391 DELAY_VBIASP.n25 VSS 0.8374f ; **FLOATING
C1392 DELAY_VBIASP.t5 VSS 0.67526f ; **FLOATING
C1393 DELAY_VBIASP.n26 VSS 0.8374f ; **FLOATING
C1394 DELAY_VBIASP.t4 VSS 0.67526f ; **FLOATING
C1395 DELAY_VBIASP.n27 VSS 0.8374f ; **FLOATING
C1396 DELAY_VBIASP.t3 VSS 0.67526f ; **FLOATING
C1397 DELAY_VBIASP.n28 VSS 0.8374f ; **FLOATING
C1398 DELAY_VBIASP.t2 VSS 0.67526f ; **FLOATING
C1399 DELAY_VBIASP.n29 VSS 0.8374f ; **FLOATING
C1400 DELAY_VBIASP.t1 VSS 0.67526f ; **FLOATING
C1401 DELAY_VBIASP.n30 VSS 0.8374f ; **FLOATING
C1402 DELAY_VBIASP.t0 VSS 0.67526f ; **FLOATING
C1403 DELAY_VBIASN.n0 VSS 0.20958f ; **FLOATING
C1404 DELAY_VBIASN.t31 VSS 0.12503f ; **FLOATING
C1405 DELAY_VBIASN.t30 VSS 0.12136f ; **FLOATING
C1406 DELAY_VBIASN.n1 VSS 0.2872f ; **FLOATING
C1407 DELAY_VBIASN.t29 VSS 0.12136f ; **FLOATING
C1408 DELAY_VBIASN.n2 VSS 0.19922f ; **FLOATING
C1409 DELAY_VBIASN.t28 VSS 0.12136f ; **FLOATING
C1410 DELAY_VBIASN.n3 VSS 0.19922f ; **FLOATING
C1411 DELAY_VBIASN.t27 VSS 0.12136f ; **FLOATING
C1412 DELAY_VBIASN.n4 VSS 0.19922f ; **FLOATING
C1413 DELAY_VBIASN.t26 VSS 0.12136f ; **FLOATING
C1414 DELAY_VBIASN.n5 VSS 0.19922f ; **FLOATING
C1415 DELAY_VBIASN.t25 VSS 0.12136f ; **FLOATING
C1416 DELAY_VBIASN.n6 VSS 0.19922f ; **FLOATING
C1417 DELAY_VBIASN.t24 VSS 0.12136f ; **FLOATING
C1418 DELAY_VBIASN.n7 VSS 0.19922f ; **FLOATING
C1419 DELAY_VBIASN.t23 VSS 0.12136f ; **FLOATING
C1420 DELAY_VBIASN.n8 VSS 0.19922f ; **FLOATING
C1421 DELAY_VBIASN.t22 VSS 0.12136f ; **FLOATING
C1422 DELAY_VBIASN.n9 VSS 0.19922f ; **FLOATING
C1423 DELAY_VBIASN.t21 VSS 0.12136f ; **FLOATING
C1424 DELAY_VBIASN.n10 VSS 0.19922f ; **FLOATING
C1425 DELAY_VBIASN.t20 VSS 0.12136f ; **FLOATING
C1426 DELAY_VBIASN.n11 VSS 0.19922f ; **FLOATING
C1427 DELAY_VBIASN.t19 VSS 0.12136f ; **FLOATING
C1428 DELAY_VBIASN.n12 VSS 0.19922f ; **FLOATING
C1429 DELAY_VBIASN.t18 VSS 0.12136f ; **FLOATING
C1430 DELAY_VBIASN.n13 VSS 0.19922f ; **FLOATING
C1431 DELAY_VBIASN.t17 VSS 0.12136f ; **FLOATING
C1432 DELAY_VBIASN.n14 VSS 0.19922f ; **FLOATING
C1433 DELAY_VBIASN.t16 VSS 0.12136f ; **FLOATING
C1434 DELAY_VBIASN.n15 VSS 0.19922f ; **FLOATING
C1435 DELAY_VBIASN.t15 VSS 0.12136f ; **FLOATING
C1436 DELAY_VBIASN.n16 VSS 0.19922f ; **FLOATING
C1437 DELAY_VBIASN.t14 VSS 0.12136f ; **FLOATING
C1438 DELAY_VBIASN.n17 VSS 0.19922f ; **FLOATING
C1439 DELAY_VBIASN.t13 VSS 0.12136f ; **FLOATING
C1440 DELAY_VBIASN.n18 VSS 0.19922f ; **FLOATING
C1441 DELAY_VBIASN.t12 VSS 0.12136f ; **FLOATING
C1442 DELAY_VBIASN.n19 VSS 0.19922f ; **FLOATING
C1443 DELAY_VBIASN.t11 VSS 0.12136f ; **FLOATING
C1444 DELAY_VBIASN.n20 VSS 0.19922f ; **FLOATING
C1445 DELAY_VBIASN.t10 VSS 0.12136f ; **FLOATING
C1446 DELAY_VBIASN.n21 VSS 0.19922f ; **FLOATING
C1447 DELAY_VBIASN.t9 VSS 0.12136f ; **FLOATING
C1448 DELAY_VBIASN.n22 VSS 0.19922f ; **FLOATING
C1449 DELAY_VBIASN.t8 VSS 0.12136f ; **FLOATING
C1450 DELAY_VBIASN.n23 VSS 0.19922f ; **FLOATING
C1451 DELAY_VBIASN.t7 VSS 0.12136f ; **FLOATING
C1452 DELAY_VBIASN.n24 VSS 0.19922f ; **FLOATING
C1453 DELAY_VBIASN.t6 VSS 0.12136f ; **FLOATING
C1454 DELAY_VBIASN.n25 VSS 0.19922f ; **FLOATING
C1455 DELAY_VBIASN.t5 VSS 0.12136f ; **FLOATING
C1456 DELAY_VBIASN.n26 VSS 0.19922f ; **FLOATING
C1457 DELAY_VBIASN.t4 VSS 0.12136f ; **FLOATING
C1458 DELAY_VBIASN.n27 VSS 0.19922f ; **FLOATING
C1459 DELAY_VBIASN.t3 VSS 0.12136f ; **FLOATING
C1460 DELAY_VBIASN.n28 VSS 0.19922f ; **FLOATING
C1461 DELAY_VBIASN.t2 VSS 0.12136f ; **FLOATING
C1462 DELAY_VBIASN.n29 VSS 0.19922f ; **FLOATING
C1463 DELAY_VBIASN.t1 VSS 0.12136f ; **FLOATING
C1464 DELAY_VBIASN.n30 VSS 0.19922f ; **FLOATING
C1465 DELAY_VBIASN.t0 VSS 0.12136f ; **FLOATING
.ends
