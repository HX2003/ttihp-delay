* NGSPICE file created from hx_delay_line.ext - technology: ihp-sg13g2

.subckt hx_delay_line VSS VDD DELAY_OUT_LAST DELAY_OUT_TAP1 DELAY_OUT_TAP2 DELAY_OUT_TAP3
+ DELAY_OUT_TAP4 DELAY_OUT_TAP5 DELAY_OUT_TAP6 DELAY_OUT_TAP7 DELAY_OUT_TAP8 DELAY_OUT_TAP9
+ DELAY_OUT_TAP10 DELAY_OUT_TAP11 DELAY_OUT_TAP12 DELAY_OUT_TAP13 DELAY_OUT_TAP14
+ DELAY_OUT_TAP15 DELAY_OUT_TAP16 DELAY_OUT_TAP17 DELAY_OUT_TAP18 DELAY_OUT_TAP19
+ DELAY_OUT_TAP20 DELAY_OUT_TAP21 DELAY_OUT_TAP22 DELAY_OUT_TAP23 DELAY_OUT_TAP24
+ DELAY_OUT_TAP25 DELAY_OUT_TAP26 DELAY_OUT_TAP27 DELAY_OUT_TAP28 DELAY_OUT_TAP29
+ DELAY_OUT_TAP30 DELAY_OUT_TAP31 DELAY_IN DELAY_VBIASN DELAY_VBIASP
X0 VDD.t56 DELAY_VBIASP.t3 a_25131_2470# VDD.t0 sg13_lv_pmos ad=0.3808p pd=2.92u as=0.2128p ps=1.5u w=1.12u l=0.6u
X1 VSS.t78 a_5263_1842# DELAY_OUT_TAP3 VSS.t92 sg13_lv_nmos ad=0.1406p pd=1.12u as=0.2516p ps=2.16u w=0.74u l=0.13u
X2 VDD.t63 DELAY_VBIASP.t31 a_3851_2470# VDD.t0 sg13_lv_pmos ad=0.3808p pd=2.92u as=0.2128p ps=1.5u w=1.12u l=0.6u
X3 a_27411_2470# a_27173_1842# a_27303_1842# VDD.t0 sg13_lv_pmos ad=0.2128p pd=1.5u as=0.3808p ps=2.92u w=1.12u l=0.2u
X4 a_9171_1842# a_8933_1842# a_9063_1842# VSS.t2 sg13_lv_nmos ad=0.1406p pd=1.12u as=0.2516p ps=2.16u w=0.74u l=0.2u
X5 a_18053_1842# DELAY_OUT_TAP19 VSS.t86 VSS.t85 sg13_lv_nmos ad=0.2516p pd=2.16u as=0.1406p ps=1.12u w=0.74u l=0.13u
X6 a_15013_1842# DELAY_OUT_TAP15 VDD.t46 VDD.t0 sg13_lv_pmos ad=0.3808p pd=2.92u as=0.2128p ps=1.5u w=1.12u l=0.13u
X7 VDD.t58 DELAY_VBIASP.t15 a_16011_2470# VDD.t0 sg13_lv_pmos ad=0.3808p pd=2.92u as=0.2128p ps=1.5u w=1.12u l=0.6u
X8 VSS.t32 a_7543_1842# DELAY_OUT_TAP6 VSS.t31 sg13_lv_nmos ad=0.1406p pd=1.12u as=0.2516p ps=2.16u w=0.74u l=0.13u
X9 VDD.t64 DELAY_VBIASP.t28 a_6131_2470# VDD.t0 sg13_lv_pmos ad=0.3808p pd=2.92u as=0.2128p ps=1.5u w=1.12u l=0.6u
X10 VDD.t43 a_25783_1842# DELAY_OUT_TAP30 VDD.t0 sg13_lv_pmos ad=0.2128p pd=1.5u as=0.3808p ps=2.92u w=1.12u l=0.13u
X11 a_14491_1842# a_14253_1842# a_14383_1842# VSS.t150 sg13_lv_nmos ad=0.1406p pd=1.12u as=0.2516p ps=2.16u w=0.74u l=0.2u
X12 a_8411_2470# a_8173_1842# a_8303_1842# VDD.t0 sg13_lv_pmos ad=0.2128p pd=1.5u as=0.3808p ps=2.92u w=1.12u l=0.2u
X13 a_17293_1842# DELAY_OUT_TAP18 VDD.t3 VDD.t0 sg13_lv_pmos ad=0.3808p pd=2.92u as=0.2128p ps=1.5u w=1.12u l=0.13u
X14 VSS.t18 VSS.t14 VSS.t14 VSS.t16 sg13_lv_nmos ad=0.1406p pd=1.12u as=0 ps=0 w=0.74u l=0.13u
X15 VDD.t44 a_17423_1842# DELAY_OUT_TAP19 VDD.t0 sg13_lv_pmos ad=0.2128p pd=1.5u as=0.3808p ps=2.92u w=1.12u l=0.13u
X16 a_21093_1842# DELAY_OUT_TAP23 VDD.t8 VDD.t0 sg13_lv_pmos ad=0.3808p pd=2.92u as=0.2128p ps=1.5u w=1.12u l=0.13u
X17 a_22851_2470# a_22613_1842# a_22743_1842# VDD.t0 sg13_lv_pmos ad=0.2128p pd=1.5u as=0.3808p ps=2.92u w=1.12u l=0.2u
X18 VSS.t11 a_12863_1842# DELAY_OUT_TAP13 VSS.t10 sg13_lv_nmos ad=0.1406p pd=1.12u as=0.2516p ps=2.16u w=0.74u l=0.13u
X19 VDD.t16 a_6783_1842# DELAY_OUT_TAP5 VDD.t0 sg13_lv_pmos ad=0.2128p pd=1.5u as=0.3808p ps=2.92u w=1.12u l=0.13u
X20 VDD.t69 DELAY_VBIASP.t21 a_11451_2470# VDD.t0 sg13_lv_pmos ad=0.3808p pd=2.92u as=0.2128p ps=1.5u w=1.12u l=0.6u
X21 VDD.t53 a_21223_1842# DELAY_OUT_TAP24 VDD.t0 sg13_lv_pmos ad=0.2128p pd=1.5u as=0.3808p ps=2.92u w=1.12u l=0.13u
X22 a_12733_1842# DELAY_OUT_TAP12 VDD.t2 VDD.t0 sg13_lv_pmos ad=0.3808p pd=2.92u as=0.2128p ps=1.5u w=1.12u l=0.13u
X23 a_13731_2470# a_13493_1842# a_13623_1842# VDD.t0 sg13_lv_pmos ad=0.2128p pd=1.5u as=0.3808p ps=2.92u w=1.12u l=0.2u
X24 a_3851_2470# DELAY_IN a_3743_1842# VDD.t0 sg13_lv_pmos ad=0.2128p pd=1.5u as=0.3808p ps=2.92u w=1.12u l=0.2u
X25 VSS.t73 DELAY_VBIASN.t12 a_18291_1842# VSS.t134 sg13_lv_nmos ad=0.2516p pd=2.16u as=0.1406p ps=1.12u w=0.74u l=0.6u
X26 VDD.t9 a_23503_1842# DELAY_OUT_TAP27 VDD.t0 sg13_lv_pmos ad=0.2128p pd=1.5u as=0.3808p ps=2.92u w=1.12u l=0.13u
X27 VDD.t85 DELAY_VBIASP.t1 a_26651_2470# VDD.t0 sg13_lv_pmos ad=0.3808p pd=2.92u as=0.2128p ps=1.5u w=1.12u l=0.6u
X28 VSS.t105 DELAY_VBIASN.t7 a_22091_1842# VSS.t141 sg13_lv_nmos ad=0.2516p pd=2.16u as=0.1406p ps=1.12u w=0.74u l=0.6u
X29 a_19573_1842# DELAY_OUT_TAP21 VSS.t70 VSS.t87 sg13_lv_nmos ad=0.2516p pd=2.16u as=0.1406p ps=1.12u w=0.74u l=0.13u
X30 VDD.t14 a_4503_1842# DELAY_OUT_TAP2 VDD.t0 sg13_lv_pmos ad=0.2128p pd=1.5u as=0.3808p ps=2.92u w=1.12u l=0.13u
X31 DELAY_OUT_LAST a_27737_1842# VDD.t6 VDD.t0 sg13_lv_pmos ad=0.3808p pd=2.92u as=0.2128p ps=1.5u w=1.12u l=0.13u
X32 VSS.t1 a_9063_1842# DELAY_OUT_TAP8 VSS.t0 sg13_lv_nmos ad=0.1406p pd=1.12u as=0.2516p ps=2.16u w=0.74u l=0.13u
X33 a_23373_1842# DELAY_OUT_TAP26 VSS.t97 VSS.t96 sg13_lv_nmos ad=0.2516p pd=2.16u as=0.1406p ps=1.12u w=0.74u l=0.13u
X34 VDD.t60 DELAY_VBIASP.t26 a_7651_2470# VDD.t0 sg13_lv_pmos ad=0.3808p pd=2.92u as=0.2128p ps=1.5u w=1.12u l=0.6u
X35 VSS.t65 DELAY_VBIASN.t18 a_13731_1842# VSS.t123 sg13_lv_nmos ad=0.2516p pd=2.16u as=0.1406p ps=1.12u w=0.74u l=0.6u
X36 a_9931_2470# a_9693_1842# a_9823_1842# VDD.t0 sg13_lv_pmos ad=0.2128p pd=1.5u as=0.3808p ps=2.92u w=1.12u l=0.2u
X37 a_11451_2470# a_11213_1842# a_11343_1842# VDD.t0 sg13_lv_pmos ad=0.2128p pd=1.5u as=0.3808p ps=2.92u w=1.12u l=0.2u
X38 a_18813_1842# DELAY_OUT_TAP20 VDD.t23 VDD.t0 sg13_lv_pmos ad=0.3808p pd=2.92u as=0.2128p ps=1.5u w=1.12u l=0.13u
X39 a_16011_1842# a_15773_1842# a_15903_1842# VSS.t173 sg13_lv_nmos ad=0.1406p pd=1.12u as=0.2516p ps=2.16u w=0.74u l=0.2u
X40 a_8933_1842# DELAY_OUT_TAP7 VDD.t11 VDD.t0 sg13_lv_pmos ad=0.3808p pd=2.92u as=0.2128p ps=1.5u w=1.12u l=0.13u
X41 VDD.t18 a_9823_1842# DELAY_OUT_TAP9 VDD.t0 sg13_lv_pmos ad=0.2128p pd=1.5u as=0.3808p ps=2.92u w=1.12u l=0.13u
X42 a_22613_1842# DELAY_OUT_TAP25 VDD.t87 VDD.t0 sg13_lv_pmos ad=0.3808p pd=2.92u as=0.2128p ps=1.5u w=1.12u l=0.13u
X43 a_4373_1842# DELAY_OUT_TAP1 VSS.t46 VSS.t93 sg13_lv_nmos ad=0.2516p pd=2.16u as=0.1406p ps=1.12u w=0.74u l=0.13u
X44 VSS.t89 a_14383_1842# DELAY_OUT_TAP15 VSS.t172 sg13_lv_nmos ad=0.1406p pd=1.12u as=0.2516p ps=2.16u w=0.74u l=0.13u
X45 a_18291_1842# a_18053_1842# a_18183_1842# VSS.t111 sg13_lv_nmos ad=0.1406p pd=1.12u as=0.2516p ps=2.16u w=0.74u l=0.2u
X46 a_26651_2470# a_26413_1842# a_26543_1842# VDD.t0 sg13_lv_pmos ad=0.2128p pd=1.5u as=0.3808p ps=2.92u w=1.12u l=0.2u
X47 a_22091_1842# a_21853_1842# a_21983_1842# VSS.t151 sg13_lv_nmos ad=0.1406p pd=1.12u as=0.2516p ps=2.16u w=0.74u l=0.2u
X48 VSS.t7 a_16663_1842# DELAY_OUT_TAP18 VSS.t6 sg13_lv_nmos ad=0.1406p pd=1.12u as=0.2516p ps=2.16u w=0.74u l=0.13u
X49 VDD.t73 DELAY_VBIASP.t16 a_15251_2470# VDD.t0 sg13_lv_pmos ad=0.3808p pd=2.92u as=0.2128p ps=1.5u w=1.12u l=0.6u
X50 VSS.t67 DELAY_VBIASN.t10 a_19811_1842# VSS.t143 sg13_lv_nmos ad=0.2516p pd=2.16u as=0.1406p ps=1.12u w=0.74u l=0.6u
X51 VDD.t51 a_25023_1842# DELAY_OUT_TAP29 VDD.t0 sg13_lv_pmos ad=0.2128p pd=1.5u as=0.3808p ps=2.92u w=1.12u l=0.13u
X52 VSS.t38 DELAY_VBIASN.t5 a_23611_1842# VSS.t145 sg13_lv_nmos ad=0.2516p pd=2.16u as=0.1406p ps=1.12u w=0.74u l=0.6u
X53 a_17531_2470# a_17293_1842# a_17423_1842# VDD.t0 sg13_lv_pmos ad=0.2128p pd=1.5u as=0.3808p ps=2.92u w=1.12u l=0.2u
X54 a_7651_2470# a_7413_1842# a_7543_1842# VDD.t0 sg13_lv_pmos ad=0.2128p pd=1.5u as=0.3808p ps=2.92u w=1.12u l=0.2u
X55 a_16533_1842# DELAY_OUT_TAP17 VDD.t12 VDD.t0 sg13_lv_pmos ad=0.3808p pd=2.92u as=0.2128p ps=1.5u w=1.12u l=0.13u
X56 a_20333_1842# DELAY_OUT_TAP22 VDD.t21 VDD.t0 sg13_lv_pmos ad=0.3808p pd=2.92u as=0.2128p ps=1.5u w=1.12u l=0.13u
X57 a_21331_2470# a_21093_1842# a_21223_1842# VDD.t0 sg13_lv_pmos ad=0.2128p pd=1.5u as=0.3808p ps=2.92u w=1.12u l=0.2u
X58 a_24893_1842# DELAY_OUT_TAP28 VSS.t103 VSS.t102 sg13_lv_nmos ad=0.2516p pd=2.16u as=0.1406p ps=1.12u w=0.74u l=0.13u
X59 VSS.t4 a_12103_1842# DELAY_OUT_TAP12 VSS.t3 sg13_lv_nmos ad=0.1406p pd=1.12u as=0.2516p ps=2.16u w=0.74u l=0.13u
X60 VDD.t17 a_6023_1842# DELAY_OUT_TAP4 VDD.t0 sg13_lv_pmos ad=0.2128p pd=1.5u as=0.3808p ps=2.92u w=1.12u l=0.13u
X61 VSS.t51 DELAY_VBIASN.t30 a_4611_1842# VSS.t121 sg13_lv_nmos ad=0.2516p pd=2.16u as=0.1406p ps=1.12u w=0.74u l=0.6u
X62 a_11213_1842# DELAY_OUT_TAP10 VDD.t5 VDD.t0 sg13_lv_pmos ad=0.3808p pd=2.92u as=0.2128p ps=1.5u w=1.12u l=0.13u
X63 a_12971_2470# a_12733_1842# a_12863_1842# VDD.t0 sg13_lv_pmos ad=0.2128p pd=1.5u as=0.3808p ps=2.92u w=1.12u l=0.2u
X64 VDD.t19 a_11343_1842# DELAY_OUT_TAP11 VDD.t0 sg13_lv_pmos ad=0.2128p pd=1.5u as=0.3808p ps=2.92u w=1.12u l=0.13u
X65 a_5893_1842# DELAY_OUT_TAP3 VSS.t78 VSS.t77 sg13_lv_nmos ad=0.2516p pd=2.16u as=0.1406p ps=1.12u w=0.74u l=0.13u
X66 a_27173_1842# DELAY_OUT_TAP31 VSS.t116 VSS.t115 sg13_lv_nmos ad=0.2516p pd=2.16u as=0.1406p ps=1.12u w=0.74u l=0.13u
X67 VSS.t86 DELAY_VBIASN.t13 a_17531_1842# VSS.t135 sg13_lv_nmos ad=0.2516p pd=2.16u as=0.1406p ps=1.12u w=0.74u l=0.6u
X68 VSS.t30 a_27303_1842# a_27737_1842# VSS.t39 sg13_lv_nmos ad=0.1406p pd=1.12u as=0.2516p ps=2.16u w=0.74u l=0.13u
X69 VSS.t99 DELAY_VBIASN.t8 a_21331_1842# VSS.t142 sg13_lv_nmos ad=0.2516p pd=2.16u as=0.1406p ps=1.12u w=0.74u l=0.6u
X70 a_15251_2470# a_15013_1842# a_15143_1842# VDD.t0 sg13_lv_pmos ad=0.2128p pd=1.5u as=0.3808p ps=2.92u w=1.12u l=0.2u
X71 VSS.t21 VSS.t23 VSS.t23 VSS.t24 sg13_lv_nmos ad=0.1406p pd=1.12u as=0 ps=0 w=0.74u l=0.2u
X72 a_19811_1842# a_19573_1842# a_19703_1842# VSS.t159 sg13_lv_nmos ad=0.1406p pd=1.12u as=0.2516p ps=2.16u w=0.74u l=0.2u
X73 a_8173_1842# DELAY_OUT_TAP6 VSS.t32 VSS.t106 sg13_lv_nmos ad=0.2516p pd=2.16u as=0.1406p ps=1.12u w=0.74u l=0.13u
X74 a_23611_1842# a_23373_1842# a_23503_1842# VSS.t28 sg13_lv_nmos ad=0.1406p pd=1.12u as=0.2516p ps=2.16u w=0.74u l=0.2u
X75 VDD.t20 a_13623_1842# DELAY_OUT_TAP14 VDD.t0 sg13_lv_pmos ad=0.2128p pd=1.5u as=0.3808p ps=2.92u w=1.12u l=0.13u
X76 a_26413_1842# DELAY_OUT_TAP30 VDD.t43 VDD.t0 sg13_lv_pmos ad=0.3808p pd=2.92u as=0.2128p ps=1.5u w=1.12u l=0.13u
X77 VSS.t41 a_8303_1842# DELAY_OUT_TAP7 VSS.t40 sg13_lv_nmos ad=0.1406p pd=1.12u as=0.2516p ps=2.16u w=0.74u l=0.13u
X78 VSS.t73 a_18183_1842# DELAY_OUT_TAP20 VSS.t72 sg13_lv_nmos ad=0.1406p pd=1.12u as=0.2516p ps=2.16u w=0.74u l=0.13u
X79 VSS.t4 DELAY_VBIASN.t20 a_12211_1842# VSS.t124 sg13_lv_nmos ad=0.2516p pd=2.16u as=0.1406p ps=1.12u w=0.74u l=0.6u
X80 VDD.t54 DELAY_VBIASP.t14 a_16771_2470# VDD.t0 sg13_lv_pmos ad=0.3808p pd=2.92u as=0.2128p ps=1.5u w=1.12u l=0.6u
X81 VSS.t105 a_21983_1842# DELAY_OUT_TAP25 VSS.t157 sg13_lv_nmos ad=0.1406p pd=1.12u as=0.2516p ps=2.16u w=0.74u l=0.13u
X82 VDD.t80 DELAY_VBIASP.t9 a_20571_2470# VDD.t0 sg13_lv_pmos ad=0.3808p pd=2.92u as=0.2128p ps=1.5u w=1.12u l=0.6u
X83 a_4611_1842# a_4373_1842# a_4503_1842# VSS.t47 sg13_lv_nmos ad=0.1406p pd=1.12u as=0.2516p ps=2.16u w=0.74u l=0.2u
X84 a_13493_1842# DELAY_OUT_TAP13 VSS.t11 VSS.t107 sg13_lv_nmos ad=0.2516p pd=2.16u as=0.1406p ps=1.12u w=0.74u l=0.13u
X85 a_7413_1842# DELAY_OUT_TAP5 VDD.t16 VDD.t0 sg13_lv_pmos ad=0.3808p pd=2.92u as=0.2128p ps=1.5u w=1.12u l=0.13u
X86 VDD.t75 DELAY_VBIASP.t11 a_19051_2470# VDD.t0 sg13_lv_pmos ad=0.3808p pd=2.92u as=0.2128p ps=1.5u w=1.12u l=0.6u
X87 a_21853_1842# DELAY_OUT_TAP24 VDD.t53 VDD.t0 sg13_lv_pmos ad=0.3808p pd=2.92u as=0.2128p ps=1.5u w=1.12u l=0.13u
X88 VSS.t148 DELAY_VBIASN.t0 a_27411_1842# VSS.t147 sg13_lv_nmos ad=0.2516p pd=2.16u as=0.1406p ps=1.12u w=0.74u l=0.6u
X89 a_25131_2470# a_24893_1842# a_25023_1842# VDD.t0 sg13_lv_pmos ad=0.2128p pd=1.5u as=0.3808p ps=2.92u w=1.12u l=0.2u
X90 VSS.t44 a_15903_1842# DELAY_OUT_TAP17 VSS.t43 sg13_lv_nmos ad=0.1406p pd=1.12u as=0.2516p ps=2.16u w=0.74u l=0.13u
X91 a_24133_1842# DELAY_OUT_TAP27 VDD.t9 VDD.t0 sg13_lv_pmos ad=0.3808p pd=2.92u as=0.2128p ps=1.5u w=1.12u l=0.13u
X92 VSS.t60 DELAY_VBIASN.t23 a_9931_1842# VSS.t129 sg13_lv_nmos ad=0.2516p pd=2.16u as=0.1406p ps=1.12u w=0.74u l=0.6u
X93 VSS.t41 DELAY_VBIASN.t25 a_8411_1842# VSS.t131 sg13_lv_nmos ad=0.2516p pd=2.16u as=0.1406p ps=1.12u w=0.74u l=0.6u
X94 VSS.t67 a_19703_1842# DELAY_OUT_TAP22 VSS.t160 sg13_lv_nmos ad=0.1406p pd=1.12u as=0.2516p ps=2.16u w=0.74u l=0.13u
X95 a_16771_2470# a_16533_1842# a_16663_1842# VDD.t0 sg13_lv_pmos ad=0.2128p pd=1.5u as=0.3808p ps=2.92u w=1.12u l=0.2u
X96 VSS.t97 DELAY_VBIASN.t6 a_22851_1842# VSS.t138 sg13_lv_nmos ad=0.2516p pd=2.16u as=0.1406p ps=1.12u w=0.74u l=0.6u
X97 a_12211_1842# a_11973_1842# a_12103_1842# VSS.t63 sg13_lv_nmos ad=0.1406p pd=1.12u as=0.2516p ps=2.16u w=0.74u l=0.2u
X98 a_6131_2470# a_5893_1842# a_6023_1842# VDD.t0 sg13_lv_pmos ad=0.2128p pd=1.5u as=0.3808p ps=2.92u w=1.12u l=0.2u
X99 a_5133_1842# DELAY_OUT_TAP2 VDD.t14 VDD.t0 sg13_lv_pmos ad=0.3808p pd=2.92u as=0.2128p ps=1.5u w=1.12u l=0.13u
X100 VDD.t15 a_15143_1842# DELAY_OUT_TAP16 VDD.t0 sg13_lv_pmos ad=0.2128p pd=1.5u as=0.3808p ps=2.92u w=1.12u l=0.13u
X101 a_20571_2470# a_20333_1842# a_20463_1842# VDD.t0 sg13_lv_pmos ad=0.2128p pd=1.5u as=0.3808p ps=2.92u w=1.12u l=0.2u
X102 a_9693_1842# DELAY_OUT_TAP8 VSS.t1 VSS.t114 sg13_lv_nmos ad=0.2516p pd=2.16u as=0.1406p ps=1.12u w=0.74u l=0.13u
X103 VSS.t26 a_10583_1842# DELAY_OUT_TAP10 VSS.t25 sg13_lv_nmos ad=0.1406p pd=1.12u as=0.2516p ps=2.16u w=0.74u l=0.13u
X104 VSS.t46 DELAY_VBIASN.t31 a_3851_1842# VSS.t120 sg13_lv_nmos ad=0.2516p pd=2.16u as=0.1406p ps=1.12u w=0.74u l=0.6u
X105 VSS.t95 DELAY_VBIASN.t3 a_25131_1842# VSS.t146 sg13_lv_nmos ad=0.2516p pd=2.16u as=0.1406p ps=1.12u w=0.74u l=0.6u
X106 a_19051_2470# a_18813_1842# a_18943_1842# VDD.t0 sg13_lv_pmos ad=0.2128p pd=1.5u as=0.3808p ps=2.92u w=1.12u l=0.2u
X107 a_10453_1842# DELAY_OUT_TAP9 VDD.t18 VDD.t0 sg13_lv_pmos ad=0.3808p pd=2.92u as=0.2128p ps=1.5u w=1.12u l=0.13u
X108 a_27411_1842# a_27173_1842# a_27303_1842# VSS.t164 sg13_lv_nmos ad=0.1406p pd=1.12u as=0.2516p ps=2.16u w=0.74u l=0.2u
X109 a_15013_1842# DELAY_OUT_TAP15 VSS.t89 VSS.t88 sg13_lv_nmos ad=0.2516p pd=2.16u as=0.1406p ps=1.12u w=0.74u l=0.13u
X110 VSS.t84 a_25783_1842# DELAY_OUT_TAP30 VSS.t165 sg13_lv_nmos ad=0.1406p pd=1.12u as=0.2516p ps=2.16u w=0.74u l=0.13u
X111 VSS.t44 DELAY_VBIASN.t15 a_16011_1842# VSS.t118 sg13_lv_nmos ad=0.2516p pd=2.16u as=0.1406p ps=1.12u w=0.74u l=0.6u
X112 VDD.t82 DELAY_VBIASP.t4 a_24371_2470# VDD.t0 sg13_lv_pmos ad=0.3808p pd=2.92u as=0.2128p ps=1.5u w=1.12u l=0.6u
X113 VSS.t57 DELAY_VBIASN.t28 a_6131_1842# VSS.t117 sg13_lv_nmos ad=0.2516p pd=2.16u as=0.1406p ps=1.12u w=0.74u l=0.6u
X114 VDD.t27 VDD.t25 VDD.t26 VDD.t0 sg13_lv_pmos ad=0.3808p pd=2.92u as=0 ps=0 w=1.12u l=0.13u
X115 a_8411_1842# a_8173_1842# a_8303_1842# VSS.t9 sg13_lv_nmos ad=0.1406p pd=1.12u as=0.2516p ps=2.16u w=0.74u l=0.2u
X116 a_22851_1842# a_22613_1842# a_22743_1842# VSS.t158 sg13_lv_nmos ad=0.1406p pd=1.12u as=0.2516p ps=2.16u w=0.74u l=0.2u
X117 a_17293_1842# DELAY_OUT_TAP18 VSS.t7 VSS.t81 sg13_lv_nmos ad=0.2516p pd=2.16u as=0.1406p ps=1.12u w=0.74u l=0.13u
X118 a_25653_1842# DELAY_OUT_TAP29 VDD.t51 VDD.t0 sg13_lv_pmos ad=0.3808p pd=2.92u as=0.2128p ps=1.5u w=1.12u l=0.13u
X119 VSS.t55 a_6783_1842# DELAY_OUT_TAP5 VSS.t54 sg13_lv_nmos ad=0.1406p pd=1.12u as=0.2516p ps=2.16u w=0.74u l=0.13u
X120 a_21093_1842# DELAY_OUT_TAP23 VSS.t36 VSS.t80 sg13_lv_nmos ad=0.2516p pd=2.16u as=0.1406p ps=1.12u w=0.74u l=0.13u
X121 VSS.t86 a_17423_1842# DELAY_OUT_TAP19 VSS.t153 sg13_lv_nmos ad=0.1406p pd=1.12u as=0.2516p ps=2.16u w=0.74u l=0.13u
X122 VDD.t57 DELAY_VBIASP.t29 a_5371_2470# VDD.t0 sg13_lv_pmos ad=0.3808p pd=2.92u as=0.2128p ps=1.5u w=1.12u l=0.6u
X123 VSS.t99 a_21223_1842# DELAY_OUT_TAP24 VSS.t155 sg13_lv_nmos ad=0.1406p pd=1.12u as=0.2516p ps=2.16u w=0.74u l=0.13u
X124 VSS.t62 DELAY_VBIASN.t21 a_11451_1842# VSS.t126 sg13_lv_nmos ad=0.2516p pd=2.16u as=0.1406p ps=1.12u w=0.74u l=0.6u
X125 a_3851_1842# DELAY_IN a_3743_1842# VSS.t101 sg13_lv_nmos ad=0.1406p pd=1.12u as=0.2516p ps=2.16u w=0.74u l=0.2u
X126 a_13731_1842# a_13493_1842# a_13623_1842# VSS.t166 sg13_lv_nmos ad=0.1406p pd=1.12u as=0.2516p ps=2.16u w=0.74u l=0.2u
X127 a_12733_1842# DELAY_OUT_TAP12 VSS.t4 VSS.t113 sg13_lv_nmos ad=0.2516p pd=2.16u as=0.1406p ps=1.12u w=0.74u l=0.13u
X128 a_6653_1842# DELAY_OUT_TAP4 VDD.t17 VDD.t0 sg13_lv_pmos ad=0.3808p pd=2.92u as=0.2128p ps=1.5u w=1.12u l=0.13u
X129 VSS.t38 a_23503_1842# DELAY_OUT_TAP27 VSS.t37 sg13_lv_nmos ad=0.1406p pd=1.12u as=0.2516p ps=2.16u w=0.74u l=0.13u
X130 VDD.t71 DELAY_VBIASP.t22 a_10691_2470# VDD.t0 sg13_lv_pmos ad=0.3808p pd=2.92u as=0.2128p ps=1.5u w=1.12u l=0.6u
X131 VDD.t8 a_20463_1842# DELAY_OUT_TAP23 VDD.t0 sg13_lv_pmos ad=0.2128p pd=1.5u as=0.3808p ps=2.92u w=1.12u l=0.13u
X132 VSS.t116 DELAY_VBIASN.t1 a_26651_1842# VSS.t149 sg13_lv_nmos ad=0.2516p pd=2.16u as=0.1406p ps=1.12u w=0.74u l=0.6u
X133 a_24371_2470# a_24133_1842# a_24263_1842# VDD.t0 sg13_lv_pmos ad=0.2128p pd=1.5u as=0.3808p ps=2.92u w=1.12u l=0.2u
X134 a_11973_1842# DELAY_OUT_TAP11 VDD.t19 VDD.t0 sg13_lv_pmos ad=0.3808p pd=2.92u as=0.2128p ps=1.5u w=1.12u l=0.13u
X135 VDD.t70 DELAY_VBIASP.t19 a_12971_2470# VDD.t0 sg13_lv_pmos ad=0.3808p pd=2.92u as=0.2128p ps=1.5u w=1.12u l=0.6u
X136 VDD.t22 a_18943_1842# DELAY_OUT_TAP21 VDD.t0 sg13_lv_pmos ad=0.2128p pd=1.5u as=0.3808p ps=2.92u w=1.12u l=0.13u
X137 VSS.t51 a_4503_1842# DELAY_OUT_TAP2 VSS.t50 sg13_lv_nmos ad=0.1406p pd=1.12u as=0.2516p ps=2.16u w=0.74u l=0.13u
X138 DELAY_OUT_LAST a_27737_1842# VSS.t30 VSS.t29 sg13_lv_nmos ad=0.2516p pd=2.16u as=0.1406p ps=1.12u w=0.74u l=0.13u
X139 VDD.t52 a_22743_1842# DELAY_OUT_TAP26 VDD.t0 sg13_lv_pmos ad=0.2128p pd=1.5u as=0.3808p ps=2.92u w=1.12u l=0.13u
X140 VSS.t32 DELAY_VBIASN.t26 a_7651_1842# VSS.t130 sg13_lv_nmos ad=0.2516p pd=2.16u as=0.1406p ps=1.12u w=0.74u l=0.6u
X141 VDD.t55 DELAY_VBIASP.t2 a_25891_2470# VDD.t0 sg13_lv_pmos ad=0.3808p pd=2.92u as=0.2128p ps=1.5u w=1.12u l=0.6u
X142 a_11451_1842# a_11213_1842# a_11343_1842# VSS.t34 sg13_lv_nmos ad=0.1406p pd=1.12u as=0.2516p ps=2.16u w=0.74u l=0.2u
X143 a_5371_2470# a_5133_1842# a_5263_1842# VDD.t0 sg13_lv_pmos ad=0.2128p pd=1.5u as=0.3808p ps=2.92u w=1.12u l=0.2u
X144 a_14253_1842# DELAY_OUT_TAP14 VDD.t20 VDD.t0 sg13_lv_pmos ad=0.3808p pd=2.92u as=0.2128p ps=1.5u w=1.12u l=0.13u
X145 a_9931_1842# a_9693_1842# a_9823_1842# VSS.t5 sg13_lv_nmos ad=0.1406p pd=1.12u as=0.2516p ps=2.16u w=0.74u l=0.2u
X146 a_18813_1842# DELAY_OUT_TAP20 VSS.t73 VSS.t90 sg13_lv_nmos ad=0.2516p pd=2.16u as=0.1406p ps=1.12u w=0.74u l=0.13u
X147 a_8933_1842# DELAY_OUT_TAP7 VSS.t41 VSS.t79 sg13_lv_nmos ad=0.2516p pd=2.16u as=0.1406p ps=1.12u w=0.74u l=0.13u
X148 a_22613_1842# DELAY_OUT_TAP25 VSS.t105 VSS.t104 sg13_lv_nmos ad=0.2516p pd=2.16u as=0.1406p ps=1.12u w=0.74u l=0.13u
X149 VSS.t60 a_9823_1842# DELAY_OUT_TAP9 VSS.t59 sg13_lv_nmos ad=0.1406p pd=1.12u as=0.2516p ps=2.16u w=0.74u l=0.13u
X150 VDD.t13 a_3743_1842# DELAY_OUT_TAP1 VDD.t0 sg13_lv_pmos ad=0.2128p pd=1.5u as=0.3808p ps=2.92u w=1.12u l=0.13u
X151 VDD.t61 DELAY_VBIASP.t27 a_6891_2470# VDD.t0 sg13_lv_pmos ad=0.3808p pd=2.92u as=0.2128p ps=1.5u w=1.12u l=0.6u
X152 a_10691_2470# a_10453_1842# a_10583_1842# VDD.t0 sg13_lv_pmos ad=0.2128p pd=1.5u as=0.3808p ps=2.92u w=1.12u l=0.2u
X153 a_26651_1842# a_26413_1842# a_26543_1842# VSS.t162 sg13_lv_nmos ad=0.1406p pd=1.12u as=0.2516p ps=2.16u w=0.74u l=0.2u
X154 VSS.t53 DELAY_VBIASN.t16 a_15251_1842# VSS.t119 sg13_lv_nmos ad=0.2516p pd=2.16u as=0.1406p ps=1.12u w=0.74u l=0.6u
X155 VDD.t66 DELAY_VBIASP.t24 a_9171_2470# VDD.t0 sg13_lv_pmos ad=0.3808p pd=2.92u as=0.2128p ps=1.5u w=1.12u l=0.6u
X156 VSS.t95 a_25023_1842# DELAY_OUT_TAP29 VSS.t152 sg13_lv_nmos ad=0.1406p pd=1.12u as=0.2516p ps=2.16u w=0.74u l=0.13u
X157 a_17531_1842# a_17293_1842# a_17423_1842# VSS.t8 sg13_lv_nmos ad=0.1406p pd=1.12u as=0.2516p ps=2.16u w=0.74u l=0.2u
X158 a_7651_1842# a_7413_1842# a_7543_1842# VSS.t100 sg13_lv_nmos ad=0.1406p pd=1.12u as=0.2516p ps=2.16u w=0.74u l=0.2u
X159 a_21331_1842# a_21093_1842# a_21223_1842# VSS.t154 sg13_lv_nmos ad=0.1406p pd=1.12u as=0.2516p ps=2.16u w=0.74u l=0.2u
X160 a_16533_1842# DELAY_OUT_TAP17 VSS.t44 VSS.t91 sg13_lv_nmos ad=0.2516p pd=2.16u as=0.1406p ps=1.12u w=0.74u l=0.13u
X161 a_25891_2470# a_25653_1842# a_25783_1842# VDD.t0 sg13_lv_pmos ad=0.2128p pd=1.5u as=0.3808p ps=2.92u w=1.12u l=0.2u
X162 VSS.t57 a_6023_1842# DELAY_OUT_TAP4 VSS.t56 sg13_lv_nmos ad=0.1406p pd=1.12u as=0.2516p ps=2.16u w=0.74u l=0.13u
X163 a_20333_1842# DELAY_OUT_TAP22 VSS.t67 VSS.t66 sg13_lv_nmos ad=0.2516p pd=2.16u as=0.1406p ps=1.12u w=0.74u l=0.13u
X164 VDD.t67 DELAY_VBIASP.t17 a_14491_2470# VDD.t0 sg13_lv_pmos ad=0.3808p pd=2.92u as=0.2128p ps=1.5u w=1.12u l=0.6u
X165 VDD.t86 a_24263_1842# DELAY_OUT_TAP28 VDD.t0 sg13_lv_pmos ad=0.2128p pd=1.5u as=0.3808p ps=2.92u w=1.12u l=0.13u
X166 a_6891_2470# a_6653_1842# a_6783_1842# VDD.t0 sg13_lv_pmos ad=0.2128p pd=1.5u as=0.3808p ps=2.92u w=1.12u l=0.2u
X167 a_15773_1842# DELAY_OUT_TAP16 VDD.t15 VDD.t0 sg13_lv_pmos ad=0.3808p pd=2.92u as=0.2128p ps=1.5u w=1.12u l=0.13u
X168 VDD.t32 VDD.t30 VDD.t31 VDD.t0 sg13_lv_pmos ad=0.3808p pd=2.92u as=0 ps=0 w=1.12u l=0.6u
X169 a_12971_1842# a_12733_1842# a_12863_1842# VSS.t33 sg13_lv_nmos ad=0.1406p pd=1.12u as=0.2516p ps=2.16u w=0.74u l=0.2u
X170 a_11213_1842# DELAY_OUT_TAP10 VSS.t26 VSS.t109 sg13_lv_nmos ad=0.2516p pd=2.16u as=0.1406p ps=1.12u w=0.74u l=0.13u
X171 VDD.t96 a_26543_1842# DELAY_OUT_TAP31 VDD.t0 sg13_lv_pmos ad=0.2128p pd=1.5u as=0.3808p ps=2.92u w=1.12u l=0.13u
X172 VSS.t62 a_11343_1842# DELAY_OUT_TAP11 VSS.t61 sg13_lv_nmos ad=0.1406p pd=1.12u as=0.2516p ps=2.16u w=0.74u l=0.13u
X173 VDD.t38 a_5263_1842# DELAY_OUT_TAP3 VDD.t0 sg13_lv_pmos ad=0.2128p pd=1.5u as=0.3808p ps=2.92u w=1.12u l=0.13u
X174 a_15251_1842# a_15013_1842# a_15143_1842# VSS.t170 sg13_lv_nmos ad=0.1406p pd=1.12u as=0.2516p ps=2.16u w=0.74u l=0.2u
X175 a_9171_2470# a_8933_1842# a_9063_1842# VDD.t0 sg13_lv_pmos ad=0.2128p pd=1.5u as=0.3808p ps=2.92u w=1.12u l=0.2u
X176 a_18053_1842# DELAY_OUT_TAP19 VDD.t44 VDD.t0 sg13_lv_pmos ad=0.3808p pd=2.92u as=0.2128p ps=1.5u w=1.12u l=0.13u
X177 VSS.t65 a_13623_1842# DELAY_OUT_TAP14 VSS.t64 sg13_lv_nmos ad=0.1406p pd=1.12u as=0.2516p ps=2.16u w=0.74u l=0.13u
X178 VDD.t7 a_7543_1842# DELAY_OUT_TAP6 VDD.t0 sg13_lv_pmos ad=0.2128p pd=1.5u as=0.3808p ps=2.92u w=1.12u l=0.13u
X179 a_26413_1842# DELAY_OUT_TAP30 VSS.t84 VSS.t83 sg13_lv_nmos ad=0.2516p pd=2.16u as=0.1406p ps=1.12u w=0.74u l=0.13u
X180 VSS.t7 DELAY_VBIASN.t14 a_16771_1842# VSS.t139 sg13_lv_nmos ad=0.2516p pd=2.16u as=0.1406p ps=1.12u w=0.74u l=0.6u
X181 a_14491_2470# a_14253_1842# a_14383_1842# VDD.t0 sg13_lv_pmos ad=0.2128p pd=1.5u as=0.3808p ps=2.92u w=1.12u l=0.2u
X182 VSS.t36 DELAY_VBIASN.t9 a_20571_1842# VSS.t144 sg13_lv_nmos ad=0.2516p pd=2.16u as=0.1406p ps=1.12u w=0.74u l=0.6u
X183 VDD.t27 VDD.t28 VDD.t29 VDD.t0 sg13_lv_pmos ad=0.2128p pd=1.5u as=0 ps=0 w=1.12u l=0.13u
X184 VDD.t4 a_12863_1842# DELAY_OUT_TAP13 VDD.t0 sg13_lv_pmos ad=0.2128p pd=1.5u as=0.3808p ps=2.92u w=1.12u l=0.13u
X185 a_7413_1842# DELAY_OUT_TAP5 VSS.t55 VSS.t75 sg13_lv_nmos ad=0.2516p pd=2.16u as=0.1406p ps=1.12u w=0.74u l=0.13u
X186 a_21853_1842# DELAY_OUT_TAP24 VSS.t99 VSS.t98 sg13_lv_nmos ad=0.2516p pd=2.16u as=0.1406p ps=1.12u w=0.74u l=0.13u
X187 VSS.t70 DELAY_VBIASN.t11 a_19051_1842# VSS.t140 sg13_lv_nmos ad=0.2516p pd=2.16u as=0.1406p ps=1.12u w=0.74u l=0.6u
X188 a_25131_1842# a_24893_1842# a_25023_1842# VSS.t167 sg13_lv_nmos ad=0.1406p pd=1.12u as=0.2516p ps=2.16u w=0.74u l=0.2u
X189 VDD.t77 DELAY_VBIASP.t12 a_18291_2470# VDD.t0 sg13_lv_pmos ad=0.3808p pd=2.92u as=0.2128p ps=1.5u w=1.12u l=0.6u
X190 a_24133_1842# DELAY_OUT_TAP27 VSS.t38 VSS.t74 sg13_lv_nmos ad=0.2516p pd=2.16u as=0.1406p ps=1.12u w=0.74u l=0.13u
X191 VDD.t81 DELAY_VBIASP.t7 a_22091_2470# VDD.t0 sg13_lv_pmos ad=0.3808p pd=2.92u as=0.2128p ps=1.5u w=1.12u l=0.6u
X192 a_16771_1842# a_16533_1842# a_16663_1842# VSS.t68 sg13_lv_nmos ad=0.1406p pd=1.12u as=0.2516p ps=2.16u w=0.74u l=0.2u
X193 a_19573_1842# DELAY_OUT_TAP21 VDD.t22 VDD.t0 sg13_lv_pmos ad=0.3808p pd=2.92u as=0.2128p ps=1.5u w=1.12u l=0.13u
X194 a_6131_1842# a_5893_1842# a_6023_1842# VSS.t49 sg13_lv_nmos ad=0.1406p pd=1.12u as=0.2516p ps=2.16u w=0.74u l=0.2u
X195 a_20571_1842# a_20333_1842# a_20463_1842# VSS.t27 sg13_lv_nmos ad=0.1406p pd=1.12u as=0.2516p ps=2.16u w=0.74u l=0.2u
X196 a_23373_1842# DELAY_OUT_TAP26 VDD.t52 VDD.t0 sg13_lv_pmos ad=0.3808p pd=2.92u as=0.2128p ps=1.5u w=1.12u l=0.13u
X197 a_5133_1842# DELAY_OUT_TAP2 VSS.t51 VSS.t112 sg13_lv_nmos ad=0.2516p pd=2.16u as=0.1406p ps=1.12u w=0.74u l=0.13u
X198 VSS.t53 a_15143_1842# DELAY_OUT_TAP16 VSS.t171 sg13_lv_nmos ad=0.1406p pd=1.12u as=0.2516p ps=2.16u w=0.74u l=0.13u
X199 VDD.t1 a_9063_1842# DELAY_OUT_TAP8 VDD.t0 sg13_lv_pmos ad=0.2128p pd=1.5u as=0.3808p ps=2.92u w=1.12u l=0.13u
X200 VDD.t68 DELAY_VBIASP.t18 a_13731_2470# VDD.t0 sg13_lv_pmos ad=0.3808p pd=2.92u as=0.2128p ps=1.5u w=1.12u l=0.6u
X201 a_19051_1842# a_18813_1842# a_18943_1842# VSS.t71 sg13_lv_nmos ad=0.1406p pd=1.12u as=0.2516p ps=2.16u w=0.74u l=0.2u
X202 a_16011_2470# a_15773_1842# a_15903_1842# VDD.t0 sg13_lv_pmos ad=0.2128p pd=1.5u as=0.3808p ps=2.92u w=1.12u l=0.2u
X203 a_10453_1842# DELAY_OUT_TAP9 VSS.t60 VSS.t110 sg13_lv_nmos ad=0.2516p pd=2.16u as=0.1406p ps=1.12u w=0.74u l=0.13u
X204 a_4373_1842# DELAY_OUT_TAP1 VDD.t13 VDD.t0 sg13_lv_pmos ad=0.3808p pd=2.92u as=0.2128p ps=1.5u w=1.12u l=0.13u
X205 VDD.t46 a_14383_1842# DELAY_OUT_TAP15 VDD.t0 sg13_lv_pmos ad=0.2128p pd=1.5u as=0.3808p ps=2.92u w=1.12u l=0.13u
X206 VSS.t103 DELAY_VBIASN.t4 a_24371_1842# VSS.t136 sg13_lv_nmos ad=0.2516p pd=2.16u as=0.1406p ps=1.12u w=0.74u l=0.6u
X207 a_18291_2470# a_18053_1842# a_18183_1842# VDD.t0 sg13_lv_pmos ad=0.2128p pd=1.5u as=0.3808p ps=2.92u w=1.12u l=0.2u
X208 a_22091_2470# a_21853_1842# a_21983_1842# VDD.t0 sg13_lv_pmos ad=0.2128p pd=1.5u as=0.3808p ps=2.92u w=1.12u l=0.2u
X209 VSS.t15 VSS.t12 VSS.t14 VSS.t13 sg13_lv_nmos ad=0.2516p pd=2.16u as=0 ps=0 w=0.74u l=0.13u
X210 VDD.t3 a_16663_1842# DELAY_OUT_TAP18 VDD.t0 sg13_lv_pmos ad=0.2128p pd=1.5u as=0.3808p ps=2.92u w=1.12u l=0.13u
X211 VDD.t79 DELAY_VBIASP.t10 a_19811_2470# VDD.t0 sg13_lv_pmos ad=0.3808p pd=2.92u as=0.2128p ps=1.5u w=1.12u l=0.6u
X212 a_25653_1842# DELAY_OUT_TAP29 VSS.t95 VSS.t94 sg13_lv_nmos ad=0.2516p pd=2.16u as=0.1406p ps=1.12u w=0.74u l=0.13u
X213 VSS.t78 DELAY_VBIASN.t29 a_5371_1842# VSS.t127 sg13_lv_nmos ad=0.2516p pd=2.16u as=0.1406p ps=1.12u w=0.74u l=0.6u
X214 VDD.t83 DELAY_VBIASP.t5 a_23611_2470# VDD.t0 sg13_lv_pmos ad=0.3808p pd=2.92u as=0.2128p ps=1.5u w=1.12u l=0.6u
X215 VDD.t2 a_12103_1842# DELAY_OUT_TAP12 VDD.t0 sg13_lv_pmos ad=0.2128p pd=1.5u as=0.3808p ps=2.92u w=1.12u l=0.13u
X216 a_24893_1842# DELAY_OUT_TAP28 VDD.t86 VDD.t0 sg13_lv_pmos ad=0.3808p pd=2.92u as=0.2128p ps=1.5u w=1.12u l=0.13u
X217 a_6653_1842# DELAY_OUT_TAP4 VSS.t57 VSS.t76 sg13_lv_nmos ad=0.2516p pd=2.16u as=0.1406p ps=1.12u w=0.74u l=0.13u
X218 VSS.t36 a_20463_1842# DELAY_OUT_TAP23 VSS.t35 sg13_lv_nmos ad=0.1406p pd=1.12u as=0.2516p ps=2.16u w=0.74u l=0.13u
X219 VSS.t26 DELAY_VBIASN.t22 a_10691_1842# VSS.t122 sg13_lv_nmos ad=0.2516p pd=2.16u as=0.1406p ps=1.12u w=0.74u l=0.6u
X220 VDD.t62 DELAY_VBIASP.t30 a_4611_2470# VDD.t0 sg13_lv_pmos ad=0.3808p pd=2.92u as=0.2128p ps=1.5u w=1.12u l=0.6u
X221 a_24371_1842# a_24133_1842# a_24263_1842# VSS.t161 sg13_lv_nmos ad=0.1406p pd=1.12u as=0.2516p ps=2.16u w=0.74u l=0.2u
X222 VSS.t70 a_18943_1842# DELAY_OUT_TAP21 VSS.t69 sg13_lv_nmos ad=0.1406p pd=1.12u as=0.2516p ps=2.16u w=0.74u l=0.13u
X223 a_11973_1842# DELAY_OUT_TAP11 VSS.t62 VSS.t108 sg13_lv_nmos ad=0.2516p pd=2.16u as=0.1406p ps=1.12u w=0.74u l=0.13u
X224 a_5893_1842# DELAY_OUT_TAP3 VDD.t38 VDD.t0 sg13_lv_pmos ad=0.3808p pd=2.92u as=0.2128p ps=1.5u w=1.12u l=0.13u
X225 VDD.t76 DELAY_VBIASP.t13 a_17531_2470# VDD.t0 sg13_lv_pmos ad=0.3808p pd=2.92u as=0.2128p ps=1.5u w=1.12u l=0.6u
X226 a_27173_1842# DELAY_OUT_TAP31 VDD.t96 VDD.t0 sg13_lv_pmos ad=0.3808p pd=2.92u as=0.2128p ps=1.5u w=1.12u l=0.13u
X227 VSS.t11 DELAY_VBIASN.t19 a_12971_1842# VSS.t125 sg13_lv_nmos ad=0.2516p pd=2.16u as=0.1406p ps=1.12u w=0.74u l=0.6u
X228 VDD.t6 a_27303_1842# a_27737_1842# VDD.t0 sg13_lv_pmos ad=0.2128p pd=1.5u as=0.3808p ps=2.92u w=1.12u l=0.13u
X229 VSS.t84 DELAY_VBIASN.t2 a_25891_1842# VSS.t137 sg13_lv_nmos ad=0.2516p pd=2.16u as=0.1406p ps=1.12u w=0.74u l=0.6u
X230 VSS.t97 a_22743_1842# DELAY_OUT_TAP26 VSS.t163 sg13_lv_nmos ad=0.1406p pd=1.12u as=0.2516p ps=2.16u w=0.74u l=0.13u
X231 a_19811_2470# a_19573_1842# a_19703_1842# VDD.t0 sg13_lv_pmos ad=0.2128p pd=1.5u as=0.3808p ps=2.92u w=1.12u l=0.2u
X232 VDD.t78 DELAY_VBIASP.t8 a_21331_2470# VDD.t0 sg13_lv_pmos ad=0.3808p pd=2.92u as=0.2128p ps=1.5u w=1.12u l=0.6u
X233 VDD.t35 VDD.t33 VDD.t32 VDD.t0 sg13_lv_pmos ad=0.2128p pd=1.5u as=0 ps=0 w=1.12u l=0.2u
X234 a_5371_1842# a_5133_1842# a_5263_1842# VSS.t58 sg13_lv_nmos ad=0.1406p pd=1.12u as=0.2516p ps=2.16u w=0.74u l=0.2u
X235 a_14253_1842# DELAY_OUT_TAP14 VSS.t65 VSS.t82 sg13_lv_nmos ad=0.2516p pd=2.16u as=0.1406p ps=1.12u w=0.74u l=0.13u
X236 a_8173_1842# DELAY_OUT_TAP6 VDD.t7 VDD.t0 sg13_lv_pmos ad=0.3808p pd=2.92u as=0.2128p ps=1.5u w=1.12u l=0.13u
X237 VDD.t23 a_18183_1842# DELAY_OUT_TAP20 VDD.t0 sg13_lv_pmos ad=0.2128p pd=1.5u as=0.3808p ps=2.92u w=1.12u l=0.13u
X238 a_23611_2470# a_23373_1842# a_23503_1842# VDD.t0 sg13_lv_pmos ad=0.2128p pd=1.5u as=0.3808p ps=2.92u w=1.12u l=0.2u
X239 VSS.t46 a_3743_1842# DELAY_OUT_TAP1 VSS.t45 sg13_lv_nmos ad=0.1406p pd=1.12u as=0.2516p ps=2.16u w=0.74u l=0.13u
X240 VDD.t11 a_8303_1842# DELAY_OUT_TAP7 VDD.t0 sg13_lv_pmos ad=0.2128p pd=1.5u as=0.3808p ps=2.92u w=1.12u l=0.13u
X241 VDD.t72 DELAY_VBIASP.t20 a_12211_2470# VDD.t0 sg13_lv_pmos ad=0.3808p pd=2.92u as=0.2128p ps=1.5u w=1.12u l=0.6u
X242 VDD.t87 a_21983_1842# DELAY_OUT_TAP25 VDD.t0 sg13_lv_pmos ad=0.2128p pd=1.5u as=0.3808p ps=2.92u w=1.12u l=0.13u
X243 VSS.t55 DELAY_VBIASN.t27 a_6891_1842# VSS.t128 sg13_lv_nmos ad=0.2516p pd=2.16u as=0.1406p ps=1.12u w=0.74u l=0.6u
X244 a_4611_2470# a_4373_1842# a_4503_1842# VDD.t0 sg13_lv_pmos ad=0.2128p pd=1.5u as=0.3808p ps=2.92u w=1.12u l=0.2u
X245 a_13493_1842# DELAY_OUT_TAP13 VDD.t4 VDD.t0 sg13_lv_pmos ad=0.3808p pd=2.92u as=0.2128p ps=1.5u w=1.12u l=0.13u
X246 a_10691_1842# a_10453_1842# a_10583_1842# VSS.t42 sg13_lv_nmos ad=0.1406p pd=1.12u as=0.2516p ps=2.16u w=0.74u l=0.2u
X247 VDD.t84 DELAY_VBIASP.t0 a_27411_2470# VDD.t0 sg13_lv_pmos ad=0.3808p pd=2.92u as=0.2128p ps=1.5u w=1.12u l=0.6u
X248 VSS.t1 DELAY_VBIASN.t24 a_9171_1842# VSS.t132 sg13_lv_nmos ad=0.2516p pd=2.16u as=0.1406p ps=1.12u w=0.74u l=0.6u
X249 a_25891_1842# a_25653_1842# a_25783_1842# VSS.t168 sg13_lv_nmos ad=0.1406p pd=1.12u as=0.2516p ps=2.16u w=0.74u l=0.2u
X250 VDD.t59 DELAY_VBIASP.t23 a_9931_2470# VDD.t0 sg13_lv_pmos ad=0.3808p pd=2.92u as=0.2128p ps=1.5u w=1.12u l=0.6u
X251 VDD.t12 a_15903_1842# DELAY_OUT_TAP17 VDD.t0 sg13_lv_pmos ad=0.2128p pd=1.5u as=0.3808p ps=2.92u w=1.12u l=0.13u
X252 VSS.t89 DELAY_VBIASN.t17 a_14491_1842# VSS.t133 sg13_lv_nmos ad=0.2516p pd=2.16u as=0.1406p ps=1.12u w=0.74u l=0.6u
X253 VDD.t65 DELAY_VBIASP.t25 a_8411_2470# VDD.t0 sg13_lv_pmos ad=0.3808p pd=2.92u as=0.2128p ps=1.5u w=1.12u l=0.6u
X254 VDD.t21 a_19703_1842# DELAY_OUT_TAP22 VDD.t0 sg13_lv_pmos ad=0.2128p pd=1.5u as=0.3808p ps=2.92u w=1.12u l=0.13u
X255 VSS.t103 a_24263_1842# DELAY_OUT_TAP28 VSS.t156 sg13_lv_nmos ad=0.1406p pd=1.12u as=0.2516p ps=2.16u w=0.74u l=0.13u
X256 a_12211_2470# a_11973_1842# a_12103_1842# VDD.t0 sg13_lv_pmos ad=0.2128p pd=1.5u as=0.3808p ps=2.92u w=1.12u l=0.2u
X257 VDD.t74 DELAY_VBIASP.t6 a_22851_2470# VDD.t0 sg13_lv_pmos ad=0.3808p pd=2.92u as=0.2128p ps=1.5u w=1.12u l=0.6u
X258 a_6891_1842# a_6653_1842# a_6783_1842# VSS.t48 sg13_lv_nmos ad=0.1406p pd=1.12u as=0.2516p ps=2.16u w=0.74u l=0.2u
X259 VSS.t22 VSS.t19 VSS.t21 VSS.t20 sg13_lv_nmos ad=0.2516p pd=2.16u as=0 ps=0 w=0.74u l=0.6u
X260 a_15773_1842# DELAY_OUT_TAP16 VSS.t53 VSS.t52 sg13_lv_nmos ad=0.2516p pd=2.16u as=0.1406p ps=1.12u w=0.74u l=0.13u
X261 a_9693_1842# DELAY_OUT_TAP8 VDD.t1 VDD.t0 sg13_lv_pmos ad=0.3808p pd=2.92u as=0.2128p ps=1.5u w=1.12u l=0.13u
X262 VDD.t5 a_10583_1842# DELAY_OUT_TAP10 VDD.t0 sg13_lv_pmos ad=0.2128p pd=1.5u as=0.3808p ps=2.92u w=1.12u l=0.13u
X263 VSS.t116 a_26543_1842# DELAY_OUT_TAP31 VSS.t169 sg13_lv_nmos ad=0.1406p pd=1.12u as=0.2516p ps=2.16u w=0.74u l=0.13u
C0 a_9063_1842# a_9171_2470# 0.01697f
C1 DELAY_OUT_TAP10 DELAY_VBIASN 0.04353f
C2 DELAY_OUT_TAP21 a_19573_1842# 0.70708f
C3 a_6891_2470# a_6783_1842# 0.01697f
C4 a_13493_1842# a_13623_1842# 0.70845f
C5 VDD DELAY_OUT_TAP17 0.72899f
C6 a_5133_1842# DELAY_VBIASN 0.10601f
C7 DELAY_OUT_TAP22 a_19573_1842# 0.0114f
C8 a_24133_1842# VDD 0.4916f
C9 DELAY_VBIASN a_27173_1842# 0.10602f
C10 a_23503_1842# DELAY_VBIASN 0.07258f
C11 a_12733_1842# DELAY_VBIASP 0.11222f
C12 VDD a_21223_1842# 0.49633f
C13 a_24893_1842# DELAY_VBIASN 0.10601f
C14 a_15773_1842# DELAY_VBIASP 0.11222f
C15 a_15903_1842# DELAY_VBIASN 0.07258f
C16 DELAY_OUT_TAP5 DELAY_VBIASN 0.04353f
C17 a_17293_1842# a_17423_1842# 0.70845f
C18 a_8303_1842# a_8411_1842# 0.01163f
C19 DELAY_OUT_LAST DELAY_VBIASN 0.04786f
C20 a_20333_1842# DELAY_VBIASN 0.10601f
C21 VDD DELAY_OUT_TAP13 0.72899f
C22 VDD DELAY_OUT_TAP28 0.72899f
C23 DELAY_OUT_TAP20 VDD 0.72899f
C24 a_11451_1842# a_11343_1842# 0.01163f
C25 a_13623_1842# a_13731_2470# 0.01697f
C26 VDD a_14491_2470# 0.01806f
C27 a_19811_1842# a_19703_1842# 0.01163f
C28 DELAY_OUT_TAP24 a_21223_1842# 0.69646f
C29 a_12211_2470# a_12103_1842# 0.01697f
C30 DELAY_OUT_TAP19 a_18053_1842# 0.70708f
C31 DELAY_OUT_TAP17 DELAY_VBIASN 0.04353f
C32 a_24133_1842# DELAY_VBIASN 0.10601f
C33 a_5371_2470# VDD 0.01806f
C34 a_21331_2470# a_21223_1842# 0.01697f
C35 DELAY_OUT_TAP14 VDD 0.72899f
C36 a_21223_1842# DELAY_VBIASN 0.07258f
C37 DELAY_VBIASP a_17293_1842# 0.11222f
C38 DELAY_OUT_TAP5 a_6783_1842# 0.69646f
C39 a_24893_1842# DELAY_OUT_TAP29 0.0114f
C40 a_12863_1842# a_12971_2470# 0.01697f
C41 a_15143_1842# VDD 0.49633f
C42 DELAY_VBIASN DELAY_OUT_TAP13 0.04353f
C43 DELAY_VBIASP DELAY_OUT_TAP12 0.04137f
C44 DELAY_VBIASN DELAY_OUT_TAP28 0.04353f
C45 VDD a_22851_2470# 0.01806f
C46 a_5893_1842# DELAY_OUT_TAP4 0.0114f
C47 a_22743_1842# a_22851_1842# 0.01163f
C48 DELAY_OUT_TAP20 DELAY_VBIASN 0.04353f
C49 VDD a_25783_1842# 0.49633f
C50 DELAY_OUT_TAP9 a_9693_1842# 0.0114f
C51 VDD DELAY_OUT_TAP9 0.72899f
C52 a_20333_1842# DELAY_OUT_TAP22 0.70708f
C53 a_24133_1842# a_24263_1842# 0.70845f
C54 a_23373_1842# VDD 0.4916f
C55 a_5263_1842# a_5371_2470# 0.01697f
C56 DELAY_VBIASP a_27737_1842# 0.04001f
C57 DELAY_VBIASP a_16663_1842# 0.06627f
C58 a_18943_1842# a_19051_1842# 0.01163f
C59 a_5893_1842# DELAY_OUT_TAP3 0.70708f
C60 VDD DELAY_OUT_TAP4 0.72899f
C61 a_25023_1842# DELAY_VBIASP 0.06627f
C62 a_9931_1842# a_9823_1842# 0.01163f
C63 a_12733_1842# DELAY_OUT_TAP12 0.70708f
C64 VDD a_26543_1842# 0.49633f
C65 a_20463_1842# DELAY_VBIASP 0.06627f
C66 a_24263_1842# DELAY_OUT_TAP28 0.69646f
C67 DELAY_OUT_TAP14 DELAY_VBIASN 0.04353f
C68 VDD DELAY_OUT_TAP3 0.72899f
C69 a_23503_1842# a_23611_2470# 0.01697f
C70 a_7413_1842# DELAY_OUT_TAP5 0.70708f
C71 DELAY_OUT_TAP31 a_26543_1842# 0.69646f
C72 VDD a_16011_2470# 0.01806f
C73 a_15143_1842# DELAY_VBIASN 0.07258f
C74 VDD DELAY_OUT_TAP27 0.72899f
C75 DELAY_OUT_TAP23 a_21093_1842# 0.70708f
C76 a_25783_1842# DELAY_VBIASN 0.07258f
C77 VDD a_13493_1842# 0.4916f
C78 DELAY_VBIASN DELAY_OUT_TAP9 0.04353f
C79 VDD DELAY_OUT_TAP16 0.72899f
C80 a_23373_1842# DELAY_VBIASN 0.10601f
C81 a_18053_1842# a_18183_1842# 0.70845f
C82 VDD a_21093_1842# 0.4916f
C83 a_17423_1842# a_17531_2470# 0.01697f
C84 a_5263_1842# DELAY_OUT_TAP3 0.69646f
C85 DELAY_OUT_TAP4 DELAY_VBIASN 0.04353f
C86 VDD a_12103_1842# 0.49633f
C87 a_14383_1842# VDD 0.49633f
C88 DELAY_VBIASN a_26543_1842# 0.07258f
C89 VDD DELAY_OUT_TAP19 0.72899f
C90 VDD a_11343_1842# 0.49633f
C91 DELAY_OUT_TAP3 DELAY_VBIASN 0.04353f
C92 VDD a_13731_2470# 0.01806f
C93 DELAY_OUT_TAP27 DELAY_VBIASN 0.04353f
C94 DELAY_OUT_TAP24 a_21093_1842# 0.0114f
C95 a_15903_1842# DELAY_OUT_TAP17 0.69646f
C96 VDD a_3743_1842# 0.61241f
C97 DELAY_OUT_TAP11 a_11343_1842# 0.69646f
C98 a_13493_1842# DELAY_VBIASN 0.10601f
C99 DELAY_OUT_TAP16 DELAY_VBIASN 0.04353f
C100 a_4611_2470# VDD 0.01806f
C101 a_25023_1842# a_25131_1842# 0.01163f
C102 a_21093_1842# DELAY_VBIASN 0.10601f
C103 DELAY_VBIASN a_12103_1842# 0.07258f
C104 a_14383_1842# DELAY_VBIASN 0.07258f
C105 DELAY_OUT_TAP25 a_21983_1842# 0.69646f
C106 a_24893_1842# DELAY_OUT_TAP28 0.70708f
C107 DELAY_VBIASP DELAY_OUT_TAP18 0.04137f
C108 DELAY_OUT_TAP19 DELAY_VBIASN 0.04353f
C109 a_15013_1842# VDD 0.4916f
C110 a_22613_1842# DELAY_OUT_TAP26 0.0114f
C111 a_11343_1842# DELAY_VBIASN 0.07258f
C112 DELAY_VBIASP a_11213_1842# 0.11222f
C113 VDD a_25653_1842# 0.4916f
C114 DELAY_OUT_TAP8 a_9693_1842# 0.70708f
C115 VDD DELAY_OUT_TAP8 0.72899f
C116 DELAY_VBIASP a_21983_1842# 0.06627f
C117 a_6131_2470# a_6023_1842# 0.01697f
C118 DELAY_VBIASP a_16533_1842# 0.11222f
C119 VDD a_10583_1842# 0.49633f
C120 a_3743_1842# DELAY_VBIASN 0.0649f
C121 a_10583_1842# a_10691_1842# 0.01163f
C122 VDD a_26413_1842# 0.4916f
C123 a_24133_1842# DELAY_OUT_TAP28 0.0114f
C124 a_26651_1842# a_26543_1842# 0.01163f
C125 VDD DELAY_OUT_TAP2 0.72899f
C126 a_8303_1842# VDD 0.49633f
C127 VDD a_18183_1842# 0.49633f
C128 a_18943_1842# VDD 0.49633f
C129 DELAY_OUT_TAP31 a_26413_1842# 0.0114f
C130 a_13623_1842# a_13731_1842# 0.01163f
C131 DELAY_VBIASP a_6023_1842# 0.06627f
C132 a_22613_1842# a_22743_1842# 0.70845f
C133 VDD DELAY_OUT_TAP26 0.72899f
C134 a_15013_1842# DELAY_VBIASN 0.10601f
C135 a_23373_1842# a_23503_1842# 0.70845f
C136 a_25653_1842# DELAY_VBIASN 0.10601f
C137 DELAY_VBIASN DELAY_OUT_TAP8 0.04353f
C138 a_14383_1842# a_14491_1842# 0.01163f
C139 DELAY_VBIASP a_9823_1842# 0.06627f
C140 DELAY_VBIASP a_13623_1842# 0.06627f
C141 a_10583_1842# DELAY_VBIASN 0.07258f
C142 a_4611_2470# a_4503_1842# 0.01697f
C143 a_5133_1842# DELAY_OUT_TAP3 0.0114f
C144 VDD DELAY_OUT_TAP30 0.72899f
C145 VDD a_11973_1842# 0.4916f
C146 a_14253_1842# VDD 0.4916f
C147 DELAY_VBIASN a_26413_1842# 0.10601f
C148 a_14383_1842# DELAY_OUT_TAP15 0.69646f
C149 a_23503_1842# DELAY_OUT_TAP27 0.69646f
C150 DELAY_OUT_TAP18 a_17293_1842# 0.70708f
C151 a_15903_1842# a_16011_2470# 0.01697f
C152 DELAY_VBIASP a_27303_1842# 0.06629f
C153 DELAY_OUT_TAP2 DELAY_VBIASN 0.04353f
C154 a_8303_1842# DELAY_VBIASN 0.07258f
C155 a_18943_1842# DELAY_VBIASN 0.07258f
C156 DELAY_VBIASP a_18053_1842# 0.11222f
C157 a_18183_1842# DELAY_VBIASN 0.07258f
C158 a_23503_1842# a_23611_1842# 0.01163f
C159 a_12863_1842# VDD 0.49633f
C160 VDD a_26651_2470# 0.01806f
C161 a_22743_1842# VDD 0.49633f
C162 DELAY_OUT_TAP11 a_11973_1842# 0.70708f
C163 DELAY_OUT_TAP26 DELAY_VBIASN 0.04353f
C164 a_18943_1842# a_19051_2470# 0.01697f
C165 VDD DELAY_OUT_TAP7 0.72899f
C166 a_16663_1842# DELAY_OUT_TAP18 0.69646f
C167 a_25653_1842# DELAY_OUT_TAP29 0.70708f
C168 a_9063_1842# DELAY_OUT_TAP8 0.69646f
C169 DELAY_VBIASN DELAY_OUT_TAP30 0.04353f
C170 a_19703_1842# a_19811_2470# 0.01697f
C171 DELAY_VBIASN a_11973_1842# 0.10601f
C172 a_14253_1842# DELAY_VBIASN 0.10601f
C173 DELAY_OUT_TAP25 a_21853_1842# 0.0114f
C174 VDD a_24371_2470# 0.01806f
C175 DELAY_OUT_TAP2 a_4503_1842# 0.69646f
C176 a_22613_1842# DELAY_OUT_TAP25 0.70708f
C177 a_16533_1842# a_16663_1842# 0.70845f
C178 a_24133_1842# DELAY_OUT_TAP27 0.70708f
C179 a_8173_1842# DELAY_OUT_TAP6 0.70708f
C180 a_15013_1842# DELAY_OUT_TAP15 0.70708f
C181 DELAY_VBIASP a_21853_1842# 0.11222f
C182 VDD a_4373_1842# 0.4916f
C183 a_12863_1842# DELAY_VBIASN 0.07258f
C184 a_25891_1842# a_25783_1842# 0.01163f
C185 a_22743_1842# DELAY_VBIASN 0.07258f
C186 VDD DELAY_IN 0.45518f
C187 a_22613_1842# DELAY_VBIASP 0.11222f
C188 VDD a_10453_1842# 0.4916f
C189 a_18943_1842# DELAY_OUT_TAP21 0.69646f
C190 VDD a_17423_1842# 0.49633f
C191 VDD a_19811_2470# 0.01806f
C192 a_21093_1842# a_21223_1842# 0.70845f
C193 DELAY_VBIASP DELAY_OUT_TAP6 0.04137f
C194 DELAY_OUT_TAP7 DELAY_VBIASN 0.04353f
C195 a_13493_1842# DELAY_OUT_TAP13 0.70708f
C196 VDD a_6653_1842# 0.4916f
C197 DELAY_VBIASP a_19703_1842# 0.06627f
C198 a_10583_1842# a_10691_2470# 0.01697f
C199 VDD a_6131_2470# 0.01806f
C200 VDD a_8933_1842# 0.4916f
C201 a_8173_1842# VDD 0.4916f
C202 DELAY_OUT_TAP10 a_10583_1842# 0.69646f
C203 a_18813_1842# VDD 0.4916f
C204 a_21223_1842# a_21331_1842# 0.01163f
C205 DELAY_VBIASP a_5893_1842# 0.11222f
C206 DELAY_OUT_TAP25 VDD 0.72899f
C207 DELAY_VBIASP DELAY_OUT_TAP23 0.04137f
C208 a_6023_1842# a_6131_1842# 0.01163f
C209 DELAY_OUT_TAP1 VDD 0.72899f
C210 DELAY_VBIASP a_9693_1842# 0.11222f
C211 a_14383_1842# a_14491_2470# 0.01697f
C212 DELAY_VBIASN a_4373_1842# 0.10601f
C213 DELAY_IN DELAY_VBIASN 0.06969f
C214 DELAY_VBIASP VDD 13.2523f
C215 DELAY_OUT_TAP14 a_13493_1842# 0.0114f
C216 a_10453_1842# DELAY_VBIASN 0.10601f
C217 a_17423_1842# DELAY_VBIASN 0.07258f
C218 a_5133_1842# DELAY_OUT_TAP2 0.70708f
C219 a_5263_1842# a_5371_1842# 0.01163f
C220 a_27303_1842# a_27737_1842# 0.69646f
C221 DELAY_VBIASP DELAY_OUT_TAP31 0.04137f
C222 a_24263_1842# a_24371_2470# 0.01697f
C223 a_6653_1842# DELAY_VBIASN 0.10601f
C224 a_15143_1842# DELAY_OUT_TAP16 0.69646f
C225 a_14253_1842# DELAY_OUT_TAP15 0.0114f
C226 DELAY_VBIASP a_7543_1842# 0.06627f
C227 a_23373_1842# DELAY_OUT_TAP27 0.0114f
C228 DELAY_OUT_TAP11 DELAY_VBIASP 0.04137f
C229 a_8933_1842# DELAY_VBIASN 0.10601f
C230 a_8173_1842# DELAY_VBIASN 0.10601f
C231 a_18813_1842# DELAY_VBIASN 0.10601f
C232 a_12733_1842# VDD 0.4916f
C233 a_5263_1842# DELAY_VBIASP 0.06627f
C234 DELAY_OUT_TAP25 DELAY_VBIASN 0.04353f
C235 VDD a_25891_2470# 0.01806f
C236 DELAY_OUT_TAP24 DELAY_VBIASP 0.04137f
C237 a_16663_1842# a_16771_2470# 0.01697f
C238 DELAY_OUT_TAP1 DELAY_VBIASN 0.04353f
C239 a_4373_1842# a_4503_1842# 0.70845f
C240 a_18183_1842# a_18291_2470# 0.01697f
C241 a_15773_1842# VDD 0.4916f
C242 a_16533_1842# DELAY_OUT_TAP18 0.0114f
C243 DELAY_VBIASP DELAY_VBIASN 3.50557f
C244 a_6653_1842# a_6783_1842# 0.70845f
C245 a_12733_1842# DELAY_VBIASN 0.10601f
C246 a_24263_1842# DELAY_VBIASP 0.06627f
C247 a_8933_1842# a_9063_1842# 0.70845f
C248 DELAY_OUT_TAP20 a_18183_1842# 0.69646f
C249 a_15773_1842# DELAY_VBIASN 0.10601f
C250 a_18813_1842# DELAY_OUT_TAP21 0.0114f
C251 DELAY_VBIASP a_4503_1842# 0.06627f
C252 VDD a_17293_1842# 0.4916f
C253 a_15013_1842# a_15143_1842# 0.70845f
C254 VDD DELAY_OUT_TAP12 0.72899f
C255 VDD a_11451_2470# 0.01806f
C256 DELAY_VBIASP a_19573_1842# 0.11222f
C257 DELAY_VBIASP a_6783_1842# 0.06627f
C258 a_25653_1842# a_25783_1842# 0.70845f
C259 a_6783_1842# a_6891_1842# 0.01163f
C260 DELAY_VBIASP DELAY_OUT_TAP29 0.04137f
C261 DELAY_OUT_TAP10 a_10453_1842# 0.0114f
C262 DELAY_OUT_TAP21 DELAY_VBIASP 0.04137f
C263 DELAY_VBIASP a_9063_1842# 0.06627f
C264 DELAY_VBIASP DELAY_OUT_TAP22 0.04137f
C265 VDD a_16663_1842# 0.49633f
C266 VDD a_27737_1842# 0.75775f
C267 a_20463_1842# DELAY_OUT_TAP23 0.69646f
C268 a_25023_1842# VDD 0.49633f
C269 a_8411_2470# VDD 0.01806f
C270 a_20463_1842# VDD 0.49633f
C271 a_12863_1842# DELAY_OUT_TAP13 0.69646f
C272 a_17293_1842# DELAY_VBIASN 0.10601f
C273 DELAY_OUT_TAP5 a_6653_1842# 0.0114f
C274 DELAY_OUT_TAP15 DELAY_VBIASP 0.04137f
C275 DELAY_VBIASN DELAY_OUT_TAP12 0.04353f
C276 a_15013_1842# DELAY_OUT_TAP16 0.0114f
C277 a_26413_1842# a_26543_1842# 0.70845f
C278 a_14253_1842# DELAY_OUT_TAP14 0.70708f
C279 DELAY_VBIASP a_7413_1842# 0.11222f
C280 a_23373_1842# DELAY_OUT_TAP26 0.70708f
C281 DELAY_OUT_TAP10 DELAY_VBIASP 0.04137f
C282 a_22091_2470# a_21983_1842# 0.01697f
C283 a_5133_1842# DELAY_VBIASP 0.11222f
C284 a_16663_1842# DELAY_VBIASN 0.07258f
C285 DELAY_VBIASN a_27737_1842# 0.04176f
C286 DELAY_VBIASP a_27173_1842# 0.11222f
C287 a_18183_1842# a_18291_1842# 0.01163f
C288 a_25783_1842# DELAY_OUT_TAP30 0.69646f
C289 a_23503_1842# DELAY_VBIASP 0.06627f
C290 a_25023_1842# DELAY_VBIASN 0.07258f
C291 a_24893_1842# DELAY_VBIASP 0.11222f
C292 a_15903_1842# DELAY_VBIASP 0.06627f
C293 DELAY_VBIASP DELAY_OUT_TAP5 0.04137f
C294 DELAY_VBIASP DELAY_OUT_LAST 0.21225f
C295 a_20463_1842# DELAY_VBIASN 0.07258f
C296 a_20333_1842# DELAY_VBIASP 0.11222f
C297 VDD a_3851_2470# 0.01866f
C298 a_22743_1842# a_22851_2470# 0.01697f
C299 a_21853_1842# a_21983_1842# 0.70845f
C300 a_25023_1842# a_25131_2470# 0.01697f
C301 VDD a_15251_2470# 0.01806f
C302 VDD a_12971_2470# 0.01806f
C303 a_15773_1842# a_15903_1842# 0.70845f
C304 DELAY_VBIASP DELAY_OUT_TAP17 0.04137f
C305 VDD a_17531_2470# 0.01806f
C306 a_24133_1842# DELAY_VBIASP 0.11222f
C307 a_26651_2470# a_26543_1842# 0.01697f
C308 a_18813_1842# DELAY_OUT_TAP20 0.70708f
C309 DELAY_VBIASP a_21223_1842# 0.06627f
C310 VDD DELAY_OUT_TAP18 0.72899f
C311 a_20463_1842# a_20571_2470# 0.01697f
C312 a_25023_1842# DELAY_OUT_TAP29 0.69646f
C313 VDD a_11213_1842# 0.4916f
C314 a_11973_1842# a_12103_1842# 0.70845f
C315 DELAY_VBIASP DELAY_OUT_TAP13 0.04137f
C316 DELAY_VBIASP DELAY_OUT_TAP28 0.04137f
C317 a_14253_1842# a_14383_1842# 0.70845f
C318 DELAY_OUT_TAP20 DELAY_VBIASP 0.04137f
C319 VDD a_21983_1842# 0.49633f
C320 VDD a_16533_1842# 0.4916f
C321 a_10453_1842# DELAY_OUT_TAP9 0.70708f
C322 a_27411_2470# a_27303_1842# 0.01697f
C323 a_15773_1842# DELAY_OUT_TAP17 0.0114f
C324 a_9931_2470# a_9823_1842# 0.01697f
C325 DELAY_OUT_TAP11 a_11213_1842# 0.0114f
C326 a_5893_1842# a_6023_1842# 0.70845f
C327 a_7651_2470# VDD 0.01806f
C328 a_12733_1842# DELAY_OUT_TAP13 0.0114f
C329 DELAY_OUT_TAP4 a_6653_1842# 0.70708f
C330 DELAY_OUT_TAP14 DELAY_VBIASP 0.04137f
C331 VDD a_6023_1842# 0.49633f
C332 DELAY_OUT_TAP18 DELAY_VBIASN 0.04353f
C333 a_7651_2470# a_7543_1842# 0.01697f
C334 a_27173_1842# a_27737_1842# 0.0114f
C335 a_11213_1842# DELAY_VBIASN 0.10601f
C336 a_15903_1842# a_16011_1842# 0.01163f
C337 a_15143_1842# DELAY_VBIASP 0.06627f
C338 a_20463_1842# a_20571_1842# 0.01163f
C339 a_9693_1842# a_9823_1842# 0.70845f
C340 a_21983_1842# DELAY_VBIASN 0.07258f
C341 VDD a_9823_1842# 0.49633f
C342 DELAY_VBIASP a_25783_1842# 0.06627f
C343 VDD a_13623_1842# 0.49633f
C344 DELAY_VBIASP DELAY_OUT_TAP9 0.04137f
C345 a_16533_1842# DELAY_VBIASN 0.10601f
C346 a_24893_1842# a_25023_1842# 0.70845f
C347 DELAY_OUT_LAST a_27737_1842# 0.70955f
C348 a_23373_1842# DELAY_VBIASP 0.11222f
C349 a_25653_1842# DELAY_OUT_TAP30 0.0114f
C350 a_12211_1842# a_12103_1842# 0.01163f
C351 a_24263_1842# a_24371_1842# 0.01163f
C352 DELAY_VBIASP DELAY_OUT_TAP4 0.04137f
C353 a_20333_1842# a_20463_1842# 0.70845f
C354 DELAY_VBIASP a_26543_1842# 0.06627f
C355 VDD a_27303_1842# 0.49714f
C356 VDD a_18053_1842# 0.4916f
C357 DELAY_OUT_TAP19 a_17423_1842# 0.69646f
C358 DELAY_OUT_TAP30 a_26413_1842# 0.70708f
C359 a_25783_1842# a_25891_2470# 0.01697f
C360 DELAY_VBIASP DELAY_OUT_TAP3 0.04137f
C361 a_6023_1842# DELAY_VBIASN 0.07258f
C362 a_12863_1842# a_12971_1842# 0.01163f
C363 VDD a_12211_2470# 0.01806f
C364 DELAY_VBIASP DELAY_OUT_TAP27 0.04137f
C365 a_17531_1842# a_17423_1842# 0.01163f
C366 DELAY_IN a_3743_1842# 0.53924f
C367 DELAY_VBIASP a_13493_1842# 0.11222f
C368 DELAY_VBIASN a_9823_1842# 0.07258f
C369 a_13623_1842# DELAY_VBIASN 0.07258f
C370 a_22091_2470# VDD 0.01806f
C371 DELAY_VBIASP DELAY_OUT_TAP16 0.04137f
C372 VDD a_16771_2470# 0.01806f
C373 a_7543_1842# a_7651_1842# 0.01163f
C374 DELAY_VBIASP a_21093_1842# 0.11222f
C375 a_27411_2470# VDD 0.01806f
C376 DELAY_VBIASP a_12103_1842# 0.06627f
C377 a_14383_1842# DELAY_VBIASP 0.06627f
C378 DELAY_VBIASP DELAY_OUT_TAP19 0.04137f
C379 a_22743_1842# DELAY_OUT_TAP26 0.69646f
C380 DELAY_VBIASP a_11343_1842# 0.06627f
C381 a_8303_1842# DELAY_OUT_TAP7 0.69646f
C382 a_27303_1842# DELAY_VBIASN 0.07259f
C383 a_18053_1842# DELAY_VBIASN 0.10601f
C384 DELAY_OUT_TAP1 a_3743_1842# 0.69646f
C385 VDD a_21853_1842# 0.4916f
C386 a_22613_1842# VDD 0.4916f
C387 a_15773_1842# DELAY_OUT_TAP16 0.70708f
C388 DELAY_OUT_TAP10 a_11213_1842# 0.70708f
C389 DELAY_VBIASP a_3743_1842# 0.05992f
C390 VDD a_9931_2470# 0.01806f
C391 a_10453_1842# a_10583_1842# 0.70845f
C392 VDD DELAY_OUT_TAP6 0.72899f
C393 VDD a_19703_1842# 0.49633f
C394 a_8933_1842# DELAY_OUT_TAP8 0.0114f
C395 DELAY_OUT_TAP24 a_21853_1842# 0.70708f
C396 DELAY_OUT_TAP2 a_4373_1842# 0.0114f
C397 VDD a_5893_1842# 0.4916f
C398 VDD DELAY_OUT_TAP23 0.72899f
C399 a_7543_1842# DELAY_OUT_TAP6 0.69646f
C400 a_15013_1842# DELAY_VBIASP 0.11222f
C401 a_9063_1842# a_9171_1842# 0.01163f
C402 a_21853_1842# DELAY_VBIASN 0.10601f
C403 VDD a_9693_1842# 0.4916f
C404 DELAY_VBIASP a_25653_1842# 0.11222f
C405 a_22613_1842# DELAY_VBIASN 0.10601f
C406 DELAY_VBIASP DELAY_OUT_TAP8 0.04137f
C407 a_8173_1842# a_8303_1842# 0.70845f
C408 DELAY_VBIASP a_10583_1842# 0.06627f
C409 a_18813_1842# a_18943_1842# 0.70845f
C410 DELAY_OUT_TAP6 DELAY_VBIASN 0.04353f
C411 VDD DELAY_OUT_TAP31 0.72899f
C412 DELAY_VBIASN a_19703_1842# 0.07258f
C413 VDD a_7543_1842# 0.49633f
C414 DELAY_VBIASP a_26413_1842# 0.11222f
C415 DELAY_OUT_TAP11 VDD 0.72899f
C416 DELAY_OUT_TAP19 a_17293_1842# 0.0114f
C417 a_12103_1842# DELAY_OUT_TAP12 0.69646f
C418 a_5263_1842# VDD 0.49633f
C419 DELAY_OUT_TAP24 VDD 0.72899f
C420 DELAY_VBIASP DELAY_OUT_TAP2 0.04137f
C421 a_8303_1842# DELAY_VBIASP 0.06627f
C422 a_5893_1842# DELAY_VBIASN 0.10601f
C423 DELAY_OUT_TAP23 DELAY_VBIASN 0.04353f
C424 DELAY_VBIASP a_18183_1842# 0.06627f
C425 a_18943_1842# DELAY_VBIASP 0.06627f
C426 a_16533_1842# DELAY_OUT_TAP17 0.70708f
C427 DELAY_VBIASP DELAY_OUT_TAP26 0.04137f
C428 a_11451_2470# a_11343_1842# 0.01697f
C429 DELAY_VBIASN a_9693_1842# 0.10601f
C430 a_21331_2470# VDD 0.01806f
C431 VDD DELAY_VBIASN 0.85759f
C432 a_21983_1842# a_22091_1842# 0.01163f
C433 a_15143_1842# a_15251_2470# 0.01697f
C434 a_27303_1842# a_27173_1842# 0.70845f
C435 VDD a_19051_2470# 0.01806f
C436 DELAY_VBIASN DELAY_OUT_TAP31 0.04353f
C437 DELAY_VBIASP DELAY_OUT_TAP30 0.04137f
C438 DELAY_VBIASP a_11973_1842# 0.11222f
C439 a_14253_1842# DELAY_VBIASP 0.11222f
C440 VDD a_25131_2470# 0.01806f
C441 a_19573_1842# a_19703_1842# 0.70845f
C442 a_7543_1842# DELAY_VBIASN 0.07258f
C443 DELAY_OUT_TAP11 DELAY_VBIASN 0.04353f
C444 a_8933_1842# DELAY_OUT_TAP7 0.70708f
C445 a_8173_1842# DELAY_OUT_TAP7 0.0114f
C446 a_5263_1842# DELAY_VBIASN 0.07258f
C447 DELAY_OUT_TAP24 DELAY_VBIASN 0.04353f
C448 DELAY_OUT_TAP22 a_19703_1842# 0.69646f
C449 a_24263_1842# VDD 0.49633f
C450 a_12863_1842# DELAY_VBIASP 0.06627f
C451 VDD a_4503_1842# 0.49633f
C452 a_22743_1842# DELAY_VBIASP 0.06627f
C453 VDD a_9171_2470# 0.01806f
C454 VDD a_20571_2470# 0.01806f
C455 a_15143_1842# a_15251_1842# 0.01163f
C456 VDD a_19573_1842# 0.4916f
C457 DELAY_VBIASP DELAY_OUT_TAP7 0.04137f
C458 VDD a_6783_1842# 0.49633f
C459 VDD DELAY_OUT_TAP29 0.72899f
C460 VDD a_6891_2470# 0.01806f
C461 DELAY_OUT_TAP21 VDD 0.72899f
C462 VDD a_9063_1842# 0.49633f
C463 a_7413_1842# DELAY_OUT_TAP6 0.0114f
C464 VDD DELAY_OUT_TAP22 0.72899f
C465 a_4503_1842# a_4611_1842# 0.01163f
C466 a_12733_1842# a_12863_1842# 0.70845f
C467 DELAY_OUT_TAP1 a_4373_1842# 0.70708f
C468 DELAY_OUT_TAP1 DELAY_IN 0.01139f
C469 a_27303_1842# a_27411_1842# 0.01163f
C470 a_24263_1842# DELAY_VBIASN 0.07258f
C471 DELAY_OUT_TAP20 a_18053_1842# 0.0114f
C472 DELAY_VBIASP a_4373_1842# 0.11222f
C473 DELAY_VBIASN a_4503_1842# 0.07258f
C474 DELAY_VBIASP DELAY_IN 0.0738f
C475 DELAY_OUT_TAP14 a_13623_1842# 0.69646f
C476 DELAY_VBIASP a_10453_1842# 0.11222f
C477 DELAY_OUT_TAP15 VDD 0.72899f
C478 DELAY_VBIASP a_17423_1842# 0.06627f
C479 VDD a_10691_2470# 0.01806f
C480 a_3743_1842# a_3851_2470# 0.01697f
C481 DELAY_VBIASN a_19573_1842# 0.10601f
C482 DELAY_VBIASP a_6653_1842# 0.11222f
C483 a_6783_1842# DELAY_VBIASN 0.07258f
C484 VDD a_7413_1842# 0.4916f
C485 DELAY_OUT_TAP10 VDD 0.72899f
C486 DELAY_VBIASN DELAY_OUT_TAP29 0.04353f
C487 VDD a_23611_2470# 0.01806f
C488 a_6023_1842# DELAY_OUT_TAP4 0.69646f
C489 a_8303_1842# a_8411_2470# 0.01697f
C490 DELAY_OUT_TAP21 DELAY_VBIASN 0.04353f
C491 DELAY_VBIASP a_8933_1842# 0.11222f
C492 a_9063_1842# DELAY_VBIASN 0.07258f
C493 a_11973_1842# DELAY_OUT_TAP12 0.0114f
C494 DELAY_OUT_TAP9 a_9823_1842# 0.69646f
C495 a_5133_1842# VDD 0.4916f
C496 a_8173_1842# DELAY_VBIASP 0.11222f
C497 a_18813_1842# DELAY_VBIASP 0.11222f
C498 DELAY_OUT_TAP22 DELAY_VBIASN 0.04353f
C499 VDD a_27173_1842# 0.4916f
C500 a_20333_1842# DELAY_OUT_TAP23 0.0114f
C501 a_23503_1842# VDD 0.49633f
C502 DELAY_OUT_TAP25 DELAY_VBIASP 0.04137f
C503 DELAY_VBIASP DELAY_OUT_TAP1 0.04137f
C504 a_7413_1842# a_7543_1842# 0.70845f
C505 a_24893_1842# VDD 0.4916f
C506 a_15903_1842# VDD 0.49633f
C507 a_11213_1842# a_11343_1842# 0.70845f
C508 VDD DELAY_OUT_TAP5 0.72899f
C509 a_27173_1842# DELAY_OUT_TAP31 0.70708f
C510 VDD DELAY_OUT_LAST 0.45735f
C511 a_20333_1842# VDD 0.4916f
C512 a_3851_1842# a_3743_1842# 0.01163f
C513 DELAY_OUT_TAP15 DELAY_VBIASN 0.04353f
C514 VDD a_18291_2470# 0.01806f
C515 a_5133_1842# a_5263_1842# 0.70845f
C516 a_16663_1842# a_16771_1842# 0.01163f
C517 a_7413_1842# DELAY_VBIASN 0.10601f
R0 DELAY_VBIASN.n1 DELAY_VBIASN.t31 34.3755
R1 DELAY_VBIASN.n1 DELAY_VBIASN.t30 33.0005
R2 DELAY_VBIASN.n2 DELAY_VBIASN.t29 33.0005
R3 DELAY_VBIASN.n3 DELAY_VBIASN.t28 33.0005
R4 DELAY_VBIASN.n4 DELAY_VBIASN.t27 33.0005
R5 DELAY_VBIASN.n5 DELAY_VBIASN.t26 33.0005
R6 DELAY_VBIASN.n6 DELAY_VBIASN.t25 33.0005
R7 DELAY_VBIASN.n7 DELAY_VBIASN.t24 33.0005
R8 DELAY_VBIASN.n8 DELAY_VBIASN.t23 33.0005
R9 DELAY_VBIASN.n9 DELAY_VBIASN.t22 33.0005
R10 DELAY_VBIASN.n10 DELAY_VBIASN.t21 33.0005
R11 DELAY_VBIASN.n11 DELAY_VBIASN.t20 33.0005
R12 DELAY_VBIASN.n12 DELAY_VBIASN.t19 33.0005
R13 DELAY_VBIASN.n13 DELAY_VBIASN.t18 33.0005
R14 DELAY_VBIASN.n14 DELAY_VBIASN.t17 33.0005
R15 DELAY_VBIASN.n15 DELAY_VBIASN.t16 33.0005
R16 DELAY_VBIASN.n16 DELAY_VBIASN.t15 33.0005
R17 DELAY_VBIASN.n17 DELAY_VBIASN.t14 33.0005
R18 DELAY_VBIASN.n18 DELAY_VBIASN.t13 33.0005
R19 DELAY_VBIASN.n19 DELAY_VBIASN.t12 33.0005
R20 DELAY_VBIASN.n20 DELAY_VBIASN.t11 33.0005
R21 DELAY_VBIASN.n21 DELAY_VBIASN.t10 33.0005
R22 DELAY_VBIASN.n22 DELAY_VBIASN.t9 33.0005
R23 DELAY_VBIASN.n23 DELAY_VBIASN.t8 33.0005
R24 DELAY_VBIASN.n24 DELAY_VBIASN.t7 33.0005
R25 DELAY_VBIASN.n25 DELAY_VBIASN.t6 33.0005
R26 DELAY_VBIASN.n26 DELAY_VBIASN.t5 33.0005
R27 DELAY_VBIASN.n27 DELAY_VBIASN.t4 33.0005
R28 DELAY_VBIASN.n28 DELAY_VBIASN.t3 33.0005
R29 DELAY_VBIASN.n29 DELAY_VBIASN.t2 33.0005
R30 DELAY_VBIASN.n30 DELAY_VBIASN.t1 33.0005
R31 DELAY_VBIASN.n0 DELAY_VBIASN.t0 33.0005
R32 DELAY_VBIASN DELAY_VBIASN.n0 1.55517
R33 DELAY_VBIASN.n0 DELAY_VBIASN.n30 1.3755
R34 DELAY_VBIASN.n30 DELAY_VBIASN.n29 1.3755
R35 DELAY_VBIASN.n29 DELAY_VBIASN.n28 1.3755
R36 DELAY_VBIASN.n28 DELAY_VBIASN.n27 1.3755
R37 DELAY_VBIASN.n27 DELAY_VBIASN.n26 1.3755
R38 DELAY_VBIASN.n26 DELAY_VBIASN.n25 1.3755
R39 DELAY_VBIASN.n25 DELAY_VBIASN.n24 1.3755
R40 DELAY_VBIASN.n24 DELAY_VBIASN.n23 1.3755
R41 DELAY_VBIASN.n23 DELAY_VBIASN.n22 1.3755
R42 DELAY_VBIASN.n22 DELAY_VBIASN.n21 1.3755
R43 DELAY_VBIASN.n21 DELAY_VBIASN.n20 1.3755
R44 DELAY_VBIASN.n20 DELAY_VBIASN.n19 1.3755
R45 DELAY_VBIASN.n19 DELAY_VBIASN.n18 1.3755
R46 DELAY_VBIASN.n18 DELAY_VBIASN.n17 1.3755
R47 DELAY_VBIASN.n17 DELAY_VBIASN.n16 1.3755
R48 DELAY_VBIASN.n16 DELAY_VBIASN.n15 1.3755
R49 DELAY_VBIASN.n15 DELAY_VBIASN.n14 1.3755
R50 DELAY_VBIASN.n14 DELAY_VBIASN.n13 1.3755
R51 DELAY_VBIASN.n13 DELAY_VBIASN.n12 1.3755
R52 DELAY_VBIASN.n12 DELAY_VBIASN.n11 1.3755
R53 DELAY_VBIASN.n11 DELAY_VBIASN.n10 1.3755
R54 DELAY_VBIASN.n10 DELAY_VBIASN.n9 1.3755
R55 DELAY_VBIASN.n9 DELAY_VBIASN.n8 1.3755
R56 DELAY_VBIASN.n8 DELAY_VBIASN.n7 1.3755
R57 DELAY_VBIASN.n7 DELAY_VBIASN.n6 1.3755
R58 DELAY_VBIASN.n6 DELAY_VBIASN.n5 1.3755
R59 DELAY_VBIASN.n5 DELAY_VBIASN.n4 1.3755
R60 DELAY_VBIASN.n4 DELAY_VBIASN.n3 1.3755
R61 DELAY_VBIASN.n3 DELAY_VBIASN.n2 1.3755
R62 DELAY_VBIASN.n2 DELAY_VBIASN.n1 1.3755
R63 DELAY_VBIASP.n1 DELAY_VBIASP.t31 34.3685
R64 DELAY_VBIASP.n1 DELAY_VBIASP.t30 33.0005
R65 DELAY_VBIASP.n2 DELAY_VBIASP.t29 33.0005
R66 DELAY_VBIASP.n3 DELAY_VBIASP.t28 33.0005
R67 DELAY_VBIASP.n4 DELAY_VBIASP.t27 33.0005
R68 DELAY_VBIASP.n5 DELAY_VBIASP.t26 33.0005
R69 DELAY_VBIASP.n6 DELAY_VBIASP.t25 33.0005
R70 DELAY_VBIASP.n7 DELAY_VBIASP.t24 33.0005
R71 DELAY_VBIASP.n8 DELAY_VBIASP.t23 33.0005
R72 DELAY_VBIASP.n9 DELAY_VBIASP.t22 33.0005
R73 DELAY_VBIASP.n10 DELAY_VBIASP.t21 33.0005
R74 DELAY_VBIASP.n11 DELAY_VBIASP.t20 33.0005
R75 DELAY_VBIASP.n12 DELAY_VBIASP.t19 33.0005
R76 DELAY_VBIASP.n13 DELAY_VBIASP.t18 33.0005
R77 DELAY_VBIASP.n14 DELAY_VBIASP.t17 33.0005
R78 DELAY_VBIASP.n15 DELAY_VBIASP.t16 33.0005
R79 DELAY_VBIASP.n16 DELAY_VBIASP.t15 33.0005
R80 DELAY_VBIASP.n17 DELAY_VBIASP.t14 33.0005
R81 DELAY_VBIASP.n18 DELAY_VBIASP.t13 33.0005
R82 DELAY_VBIASP.n19 DELAY_VBIASP.t12 33.0005
R83 DELAY_VBIASP.n20 DELAY_VBIASP.t11 33.0005
R84 DELAY_VBIASP.n21 DELAY_VBIASP.t10 33.0005
R85 DELAY_VBIASP.n22 DELAY_VBIASP.t9 33.0005
R86 DELAY_VBIASP.n23 DELAY_VBIASP.t8 33.0005
R87 DELAY_VBIASP.n24 DELAY_VBIASP.t7 33.0005
R88 DELAY_VBIASP.n25 DELAY_VBIASP.t6 33.0005
R89 DELAY_VBIASP.n26 DELAY_VBIASP.t5 33.0005
R90 DELAY_VBIASP.n27 DELAY_VBIASP.t4 33.0005
R91 DELAY_VBIASP.n28 DELAY_VBIASP.t3 33.0005
R92 DELAY_VBIASP.n29 DELAY_VBIASP.t2 33.0005
R93 DELAY_VBIASP.n30 DELAY_VBIASP.t1 33.0005
R94 DELAY_VBIASP.n0 DELAY_VBIASP.t0 33.0005
R95 DELAY_VBIASP DELAY_VBIASP.n0 1.70586
R96 DELAY_VBIASP.n0 DELAY_VBIASP.n30 1.36852
R97 DELAY_VBIASP.n30 DELAY_VBIASP.n29 1.36852
R98 DELAY_VBIASP.n29 DELAY_VBIASP.n28 1.36852
R99 DELAY_VBIASP.n28 DELAY_VBIASP.n27 1.36852
R100 DELAY_VBIASP.n27 DELAY_VBIASP.n26 1.36852
R101 DELAY_VBIASP.n26 DELAY_VBIASP.n25 1.36852
R102 DELAY_VBIASP.n25 DELAY_VBIASP.n24 1.36852
R103 DELAY_VBIASP.n24 DELAY_VBIASP.n23 1.36852
R104 DELAY_VBIASP.n23 DELAY_VBIASP.n22 1.36852
R105 DELAY_VBIASP.n22 DELAY_VBIASP.n21 1.36852
R106 DELAY_VBIASP.n21 DELAY_VBIASP.n20 1.36852
R107 DELAY_VBIASP.n20 DELAY_VBIASP.n19 1.36852
R108 DELAY_VBIASP.n19 DELAY_VBIASP.n18 1.36852
R109 DELAY_VBIASP.n18 DELAY_VBIASP.n17 1.36852
R110 DELAY_VBIASP.n17 DELAY_VBIASP.n16 1.36852
R111 DELAY_VBIASP.n16 DELAY_VBIASP.n15 1.36852
R112 DELAY_VBIASP.n15 DELAY_VBIASP.n14 1.36852
R113 DELAY_VBIASP.n14 DELAY_VBIASP.n13 1.36852
R114 DELAY_VBIASP.n13 DELAY_VBIASP.n12 1.36852
R115 DELAY_VBIASP.n12 DELAY_VBIASP.n11 1.36852
R116 DELAY_VBIASP.n11 DELAY_VBIASP.n10 1.36852
R117 DELAY_VBIASP.n10 DELAY_VBIASP.n9 1.36852
R118 DELAY_VBIASP.n9 DELAY_VBIASP.n8 1.36852
R119 DELAY_VBIASP.n8 DELAY_VBIASP.n7 1.36852
R120 DELAY_VBIASP.n7 DELAY_VBIASP.n6 1.36852
R121 DELAY_VBIASP.n6 DELAY_VBIASP.n5 1.36852
R122 DELAY_VBIASP.n5 DELAY_VBIASP.n4 1.36852
R123 DELAY_VBIASP.n4 DELAY_VBIASP.n3 1.36852
R124 DELAY_VBIASP.n3 DELAY_VBIASP.n2 1.36852
R125 DELAY_VBIASP.n2 DELAY_VBIASP.n1 1.36852
R126 VDD.n12 VDD.t30 15.1333
R127 VDD.n12 VDD.t33 15.0005
R128 VDD.t0 VDD.t25 15.0005
R129 VDD VDD.n31 1.59504
R130 VDD.t0 VDD.t13 6.09923
R131 VDD.t0 VDD.t14 6.09923
R132 VDD.n47 VDD.t38 6.09923
R133 VDD.n21 VDD.t17 6.09923
R134 VDD.n33 VDD.t16 6.09923
R135 VDD.n26 VDD.t7 6.09923
R136 VDD.n49 VDD.t11 6.09923
R137 VDD.n28 VDD.t1 6.09923
R138 VDD.n51 VDD.t18 6.09923
R139 VDD.n41 VDD.t5 6.09923
R140 VDD.n24 VDD.t19 6.09923
R141 VDD.n35 VDD.t2 6.09923
R142 VDD.n30 VDD.t4 6.09923
R143 VDD.n8 VDD.t20 6.09923
R144 VDD.n8 VDD.t46 6.09923
R145 VDD.n15 VDD.t15 6.09923
R146 VDD.n15 VDD.t12 6.09923
R147 VDD.n37 VDD.t3 6.09923
R148 VDD.n19 VDD.t44 6.09923
R149 VDD.n19 VDD.t23 6.09923
R150 VDD.n53 VDD.t22 6.09923
R151 VDD.n39 VDD.t21 6.09923
R152 VDD.t0 VDD.t8 6.09923
R153 VDD.n43 VDD.t53 6.09923
R154 VDD.t0 VDD.t87 6.09923
R155 VDD.t0 VDD.t52 6.09923
R156 VDD.n45 VDD.t9 6.09923
R157 VDD.t0 VDD.t86 6.09923
R158 VDD.t0 VDD.t51 6.09923
R159 VDD.n12 VDD.t43 6.09923
R160 VDD.n12 VDD.t96 6.09923
R161 VDD.n12 VDD.t6 6.09923
R162 VDD.n22 VDD.n47 0.149633
R163 VDD.t0 VDD.n22 0.222115
R164 VDD.t0 VDD.n26 0.609199
R165 VDD.t0 VDD.n28 0.609163
R166 VDD.t0 VDD.n41 0.470732
R167 VDD.t0 VDD.n30 0.609237
R168 VDD.n16 VDD.n8 0.50294
R169 VDD.n16 VDD.n15 0.280614
R170 VDD.t0 VDD.n39 0.470718
R171 VDD.t0 VDD.t26 5.60969
R172 VDD.n12 VDD.t35 5.60347
R173 VDD.n12 VDD.t32 5.80946
R174 VDD.t0 VDD.t62 5.79039
R175 VDD.n46 VDD.t57 5.59675
R176 VDD.n20 VDD.t64 5.59675
R177 VDD.n32 VDD.t61 5.59675
R178 VDD.n25 VDD.t60 5.59675
R179 VDD.n48 VDD.t65 5.59675
R180 VDD.n27 VDD.t66 5.59675
R181 VDD.n50 VDD.t59 5.59675
R182 VDD.n40 VDD.t71 5.59675
R183 VDD.n23 VDD.t69 5.59675
R184 VDD.n34 VDD.t72 5.59675
R185 VDD.n29 VDD.t70 5.59675
R186 VDD.n7 VDD.t68 5.59675
R187 VDD.n6 VDD.t67 5.59675
R188 VDD.n14 VDD.t73 5.59675
R189 VDD.n13 VDD.t58 5.59675
R190 VDD.n36 VDD.t54 5.59675
R191 VDD.n18 VDD.t76 5.59675
R192 VDD.n17 VDD.t77 5.59675
R193 VDD.n52 VDD.t75 5.59675
R194 VDD.n38 VDD.t79 5.59675
R195 VDD.n3 VDD.t80 5.59675
R196 VDD.n42 VDD.t78 5.59675
R197 VDD.n1 VDD.t81 5.59675
R198 VDD.n4 VDD.t74 5.59675
R199 VDD.n44 VDD.t83 5.59675
R200 VDD.n0 VDD.t82 5.59675
R201 VDD.n2 VDD.t56 5.59675
R202 VDD.n10 VDD.t55 5.59675
R203 VDD.n9 VDD.t85 5.59675
R204 VDD VDD.n31 1.59504
R205 VDD.n31 VDD.t0 0.71648
R206 VDD.n33 VDD.n26 0.409347
R207 VDD.n35 VDD.n30 0.409438
R208 VDD.n49 VDD.n28 0.409773
R209 VDD.n51 VDD.n41 0.409773
R210 VDD.n53 VDD.n39 0.409773
R211 VDD.n22 VDD.n21 0.156772
R212 VDD.n43 VDD.t0 0.24013
R213 VDD.t0 VDD.n70 1.55392
R214 VDD.t0 VDD.n63 1.55387
R215 VDD.t0 VDD.n80 1.55379
R216 VDD.t0 VDD.n78 1.55377
R217 VDD.t0 VDD.n62 1.55375
R218 VDD.t0 VDD.n68 1.55373
R219 VDD.t0 VDD.n69 1.55371
R220 VDD.t0 VDD.n56 1.55361
R221 VDD.t0 VDD.n66 1.55361
R222 VDD.t0 VDD.n72 1.55361
R223 VDD.t0 VDD.n61 1.55352
R224 VDD.t0 VDD.n79 1.5535
R225 VDD.t0 VDD.n5 0.475843
R226 VDD.t0 VDD.n59 1.55344
R227 VDD.t0 VDD.n71 1.55344
R228 VDD.t0 VDD.n65 1.55339
R229 VDD.t0 VDD.n55 1.55335
R230 VDD.t0 VDD.n58 1.55334
R231 VDD.t0 VDD.n60 1.55334
R232 VDD.t0 VDD.n76 1.55334
R233 VDD.t0 VDD.n57 1.55334
R234 VDD.t0 VDD.n73 1.55332
R235 VDD.t0 VDD.n64 1.55331
R236 VDD.t0 VDD.n54 1.55327
R237 VDD.t0 VDD.n67 1.55327
R238 VDD.t0 VDD.n77 1.55327
R239 VDD.n11 VDD.n81 1.00911
R240 VDD.t0 VDD.n74 1.55325
R241 VDD.t0 VDD.n75 1.55325
R242 VDD.t0 VDD.t27 6.01456
R243 VDD.t63 VDD.t0 5.81213
R244 VDD.n46 VDD.n5 0.638467
R245 VDD.n20 VDD.n108 0.495398
R246 VDD.n32 VDD.n107 0.495398
R247 VDD.n25 VDD.n106 0.495398
R248 VDD.n48 VDD.n105 0.495398
R249 VDD.n27 VDD.n104 0.495398
R250 VDD.n50 VDD.n103 0.495398
R251 VDD.n40 VDD.n102 0.495398
R252 VDD.n23 VDD.n101 0.495398
R253 VDD.n34 VDD.n100 0.495398
R254 VDD.n29 VDD.n99 0.495398
R255 VDD.n7 VDD.n98 0.495398
R256 VDD.n6 VDD.n97 0.495398
R257 VDD.n14 VDD.n96 0.495398
R258 VDD.n13 VDD.n95 0.495398
R259 VDD.n36 VDD.n94 0.495398
R260 VDD.n18 VDD.n93 0.495398
R261 VDD.n17 VDD.n92 0.495398
R262 VDD.n52 VDD.n91 0.495398
R263 VDD.n38 VDD.n90 0.495398
R264 VDD.n3 VDD.n89 0.495398
R265 VDD.n42 VDD.n88 0.495398
R266 VDD.n1 VDD.n87 0.495398
R267 VDD.n4 VDD.n86 0.495398
R268 VDD.n44 VDD.n85 0.495398
R269 VDD.n0 VDD.n84 0.495398
R270 VDD.n2 VDD.n83 0.495398
R271 VDD.n10 VDD.n82 0.495398
R272 VDD.n9 VDD.n81 0.495398
R273 VDD.n47 VDD.n46 0.478641
R274 VDD.n21 VDD.n20 0.478641
R275 VDD.n33 VDD.n32 0.478641
R276 VDD.n26 VDD.n25 0.478641
R277 VDD.n49 VDD.n48 0.478641
R278 VDD.n28 VDD.n27 0.478641
R279 VDD.n51 VDD.n50 0.478641
R280 VDD.n41 VDD.n40 0.478641
R281 VDD.n24 VDD.n23 0.478641
R282 VDD.n35 VDD.n34 0.478641
R283 VDD.n30 VDD.n29 0.478641
R284 VDD.n8 VDD.n6 0.478641
R285 VDD.n15 VDD.n14 0.478641
R286 VDD.n15 VDD.n13 0.478641
R287 VDD.n37 VDD.n36 0.478641
R288 VDD.n19 VDD.n18 0.478641
R289 VDD.n19 VDD.n17 0.478641
R290 VDD.n53 VDD.n52 0.478641
R291 VDD.n39 VDD.n38 0.478641
R292 VDD.t0 VDD.n3 0.478641
R293 VDD.n43 VDD.n42 0.478641
R294 VDD.t0 VDD.n1 0.478641
R295 VDD.t0 VDD.n4 0.478641
R296 VDD.n45 VDD.n44 0.478641
R297 VDD.t0 VDD.n0 0.478641
R298 VDD.t0 VDD.n2 0.478641
R299 VDD.n12 VDD.n10 0.478641
R300 VDD.n12 VDD.n9 0.478641
R301 VDD.n12 VDD.t84 5.72522
R302 VDD.n12 VDD.t31 6.19118
R303 VDD.n92 VDD.n70 0.467524
R304 VDD.n99 VDD.n63 0.467485
R305 VDD.n84 VDD.n78 0.467383
R306 VDD.n100 VDD.n62 0.467273
R307 VDD.n93 VDD.n69 0.467258
R308 VDD.n82 VDD.n80 0.467234
R309 VDD.n94 VDD.n68 0.467195
R310 VDD.n96 VDD.n66 0.467143
R311 VDD.n106 VDD.n56 0.467143
R312 VDD.n90 VDD.n72 0.467143
R313 VDD.n101 VDD.n61 0.467091
R314 VDD.n5 VDD.n108 0.700575
R315 VDD.n97 VDD.n65 0.466761
R316 VDD.n105 VDD.n57 0.466741
R317 VDD.n86 VDD.n76 0.466699
R318 VDD.n104 VDD.n58 0.466699
R319 VDD.n102 VDD.n60 0.466699
R320 VDD.n98 VDD.n64 0.466677
R321 VDD.n88 VDD.n74 0.466592
R322 VDD.n87 VDD.n75 0.466592
R323 VDD.n83 VDD.n79 0.466477
R324 VDD.n85 VDD.n77 0.466464
R325 VDD.n108 VDD.n54 0.466464
R326 VDD.n95 VDD.n67 0.466439
R327 VDD.n89 VDD.n73 0.466314
R328 VDD.n107 VDD.n55 0.466177
R329 VDD.n91 VDD.n71 0.466171
R330 VDD.n103 VDD.n59 0.466129
R331 VDD.n102 VDD.n59 0.451798
R332 VDD.n106 VDD.n55 0.451743
R333 VDD.n90 VDD.n71 0.451738
R334 VDD.n88 VDD.n73 0.451566
R335 VDD.n94 VDD.n67 0.451469
R336 VDD.n107 VDD.n54 0.451456
R337 VDD.n84 VDD.n77 0.451456
R338 VDD.n82 VDD.n79 0.451426
R339 VDD.n87 VDD.n74 0.451294
R340 VDD.n86 VDD.n75 0.451294
R341 VDD.n97 VDD.n64 0.451265
R342 VDD.n103 VDD.n58 0.451252
R343 VDD.n101 VDD.n60 0.451252
R344 VDD.n85 VDD.n76 0.451252
R345 VDD.n96 VDD.n65 0.451204
R346 VDD.n104 VDD.n57 0.451193
R347 VDD.n100 VDD.n61 0.450884
R348 VDD.n105 VDD.n56 0.450828
R349 VDD.n95 VDD.n66 0.450828
R350 VDD.n89 VDD.n72 0.450828
R351 VDD.n93 VDD.n68 0.450767
R352 VDD.n92 VDD.n69 0.450729
R353 VDD.n81 VDD.n80 0.450709
R354 VDD.n99 VDD.n62 0.450672
R355 VDD.n83 VDD.n78 0.450641
R356 VDD.n98 VDD.n63 0.450539
R357 VDD.n91 VDD.n70 0.450481
R358 VDD.t29 VDD.t0 5.71158
R359 VDD.t0 VDD.t28 15.0661
R360 VDD.n8 VDD.n7 1.40682
R361 VDD.n21 VDD.n33 1.23768
R362 VDD.n15 VDD.n37 1.23766
R363 VDD.n24 VDD.n35 1.23757
R364 VDD.n30 VDD.n8 1.23749
R365 VDD.t0 VDD.n45 0.240125
R366 VDD.n26 VDD.n49 1.23744
R367 VDD.n28 VDD.n51 1.23736
R368 VDD.n19 VDD.n53 1.23734
R369 VDD.t0 VDD.n19 1.18695
R370 VDD.t0 VDD.n16 1.11698
R371 VDD.t0 VDD.n11 1.11226
R372 VDD.n12 VDD.n11 0.207224
R373 VDD.n37 VDD.n19 1.06172
R374 VDD.t0 VDD.n24 1.03991
R375 VSS.n2 VSS.t121 108.746
R376 VSS.t117 VSS.n96 108.746
R377 VSS.n4 VSS.t128 108.746
R378 VSS.t131 VSS.n94 108.746
R379 VSS.t132 VSS.n93 108.746
R380 VSS.n9 VSS.t129 108.746
R381 VSS.t126 VSS.n90 108.746
R382 VSS.n12 VSS.t124 108.746
R383 VSS.n14 VSS.t125 108.746
R384 VSS.n15 VSS.t123 108.746
R385 VSS.n17 VSS.t133 108.746
R386 VSS.n18 VSS.t119 108.746
R387 VSS.t118 VSS.n85 108.746
R388 VSS.n21 VSS.t135 108.746
R389 VSS.n23 VSS.t134 108.746
R390 VSS.n25 VSS.t140 108.746
R391 VSS.t143 VSS.n83 108.746
R392 VSS.t144 VSS.n82 108.746
R393 VSS.t142 VSS.n80 108.746
R394 VSS.t141 VSS.n79 108.746
R395 VSS.n32 VSS.t145 108.746
R396 VSS.t136 VSS.n77 108.746
R397 VSS.t146 VSS.n76 108.746
R398 VSS.t149 VSS.n74 108.746
R399 VSS.n37 VSS.t147 108.746
R400 VSS.n0 VSS.t120 108.746
R401 VSS.n3 VSS.t127 108.746
R402 VSS.n6 VSS.t130 108.746
R403 VSS.n11 VSS.t122 108.746
R404 VSS.n19 VSS.t139 108.746
R405 VSS.n30 VSS.t138 108.746
R406 VSS.n34 VSS.t137 108.746
R407 VSS.n1 VSS.t47 106.056
R408 VSS.n10 VSS.t42 106.056
R409 VSS.n16 VSS.t150 106.056
R410 VSS.n20 VSS.t8 106.056
R411 VSS.n22 VSS.t111 106.056
R412 VSS.n28 VSS.t151 106.056
R413 VSS.n35 VSS.t162 106.056
R414 VSS.t101 VSS.n99 106.056
R415 VSS.t58 VSS.n98 106.056
R416 VSS.t49 VSS.n97 106.056
R417 VSS.t48 VSS.n95 106.056
R418 VSS.n5 VSS.t100 106.056
R419 VSS.n7 VSS.t9 106.056
R420 VSS.n8 VSS.t2 106.056
R421 VSS.t5 VSS.n92 106.056
R422 VSS.t34 VSS.n91 106.056
R423 VSS.t63 VSS.n89 106.056
R424 VSS.n13 VSS.t33 106.056
R425 VSS.t166 VSS.n88 106.056
R426 VSS.t170 VSS.n87 106.056
R427 VSS.t173 VSS.n86 106.056
R428 VSS.t68 VSS.n84 106.056
R429 VSS.n24 VSS.t71 106.056
R430 VSS.n26 VSS.t159 106.056
R431 VSS.n27 VSS.t27 106.056
R432 VSS.t154 VSS.n81 106.056
R433 VSS.n29 VSS.t158 106.056
R434 VSS.n31 VSS.t28 106.056
R435 VSS.t161 VSS.n78 106.056
R436 VSS.n33 VSS.t167 106.056
R437 VSS.t168 VSS.n75 106.056
R438 VSS.n36 VSS.t164 106.056
R439 VSS.t13 VSS.t16 99.7537
R440 VSS.t93 VSS.n142 94.1709
R441 VSS.n145 VSS.t112 94.1709
R442 VSS.n148 VSS.t77 94.1709
R443 VSS.n151 VSS.t76 94.1709
R444 VSS.t75 VSS.n154 94.1709
R445 VSS.t106 VSS.n157 94.1709
R446 VSS.t79 VSS.n160 94.1709
R447 VSS.n163 VSS.t114 94.1709
R448 VSS.t110 VSS.n166 94.1709
R449 VSS.n169 VSS.t109 94.1709
R450 VSS.n172 VSS.t108 94.1709
R451 VSS.t113 VSS.n175 94.1709
R452 VSS.n178 VSS.t107 94.1709
R453 VSS.t82 VSS.n181 94.1709
R454 VSS.n184 VSS.t88 94.1709
R455 VSS.n187 VSS.t52 94.1709
R456 VSS.n190 VSS.t91 94.1709
R457 VSS.t81 VSS.n193 94.1709
R458 VSS.t85 VSS.n196 94.1709
R459 VSS.t90 VSS.n199 94.1709
R460 VSS.t87 VSS.n202 94.1709
R461 VSS.t66 VSS.n205 94.1709
R462 VSS.n208 VSS.t80 94.1709
R463 VSS.t98 VSS.n211 94.1709
R464 VSS.t104 VSS.n214 94.1709
R465 VSS.t96 VSS.n217 94.1709
R466 VSS.n220 VSS.t74 94.1709
R467 VSS.t102 VSS.n223 94.1709
R468 VSS.n226 VSS.t94 94.1709
R469 VSS.t83 VSS.n229 94.1709
R470 VSS.t115 VSS.n232 94.1709
R471 VSS.n234 VSS.t29 94.1709
R472 VSS.n0 VSS.t45 67.0429
R473 VSS.n3 VSS.t92 67.0429
R474 VSS.n6 VSS.t31 67.0429
R475 VSS.n11 VSS.t25 67.0429
R476 VSS.n19 VSS.t6 67.0429
R477 VSS.n30 VSS.t163 67.0429
R478 VSS.n34 VSS.t165 67.0429
R479 VSS.n2 VSS.t50 67.0426
R480 VSS.t56 VSS.n96 67.0426
R481 VSS.n4 VSS.t54 67.0426
R482 VSS.t40 VSS.n94 67.0426
R483 VSS.t0 VSS.n93 67.0426
R484 VSS.n9 VSS.t59 67.0426
R485 VSS.t61 VSS.n90 67.0426
R486 VSS.n12 VSS.t3 67.0426
R487 VSS.n14 VSS.t10 67.0426
R488 VSS.n15 VSS.t64 67.0426
R489 VSS.n17 VSS.t172 67.0426
R490 VSS.n18 VSS.t171 67.0426
R491 VSS.t43 VSS.n85 67.0426
R492 VSS.n21 VSS.t153 67.0426
R493 VSS.n23 VSS.t72 67.0426
R494 VSS.n25 VSS.t69 67.0426
R495 VSS.t160 VSS.n83 67.0426
R496 VSS.t35 VSS.n82 67.0426
R497 VSS.t155 VSS.n80 67.0426
R498 VSS.t157 VSS.n79 67.0426
R499 VSS.n32 VSS.t37 67.0426
R500 VSS.t156 VSS.n77 67.0426
R501 VSS.t152 VSS.n76 67.0426
R502 VSS.t169 VSS.n74 67.0426
R503 VSS.n37 VSS.t39 67.0426
R504 VSS.t24 VSS.n72 62.4463
R505 VSS.n72 VSS.t20 59.7564
R506 VSS.t20 VSS.n73 57.6659
R507 VSS.t45 VSS.n142 43.0498
R508 VSS.t50 VSS.n145 43.0498
R509 VSS.t92 VSS.n148 43.0498
R510 VSS.n151 VSS.t56 43.0498
R511 VSS.t54 VSS.n154 43.0498
R512 VSS.t31 VSS.n157 43.0498
R513 VSS.n160 VSS.t40 43.0498
R514 VSS.n163 VSS.t0 43.0498
R515 VSS.t59 VSS.n166 43.0498
R516 VSS.t25 VSS.n169 43.0498
R517 VSS.n172 VSS.t61 43.0498
R518 VSS.t3 VSS.n175 43.0498
R519 VSS.t10 VSS.n178 43.0498
R520 VSS.t64 VSS.n181 43.0498
R521 VSS.t172 VSS.n184 43.0498
R522 VSS.t171 VSS.n187 43.0498
R523 VSS.n190 VSS.t43 43.0498
R524 VSS.t6 VSS.n193 43.0498
R525 VSS.t153 VSS.n196 43.0498
R526 VSS.t72 VSS.n199 43.0498
R527 VSS.t69 VSS.n202 43.0498
R528 VSS.n205 VSS.t160 43.0498
R529 VSS.n208 VSS.t35 43.0498
R530 VSS.n211 VSS.t155 43.0498
R531 VSS.n214 VSS.t157 43.0498
R532 VSS.t163 VSS.n217 43.0498
R533 VSS.t37 VSS.n220 43.0498
R534 VSS.n223 VSS.t156 43.0498
R535 VSS.n226 VSS.t152 43.0498
R536 VSS.t165 VSS.n229 43.0498
R537 VSS.n232 VSS.t169 43.0498
R538 VSS.t39 VSS.n234 43.0498
R539 VSS.n100 VSS.n137 17.0005
R540 VSS.n100 VSS.n60 17.0005
R541 VSS.n100 VSS.n241 17.0005
R542 VSS.t29 VSS.n73 15.9628
R543 VSS.t112 VSS.n98 15.9213
R544 VSS.t77 VSS.n97 15.9213
R545 VSS.t76 VSS.n95 15.9213
R546 VSS.n5 VSS.t75 15.9213
R547 VSS.n7 VSS.t106 15.9213
R548 VSS.n8 VSS.t79 15.9213
R549 VSS.t114 VSS.n92 15.9213
R550 VSS.t109 VSS.n91 15.9213
R551 VSS.t108 VSS.n89 15.9213
R552 VSS.n13 VSS.t113 15.9213
R553 VSS.t107 VSS.n88 15.9213
R554 VSS.t88 VSS.n87 15.9213
R555 VSS.t52 VSS.n86 15.9213
R556 VSS.t91 VSS.n84 15.9213
R557 VSS.n24 VSS.t90 15.9213
R558 VSS.n26 VSS.t87 15.9213
R559 VSS.n27 VSS.t66 15.9213
R560 VSS.t80 VSS.n81 15.9213
R561 VSS.n29 VSS.t104 15.9213
R562 VSS.n31 VSS.t96 15.9213
R563 VSS.t74 VSS.n78 15.9213
R564 VSS.n33 VSS.t102 15.9213
R565 VSS.t94 VSS.n75 15.9213
R566 VSS.n36 VSS.t115 15.9213
R567 VSS.n1 VSS.t93 15.9203
R568 VSS.n10 VSS.t110 15.9203
R569 VSS.n16 VSS.t82 15.9203
R570 VSS.n20 VSS.t81 15.9203
R571 VSS.n22 VSS.t85 15.9203
R572 VSS.n28 VSS.t98 15.9203
R573 VSS.n35 VSS.t83 15.9203
R574 VSS.n38 VSS.t24 54.98
R575 VSS.t16 VSS.n99 13.2307
R576 VSS.n61 VSS.t58 11.8854
R577 VSS.n62 VSS.t49 11.8854
R578 VSS.n57 VSS.t48 11.8854
R579 VSS.t100 VSS.n63 11.8854
R580 VSS.t9 VSS.n56 11.8854
R581 VSS.t2 VSS.n55 11.8854
R582 VSS.n54 VSS.t5 11.8854
R583 VSS.t42 VSS.n53 11.8854
R584 VSS.n64 VSS.t34 11.8854
R585 VSS.n65 VSS.t166 11.8854
R586 VSS.n48 VSS.t173 11.8854
R587 VSS.t111 VSS.n45 11.8854
R588 VSS.t71 VSS.n44 11.8854
R589 VSS.t159 VSS.n66 11.8854
R590 VSS.t27 VSS.n43 11.8854
R591 VSS.n67 VSS.t154 11.8854
R592 VSS.t151 VSS.n68 11.8854
R593 VSS.t158 VSS.n69 11.8854
R594 VSS.t28 VSS.n42 11.8854
R595 VSS.t162 VSS.n70 11.8854
R596 VSS.t164 VSS.n71 11.8854
R597 VSS.n59 VSS.t101 11.8844
R598 VSS.t47 VSS.n58 11.8844
R599 VSS.n52 VSS.t63 11.8844
R600 VSS.t33 VSS.n51 11.8844
R601 VSS.t150 VSS.n50 11.8844
R602 VSS.n49 VSS.t170 11.8844
R603 VSS.n47 VSS.t68 11.8844
R604 VSS.t8 VSS.n46 11.8844
R605 VSS.n41 VSS.t161 11.8844
R606 VSS.t167 VSS.n40 11.8844
R607 VSS.n39 VSS.t168 11.8844
R608 VSS.t120 VSS.n59 9.19536
R609 VSS.t121 VSS.n58 9.19536
R610 VSS.t124 VSS.n52 9.19536
R611 VSS.t125 VSS.n51 9.19536
R612 VSS.t133 VSS.n50 9.19536
R613 VSS.t119 VSS.n49 9.19536
R614 VSS.t139 VSS.n47 9.19536
R615 VSS.t135 VSS.n46 9.19536
R616 VSS.n41 VSS.t136 9.19536
R617 VSS.n40 VSS.t146 9.19536
R618 VSS.t137 VSS.n39 9.19536
R619 VSS.t127 VSS.n61 9.19506
R620 VSS.n62 VSS.t117 9.19506
R621 VSS.t128 VSS.n57 9.19506
R622 VSS.t130 VSS.n63 9.19506
R623 VSS.n56 VSS.t131 9.19506
R624 VSS.n55 VSS.t132 9.19506
R625 VSS.t129 VSS.n54 9.19506
R626 VSS.t122 VSS.n53 9.19506
R627 VSS.n64 VSS.t126 9.19506
R628 VSS.t123 VSS.n65 9.19506
R629 VSS.n48 VSS.t118 9.19506
R630 VSS.t134 VSS.n45 9.19506
R631 VSS.t140 VSS.n44 9.19506
R632 VSS.n66 VSS.t143 9.19506
R633 VSS.n43 VSS.t144 9.19506
R634 VSS.n67 VSS.t142 9.19506
R635 VSS.n68 VSS.t141 9.19506
R636 VSS.t138 VSS.n69 9.19506
R637 VSS.t145 VSS.n42 9.19506
R638 VSS.n70 VSS.t149 9.19506
R639 VSS.t147 VSS.n71 9.19506
R640 VSS.n100 VSS.n142 8.5005
R641 VSS.n100 VSS.n145 8.5005
R642 VSS.n100 VSS.n148 8.5005
R643 VSS.n100 VSS.n151 8.5005
R644 VSS.n100 VSS.n154 8.5005
R645 VSS.n100 VSS.n157 8.5005
R646 VSS.n100 VSS.n160 8.5005
R647 VSS.n100 VSS.n163 8.5005
R648 VSS.n100 VSS.n166 8.5005
R649 VSS.n100 VSS.n169 8.5005
R650 VSS.n100 VSS.n172 8.5005
R651 VSS.n100 VSS.n175 8.5005
R652 VSS.n100 VSS.n178 8.5005
R653 VSS.n100 VSS.n181 8.5005
R654 VSS.n100 VSS.n184 8.5005
R655 VSS.n100 VSS.n187 8.5005
R656 VSS.n100 VSS.n190 8.5005
R657 VSS.n100 VSS.n193 8.5005
R658 VSS.n100 VSS.n196 8.5005
R659 VSS.n100 VSS.n199 8.5005
R660 VSS.n100 VSS.n202 8.5005
R661 VSS.n100 VSS.n205 8.5005
R662 VSS.n100 VSS.n208 8.5005
R663 VSS.n100 VSS.n211 8.5005
R664 VSS.n100 VSS.n214 8.5005
R665 VSS.n100 VSS.n217 8.5005
R666 VSS.n100 VSS.n220 8.5005
R667 VSS.n100 VSS.n223 8.5005
R668 VSS.n100 VSS.n226 8.5005
R669 VSS.n100 VSS.n229 8.5005
R670 VSS.n100 VSS.n232 8.5005
R671 VSS.n100 VSS.n234 8.5005
R672 VSS.n100 VSS.n138 8.47732
R673 VSS.n100 VSS.t19 8.47732
R674 VSS.n100 VSS.n135 8.47732
R675 VSS.n100 VSS.n246 8.47732
R676 VSS.n100 VSS.n235 8.47732
R677 VSS.n100 VSS.n237 8.47732
R678 VSS.n100 VSS.n136 5.63777
R679 VSS.n100 VSS.t13 5.00032
R680 VSS.n100 VSS.n239 4.20662
R681 VSS VSS.n248 2.9705
R682 VSS.n100 VSS.n101 2.74446
R683 VSS.n100 VSS.n133 2.74446
R684 VSS.n100 VSS.n139 2.74446
R685 VSS.n247 VSS.n100 2.74412
R686 VSS.n100 VSS.t30 2.74394
R687 VSS.n100 VSS.n102 1.55465
R688 VSS.n100 VSS.n103 1.55465
R689 VSS.n100 VSS.n104 1.55465
R690 VSS.n100 VSS.n105 1.55465
R691 VSS.n100 VSS.n106 1.55465
R692 VSS.n100 VSS.n107 1.55465
R693 VSS.n100 VSS.n108 1.55465
R694 VSS.n100 VSS.n109 1.55465
R695 VSS.n100 VSS.n110 1.55465
R696 VSS.n100 VSS.n111 1.55465
R697 VSS.n100 VSS.n112 1.55465
R698 VSS.n100 VSS.n113 1.55465
R699 VSS.n100 VSS.n114 1.55465
R700 VSS.n100 VSS.n115 1.55465
R701 VSS.n100 VSS.n116 1.55465
R702 VSS.n100 VSS.n117 1.55465
R703 VSS.n100 VSS.n118 1.55465
R704 VSS.n100 VSS.n119 1.55465
R705 VSS.n100 VSS.n120 1.55465
R706 VSS.n100 VSS.n121 1.55465
R707 VSS.n100 VSS.n122 1.55465
R708 VSS.n100 VSS.n123 1.55465
R709 VSS.n100 VSS.n124 1.55465
R710 VSS.n100 VSS.n125 1.55465
R711 VSS.n100 VSS.n126 1.55465
R712 VSS.n100 VSS.n127 1.55465
R713 VSS.n100 VSS.n128 1.55465
R714 VSS.n100 VSS.n129 1.55465
R715 VSS.n100 VSS.n130 1.55465
R716 VSS.n100 VSS.n131 1.55465
R717 VSS.n100 VSS.n132 1.55465
R718 VSS.n100 VSS.n140 1.55388
R719 VSS.n100 VSS.n143 1.55388
R720 VSS.n100 VSS.n146 1.55388
R721 VSS.n100 VSS.n149 1.55388
R722 VSS.n100 VSS.n152 1.55388
R723 VSS.n100 VSS.n155 1.55388
R724 VSS.n100 VSS.n158 1.55388
R725 VSS.n100 VSS.n161 1.55388
R726 VSS.n100 VSS.n164 1.55388
R727 VSS.n100 VSS.n167 1.55388
R728 VSS.n100 VSS.n170 1.55388
R729 VSS.n100 VSS.n173 1.55388
R730 VSS.n100 VSS.n176 1.55388
R731 VSS.n100 VSS.n179 1.55388
R732 VSS.n100 VSS.n182 1.55388
R733 VSS.n100 VSS.n185 1.55388
R734 VSS.n100 VSS.n188 1.55388
R735 VSS.n100 VSS.n191 1.55388
R736 VSS.n100 VSS.n194 1.55388
R737 VSS.n100 VSS.n197 1.55388
R738 VSS.n100 VSS.n200 1.55388
R739 VSS.n100 VSS.n203 1.55388
R740 VSS.n100 VSS.n206 1.55388
R741 VSS.n100 VSS.n209 1.55388
R742 VSS.n100 VSS.n212 1.55388
R743 VSS.n100 VSS.n215 1.55388
R744 VSS.n100 VSS.n218 1.55388
R745 VSS.n100 VSS.n221 1.55388
R746 VSS.n100 VSS.n224 1.55388
R747 VSS.n100 VSS.n227 1.55388
R748 VSS.n100 VSS.n230 1.55388
R749 VSS.t12 VSS.t15 0.806856
R750 VSS.t51 VSS.n144 0.802775
R751 VSS.t78 VSS.n147 0.802775
R752 VSS.t57 VSS.n150 0.802775
R753 VSS.t55 VSS.n153 0.802775
R754 VSS.t32 VSS.n156 0.802775
R755 VSS.t41 VSS.n159 0.802775
R756 VSS.t1 VSS.n162 0.802775
R757 VSS.t60 VSS.n165 0.802775
R758 VSS.t26 VSS.n168 0.802775
R759 VSS.t62 VSS.n171 0.802775
R760 VSS.t4 VSS.n174 0.802775
R761 VSS.t11 VSS.n177 0.802775
R762 VSS.t65 VSS.n180 0.802775
R763 VSS.t89 VSS.n183 0.802775
R764 VSS.t53 VSS.n186 0.802775
R765 VSS.t44 VSS.n189 0.802775
R766 VSS.t7 VSS.n192 0.802775
R767 VSS.t86 VSS.n195 0.802775
R768 VSS.t73 VSS.n198 0.802775
R769 VSS.t70 VSS.n201 0.802775
R770 VSS.t67 VSS.n204 0.802775
R771 VSS.t36 VSS.n207 0.802775
R772 VSS.t99 VSS.n210 0.802775
R773 VSS.t105 VSS.n213 0.802775
R774 VSS.t97 VSS.n216 0.802775
R775 VSS.t38 VSS.n219 0.802775
R776 VSS.t103 VSS.n222 0.802775
R777 VSS.t95 VSS.n225 0.802775
R778 VSS.t84 VSS.n228 0.802775
R779 VSS.t116 VSS.n231 0.802775
R780 VSS.t148 VSS.n233 0.802775
R781 VSS.t22 VSS.n134 0.802775
R782 VSS.t46 VSS.n141 0.802775
R783 VSS.n238 VSS.t23 0.723599
R784 VSS.t21 VSS.n236 0.723599
R785 VSS.n100 VSS.n72 0.607264
R786 VSS.n245 VSS.t14 0.595317
R787 VSS.t18 VSS.n244 0.595317
R788 VSS.n230 VSS.t116 0.47671
R789 VSS.n227 VSS.t84 0.47671
R790 VSS.n224 VSS.t95 0.47671
R791 VSS.n221 VSS.t103 0.47671
R792 VSS.n218 VSS.t38 0.47671
R793 VSS.n215 VSS.t97 0.47671
R794 VSS.n212 VSS.t105 0.47671
R795 VSS.n209 VSS.t99 0.47671
R796 VSS.n206 VSS.t36 0.47671
R797 VSS.n203 VSS.t67 0.47671
R798 VSS.n200 VSS.t70 0.47671
R799 VSS.n197 VSS.t73 0.47671
R800 VSS.n194 VSS.t86 0.47671
R801 VSS.n191 VSS.t7 0.47671
R802 VSS.n188 VSS.t44 0.47671
R803 VSS.n185 VSS.t53 0.47671
R804 VSS.n182 VSS.t89 0.47671
R805 VSS.n179 VSS.t65 0.47671
R806 VSS.n176 VSS.t11 0.47671
R807 VSS.n173 VSS.t4 0.47671
R808 VSS.n170 VSS.t62 0.47671
R809 VSS.n167 VSS.t26 0.47671
R810 VSS.n164 VSS.t60 0.47671
R811 VSS.n161 VSS.t1 0.47671
R812 VSS.n158 VSS.t41 0.47671
R813 VSS.n155 VSS.t32 0.47671
R814 VSS.n152 VSS.t55 0.47671
R815 VSS.n149 VSS.t57 0.47671
R816 VSS.n146 VSS.t78 0.47671
R817 VSS.n143 VSS.t51 0.47671
R818 VSS.n140 VSS.t46 0.47671
R819 VSS.n141 VSS.n102 0.46466
R820 VSS.n144 VSS.n103 0.46466
R821 VSS.n147 VSS.n104 0.46466
R822 VSS.n150 VSS.n105 0.46466
R823 VSS.n153 VSS.n106 0.46466
R824 VSS.n156 VSS.n107 0.46466
R825 VSS.n159 VSS.n108 0.46466
R826 VSS.n162 VSS.n109 0.46466
R827 VSS.n165 VSS.n110 0.46466
R828 VSS.n168 VSS.n111 0.46466
R829 VSS.n171 VSS.n112 0.46466
R830 VSS.n174 VSS.n113 0.46466
R831 VSS.n177 VSS.n114 0.46466
R832 VSS.n180 VSS.n115 0.46466
R833 VSS.n183 VSS.n116 0.46466
R834 VSS.n186 VSS.n117 0.46466
R835 VSS.n189 VSS.n118 0.46466
R836 VSS.n192 VSS.n119 0.46466
R837 VSS.n195 VSS.n120 0.46466
R838 VSS.n198 VSS.n121 0.46466
R839 VSS.n201 VSS.n122 0.46466
R840 VSS.n204 VSS.n123 0.46466
R841 VSS.n207 VSS.n124 0.46466
R842 VSS.n210 VSS.n125 0.46466
R843 VSS.n213 VSS.n126 0.46466
R844 VSS.n216 VSS.n127 0.46466
R845 VSS.n219 VSS.n128 0.46466
R846 VSS.n222 VSS.n129 0.46466
R847 VSS.n225 VSS.n130 0.46466
R848 VSS.n228 VSS.n131 0.46466
R849 VSS.n231 VSS.n132 0.46466
R850 VSS.n144 VSS.n102 0.45349
R851 VSS.n147 VSS.n103 0.45349
R852 VSS.n150 VSS.n104 0.45349
R853 VSS.n153 VSS.n105 0.45349
R854 VSS.n156 VSS.n106 0.45349
R855 VSS.n159 VSS.n107 0.45349
R856 VSS.n162 VSS.n108 0.45349
R857 VSS.n165 VSS.n109 0.45349
R858 VSS.n168 VSS.n110 0.45349
R859 VSS.n171 VSS.n111 0.45349
R860 VSS.n174 VSS.n112 0.45349
R861 VSS.n177 VSS.n113 0.45349
R862 VSS.n180 VSS.n114 0.45349
R863 VSS.n183 VSS.n115 0.45349
R864 VSS.n186 VSS.n116 0.45349
R865 VSS.n189 VSS.n117 0.45349
R866 VSS.n192 VSS.n118 0.45349
R867 VSS.n195 VSS.n119 0.45349
R868 VSS.n198 VSS.n120 0.45349
R869 VSS.n201 VSS.n121 0.45349
R870 VSS.n204 VSS.n122 0.45349
R871 VSS.n207 VSS.n123 0.45349
R872 VSS.n210 VSS.n124 0.45349
R873 VSS.n213 VSS.n125 0.45349
R874 VSS.n216 VSS.n126 0.45349
R875 VSS.n219 VSS.n127 0.45349
R876 VSS.n222 VSS.n128 0.45349
R877 VSS.n225 VSS.n129 0.45349
R878 VSS.n228 VSS.n130 0.45349
R879 VSS.n231 VSS.n131 0.45349
R880 VSS.n233 VSS.n132 0.45349
R881 VSS.n140 VSS.t51 0.441374
R882 VSS.n143 VSS.t78 0.441374
R883 VSS.n146 VSS.t57 0.441374
R884 VSS.n149 VSS.t55 0.441374
R885 VSS.n152 VSS.t32 0.441374
R886 VSS.n155 VSS.t41 0.441374
R887 VSS.n158 VSS.t1 0.441374
R888 VSS.n161 VSS.t60 0.441374
R889 VSS.n164 VSS.t26 0.441374
R890 VSS.n167 VSS.t62 0.441374
R891 VSS.n170 VSS.t4 0.441374
R892 VSS.n173 VSS.t11 0.441374
R893 VSS.n176 VSS.t65 0.441374
R894 VSS.n179 VSS.t89 0.441374
R895 VSS.n182 VSS.t53 0.441374
R896 VSS.n185 VSS.t44 0.441374
R897 VSS.n188 VSS.t7 0.441374
R898 VSS.n191 VSS.t86 0.441374
R899 VSS.n194 VSS.t73 0.441374
R900 VSS.n197 VSS.t70 0.441374
R901 VSS.n200 VSS.t67 0.441374
R902 VSS.n203 VSS.t36 0.441374
R903 VSS.n206 VSS.t99 0.441374
R904 VSS.n209 VSS.t105 0.441374
R905 VSS.n212 VSS.t97 0.441374
R906 VSS.n215 VSS.t38 0.441374
R907 VSS.n218 VSS.t103 0.441374
R908 VSS.n221 VSS.t95 0.441374
R909 VSS.n224 VSS.t84 0.441374
R910 VSS.n227 VSS.t116 0.441374
R911 VSS.n230 VSS.t148 0.441374
R912 VSS.n247 VSS.t15 0.334469
R913 VSS.n248 VSS.n247 0.330494
R914 VSS.t30 VSS.t148 0.301976
R915 VSS.n233 VSS.n133 0.290049
R916 VSS.n141 VSS.n101 0.276768
R917 VSS.n243 VSS.n101 0.271299
R918 VSS.n244 VSS.n139 0.271299
R919 VSS.t46 VSS.n139 0.265518
R920 VSS.n240 VSS.n239 0.259448
R921 VSS.t30 VSS.t22 0.254814
R922 VSS.n134 VSS.n133 0.244268
R923 VSS.n240 VSS.n136 0.206787
R924 VSS.t14 VSS.t18 0.1875
R925 VSS.n239 VSS.n238 0.177116
R926 VSS.t23 VSS.n136 0.141022
R927 VSS.n134 VSS.t19 0.135868
R928 VSS.t22 VSS.n235 0.124618
R929 VSS.n236 VSS.t19 0.122118
R930 VSS.t21 VSS.n235 0.122118
R931 VSS.t12 VSS.n60 0.08925
R932 VSS.n100 VSS.n38 0.00100257
R933 VSS.t14 VSS.n242 0.0851154
R934 VSS.t18 VSS.n243 0.0851154
R935 VSS.t23 VSS.n135 0.0771176
R936 VSS.n238 VSS.n237 0.0771176
R937 VSS.n242 VSS.n138 0.0746176
R938 VSS.n246 VSS.n245 0.0746176
R939 VSS.n236 VSS.n135 0.0696176
R940 VSS.n237 VSS.t21 0.0696176
R941 VSS.n242 VSS.n137 0.06925
R942 VSS.n245 VSS.n241 0.06925
R943 VSS.n243 VSS.n137 0.05925
R944 VSS.n244 VSS.n241 0.05925
R945 VSS.n138 VSS.t15 0.0546176
R946 VSS.n246 VSS.t12 0.0546176
R947 VSS.n100 VSS.n59 0.0444724
R948 VSS.n100 VSS.n0 0.0444724
R949 VSS.n100 VSS.n1 0.0444724
R950 VSS.n100 VSS.n58 0.0444724
R951 VSS.n100 VSS.n3 0.0444724
R952 VSS.n100 VSS.n6 0.0444724
R953 VSS.n100 VSS.n10 0.0444724
R954 VSS.n100 VSS.n11 0.0444724
R955 VSS.n100 VSS.n52 0.0444724
R956 VSS.n100 VSS.n51 0.0444724
R957 VSS.n100 VSS.n16 0.0444724
R958 VSS.n100 VSS.n50 0.0444724
R959 VSS.n100 VSS.n49 0.0444724
R960 VSS.n100 VSS.n47 0.0444724
R961 VSS.n100 VSS.n19 0.0444724
R962 VSS.n100 VSS.n20 0.0444724
R963 VSS.n100 VSS.n46 0.0444724
R964 VSS.n100 VSS.n22 0.0444724
R965 VSS.n100 VSS.n28 0.0444724
R966 VSS.n100 VSS.n30 0.0444724
R967 VSS.n100 VSS.n41 0.0444724
R968 VSS.n100 VSS.n40 0.0444724
R969 VSS.n100 VSS.n39 0.0444724
R970 VSS.n100 VSS.n34 0.0444724
R971 VSS.n100 VSS.n35 0.0444724
R972 VSS.n100 VSS.n99 0.0444549
R973 VSS.n100 VSS.n98 0.0444549
R974 VSS.n100 VSS.n61 0.0444549
R975 VSS.n100 VSS.n97 0.0444549
R976 VSS.n100 VSS.n62 0.0444549
R977 VSS.n100 VSS.n96 0.0444549
R978 VSS.n100 VSS.n95 0.0444549
R979 VSS.n100 VSS.n63 0.0444549
R980 VSS.n100 VSS.n94 0.0444549
R981 VSS.n100 VSS.n93 0.0444549
R982 VSS.n100 VSS.n92 0.0444549
R983 VSS.n100 VSS.n91 0.0444549
R984 VSS.n100 VSS.n64 0.0444549
R985 VSS.n100 VSS.n90 0.0444549
R986 VSS.n100 VSS.n89 0.0444549
R987 VSS.n100 VSS.n88 0.0444549
R988 VSS.n100 VSS.n65 0.0444549
R989 VSS.n100 VSS.n87 0.0444549
R990 VSS.n100 VSS.n86 0.0444549
R991 VSS.n100 VSS.n85 0.0444549
R992 VSS.n100 VSS.n84 0.0444549
R993 VSS.n100 VSS.n66 0.0444549
R994 VSS.n100 VSS.n83 0.0444549
R995 VSS.n100 VSS.n82 0.0444549
R996 VSS.n100 VSS.n81 0.0444549
R997 VSS.n100 VSS.n67 0.0444549
R998 VSS.n100 VSS.n80 0.0444549
R999 VSS.n100 VSS.n68 0.0444549
R1000 VSS.n100 VSS.n79 0.0444549
R1001 VSS.n100 VSS.n69 0.0444549
R1002 VSS.n100 VSS.n78 0.0444549
R1003 VSS.n100 VSS.n77 0.0444549
R1004 VSS.n100 VSS.n76 0.0444549
R1005 VSS.n100 VSS.n75 0.0444549
R1006 VSS.n100 VSS.n70 0.0444549
R1007 VSS.n100 VSS.n74 0.0444549
R1008 VSS.n100 VSS.n71 0.0444549
R1009 VSS.n100 VSS.n2 0.0444549
R1010 VSS.n100 VSS.n57 0.0444549
R1011 VSS.n100 VSS.n4 0.0444549
R1012 VSS.n100 VSS.n5 0.0444549
R1013 VSS.n100 VSS.n7 0.0444549
R1014 VSS.n100 VSS.n56 0.0444549
R1015 VSS.n100 VSS.n8 0.0444549
R1016 VSS.n100 VSS.n55 0.0444549
R1017 VSS.n100 VSS.n54 0.0444549
R1018 VSS.n100 VSS.n9 0.0444549
R1019 VSS.n100 VSS.n53 0.0444549
R1020 VSS.n100 VSS.n12 0.0444549
R1021 VSS.n100 VSS.n13 0.0444549
R1022 VSS.n100 VSS.n14 0.0444549
R1023 VSS.n100 VSS.n15 0.0444549
R1024 VSS.n100 VSS.n17 0.0444549
R1025 VSS.n100 VSS.n18 0.0444549
R1026 VSS.n100 VSS.n48 0.0444549
R1027 VSS.n100 VSS.n21 0.0444549
R1028 VSS.n100 VSS.n45 0.0444549
R1029 VSS.n100 VSS.n23 0.0444549
R1030 VSS.n100 VSS.n24 0.0444549
R1031 VSS.n100 VSS.n44 0.0444549
R1032 VSS.n100 VSS.n25 0.0444549
R1033 VSS.n100 VSS.n26 0.0444549
R1034 VSS.n100 VSS.n27 0.0444549
R1035 VSS.n100 VSS.n43 0.0444549
R1036 VSS.n100 VSS.n29 0.0444549
R1037 VSS.n100 VSS.n31 0.0444549
R1038 VSS.n100 VSS.n42 0.0444549
R1039 VSS.n100 VSS.n32 0.0444549
R1040 VSS.n100 VSS.n33 0.0444549
R1041 VSS.n100 VSS.n36 0.0444549
R1042 VSS.n100 VSS.n37 0.0444549
R1043 VSS.n248 VSS.n60 0.00675
R1044 VSS.n100 VSS.n73 0.00413369
R1045 VSS.n240 VSS.n38 8.47948
C518 DELAY_VBIASN VSS 16.43641f
C519 DELAY_OUT_LAST VSS 0.40486f
C520 DELAY_OUT_TAP31 VSS 0.6437f
C521 DELAY_OUT_TAP30 VSS 0.6437f
C522 DELAY_OUT_TAP29 VSS 0.6437f
C523 DELAY_OUT_TAP28 VSS 0.6437f
C524 DELAY_OUT_TAP27 VSS 0.6437f
C525 DELAY_OUT_TAP26 VSS 0.6437f
C526 DELAY_OUT_TAP25 VSS 0.6437f
C527 DELAY_OUT_TAP24 VSS 0.6437f
C528 DELAY_OUT_TAP23 VSS 0.6437f
C529 DELAY_OUT_TAP22 VSS 0.6437f
C530 DELAY_OUT_TAP21 VSS 0.6437f
C531 DELAY_OUT_TAP20 VSS 0.6437f
C532 DELAY_OUT_TAP19 VSS 0.6437f
C533 DELAY_OUT_TAP18 VSS 0.6437f
C534 DELAY_OUT_TAP17 VSS 0.6437f
C535 DELAY_OUT_TAP16 VSS 0.6437f
C536 DELAY_OUT_TAP15 VSS 0.6437f
C537 DELAY_OUT_TAP14 VSS 0.6437f
C538 DELAY_OUT_TAP13 VSS 0.6437f
C539 DELAY_OUT_TAP12 VSS 0.6437f
C540 DELAY_OUT_TAP11 VSS 0.6437f
C541 DELAY_OUT_TAP10 VSS 0.6437f
C542 DELAY_OUT_TAP9 VSS 0.6437f
C543 DELAY_OUT_TAP8 VSS 0.6437f
C544 DELAY_OUT_TAP7 VSS 0.6437f
C545 DELAY_OUT_TAP6 VSS 0.6437f
C546 DELAY_OUT_TAP5 VSS 0.6437f
C547 DELAY_OUT_TAP4 VSS 0.6437f
C548 DELAY_OUT_TAP3 VSS 0.6437f
C549 DELAY_OUT_TAP2 VSS 0.6437f
C550 DELAY_OUT_TAP1 VSS 0.64371f
C551 DELAY_VBIASP VSS 4.15787f
C552 DELAY_IN VSS 0.57171f
C553 VDD VSS 20.97692f
C554 a_27411_1842# VSS 0.01336f ; **FLOATING
C555 a_26651_1842# VSS 0.01336f ; **FLOATING
C556 a_25891_1842# VSS 0.01336f ; **FLOATING
C557 a_25131_1842# VSS 0.01336f ; **FLOATING
C558 a_24371_1842# VSS 0.01336f ; **FLOATING
C559 a_23611_1842# VSS 0.01336f ; **FLOATING
C560 a_22851_1842# VSS 0.01336f ; **FLOATING
C561 a_22091_1842# VSS 0.01336f ; **FLOATING
C562 a_21331_1842# VSS 0.01336f ; **FLOATING
C563 a_20571_1842# VSS 0.01336f ; **FLOATING
C564 a_19811_1842# VSS 0.01336f ; **FLOATING
C565 a_19051_1842# VSS 0.01336f ; **FLOATING
C566 a_18291_1842# VSS 0.01336f ; **FLOATING
C567 a_17531_1842# VSS 0.01336f ; **FLOATING
C568 a_16771_1842# VSS 0.01336f ; **FLOATING
C569 a_16011_1842# VSS 0.01336f ; **FLOATING
C570 a_15251_1842# VSS 0.01336f ; **FLOATING
C571 a_14491_1842# VSS 0.01336f ; **FLOATING
C572 a_13731_1842# VSS 0.01336f ; **FLOATING
C573 a_12971_1842# VSS 0.01336f ; **FLOATING
C574 a_12211_1842# VSS 0.01336f ; **FLOATING
C575 a_11451_1842# VSS 0.01336f ; **FLOATING
C576 a_10691_1842# VSS 0.01336f ; **FLOATING
C577 a_9931_1842# VSS 0.01336f ; **FLOATING
C578 a_9171_1842# VSS 0.01336f ; **FLOATING
C579 a_8411_1842# VSS 0.01336f ; **FLOATING
C580 a_7651_1842# VSS 0.01336f ; **FLOATING
C581 a_6891_1842# VSS 0.01336f ; **FLOATING
C582 a_6131_1842# VSS 0.01336f ; **FLOATING
C583 a_5371_1842# VSS 0.01336f ; **FLOATING
C584 a_4611_1842# VSS 0.01336f ; **FLOATING
C585 a_3851_1842# VSS 0.0139f ; **FLOATING
C586 a_27303_1842# VSS 0.54306f ; **FLOATING
C587 a_27737_1842# VSS 0.67217f ; **FLOATING
C588 a_27173_1842# VSS 0.48844f ; **FLOATING
C589 a_26543_1842# VSS 0.54063f ; **FLOATING
C590 a_26413_1842# VSS 0.48844f ; **FLOATING
C591 a_25783_1842# VSS 0.54063f ; **FLOATING
C592 a_25653_1842# VSS 0.48844f ; **FLOATING
C593 a_25023_1842# VSS 0.54063f ; **FLOATING
C594 a_24893_1842# VSS 0.48844f ; **FLOATING
C595 a_24263_1842# VSS 0.54063f ; **FLOATING
C596 a_24133_1842# VSS 0.48844f ; **FLOATING
C597 a_23503_1842# VSS 0.54063f ; **FLOATING
C598 a_23373_1842# VSS 0.48844f ; **FLOATING
C599 a_22743_1842# VSS 0.54063f ; **FLOATING
C600 a_22613_1842# VSS 0.48844f ; **FLOATING
C601 a_21983_1842# VSS 0.54063f ; **FLOATING
C602 a_21853_1842# VSS 0.48844f ; **FLOATING
C603 a_21223_1842# VSS 0.54063f ; **FLOATING
C604 a_21093_1842# VSS 0.48844f ; **FLOATING
C605 a_20463_1842# VSS 0.54063f ; **FLOATING
C606 a_20333_1842# VSS 0.48844f ; **FLOATING
C607 a_19703_1842# VSS 0.54063f ; **FLOATING
C608 a_19573_1842# VSS 0.48844f ; **FLOATING
C609 a_18943_1842# VSS 0.54063f ; **FLOATING
C610 a_18813_1842# VSS 0.48844f ; **FLOATING
C611 a_18183_1842# VSS 0.54063f ; **FLOATING
C612 a_18053_1842# VSS 0.48844f ; **FLOATING
C613 a_17423_1842# VSS 0.54063f ; **FLOATING
C614 a_17293_1842# VSS 0.48844f ; **FLOATING
C615 a_16663_1842# VSS 0.54063f ; **FLOATING
C616 a_16533_1842# VSS 0.48844f ; **FLOATING
C617 a_15903_1842# VSS 0.54063f ; **FLOATING
C618 a_15773_1842# VSS 0.48844f ; **FLOATING
C619 a_15143_1842# VSS 0.54063f ; **FLOATING
C620 a_15013_1842# VSS 0.48844f ; **FLOATING
C621 a_14383_1842# VSS 0.54063f ; **FLOATING
C622 a_14253_1842# VSS 0.48844f ; **FLOATING
C623 a_13623_1842# VSS 0.54063f ; **FLOATING
C624 a_13493_1842# VSS 0.48844f ; **FLOATING
C625 a_12863_1842# VSS 0.54063f ; **FLOATING
C626 a_12733_1842# VSS 0.48844f ; **FLOATING
C627 a_12103_1842# VSS 0.54063f ; **FLOATING
C628 a_11973_1842# VSS 0.48844f ; **FLOATING
C629 a_11343_1842# VSS 0.54063f ; **FLOATING
C630 a_11213_1842# VSS 0.48844f ; **FLOATING
C631 a_10583_1842# VSS 0.54063f ; **FLOATING
C632 a_10453_1842# VSS 0.48844f ; **FLOATING
C633 a_9823_1842# VSS 0.54063f ; **FLOATING
C634 a_9693_1842# VSS 0.48844f ; **FLOATING
C635 a_9063_1842# VSS 0.54063f ; **FLOATING
C636 a_8933_1842# VSS 0.48844f ; **FLOATING
C637 a_8303_1842# VSS 0.54063f ; **FLOATING
C638 a_8173_1842# VSS 0.48844f ; **FLOATING
C639 a_7543_1842# VSS 0.54063f ; **FLOATING
C640 a_7413_1842# VSS 0.48844f ; **FLOATING
C641 a_6783_1842# VSS 0.54063f ; **FLOATING
C642 a_6653_1842# VSS 0.48844f ; **FLOATING
C643 a_6023_1842# VSS 0.54063f ; **FLOATING
C644 a_5893_1842# VSS 0.48844f ; **FLOATING
C645 a_5263_1842# VSS 0.54063f ; **FLOATING
C646 a_5133_1842# VSS 0.48844f ; **FLOATING
C647 a_4503_1842# VSS 0.54063f ; **FLOATING
C648 a_4373_1842# VSS 0.48844f ; **FLOATING
C649 a_3743_1842# VSS 0.61828f ; **FLOATING
C650 VDD.n0 VSS 0.02735f ; **FLOATING
C651 VDD.n1 VSS 0.02735f ; **FLOATING
C652 VDD.n2 VSS 0.02735f ; **FLOATING
C653 VDD.n3 VSS 0.02735f ; **FLOATING
C654 VDD.n4 VSS 0.02735f ; **FLOATING
C655 VDD.t0 VSS 53.6516f ; **FLOATING
C656 VDD.n5 VSS 0.17158f ; **FLOATING
C657 VDD.n6 VSS 0.02735f ; **FLOATING
C658 VDD.n7 VSS 0.02735f ; **FLOATING
C659 VDD.n8 VSS 0.42838f ; **FLOATING
C660 VDD.n9 VSS 0.02735f ; **FLOATING
C661 VDD.n10 VSS 0.02735f ; **FLOATING
C662 VDD.n11 VSS 0.02591f ; **FLOATING
C663 VDD.n12 VSS 1.30919f ; **FLOATING
C664 VDD.t84 VSS 0.0375f ; **FLOATING
C665 VDD.n13 VSS 0.02735f ; **FLOATING
C666 VDD.n14 VSS 0.02735f ; **FLOATING
C667 VDD.n15 VSS 0.42819f ; **FLOATING
C668 VDD.n17 VSS 0.02735f ; **FLOATING
C669 VDD.n18 VSS 0.02735f ; **FLOATING
C670 VDD.n19 VSS 0.42829f ; **FLOATING
C671 VDD.n20 VSS 0.02735f ; **FLOATING
C672 VDD.n21 VSS 0.2141f ; **FLOATING
C673 VDD.n23 VSS 0.02735f ; **FLOATING
C674 VDD.n24 VSS 0.21413f ; **FLOATING
C675 VDD.n25 VSS 0.02735f ; **FLOATING
C676 VDD.n26 VSS 0.21414f ; **FLOATING
C677 VDD.n27 VSS 0.02735f ; **FLOATING
C678 VDD.n28 VSS 0.21414f ; **FLOATING
C679 VDD.n29 VSS 0.02735f ; **FLOATING
C680 VDD.n30 VSS 0.21409f ; **FLOATING
C681 VDD.t31 VSS 0.03951f ; **FLOATING
C682 VDD.t27 VSS 0.04253f ; **FLOATING
C683 VDD.n32 VSS 0.02735f ; **FLOATING
C684 VDD.n33 VSS 0.21414f ; **FLOATING
C685 VDD.n34 VSS 0.02735f ; **FLOATING
C686 VDD.n35 VSS 0.21414f ; **FLOATING
C687 VDD.n36 VSS 0.02735f ; **FLOATING
C688 VDD.n37 VSS 0.21419f ; **FLOATING
C689 VDD.n38 VSS 0.02735f ; **FLOATING
C690 VDD.n39 VSS 0.2141f ; **FLOATING
C691 VDD.n40 VSS 0.02735f ; **FLOATING
C692 VDD.n41 VSS 0.21411f ; **FLOATING
C693 VDD.n42 VSS 0.02735f ; **FLOATING
C694 VDD.n43 VSS 0.21418f ; **FLOATING
C695 VDD.n44 VSS 0.02735f ; **FLOATING
C696 VDD.n45 VSS 0.21417f ; **FLOATING
C697 VDD.n46 VSS 0.06654f ; **FLOATING
C698 VDD.n47 VSS 0.22091f ; **FLOATING
C699 VDD.n48 VSS 0.02735f ; **FLOATING
C700 VDD.n49 VSS 0.21419f ; **FLOATING
C701 VDD.n50 VSS 0.02735f ; **FLOATING
C702 VDD.n51 VSS 0.21414f ; **FLOATING
C703 VDD.n52 VSS 0.02735f ; **FLOATING
C704 VDD.n53 VSS 0.21418f ; **FLOATING
C705 VDD.t28 VSS 0.02172f ; **FLOATING
C706 VDD.n54 VSS 0.05611f ; **FLOATING
C707 VDD.n55 VSS 0.05609f ; **FLOATING
C708 VDD.n56 VSS 0.05607f ; **FLOATING
C709 VDD.n57 VSS 0.05611f ; **FLOATING
C710 VDD.n58 VSS 0.05614f ; **FLOATING
C711 VDD.n59 VSS 0.05607f ; **FLOATING
C712 VDD.n60 VSS 0.05614f ; **FLOATING
C713 VDD.n61 VSS 0.05611f ; **FLOATING
C714 VDD.n62 VSS 0.05598f ; **FLOATING
C715 VDD.n63 VSS 0.05607f ; **FLOATING
C716 VDD.n64 VSS 0.05614f ; **FLOATING
C717 VDD.n65 VSS 0.05614f ; **FLOATING
C718 VDD.n66 VSS 0.05607f ; **FLOATING
C719 VDD.n67 VSS 0.05609f ; **FLOATING
C720 VDD.n68 VSS 0.05602f ; **FLOATING
C721 VDD.n69 VSS 0.05606f ; **FLOATING
C722 VDD.n70 VSS 0.05602f ; **FLOATING
C723 VDD.n71 VSS 0.05604f ; **FLOATING
C724 VDD.n72 VSS 0.05607f ; **FLOATING
C725 VDD.n73 VSS 0.05603f ; **FLOATING
C726 VDD.n74 VSS 0.05606f ; **FLOATING
C727 VDD.n75 VSS 0.05606f ; **FLOATING
C728 VDD.n76 VSS 0.05614f ; **FLOATING
C729 VDD.n77 VSS 0.05611f ; **FLOATING
C730 VDD.n78 VSS 0.0561f ; **FLOATING
C731 VDD.n79 VSS 0.05601f ; **FLOATING
C732 VDD.n80 VSS 0.05597f ; **FLOATING
C733 VDD.t30 VSS 0.07737f ; **FLOATING
C734 VDD.t35 VSS 0.03688f ; **FLOATING
C735 VDD.t33 VSS 0.03564f ; **FLOATING
C736 VDD.t32 VSS 0.04228f ; **FLOATING
C737 VDD.t6 VSS 0.04326f ; **FLOATING
C738 VDD.t96 VSS 0.04326f ; **FLOATING
C739 VDD.t85 VSS 0.03688f ; **FLOATING
C740 VDD.n81 VSS 0.15144f ; **FLOATING
C741 VDD.t43 VSS 0.04326f ; **FLOATING
C742 VDD.t55 VSS 0.03688f ; **FLOATING
C743 VDD.n82 VSS 0.12124f ; **FLOATING
C744 VDD.t51 VSS 0.04326f ; **FLOATING
C745 VDD.t56 VSS 0.03688f ; **FLOATING
C746 VDD.n83 VSS 0.12124f ; **FLOATING
C747 VDD.t86 VSS 0.04326f ; **FLOATING
C748 VDD.t82 VSS 0.03688f ; **FLOATING
C749 VDD.n84 VSS 0.12111f ; **FLOATING
C750 VDD.t9 VSS 0.04326f ; **FLOATING
C751 VDD.t83 VSS 0.03688f ; **FLOATING
C752 VDD.n85 VSS 0.12114f ; **FLOATING
C753 VDD.t52 VSS 0.04326f ; **FLOATING
C754 VDD.t74 VSS 0.03688f ; **FLOATING
C755 VDD.n86 VSS 0.12116f ; **FLOATING
C756 VDD.t87 VSS 0.04326f ; **FLOATING
C757 VDD.t81 VSS 0.03688f ; **FLOATING
C758 VDD.n87 VSS 0.12119f ; **FLOATING
C759 VDD.t53 VSS 0.04326f ; **FLOATING
C760 VDD.t78 VSS 0.03688f ; **FLOATING
C761 VDD.n88 VSS 0.1212f ; **FLOATING
C762 VDD.t8 VSS 0.04326f ; **FLOATING
C763 VDD.t80 VSS 0.03688f ; **FLOATING
C764 VDD.n89 VSS 0.12124f ; **FLOATING
C765 VDD.t21 VSS 0.04326f ; **FLOATING
C766 VDD.t79 VSS 0.03688f ; **FLOATING
C767 VDD.n90 VSS 0.12117f ; **FLOATING
C768 VDD.t22 VSS 0.04326f ; **FLOATING
C769 VDD.t75 VSS 0.03688f ; **FLOATING
C770 VDD.n91 VSS 0.12129f ; **FLOATING
C771 VDD.t23 VSS 0.04326f ; **FLOATING
C772 VDD.t77 VSS 0.03688f ; **FLOATING
C773 VDD.n92 VSS 0.1212f ; **FLOATING
C774 VDD.t44 VSS 0.04326f ; **FLOATING
C775 VDD.t76 VSS 0.03688f ; **FLOATING
C776 VDD.n93 VSS 0.12121f ; **FLOATING
C777 VDD.t3 VSS 0.04326f ; **FLOATING
C778 VDD.t54 VSS 0.03688f ; **FLOATING
C779 VDD.n94 VSS 0.12117f ; **FLOATING
C780 VDD.t12 VSS 0.04326f ; **FLOATING
C781 VDD.t58 VSS 0.03688f ; **FLOATING
C782 VDD.n95 VSS 0.1212f ; **FLOATING
C783 VDD.t15 VSS 0.04326f ; **FLOATING
C784 VDD.t73 VSS 0.03688f ; **FLOATING
C785 VDD.n96 VSS 0.12113f ; **FLOATING
C786 VDD.t46 VSS 0.04326f ; **FLOATING
C787 VDD.t67 VSS 0.03688f ; **FLOATING
C788 VDD.n97 VSS 0.12112f ; **FLOATING
C789 VDD.t20 VSS 0.04326f ; **FLOATING
C790 VDD.t68 VSS 0.03688f ; **FLOATING
C791 VDD.n98 VSS 0.12119f ; **FLOATING
C792 VDD.t4 VSS 0.04326f ; **FLOATING
C793 VDD.t70 VSS 0.03688f ; **FLOATING
C794 VDD.n99 VSS 0.12123f ; **FLOATING
C795 VDD.t2 VSS 0.04326f ; **FLOATING
C796 VDD.t72 VSS 0.03688f ; **FLOATING
C797 VDD.n100 VSS 0.1212f ; **FLOATING
C798 VDD.t19 VSS 0.04326f ; **FLOATING
C799 VDD.t69 VSS 0.03688f ; **FLOATING
C800 VDD.n101 VSS 0.12111f ; **FLOATING
C801 VDD.t5 VSS 0.04326f ; **FLOATING
C802 VDD.t71 VSS 0.03688f ; **FLOATING
C803 VDD.n102 VSS 0.12113f ; **FLOATING
C804 VDD.t18 VSS 0.04326f ; **FLOATING
C805 VDD.t59 VSS 0.03688f ; **FLOATING
C806 VDD.n103 VSS 0.12117f ; **FLOATING
C807 VDD.t1 VSS 0.04326f ; **FLOATING
C808 VDD.t66 VSS 0.03688f ; **FLOATING
C809 VDD.n104 VSS 0.12114f ; **FLOATING
C810 VDD.t11 VSS 0.04326f ; **FLOATING
C811 VDD.t65 VSS 0.03688f ; **FLOATING
C812 VDD.n105 VSS 0.12118f ; **FLOATING
C813 VDD.t7 VSS 0.04326f ; **FLOATING
C814 VDD.t60 VSS 0.03688f ; **FLOATING
C815 VDD.n106 VSS 0.12114f ; **FLOATING
C816 VDD.t16 VSS 0.04326f ; **FLOATING
C817 VDD.t61 VSS 0.03688f ; **FLOATING
C818 VDD.n107 VSS 0.12117f ; **FLOATING
C819 VDD.t17 VSS 0.04326f ; **FLOATING
C820 VDD.t64 VSS 0.03688f ; **FLOATING
C821 VDD.n108 VSS 0.14117f ; **FLOATING
C822 VDD.t38 VSS 0.04326f ; **FLOATING
C823 VDD.t57 VSS 0.03688f ; **FLOATING
C824 VDD.t14 VSS 0.04326f ; **FLOATING
C825 VDD.t62 VSS 0.03896f ; **FLOATING
C826 VDD.t13 VSS 0.04326f ; **FLOATING
C827 VDD.t63 VSS 0.03834f ; **FLOATING
C828 VDD.t29 VSS 0.0373f ; **FLOATING
C829 VDD.t26 VSS 0.03688f ; **FLOATING
C830 VDD.t25 VSS 0.02663f ; **FLOATING
C831 DELAY_VBIASP.n0 VSS 0.14347f ; **FLOATING
C832 DELAY_VBIASP.t31 VSS 0.36739f ; **FLOATING
C833 DELAY_VBIASP.t30 VSS 0.35917f ; **FLOATING
C834 DELAY_VBIASP.n1 VSS 0.64365f ; **FLOATING
C835 DELAY_VBIASP.t29 VSS 0.35917f ; **FLOATING
C836 DELAY_VBIASP.n2 VSS 0.44541f ; **FLOATING
C837 DELAY_VBIASP.t28 VSS 0.35917f ; **FLOATING
C838 DELAY_VBIASP.n3 VSS 0.44541f ; **FLOATING
C839 DELAY_VBIASP.t27 VSS 0.35917f ; **FLOATING
C840 DELAY_VBIASP.n4 VSS 0.44541f ; **FLOATING
C841 DELAY_VBIASP.t26 VSS 0.35917f ; **FLOATING
C842 DELAY_VBIASP.n5 VSS 0.44541f ; **FLOATING
C843 DELAY_VBIASP.t25 VSS 0.35917f ; **FLOATING
C844 DELAY_VBIASP.n6 VSS 0.44541f ; **FLOATING
C845 DELAY_VBIASP.t24 VSS 0.35917f ; **FLOATING
C846 DELAY_VBIASP.n7 VSS 0.44541f ; **FLOATING
C847 DELAY_VBIASP.t23 VSS 0.35917f ; **FLOATING
C848 DELAY_VBIASP.n8 VSS 0.44541f ; **FLOATING
C849 DELAY_VBIASP.t22 VSS 0.35917f ; **FLOATING
C850 DELAY_VBIASP.n9 VSS 0.44541f ; **FLOATING
C851 DELAY_VBIASP.t21 VSS 0.35917f ; **FLOATING
C852 DELAY_VBIASP.n10 VSS 0.44541f ; **FLOATING
C853 DELAY_VBIASP.t20 VSS 0.35917f ; **FLOATING
C854 DELAY_VBIASP.n11 VSS 0.44541f ; **FLOATING
C855 DELAY_VBIASP.t19 VSS 0.35917f ; **FLOATING
C856 DELAY_VBIASP.n12 VSS 0.44541f ; **FLOATING
C857 DELAY_VBIASP.t18 VSS 0.35917f ; **FLOATING
C858 DELAY_VBIASP.n13 VSS 0.44541f ; **FLOATING
C859 DELAY_VBIASP.t17 VSS 0.35917f ; **FLOATING
C860 DELAY_VBIASP.n14 VSS 0.44541f ; **FLOATING
C861 DELAY_VBIASP.t16 VSS 0.35917f ; **FLOATING
C862 DELAY_VBIASP.n15 VSS 0.44541f ; **FLOATING
C863 DELAY_VBIASP.t15 VSS 0.35917f ; **FLOATING
C864 DELAY_VBIASP.n16 VSS 0.44541f ; **FLOATING
C865 DELAY_VBIASP.t14 VSS 0.35917f ; **FLOATING
C866 DELAY_VBIASP.n17 VSS 0.44541f ; **FLOATING
C867 DELAY_VBIASP.t13 VSS 0.35917f ; **FLOATING
C868 DELAY_VBIASP.n18 VSS 0.44541f ; **FLOATING
C869 DELAY_VBIASP.t12 VSS 0.35917f ; **FLOATING
C870 DELAY_VBIASP.n19 VSS 0.44541f ; **FLOATING
C871 DELAY_VBIASP.t11 VSS 0.35917f ; **FLOATING
C872 DELAY_VBIASP.n20 VSS 0.44541f ; **FLOATING
C873 DELAY_VBIASP.t10 VSS 0.35917f ; **FLOATING
C874 DELAY_VBIASP.n21 VSS 0.44541f ; **FLOATING
C875 DELAY_VBIASP.t9 VSS 0.35917f ; **FLOATING
C876 DELAY_VBIASP.n22 VSS 0.44541f ; **FLOATING
C877 DELAY_VBIASP.t8 VSS 0.35917f ; **FLOATING
C878 DELAY_VBIASP.n23 VSS 0.44541f ; **FLOATING
C879 DELAY_VBIASP.t7 VSS 0.35917f ; **FLOATING
C880 DELAY_VBIASP.n24 VSS 0.44541f ; **FLOATING
C881 DELAY_VBIASP.t6 VSS 0.35917f ; **FLOATING
C882 DELAY_VBIASP.n25 VSS 0.44541f ; **FLOATING
C883 DELAY_VBIASP.t5 VSS 0.35917f ; **FLOATING
C884 DELAY_VBIASP.n26 VSS 0.44541f ; **FLOATING
C885 DELAY_VBIASP.t4 VSS 0.35917f ; **FLOATING
C886 DELAY_VBIASP.n27 VSS 0.44541f ; **FLOATING
C887 DELAY_VBIASP.t3 VSS 0.35917f ; **FLOATING
C888 DELAY_VBIASP.n28 VSS 0.44541f ; **FLOATING
C889 DELAY_VBIASP.t2 VSS 0.35917f ; **FLOATING
C890 DELAY_VBIASP.n29 VSS 0.44541f ; **FLOATING
C891 DELAY_VBIASP.t1 VSS 0.35917f ; **FLOATING
C892 DELAY_VBIASP.n30 VSS 0.44541f ; **FLOATING
C893 DELAY_VBIASP.t0 VSS 0.35917f ; **FLOATING
C894 DELAY_VBIASN.n0 VSS 0.25441f ; **FLOATING
C895 DELAY_VBIASN.t31 VSS 0.15177f ; **FLOATING
C896 DELAY_VBIASN.t30 VSS 0.14732f ; **FLOATING
C897 DELAY_VBIASN.n1 VSS 0.34864f ; **FLOATING
C898 DELAY_VBIASN.t29 VSS 0.14732f ; **FLOATING
C899 DELAY_VBIASN.n2 VSS 0.24183f ; **FLOATING
C900 DELAY_VBIASN.t28 VSS 0.14732f ; **FLOATING
C901 DELAY_VBIASN.n3 VSS 0.24183f ; **FLOATING
C902 DELAY_VBIASN.t27 VSS 0.14732f ; **FLOATING
C903 DELAY_VBIASN.n4 VSS 0.24183f ; **FLOATING
C904 DELAY_VBIASN.t26 VSS 0.14732f ; **FLOATING
C905 DELAY_VBIASN.n5 VSS 0.24183f ; **FLOATING
C906 DELAY_VBIASN.t25 VSS 0.14732f ; **FLOATING
C907 DELAY_VBIASN.n6 VSS 0.24183f ; **FLOATING
C908 DELAY_VBIASN.t24 VSS 0.14732f ; **FLOATING
C909 DELAY_VBIASN.n7 VSS 0.24183f ; **FLOATING
C910 DELAY_VBIASN.t23 VSS 0.14732f ; **FLOATING
C911 DELAY_VBIASN.n8 VSS 0.24183f ; **FLOATING
C912 DELAY_VBIASN.t22 VSS 0.14732f ; **FLOATING
C913 DELAY_VBIASN.n9 VSS 0.24183f ; **FLOATING
C914 DELAY_VBIASN.t21 VSS 0.14732f ; **FLOATING
C915 DELAY_VBIASN.n10 VSS 0.24183f ; **FLOATING
C916 DELAY_VBIASN.t20 VSS 0.14732f ; **FLOATING
C917 DELAY_VBIASN.n11 VSS 0.24183f ; **FLOATING
C918 DELAY_VBIASN.t19 VSS 0.14732f ; **FLOATING
C919 DELAY_VBIASN.n12 VSS 0.24183f ; **FLOATING
C920 DELAY_VBIASN.t18 VSS 0.14732f ; **FLOATING
C921 DELAY_VBIASN.n13 VSS 0.24183f ; **FLOATING
C922 DELAY_VBIASN.t17 VSS 0.14732f ; **FLOATING
C923 DELAY_VBIASN.n14 VSS 0.24183f ; **FLOATING
C924 DELAY_VBIASN.t16 VSS 0.14732f ; **FLOATING
C925 DELAY_VBIASN.n15 VSS 0.24183f ; **FLOATING
C926 DELAY_VBIASN.t15 VSS 0.14732f ; **FLOATING
C927 DELAY_VBIASN.n16 VSS 0.24183f ; **FLOATING
C928 DELAY_VBIASN.t14 VSS 0.14732f ; **FLOATING
C929 DELAY_VBIASN.n17 VSS 0.24183f ; **FLOATING
C930 DELAY_VBIASN.t13 VSS 0.14732f ; **FLOATING
C931 DELAY_VBIASN.n18 VSS 0.24183f ; **FLOATING
C932 DELAY_VBIASN.t12 VSS 0.14732f ; **FLOATING
C933 DELAY_VBIASN.n19 VSS 0.24183f ; **FLOATING
C934 DELAY_VBIASN.t11 VSS 0.14732f ; **FLOATING
C935 DELAY_VBIASN.n20 VSS 0.24183f ; **FLOATING
C936 DELAY_VBIASN.t10 VSS 0.14732f ; **FLOATING
C937 DELAY_VBIASN.n21 VSS 0.24183f ; **FLOATING
C938 DELAY_VBIASN.t9 VSS 0.14732f ; **FLOATING
C939 DELAY_VBIASN.n22 VSS 0.24183f ; **FLOATING
C940 DELAY_VBIASN.t8 VSS 0.14732f ; **FLOATING
C941 DELAY_VBIASN.n23 VSS 0.24183f ; **FLOATING
C942 DELAY_VBIASN.t7 VSS 0.14732f ; **FLOATING
C943 DELAY_VBIASN.n24 VSS 0.24183f ; **FLOATING
C944 DELAY_VBIASN.t6 VSS 0.14732f ; **FLOATING
C945 DELAY_VBIASN.n25 VSS 0.24183f ; **FLOATING
C946 DELAY_VBIASN.t5 VSS 0.14732f ; **FLOATING
C947 DELAY_VBIASN.n26 VSS 0.24183f ; **FLOATING
C948 DELAY_VBIASN.t4 VSS 0.14732f ; **FLOATING
C949 DELAY_VBIASN.n27 VSS 0.24183f ; **FLOATING
C950 DELAY_VBIASN.t3 VSS 0.14732f ; **FLOATING
C951 DELAY_VBIASN.n28 VSS 0.24183f ; **FLOATING
C952 DELAY_VBIASN.t2 VSS 0.14732f ; **FLOATING
C953 DELAY_VBIASN.n29 VSS 0.24183f ; **FLOATING
C954 DELAY_VBIASN.t1 VSS 0.14732f ; **FLOATING
C955 DELAY_VBIASN.n30 VSS 0.24183f ; **FLOATING
C956 DELAY_VBIASN.t0 VSS 0.14732f ; **FLOATING
.ends
