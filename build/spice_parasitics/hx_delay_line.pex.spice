* NGSPICE file created from hx_delay_line.ext - technology: ihp-sg13g2

.subckt hx_delay_line VSS VDD DELAY_OUT_LAST DELAY_OUT_TAP1 DELAY_OUT_TAP2 DELAY_OUT_TAP3
+ DELAY_OUT_TAP4 DELAY_OUT_TAP5 DELAY_OUT_TAP6 DELAY_OUT_TAP7 DELAY_OUT_TAP8 DELAY_OUT_TAP9
+ DELAY_OUT_TAP10 DELAY_OUT_TAP11 DELAY_OUT_TAP12 DELAY_OUT_TAP13 DELAY_OUT_TAP14
+ DELAY_OUT_TAP15 DELAY_OUT_TAP16 DELAY_OUT_TAP17 DELAY_OUT_TAP18 DELAY_OUT_TAP19
+ DELAY_OUT_TAP20 DELAY_OUT_TAP21 DELAY_OUT_TAP22 DELAY_OUT_TAP23 DELAY_OUT_TAP24
+ DELAY_OUT_TAP25 DELAY_OUT_TAP26 DELAY_OUT_TAP27 DELAY_OUT_TAP28 DELAY_OUT_TAP29
+ DELAY_OUT_TAP30 DELAY_OUT_TAP31 DELAY_IN DELAY_VBIASN DELAY_VBIASP
X0 VDD.t44 DELAY_VBIASP.t3 a_25131_2470# VDD.t0 sg13_lv_pmos ad=0.3808p pd=2.92u as=0.2128p ps=1.5u w=1.12u l=0.6u
X1 VSS.t9 a_5263_1842# DELAY_OUT_TAP3 VSS.t48 sg13_lv_nmos ad=0.1406p pd=1.12u as=0.2516p ps=2.16u w=0.74u l=0.13u
X2 VDD.t24 DELAY_VBIASP.t31 a_3851_2470# VDD.t0 sg13_lv_pmos ad=0.3808p pd=2.92u as=0.2128p ps=1.5u w=1.12u l=0.6u
X3 a_27411_2470# a_27173_1842# a_27303_1842# VDD.t0 sg13_lv_pmos ad=0.2128p pd=1.5u as=0.3808p ps=2.92u w=1.12u l=0.2u
X4 a_9171_1842# a_8933_1842# a_9063_1842# VSS.t52 sg13_lv_nmos ad=0.1406p pd=1.12u as=0.2516p ps=2.16u w=0.74u l=0.2u
X5 a_18053_1842# DELAY_OUT_TAP19 VSS.t45 VSS.t109 sg13_lv_nmos ad=0.2516p pd=2.16u as=0.1406p ps=1.12u w=0.74u l=0.13u
X6 a_15013_1842# DELAY_OUT_TAP15 VDD.t8 VDD.t0 sg13_lv_pmos ad=0.3808p pd=2.92u as=0.2128p ps=1.5u w=1.12u l=0.13u
X7 VDD.t37 DELAY_VBIASP.t15 a_16011_2470# VDD.t0 sg13_lv_pmos ad=0.3808p pd=2.92u as=0.2128p ps=1.5u w=1.12u l=0.6u
X8 VSS.t25 a_7543_1842# DELAY_OUT_TAP6 VSS.t62 sg13_lv_nmos ad=0.1406p pd=1.12u as=0.2516p ps=2.16u w=0.74u l=0.13u
X9 VDD.t26 DELAY_VBIASP.t28 a_6131_2470# VDD.t0 sg13_lv_pmos ad=0.3808p pd=2.92u as=0.2128p ps=1.5u w=1.12u l=0.6u
X10 VDD.t71 a_25783_1842# DELAY_OUT_TAP30 VDD.t0 sg13_lv_pmos ad=0.2128p pd=1.5u as=0.3808p ps=2.92u w=1.12u l=0.13u
X11 a_14491_1842# a_14253_1842# a_14383_1842# VSS.t33 sg13_lv_nmos ad=0.1406p pd=1.12u as=0.2516p ps=2.16u w=0.74u l=0.2u
X12 a_8411_2470# a_8173_1842# a_8303_1842# VDD.t0 sg13_lv_pmos ad=0.2128p pd=1.5u as=0.3808p ps=2.92u w=1.12u l=0.2u
X13 a_17293_1842# DELAY_OUT_TAP18 VDD.t91 VDD.t0 sg13_lv_pmos ad=0.3808p pd=2.92u as=0.2128p ps=1.5u w=1.12u l=0.13u
X14 VSS.t72 VSS.t68 VSS.t68 VSS.t70 sg13_lv_nmos ad=0.1406p pd=1.12u as=0 ps=0 w=0.74u l=0.13u
X15 VDD.t51 a_17423_1842# DELAY_OUT_TAP19 VDD.t0 sg13_lv_pmos ad=0.2128p pd=1.5u as=0.3808p ps=2.92u w=1.12u l=0.13u
X16 a_21093_1842# DELAY_OUT_TAP23 VDD.t63 VDD.t0 sg13_lv_pmos ad=0.3808p pd=2.92u as=0.2128p ps=1.5u w=1.12u l=0.13u
X17 a_22851_2470# a_22613_1842# a_22743_1842# VDD.t0 sg13_lv_pmos ad=0.2128p pd=1.5u as=0.3808p ps=2.92u w=1.12u l=0.2u
X18 VSS.t36 a_12863_1842# DELAY_OUT_TAP13 VSS.t105 sg13_lv_nmos ad=0.1406p pd=1.12u as=0.2516p ps=2.16u w=0.74u l=0.13u
X19 VDD.t7 a_6783_1842# DELAY_OUT_TAP5 VDD.t0 sg13_lv_pmos ad=0.2128p pd=1.5u as=0.3808p ps=2.92u w=1.12u l=0.13u
X20 VDD.t19 DELAY_VBIASP.t21 a_11451_2470# VDD.t0 sg13_lv_pmos ad=0.3808p pd=2.92u as=0.2128p ps=1.5u w=1.12u l=0.6u
X21 VDD.t62 a_21223_1842# DELAY_OUT_TAP24 VDD.t0 sg13_lv_pmos ad=0.2128p pd=1.5u as=0.3808p ps=2.92u w=1.12u l=0.13u
X22 a_12733_1842# DELAY_OUT_TAP12 VDD.t5 VDD.t0 sg13_lv_pmos ad=0.3808p pd=2.92u as=0.2128p ps=1.5u w=1.12u l=0.13u
X23 a_13731_2470# a_13493_1842# a_13623_1842# VDD.t0 sg13_lv_pmos ad=0.2128p pd=1.5u as=0.3808p ps=2.92u w=1.12u l=0.2u
X24 a_3851_2470# DELAY_IN a_3743_1842# VDD.t0 sg13_lv_pmos ad=0.2128p pd=1.5u as=0.3808p ps=2.92u w=1.12u l=0.2u
X25 VSS.t27 DELAY_VBIASN.t12 a_18291_1842# VSS.t141 sg13_lv_nmos ad=0.2516p pd=2.16u as=0.1406p ps=1.12u w=0.74u l=0.6u
X26 VDD.t70 a_23503_1842# DELAY_OUT_TAP27 VDD.t0 sg13_lv_pmos ad=0.2128p pd=1.5u as=0.3808p ps=2.92u w=1.12u l=0.13u
X27 VDD.t45 DELAY_VBIASP.t1 a_26651_2470# VDD.t0 sg13_lv_pmos ad=0.3808p pd=2.92u as=0.2128p ps=1.5u w=1.12u l=0.6u
X28 VSS.t103 DELAY_VBIASN.t7 a_22091_1842# VSS.t149 sg13_lv_nmos ad=0.2516p pd=2.16u as=0.1406p ps=1.12u w=0.74u l=0.6u
X29 a_19573_1842# DELAY_OUT_TAP21 VSS.t80 VSS.t106 sg13_lv_nmos ad=0.2516p pd=2.16u as=0.1406p ps=1.12u w=0.74u l=0.13u
X30 VDD.t49 a_4503_1842# DELAY_OUT_TAP2 VDD.t0 sg13_lv_pmos ad=0.2128p pd=1.5u as=0.3808p ps=2.92u w=1.12u l=0.13u
X31 DELAY_OUT_LAST a_27737_1842# VDD.t12 VDD.t0 sg13_lv_pmos ad=0.3808p pd=2.92u as=0.2128p ps=1.5u w=1.12u l=0.13u
X32 VSS.t59 a_9063_1842# DELAY_OUT_TAP8 VSS.t58 sg13_lv_nmos ad=0.1406p pd=1.12u as=0.2516p ps=2.16u w=0.74u l=0.13u
X33 a_23373_1842# DELAY_OUT_TAP26 VSS.t100 VSS.t99 sg13_lv_nmos ad=0.2516p pd=2.16u as=0.1406p ps=1.12u w=0.74u l=0.13u
X34 VDD.t30 DELAY_VBIASP.t26 a_7651_2470# VDD.t0 sg13_lv_pmos ad=0.3808p pd=2.92u as=0.2128p ps=1.5u w=1.12u l=0.6u
X35 VSS.t7 DELAY_VBIASN.t18 a_13731_1842# VSS.t135 sg13_lv_nmos ad=0.2516p pd=2.16u as=0.1406p ps=1.12u w=0.74u l=0.6u
X36 a_9931_2470# a_9693_1842# a_9823_1842# VDD.t0 sg13_lv_pmos ad=0.2128p pd=1.5u as=0.3808p ps=2.92u w=1.12u l=0.2u
X37 a_11451_2470# a_11213_1842# a_11343_1842# VDD.t0 sg13_lv_pmos ad=0.2128p pd=1.5u as=0.3808p ps=2.92u w=1.12u l=0.2u
X38 a_18813_1842# DELAY_OUT_TAP20 VDD.t11 VDD.t0 sg13_lv_pmos ad=0.3808p pd=2.92u as=0.2128p ps=1.5u w=1.12u l=0.13u
X39 a_16011_1842# a_15773_1842# a_15903_1842# VSS.t19 sg13_lv_nmos ad=0.1406p pd=1.12u as=0.2516p ps=2.16u w=0.74u l=0.2u
X40 a_8933_1842# DELAY_OUT_TAP7 VDD.t58 VDD.t0 sg13_lv_pmos ad=0.3808p pd=2.92u as=0.2128p ps=1.5u w=1.12u l=0.13u
X41 VDD.t55 a_9823_1842# DELAY_OUT_TAP9 VDD.t0 sg13_lv_pmos ad=0.2128p pd=1.5u as=0.3808p ps=2.92u w=1.12u l=0.13u
X42 a_22613_1842# DELAY_OUT_TAP25 VDD.t74 VDD.t0 sg13_lv_pmos ad=0.3808p pd=2.92u as=0.2128p ps=1.5u w=1.12u l=0.13u
X43 a_4373_1842# DELAY_OUT_TAP1 VSS.t23 VSS.t22 sg13_lv_nmos ad=0.2516p pd=2.16u as=0.1406p ps=1.12u w=0.74u l=0.13u
X44 VSS.t21 a_14383_1842# DELAY_OUT_TAP15 VSS.t20 sg13_lv_nmos ad=0.1406p pd=1.12u as=0.2516p ps=2.16u w=0.74u l=0.13u
X45 a_18291_1842# a_18053_1842# a_18183_1842# VSS.t168 sg13_lv_nmos ad=0.1406p pd=1.12u as=0.2516p ps=2.16u w=0.74u l=0.2u
X46 a_26651_2470# a_26413_1842# a_26543_1842# VDD.t0 sg13_lv_pmos ad=0.2128p pd=1.5u as=0.3808p ps=2.92u w=1.12u l=0.2u
X47 a_22091_1842# a_21853_1842# a_21983_1842# VSS.t156 sg13_lv_nmos ad=0.1406p pd=1.12u as=0.2516p ps=2.16u w=0.74u l=0.2u
X48 VSS.t111 a_16663_1842# DELAY_OUT_TAP18 VSS.t171 sg13_lv_nmos ad=0.1406p pd=1.12u as=0.2516p ps=2.16u w=0.74u l=0.13u
X49 VDD.t35 DELAY_VBIASP.t16 a_15251_2470# VDD.t0 sg13_lv_pmos ad=0.3808p pd=2.92u as=0.2128p ps=1.5u w=1.12u l=0.6u
X50 VSS.t89 DELAY_VBIASN.t10 a_19811_1842# VSS.t147 sg13_lv_nmos ad=0.2516p pd=2.16u as=0.1406p ps=1.12u w=0.74u l=0.6u
X51 VDD.t95 a_25023_1842# DELAY_OUT_TAP29 VDD.t0 sg13_lv_pmos ad=0.2128p pd=1.5u as=0.3808p ps=2.92u w=1.12u l=0.13u
X52 VSS.t96 DELAY_VBIASN.t5 a_23611_1842# VSS.t152 sg13_lv_nmos ad=0.2516p pd=2.16u as=0.1406p ps=1.12u w=0.74u l=0.6u
X53 a_17531_2470# a_17293_1842# a_17423_1842# VDD.t0 sg13_lv_pmos ad=0.2128p pd=1.5u as=0.3808p ps=2.92u w=1.12u l=0.2u
X54 a_7651_2470# a_7413_1842# a_7543_1842# VDD.t0 sg13_lv_pmos ad=0.2128p pd=1.5u as=0.3808p ps=2.92u w=1.12u l=0.2u
X55 a_16533_1842# DELAY_OUT_TAP17 VDD.t48 VDD.t0 sg13_lv_pmos ad=0.3808p pd=2.92u as=0.2128p ps=1.5u w=1.12u l=0.13u
X56 a_20333_1842# DELAY_OUT_TAP22 VDD.t64 VDD.t0 sg13_lv_pmos ad=0.3808p pd=2.92u as=0.2128p ps=1.5u w=1.12u l=0.13u
X57 a_21331_2470# a_21093_1842# a_21223_1842# VDD.t0 sg13_lv_pmos ad=0.2128p pd=1.5u as=0.3808p ps=2.92u w=1.12u l=0.2u
X58 a_24893_1842# DELAY_OUT_TAP28 VSS.t14 VSS.t120 sg13_lv_nmos ad=0.2516p pd=2.16u as=0.1406p ps=1.12u w=0.74u l=0.13u
X59 VSS.t11 a_12103_1842# DELAY_OUT_TAP12 VSS.t55 sg13_lv_nmos ad=0.1406p pd=1.12u as=0.2516p ps=2.16u w=0.74u l=0.13u
X60 VDD.t2 a_6023_1842# DELAY_OUT_TAP4 VDD.t0 sg13_lv_pmos ad=0.2128p pd=1.5u as=0.3808p ps=2.92u w=1.12u l=0.13u
X61 VSS.t41 DELAY_VBIASN.t30 a_4611_1842# VSS.t131 sg13_lv_nmos ad=0.2516p pd=2.16u as=0.1406p ps=1.12u w=0.74u l=0.6u
X62 a_11213_1842# DELAY_OUT_TAP10 VDD.t1 VDD.t0 sg13_lv_pmos ad=0.3808p pd=2.92u as=0.2128p ps=1.5u w=1.12u l=0.13u
X63 a_12971_2470# a_12733_1842# a_12863_1842# VDD.t0 sg13_lv_pmos ad=0.2128p pd=1.5u as=0.3808p ps=2.92u w=1.12u l=0.2u
X64 VDD.t60 a_11343_1842# DELAY_OUT_TAP11 VDD.t0 sg13_lv_pmos ad=0.2128p pd=1.5u as=0.3808p ps=2.92u w=1.12u l=0.13u
X65 a_5893_1842# DELAY_OUT_TAP3 VSS.t9 VSS.t8 sg13_lv_nmos ad=0.2516p pd=2.16u as=0.1406p ps=1.12u w=0.74u l=0.13u
X66 a_27173_1842# DELAY_OUT_TAP31 VSS.t122 VSS.t121 sg13_lv_nmos ad=0.2516p pd=2.16u as=0.1406p ps=1.12u w=0.74u l=0.13u
X67 VSS.t45 DELAY_VBIASN.t13 a_17531_1842# VSS.t144 sg13_lv_nmos ad=0.2516p pd=2.16u as=0.1406p ps=1.12u w=0.74u l=0.6u
X68 VSS.t29 a_27303_1842# a_27737_1842# VSS.t28 sg13_lv_nmos ad=0.1406p pd=1.12u as=0.2516p ps=2.16u w=0.74u l=0.13u
X69 VSS.t83 DELAY_VBIASN.t8 a_21331_1842# VSS.t146 sg13_lv_nmos ad=0.2516p pd=2.16u as=0.1406p ps=1.12u w=0.74u l=0.6u
X70 a_15251_2470# a_15013_1842# a_15143_1842# VDD.t0 sg13_lv_pmos ad=0.2128p pd=1.5u as=0.3808p ps=2.92u w=1.12u l=0.2u
X71 VSS.t75 VSS.t77 VSS.t77 VSS.t78 sg13_lv_nmos ad=0.1406p pd=1.12u as=0 ps=0 w=0.74u l=0.2u
X72 a_19811_1842# a_19573_1842# a_19703_1842# VSS.t170 sg13_lv_nmos ad=0.1406p pd=1.12u as=0.2516p ps=2.16u w=0.74u l=0.2u
X73 a_8173_1842# DELAY_OUT_TAP6 VSS.t25 VSS.t24 sg13_lv_nmos ad=0.2516p pd=2.16u as=0.1406p ps=1.12u w=0.74u l=0.13u
X74 a_23611_1842# a_23373_1842# a_23503_1842# VSS.t157 sg13_lv_nmos ad=0.1406p pd=1.12u as=0.2516p ps=2.16u w=0.74u l=0.2u
X75 VDD.t3 a_13623_1842# DELAY_OUT_TAP14 VDD.t0 sg13_lv_pmos ad=0.2128p pd=1.5u as=0.3808p ps=2.92u w=1.12u l=0.13u
X76 a_26413_1842# DELAY_OUT_TAP30 VDD.t71 VDD.t0 sg13_lv_pmos ad=0.3808p pd=2.92u as=0.2128p ps=1.5u w=1.12u l=0.13u
X77 VSS.t61 a_8303_1842# DELAY_OUT_TAP7 VSS.t60 sg13_lv_nmos ad=0.1406p pd=1.12u as=0.2516p ps=2.16u w=0.74u l=0.13u
X78 VSS.t27 a_18183_1842# DELAY_OUT_TAP20 VSS.t26 sg13_lv_nmos ad=0.1406p pd=1.12u as=0.2516p ps=2.16u w=0.74u l=0.13u
X79 VSS.t11 DELAY_VBIASN.t20 a_12211_1842# VSS.t126 sg13_lv_nmos ad=0.2516p pd=2.16u as=0.1406p ps=1.12u w=0.74u l=0.6u
X80 VDD.t21 DELAY_VBIASP.t14 a_16771_2470# VDD.t0 sg13_lv_pmos ad=0.3808p pd=2.92u as=0.2128p ps=1.5u w=1.12u l=0.6u
X81 VSS.t103 a_21983_1842# DELAY_OUT_TAP25 VSS.t172 sg13_lv_nmos ad=0.1406p pd=1.12u as=0.2516p ps=2.16u w=0.74u l=0.13u
X82 VDD.t42 DELAY_VBIASP.t9 a_20571_2470# VDD.t0 sg13_lv_pmos ad=0.3808p pd=2.92u as=0.2128p ps=1.5u w=1.12u l=0.6u
X83 a_4611_1842# a_4373_1842# a_4503_1842# VSS.t18 sg13_lv_nmos ad=0.1406p pd=1.12u as=0.2516p ps=2.16u w=0.74u l=0.2u
X84 a_13493_1842# DELAY_OUT_TAP13 VSS.t36 VSS.t35 sg13_lv_nmos ad=0.2516p pd=2.16u as=0.1406p ps=1.12u w=0.74u l=0.13u
X85 a_7413_1842# DELAY_OUT_TAP5 VDD.t7 VDD.t0 sg13_lv_pmos ad=0.3808p pd=2.92u as=0.2128p ps=1.5u w=1.12u l=0.13u
X86 VDD.t17 DELAY_VBIASP.t11 a_19051_2470# VDD.t0 sg13_lv_pmos ad=0.3808p pd=2.92u as=0.2128p ps=1.5u w=1.12u l=0.6u
X87 a_21853_1842# DELAY_OUT_TAP24 VDD.t62 VDD.t0 sg13_lv_pmos ad=0.3808p pd=2.92u as=0.2128p ps=1.5u w=1.12u l=0.13u
X88 VSS.t151 DELAY_VBIASN.t0 a_27411_1842# VSS.t150 sg13_lv_nmos ad=0.2516p pd=2.16u as=0.1406p ps=1.12u w=0.74u l=0.6u
X89 a_25131_2470# a_24893_1842# a_25023_1842# VDD.t0 sg13_lv_pmos ad=0.2128p pd=1.5u as=0.3808p ps=2.92u w=1.12u l=0.2u
X90 VSS.t38 a_15903_1842# DELAY_OUT_TAP17 VSS.t37 sg13_lv_nmos ad=0.1406p pd=1.12u as=0.2516p ps=2.16u w=0.74u l=0.13u
X91 a_24133_1842# DELAY_OUT_TAP27 VDD.t70 VDD.t0 sg13_lv_pmos ad=0.3808p pd=2.92u as=0.2128p ps=1.5u w=1.12u l=0.13u
X92 VSS.t50 DELAY_VBIASN.t23 a_9931_1842# VSS.t127 sg13_lv_nmos ad=0.2516p pd=2.16u as=0.1406p ps=1.12u w=0.74u l=0.6u
X93 VSS.t61 DELAY_VBIASN.t25 a_8411_1842# VSS.t133 sg13_lv_nmos ad=0.2516p pd=2.16u as=0.1406p ps=1.12u w=0.74u l=0.6u
X94 VSS.t89 a_19703_1842# DELAY_OUT_TAP22 VSS.t88 sg13_lv_nmos ad=0.1406p pd=1.12u as=0.2516p ps=2.16u w=0.74u l=0.13u
X95 a_16771_2470# a_16533_1842# a_16663_1842# VDD.t0 sg13_lv_pmos ad=0.2128p pd=1.5u as=0.3808p ps=2.92u w=1.12u l=0.2u
X96 VSS.t100 DELAY_VBIASN.t6 a_22851_1842# VSS.t143 sg13_lv_nmos ad=0.2516p pd=2.16u as=0.1406p ps=1.12u w=0.74u l=0.6u
X97 a_12211_1842# a_11973_1842# a_12103_1842# VSS.t107 sg13_lv_nmos ad=0.1406p pd=1.12u as=0.2516p ps=2.16u w=0.74u l=0.2u
X98 a_6131_2470# a_5893_1842# a_6023_1842# VDD.t0 sg13_lv_pmos ad=0.2128p pd=1.5u as=0.3808p ps=2.92u w=1.12u l=0.2u
X99 a_5133_1842# DELAY_OUT_TAP2 VDD.t49 VDD.t0 sg13_lv_pmos ad=0.3808p pd=2.92u as=0.2128p ps=1.5u w=1.12u l=0.13u
X100 VDD.t14 a_15143_1842# DELAY_OUT_TAP16 VDD.t0 sg13_lv_pmos ad=0.2128p pd=1.5u as=0.3808p ps=2.92u w=1.12u l=0.13u
X101 a_20571_2470# a_20333_1842# a_20463_1842# VDD.t0 sg13_lv_pmos ad=0.2128p pd=1.5u as=0.3808p ps=2.92u w=1.12u l=0.2u
X102 a_9693_1842# DELAY_OUT_TAP8 VSS.t59 VSS.t93 sg13_lv_nmos ad=0.2516p pd=2.16u as=0.1406p ps=1.12u w=0.74u l=0.13u
X103 VSS.t2 a_10583_1842# DELAY_OUT_TAP10 VSS.t1 sg13_lv_nmos ad=0.1406p pd=1.12u as=0.2516p ps=2.16u w=0.74u l=0.13u
X104 VSS.t23 DELAY_VBIASN.t31 a_3851_1842# VSS.t130 sg13_lv_nmos ad=0.2516p pd=2.16u as=0.1406p ps=1.12u w=0.74u l=0.6u
X105 VSS.t116 DELAY_VBIASN.t3 a_25131_1842# VSS.t142 sg13_lv_nmos ad=0.2516p pd=2.16u as=0.1406p ps=1.12u w=0.74u l=0.6u
X106 a_19051_2470# a_18813_1842# a_18943_1842# VDD.t0 sg13_lv_pmos ad=0.2128p pd=1.5u as=0.3808p ps=2.92u w=1.12u l=0.2u
X107 a_10453_1842# DELAY_OUT_TAP9 VDD.t55 VDD.t0 sg13_lv_pmos ad=0.3808p pd=2.92u as=0.2128p ps=1.5u w=1.12u l=0.13u
X108 a_27411_1842# a_27173_1842# a_27303_1842# VSS.t164 sg13_lv_nmos ad=0.1406p pd=1.12u as=0.2516p ps=2.16u w=0.74u l=0.2u
X109 a_15013_1842# DELAY_OUT_TAP15 VSS.t21 VSS.t113 sg13_lv_nmos ad=0.2516p pd=2.16u as=0.1406p ps=1.12u w=0.74u l=0.13u
X110 VSS.t98 a_25783_1842# DELAY_OUT_TAP30 VSS.t162 sg13_lv_nmos ad=0.1406p pd=1.12u as=0.2516p ps=2.16u w=0.74u l=0.13u
X111 VSS.t38 DELAY_VBIASN.t15 a_16011_1842# VSS.t124 sg13_lv_nmos ad=0.2516p pd=2.16u as=0.1406p ps=1.12u w=0.74u l=0.6u
X112 VDD.t18 DELAY_VBIASP.t4 a_24371_2470# VDD.t0 sg13_lv_pmos ad=0.3808p pd=2.92u as=0.2128p ps=1.5u w=1.12u l=0.6u
X113 VSS.t4 DELAY_VBIASN.t28 a_6131_1842# VSS.t128 sg13_lv_nmos ad=0.2516p pd=2.16u as=0.1406p ps=1.12u w=0.74u l=0.6u
X114 VDD.t80 VDD.t78 VDD.t79 VDD.t0 sg13_lv_pmos ad=0.3808p pd=2.92u as=0 ps=0 w=1.12u l=0.13u
X115 a_8411_1842# a_8173_1842# a_8303_1842# VSS.t53 sg13_lv_nmos ad=0.1406p pd=1.12u as=0.2516p ps=2.16u w=0.74u l=0.2u
X116 a_22851_1842# a_22613_1842# a_22743_1842# VSS.t117 sg13_lv_nmos ad=0.1406p pd=1.12u as=0.2516p ps=2.16u w=0.74u l=0.2u
X117 a_17293_1842# DELAY_OUT_TAP18 VSS.t111 VSS.t110 sg13_lv_nmos ad=0.2516p pd=2.16u as=0.1406p ps=1.12u w=0.74u l=0.13u
X118 a_25653_1842# DELAY_OUT_TAP29 VDD.t95 VDD.t0 sg13_lv_pmos ad=0.3808p pd=2.92u as=0.2128p ps=1.5u w=1.12u l=0.13u
X119 VSS.t16 a_6783_1842# DELAY_OUT_TAP5 VSS.t30 sg13_lv_nmos ad=0.1406p pd=1.12u as=0.2516p ps=2.16u w=0.74u l=0.13u
X120 a_21093_1842# DELAY_OUT_TAP23 VSS.t86 VSS.t101 sg13_lv_nmos ad=0.2516p pd=2.16u as=0.1406p ps=1.12u w=0.74u l=0.13u
X121 VSS.t45 a_17423_1842# DELAY_OUT_TAP19 VSS.t44 sg13_lv_nmos ad=0.1406p pd=1.12u as=0.2516p ps=2.16u w=0.74u l=0.13u
X122 VDD.t23 DELAY_VBIASP.t29 a_5371_2470# VDD.t0 sg13_lv_pmos ad=0.3808p pd=2.92u as=0.2128p ps=1.5u w=1.12u l=0.6u
X123 VSS.t83 a_21223_1842# DELAY_OUT_TAP24 VSS.t82 sg13_lv_nmos ad=0.1406p pd=1.12u as=0.2516p ps=2.16u w=0.74u l=0.13u
X124 VSS.t65 DELAY_VBIASN.t21 a_11451_1842# VSS.t139 sg13_lv_nmos ad=0.2516p pd=2.16u as=0.1406p ps=1.12u w=0.74u l=0.6u
X125 a_3851_1842# DELAY_IN a_3743_1842# VSS.t42 sg13_lv_nmos ad=0.1406p pd=1.12u as=0.2516p ps=2.16u w=0.74u l=0.2u
X126 a_13731_1842# a_13493_1842# a_13623_1842# VSS.t5 sg13_lv_nmos ad=0.1406p pd=1.12u as=0.2516p ps=2.16u w=0.74u l=0.2u
X127 a_12733_1842# DELAY_OUT_TAP12 VSS.t11 VSS.t10 sg13_lv_nmos ad=0.2516p pd=2.16u as=0.1406p ps=1.12u w=0.74u l=0.13u
X128 a_6653_1842# DELAY_OUT_TAP4 VDD.t2 VDD.t0 sg13_lv_pmos ad=0.3808p pd=2.92u as=0.2128p ps=1.5u w=1.12u l=0.13u
X129 VSS.t96 a_23503_1842# DELAY_OUT_TAP27 VSS.t163 sg13_lv_nmos ad=0.1406p pd=1.12u as=0.2516p ps=2.16u w=0.74u l=0.13u
X130 VDD.t33 DELAY_VBIASP.t22 a_10691_2470# VDD.t0 sg13_lv_pmos ad=0.3808p pd=2.92u as=0.2128p ps=1.5u w=1.12u l=0.6u
X131 VDD.t63 a_20463_1842# DELAY_OUT_TAP23 VDD.t0 sg13_lv_pmos ad=0.2128p pd=1.5u as=0.3808p ps=2.92u w=1.12u l=0.13u
X132 VSS.t122 DELAY_VBIASN.t1 a_26651_1842# VSS.t155 sg13_lv_nmos ad=0.2516p pd=2.16u as=0.1406p ps=1.12u w=0.74u l=0.6u
X133 a_24371_2470# a_24133_1842# a_24263_1842# VDD.t0 sg13_lv_pmos ad=0.2128p pd=1.5u as=0.3808p ps=2.92u w=1.12u l=0.2u
X134 a_11973_1842# DELAY_OUT_TAP11 VDD.t60 VDD.t0 sg13_lv_pmos ad=0.3808p pd=2.92u as=0.2128p ps=1.5u w=1.12u l=0.13u
X135 VDD.t20 DELAY_VBIASP.t19 a_12971_2470# VDD.t0 sg13_lv_pmos ad=0.3808p pd=2.92u as=0.2128p ps=1.5u w=1.12u l=0.6u
X136 VDD.t61 a_18943_1842# DELAY_OUT_TAP21 VDD.t0 sg13_lv_pmos ad=0.2128p pd=1.5u as=0.3808p ps=2.92u w=1.12u l=0.13u
X137 VSS.t41 a_4503_1842# DELAY_OUT_TAP2 VSS.t43 sg13_lv_nmos ad=0.1406p pd=1.12u as=0.2516p ps=2.16u w=0.74u l=0.13u
X138 DELAY_OUT_LAST a_27737_1842# VSS.t29 VSS.t166 sg13_lv_nmos ad=0.2516p pd=2.16u as=0.1406p ps=1.12u w=0.74u l=0.13u
X139 VDD.t72 a_22743_1842# DELAY_OUT_TAP26 VDD.t0 sg13_lv_pmos ad=0.2128p pd=1.5u as=0.3808p ps=2.92u w=1.12u l=0.13u
X140 VSS.t25 DELAY_VBIASN.t26 a_7651_1842# VSS.t125 sg13_lv_nmos ad=0.2516p pd=2.16u as=0.1406p ps=1.12u w=0.74u l=0.6u
X141 VDD.t16 DELAY_VBIASP.t2 a_25891_2470# VDD.t0 sg13_lv_pmos ad=0.3808p pd=2.92u as=0.2128p ps=1.5u w=1.12u l=0.6u
X142 a_11451_1842# a_11213_1842# a_11343_1842# VSS.t12 sg13_lv_nmos ad=0.1406p pd=1.12u as=0.2516p ps=2.16u w=0.74u l=0.2u
X143 a_5371_2470# a_5133_1842# a_5263_1842# VDD.t0 sg13_lv_pmos ad=0.2128p pd=1.5u as=0.3808p ps=2.92u w=1.12u l=0.2u
X144 a_14253_1842# DELAY_OUT_TAP14 VDD.t3 VDD.t0 sg13_lv_pmos ad=0.3808p pd=2.92u as=0.2128p ps=1.5u w=1.12u l=0.13u
X145 a_9931_1842# a_9693_1842# a_9823_1842# VSS.t51 sg13_lv_nmos ad=0.1406p pd=1.12u as=0.2516p ps=2.16u w=0.74u l=0.2u
X146 a_18813_1842# DELAY_OUT_TAP20 VSS.t27 VSS.t108 sg13_lv_nmos ad=0.2516p pd=2.16u as=0.1406p ps=1.12u w=0.74u l=0.13u
X147 a_8933_1842# DELAY_OUT_TAP7 VSS.t61 VSS.t94 sg13_lv_nmos ad=0.2516p pd=2.16u as=0.1406p ps=1.12u w=0.74u l=0.13u
X148 a_22613_1842# DELAY_OUT_TAP25 VSS.t103 VSS.t102 sg13_lv_nmos ad=0.2516p pd=2.16u as=0.1406p ps=1.12u w=0.74u l=0.13u
X149 VSS.t50 a_9823_1842# DELAY_OUT_TAP9 VSS.t49 sg13_lv_nmos ad=0.1406p pd=1.12u as=0.2516p ps=2.16u w=0.74u l=0.13u
X150 VDD.t9 a_3743_1842# DELAY_OUT_TAP1 VDD.t0 sg13_lv_pmos ad=0.2128p pd=1.5u as=0.3808p ps=2.92u w=1.12u l=0.13u
X151 VDD.t29 DELAY_VBIASP.t27 a_6891_2470# VDD.t0 sg13_lv_pmos ad=0.3808p pd=2.92u as=0.2128p ps=1.5u w=1.12u l=0.6u
X152 a_10691_2470# a_10453_1842# a_10583_1842# VDD.t0 sg13_lv_pmos ad=0.2128p pd=1.5u as=0.3808p ps=2.92u w=1.12u l=0.2u
X153 a_26651_1842# a_26413_1842# a_26543_1842# VSS.t169 sg13_lv_nmos ad=0.1406p pd=1.12u as=0.2516p ps=2.16u w=0.74u l=0.2u
X154 VSS.t32 DELAY_VBIASN.t16 a_15251_1842# VSS.t136 sg13_lv_nmos ad=0.2516p pd=2.16u as=0.1406p ps=1.12u w=0.74u l=0.6u
X155 VDD.t32 DELAY_VBIASP.t24 a_9171_2470# VDD.t0 sg13_lv_pmos ad=0.3808p pd=2.92u as=0.2128p ps=1.5u w=1.12u l=0.6u
X156 VSS.t116 a_25023_1842# DELAY_OUT_TAP29 VSS.t159 sg13_lv_nmos ad=0.1406p pd=1.12u as=0.2516p ps=2.16u w=0.74u l=0.13u
X157 a_17531_1842# a_17293_1842# a_17423_1842# VSS.t173 sg13_lv_nmos ad=0.1406p pd=1.12u as=0.2516p ps=2.16u w=0.74u l=0.2u
X158 a_7651_1842# a_7413_1842# a_7543_1842# VSS.t0 sg13_lv_nmos ad=0.1406p pd=1.12u as=0.2516p ps=2.16u w=0.74u l=0.2u
X159 a_21331_1842# a_21093_1842# a_21223_1842# VSS.t84 sg13_lv_nmos ad=0.1406p pd=1.12u as=0.2516p ps=2.16u w=0.74u l=0.2u
X160 a_16533_1842# DELAY_OUT_TAP17 VSS.t38 VSS.t112 sg13_lv_nmos ad=0.2516p pd=2.16u as=0.1406p ps=1.12u w=0.74u l=0.13u
X161 a_25891_2470# a_25653_1842# a_25783_1842# VDD.t0 sg13_lv_pmos ad=0.2128p pd=1.5u as=0.3808p ps=2.92u w=1.12u l=0.2u
X162 VSS.t4 a_6023_1842# DELAY_OUT_TAP4 VSS.t47 sg13_lv_nmos ad=0.1406p pd=1.12u as=0.2516p ps=2.16u w=0.74u l=0.13u
X163 a_20333_1842# DELAY_OUT_TAP22 VSS.t89 VSS.t114 sg13_lv_nmos ad=0.2516p pd=2.16u as=0.1406p ps=1.12u w=0.74u l=0.13u
X164 VDD.t36 DELAY_VBIASP.t17 a_14491_2470# VDD.t0 sg13_lv_pmos ad=0.3808p pd=2.92u as=0.2128p ps=1.5u w=1.12u l=0.6u
X165 VDD.t6 a_24263_1842# DELAY_OUT_TAP28 VDD.t0 sg13_lv_pmos ad=0.2128p pd=1.5u as=0.3808p ps=2.92u w=1.12u l=0.13u
X166 a_6891_2470# a_6653_1842# a_6783_1842# VDD.t0 sg13_lv_pmos ad=0.2128p pd=1.5u as=0.3808p ps=2.92u w=1.12u l=0.2u
X167 a_15773_1842# DELAY_OUT_TAP16 VDD.t14 VDD.t0 sg13_lv_pmos ad=0.3808p pd=2.92u as=0.2128p ps=1.5u w=1.12u l=0.13u
X168 VDD.t85 VDD.t83 VDD.t84 VDD.t0 sg13_lv_pmos ad=0.3808p pd=2.92u as=0 ps=0 w=1.12u l=0.6u
X169 a_12971_1842# a_12733_1842# a_12863_1842# VSS.t63 sg13_lv_nmos ad=0.1406p pd=1.12u as=0.2516p ps=2.16u w=0.74u l=0.2u
X170 a_11213_1842# DELAY_OUT_TAP10 VSS.t2 VSS.t91 sg13_lv_nmos ad=0.2516p pd=2.16u as=0.1406p ps=1.12u w=0.74u l=0.13u
X171 VDD.t99 a_26543_1842# DELAY_OUT_TAP31 VDD.t0 sg13_lv_pmos ad=0.2128p pd=1.5u as=0.3808p ps=2.92u w=1.12u l=0.13u
X172 VSS.t65 a_11343_1842# DELAY_OUT_TAP11 VSS.t64 sg13_lv_nmos ad=0.1406p pd=1.12u as=0.2516p ps=2.16u w=0.74u l=0.13u
X173 VDD.t4 a_5263_1842# DELAY_OUT_TAP3 VDD.t0 sg13_lv_pmos ad=0.2128p pd=1.5u as=0.3808p ps=2.92u w=1.12u l=0.13u
X174 a_15251_1842# a_15013_1842# a_15143_1842# VSS.t39 sg13_lv_nmos ad=0.1406p pd=1.12u as=0.2516p ps=2.16u w=0.74u l=0.2u
X175 a_9171_2470# a_8933_1842# a_9063_1842# VDD.t0 sg13_lv_pmos ad=0.2128p pd=1.5u as=0.3808p ps=2.92u w=1.12u l=0.2u
X176 a_18053_1842# DELAY_OUT_TAP19 VDD.t51 VDD.t0 sg13_lv_pmos ad=0.3808p pd=2.92u as=0.2128p ps=1.5u w=1.12u l=0.13u
X177 VSS.t7 a_13623_1842# DELAY_OUT_TAP14 VSS.t6 sg13_lv_nmos ad=0.1406p pd=1.12u as=0.2516p ps=2.16u w=0.74u l=0.13u
X178 VDD.t10 a_7543_1842# DELAY_OUT_TAP6 VDD.t0 sg13_lv_pmos ad=0.2128p pd=1.5u as=0.3808p ps=2.92u w=1.12u l=0.13u
X179 a_26413_1842# DELAY_OUT_TAP30 VSS.t98 VSS.t97 sg13_lv_nmos ad=0.2516p pd=2.16u as=0.1406p ps=1.12u w=0.74u l=0.13u
X180 VSS.t111 DELAY_VBIASN.t14 a_16771_1842# VSS.t145 sg13_lv_nmos ad=0.2516p pd=2.16u as=0.1406p ps=1.12u w=0.74u l=0.6u
X181 a_14491_2470# a_14253_1842# a_14383_1842# VDD.t0 sg13_lv_pmos ad=0.2128p pd=1.5u as=0.3808p ps=2.92u w=1.12u l=0.2u
X182 VSS.t86 DELAY_VBIASN.t9 a_20571_1842# VSS.t148 sg13_lv_nmos ad=0.2516p pd=2.16u as=0.1406p ps=1.12u w=0.74u l=0.6u
X183 VDD.t80 VDD.t81 VDD.t82 VDD.t0 sg13_lv_pmos ad=0.2128p pd=1.5u as=0 ps=0 w=1.12u l=0.13u
X184 VDD.t47 a_12863_1842# DELAY_OUT_TAP13 VDD.t0 sg13_lv_pmos ad=0.2128p pd=1.5u as=0.3808p ps=2.92u w=1.12u l=0.13u
X185 a_7413_1842# DELAY_OUT_TAP5 VSS.t16 VSS.t15 sg13_lv_nmos ad=0.2516p pd=2.16u as=0.1406p ps=1.12u w=0.74u l=0.13u
X186 a_21853_1842# DELAY_OUT_TAP24 VSS.t83 VSS.t104 sg13_lv_nmos ad=0.2516p pd=2.16u as=0.1406p ps=1.12u w=0.74u l=0.13u
X187 VSS.t80 DELAY_VBIASN.t11 a_19051_1842# VSS.t140 sg13_lv_nmos ad=0.2516p pd=2.16u as=0.1406p ps=1.12u w=0.74u l=0.6u
X188 a_25131_1842# a_24893_1842# a_25023_1842# VSS.t17 sg13_lv_nmos ad=0.1406p pd=1.12u as=0.2516p ps=2.16u w=0.74u l=0.2u
X189 VDD.t38 DELAY_VBIASP.t12 a_18291_2470# VDD.t0 sg13_lv_pmos ad=0.3808p pd=2.92u as=0.2128p ps=1.5u w=1.12u l=0.6u
X190 a_24133_1842# DELAY_OUT_TAP27 VSS.t96 VSS.t95 sg13_lv_nmos ad=0.2516p pd=2.16u as=0.1406p ps=1.12u w=0.74u l=0.13u
X191 VDD.t39 DELAY_VBIASP.t7 a_22091_2470# VDD.t0 sg13_lv_pmos ad=0.3808p pd=2.92u as=0.2128p ps=1.5u w=1.12u l=0.6u
X192 a_16771_1842# a_16533_1842# a_16663_1842# VSS.t81 sg13_lv_nmos ad=0.1406p pd=1.12u as=0.2516p ps=2.16u w=0.74u l=0.2u
X193 a_19573_1842# DELAY_OUT_TAP21 VDD.t61 VDD.t0 sg13_lv_pmos ad=0.3808p pd=2.92u as=0.2128p ps=1.5u w=1.12u l=0.13u
X194 a_6131_1842# a_5893_1842# a_6023_1842# VSS.t57 sg13_lv_nmos ad=0.1406p pd=1.12u as=0.2516p ps=2.16u w=0.74u l=0.2u
X195 a_20571_1842# a_20333_1842# a_20463_1842# VSS.t87 sg13_lv_nmos ad=0.1406p pd=1.12u as=0.2516p ps=2.16u w=0.74u l=0.2u
X196 a_23373_1842# DELAY_OUT_TAP26 VDD.t72 VDD.t0 sg13_lv_pmos ad=0.3808p pd=2.92u as=0.2128p ps=1.5u w=1.12u l=0.13u
X197 a_5133_1842# DELAY_OUT_TAP2 VSS.t41 VSS.t40 sg13_lv_nmos ad=0.2516p pd=2.16u as=0.1406p ps=1.12u w=0.74u l=0.13u
X198 VSS.t32 a_15143_1842# DELAY_OUT_TAP16 VSS.t31 sg13_lv_nmos ad=0.1406p pd=1.12u as=0.2516p ps=2.16u w=0.74u l=0.13u
X199 VDD.t57 a_9063_1842# DELAY_OUT_TAP8 VDD.t0 sg13_lv_pmos ad=0.2128p pd=1.5u as=0.3808p ps=2.92u w=1.12u l=0.13u
X200 VDD.t34 DELAY_VBIASP.t18 a_13731_2470# VDD.t0 sg13_lv_pmos ad=0.3808p pd=2.92u as=0.2128p ps=1.5u w=1.12u l=0.6u
X201 a_19051_1842# a_18813_1842# a_18943_1842# VSS.t34 sg13_lv_nmos ad=0.1406p pd=1.12u as=0.2516p ps=2.16u w=0.74u l=0.2u
X202 a_16011_2470# a_15773_1842# a_15903_1842# VDD.t0 sg13_lv_pmos ad=0.2128p pd=1.5u as=0.3808p ps=2.92u w=1.12u l=0.2u
X203 a_10453_1842# DELAY_OUT_TAP9 VSS.t50 VSS.t92 sg13_lv_nmos ad=0.2516p pd=2.16u as=0.1406p ps=1.12u w=0.74u l=0.13u
X204 a_4373_1842# DELAY_OUT_TAP1 VDD.t9 VDD.t0 sg13_lv_pmos ad=0.3808p pd=2.92u as=0.2128p ps=1.5u w=1.12u l=0.13u
X205 VDD.t8 a_14383_1842# DELAY_OUT_TAP15 VDD.t0 sg13_lv_pmos ad=0.2128p pd=1.5u as=0.3808p ps=2.92u w=1.12u l=0.13u
X206 VSS.t14 DELAY_VBIASN.t4 a_24371_1842# VSS.t153 sg13_lv_nmos ad=0.2516p pd=2.16u as=0.1406p ps=1.12u w=0.74u l=0.6u
X207 a_18291_2470# a_18053_1842# a_18183_1842# VDD.t0 sg13_lv_pmos ad=0.2128p pd=1.5u as=0.3808p ps=2.92u w=1.12u l=0.2u
X208 a_22091_2470# a_21853_1842# a_21983_1842# VDD.t0 sg13_lv_pmos ad=0.2128p pd=1.5u as=0.3808p ps=2.92u w=1.12u l=0.2u
X209 VSS.t69 VSS.t66 VSS.t68 VSS.t67 sg13_lv_nmos ad=0.2516p pd=2.16u as=0 ps=0 w=0.74u l=0.13u
X210 VDD.t91 a_16663_1842# DELAY_OUT_TAP18 VDD.t0 sg13_lv_pmos ad=0.2128p pd=1.5u as=0.3808p ps=2.92u w=1.12u l=0.13u
X211 VDD.t41 DELAY_VBIASP.t10 a_19811_2470# VDD.t0 sg13_lv_pmos ad=0.3808p pd=2.92u as=0.2128p ps=1.5u w=1.12u l=0.6u
X212 a_25653_1842# DELAY_OUT_TAP29 VSS.t116 VSS.t115 sg13_lv_nmos ad=0.2516p pd=2.16u as=0.1406p ps=1.12u w=0.74u l=0.13u
X213 VSS.t9 DELAY_VBIASN.t29 a_5371_1842# VSS.t129 sg13_lv_nmos ad=0.2516p pd=2.16u as=0.1406p ps=1.12u w=0.74u l=0.6u
X214 VDD.t43 DELAY_VBIASP.t5 a_23611_2470# VDD.t0 sg13_lv_pmos ad=0.3808p pd=2.92u as=0.2128p ps=1.5u w=1.12u l=0.6u
X215 VDD.t5 a_12103_1842# DELAY_OUT_TAP12 VDD.t0 sg13_lv_pmos ad=0.2128p pd=1.5u as=0.3808p ps=2.92u w=1.12u l=0.13u
X216 a_24893_1842# DELAY_OUT_TAP28 VDD.t6 VDD.t0 sg13_lv_pmos ad=0.3808p pd=2.92u as=0.2128p ps=1.5u w=1.12u l=0.13u
X217 a_6653_1842# DELAY_OUT_TAP4 VSS.t4 VSS.t3 sg13_lv_nmos ad=0.2516p pd=2.16u as=0.1406p ps=1.12u w=0.74u l=0.13u
X218 VSS.t86 a_20463_1842# DELAY_OUT_TAP23 VSS.t85 sg13_lv_nmos ad=0.1406p pd=1.12u as=0.2516p ps=2.16u w=0.74u l=0.13u
X219 VSS.t2 DELAY_VBIASN.t22 a_10691_1842# VSS.t123 sg13_lv_nmos ad=0.2516p pd=2.16u as=0.1406p ps=1.12u w=0.74u l=0.6u
X220 VDD.t28 DELAY_VBIASP.t30 a_4611_2470# VDD.t0 sg13_lv_pmos ad=0.3808p pd=2.92u as=0.2128p ps=1.5u w=1.12u l=0.6u
X221 a_24371_1842# a_24133_1842# a_24263_1842# VSS.t165 sg13_lv_nmos ad=0.1406p pd=1.12u as=0.2516p ps=2.16u w=0.74u l=0.2u
X222 VSS.t80 a_18943_1842# DELAY_OUT_TAP21 VSS.t79 sg13_lv_nmos ad=0.1406p pd=1.12u as=0.2516p ps=2.16u w=0.74u l=0.13u
X223 a_11973_1842# DELAY_OUT_TAP11 VSS.t65 VSS.t90 sg13_lv_nmos ad=0.2516p pd=2.16u as=0.1406p ps=1.12u w=0.74u l=0.13u
X224 a_5893_1842# DELAY_OUT_TAP3 VDD.t4 VDD.t0 sg13_lv_pmos ad=0.3808p pd=2.92u as=0.2128p ps=1.5u w=1.12u l=0.13u
X225 VDD.t22 DELAY_VBIASP.t13 a_17531_2470# VDD.t0 sg13_lv_pmos ad=0.3808p pd=2.92u as=0.2128p ps=1.5u w=1.12u l=0.6u
X226 a_27173_1842# DELAY_OUT_TAP31 VDD.t99 VDD.t0 sg13_lv_pmos ad=0.3808p pd=2.92u as=0.2128p ps=1.5u w=1.12u l=0.13u
X227 VSS.t36 DELAY_VBIASN.t19 a_12971_1842# VSS.t138 sg13_lv_nmos ad=0.2516p pd=2.16u as=0.1406p ps=1.12u w=0.74u l=0.6u
X228 VDD.t12 a_27303_1842# a_27737_1842# VDD.t0 sg13_lv_pmos ad=0.2128p pd=1.5u as=0.3808p ps=2.92u w=1.12u l=0.13u
X229 VSS.t98 DELAY_VBIASN.t2 a_25891_1842# VSS.t154 sg13_lv_nmos ad=0.2516p pd=2.16u as=0.1406p ps=1.12u w=0.74u l=0.6u
X230 VSS.t100 a_22743_1842# DELAY_OUT_TAP26 VSS.t161 sg13_lv_nmos ad=0.1406p pd=1.12u as=0.2516p ps=2.16u w=0.74u l=0.13u
X231 a_19811_2470# a_19573_1842# a_19703_1842# VDD.t0 sg13_lv_pmos ad=0.2128p pd=1.5u as=0.3808p ps=2.92u w=1.12u l=0.2u
X232 VDD.t40 DELAY_VBIASP.t8 a_21331_2470# VDD.t0 sg13_lv_pmos ad=0.3808p pd=2.92u as=0.2128p ps=1.5u w=1.12u l=0.6u
X233 VDD.t88 VDD.t86 VDD.t85 VDD.t0 sg13_lv_pmos ad=0.2128p pd=1.5u as=0 ps=0 w=1.12u l=0.2u
X234 a_5371_1842# a_5133_1842# a_5263_1842# VSS.t167 sg13_lv_nmos ad=0.1406p pd=1.12u as=0.2516p ps=2.16u w=0.74u l=0.2u
X235 a_14253_1842# DELAY_OUT_TAP14 VSS.t7 VSS.t118 sg13_lv_nmos ad=0.2516p pd=2.16u as=0.1406p ps=1.12u w=0.74u l=0.13u
X236 a_8173_1842# DELAY_OUT_TAP6 VDD.t10 VDD.t0 sg13_lv_pmos ad=0.3808p pd=2.92u as=0.2128p ps=1.5u w=1.12u l=0.13u
X237 VDD.t11 a_18183_1842# DELAY_OUT_TAP20 VDD.t0 sg13_lv_pmos ad=0.2128p pd=1.5u as=0.3808p ps=2.92u w=1.12u l=0.13u
X238 a_23611_2470# a_23373_1842# a_23503_1842# VDD.t0 sg13_lv_pmos ad=0.2128p pd=1.5u as=0.3808p ps=2.92u w=1.12u l=0.2u
X239 VSS.t23 a_3743_1842# DELAY_OUT_TAP1 VSS.t46 sg13_lv_nmos ad=0.1406p pd=1.12u as=0.2516p ps=2.16u w=0.74u l=0.13u
X240 VDD.t58 a_8303_1842# DELAY_OUT_TAP7 VDD.t0 sg13_lv_pmos ad=0.2128p pd=1.5u as=0.3808p ps=2.92u w=1.12u l=0.13u
X241 VDD.t15 DELAY_VBIASP.t20 a_12211_2470# VDD.t0 sg13_lv_pmos ad=0.3808p pd=2.92u as=0.2128p ps=1.5u w=1.12u l=0.6u
X242 VDD.t74 a_21983_1842# DELAY_OUT_TAP25 VDD.t0 sg13_lv_pmos ad=0.2128p pd=1.5u as=0.3808p ps=2.92u w=1.12u l=0.13u
X243 VSS.t16 DELAY_VBIASN.t27 a_6891_1842# VSS.t132 sg13_lv_nmos ad=0.2516p pd=2.16u as=0.1406p ps=1.12u w=0.74u l=0.6u
X244 a_4611_2470# a_4373_1842# a_4503_1842# VDD.t0 sg13_lv_pmos ad=0.2128p pd=1.5u as=0.3808p ps=2.92u w=1.12u l=0.2u
X245 a_13493_1842# DELAY_OUT_TAP13 VDD.t47 VDD.t0 sg13_lv_pmos ad=0.3808p pd=2.92u as=0.2128p ps=1.5u w=1.12u l=0.13u
X246 a_10691_1842# a_10453_1842# a_10583_1842# VSS.t54 sg13_lv_nmos ad=0.1406p pd=1.12u as=0.2516p ps=2.16u w=0.74u l=0.2u
X247 VDD.t46 DELAY_VBIASP.t0 a_27411_2470# VDD.t0 sg13_lv_pmos ad=0.3808p pd=2.92u as=0.2128p ps=1.5u w=1.12u l=0.6u
X248 VSS.t59 DELAY_VBIASN.t24 a_9171_1842# VSS.t134 sg13_lv_nmos ad=0.2516p pd=2.16u as=0.1406p ps=1.12u w=0.74u l=0.6u
X249 a_25891_1842# a_25653_1842# a_25783_1842# VSS.t160 sg13_lv_nmos ad=0.1406p pd=1.12u as=0.2516p ps=2.16u w=0.74u l=0.2u
X250 VDD.t25 DELAY_VBIASP.t23 a_9931_2470# VDD.t0 sg13_lv_pmos ad=0.3808p pd=2.92u as=0.2128p ps=1.5u w=1.12u l=0.6u
X251 VDD.t48 a_15903_1842# DELAY_OUT_TAP17 VDD.t0 sg13_lv_pmos ad=0.2128p pd=1.5u as=0.3808p ps=2.92u w=1.12u l=0.13u
X252 VSS.t21 DELAY_VBIASN.t17 a_14491_1842# VSS.t137 sg13_lv_nmos ad=0.2516p pd=2.16u as=0.1406p ps=1.12u w=0.74u l=0.6u
X253 VDD.t31 DELAY_VBIASP.t25 a_8411_2470# VDD.t0 sg13_lv_pmos ad=0.3808p pd=2.92u as=0.2128p ps=1.5u w=1.12u l=0.6u
X254 VDD.t64 a_19703_1842# DELAY_OUT_TAP22 VDD.t0 sg13_lv_pmos ad=0.2128p pd=1.5u as=0.3808p ps=2.92u w=1.12u l=0.13u
X255 VSS.t14 a_24263_1842# DELAY_OUT_TAP28 VSS.t13 sg13_lv_nmos ad=0.1406p pd=1.12u as=0.2516p ps=2.16u w=0.74u l=0.13u
X256 a_12211_2470# a_11973_1842# a_12103_1842# VDD.t0 sg13_lv_pmos ad=0.2128p pd=1.5u as=0.3808p ps=2.92u w=1.12u l=0.2u
X257 VDD.t27 DELAY_VBIASP.t6 a_22851_2470# VDD.t0 sg13_lv_pmos ad=0.3808p pd=2.92u as=0.2128p ps=1.5u w=1.12u l=0.6u
X258 a_6891_1842# a_6653_1842# a_6783_1842# VSS.t56 sg13_lv_nmos ad=0.1406p pd=1.12u as=0.2516p ps=2.16u w=0.74u l=0.2u
X259 VSS.t76 VSS.t73 VSS.t75 VSS.t74 sg13_lv_nmos ad=0.2516p pd=2.16u as=0 ps=0 w=0.74u l=0.6u
X260 a_15773_1842# DELAY_OUT_TAP16 VSS.t32 VSS.t119 sg13_lv_nmos ad=0.2516p pd=2.16u as=0.1406p ps=1.12u w=0.74u l=0.13u
X261 a_9693_1842# DELAY_OUT_TAP8 VDD.t57 VDD.t0 sg13_lv_pmos ad=0.3808p pd=2.92u as=0.2128p ps=1.5u w=1.12u l=0.13u
X262 VDD.t1 a_10583_1842# DELAY_OUT_TAP10 VDD.t0 sg13_lv_pmos ad=0.2128p pd=1.5u as=0.3808p ps=2.92u w=1.12u l=0.13u
X263 VSS.t122 a_26543_1842# DELAY_OUT_TAP31 VSS.t158 sg13_lv_nmos ad=0.1406p pd=1.12u as=0.2516p ps=2.16u w=0.74u l=0.13u
C0 a_9823_1842# a_9931_2470# 0.01697f
C1 VDD DELAY_OUT_TAP2 0.72899f
C2 VDD DELAY_OUT_TAP12 0.72899f
C3 DELAY_VBIASP DELAY_OUT_TAP24 0.04137f
C4 a_9063_1842# VDD 0.49633f
C5 a_9823_1842# DELAY_OUT_TAP9 0.69646f
C6 DELAY_VBIASP a_14253_1842# 0.11222f
C7 a_6891_2470# a_6783_1842# 0.01697f
C8 DELAY_VBIASN a_5263_1842# 0.07258f
C9 a_5893_1842# DELAY_OUT_TAP4 0.0114f
C10 DELAY_OUT_TAP26 a_22743_1842# 0.69646f
C11 VDD DELAY_OUT_TAP23 0.72899f
C12 DELAY_VBIASN DELAY_OUT_TAP14 0.04353f
C13 DELAY_OUT_TAP28 DELAY_VBIASP 0.04137f
C14 a_3851_1842# a_3743_1842# 0.01163f
C15 a_25653_1842# VDD 0.4916f
C16 VDD a_11451_2470# 0.01806f
C17 a_21983_1842# a_22091_2470# 0.01697f
C18 a_21853_1842# DELAY_OUT_TAP24 0.70708f
C19 a_22091_2470# VDD 0.01806f
C20 a_17293_1842# a_17423_1842# 0.70845f
C21 a_15251_1842# a_15143_1842# 0.01163f
C22 DELAY_VBIASP a_24133_1842# 0.11222f
C23 a_12733_1842# VDD 0.4916f
C24 a_9823_1842# VDD 0.49633f
C25 DELAY_OUT_LAST VDD 0.45735f
C26 DELAY_VBIASP DELAY_OUT_TAP29 0.04137f
C27 DELAY_VBIASP a_15773_1842# 0.11222f
C28 DELAY_OUT_TAP15 a_14383_1842# 0.69646f
C29 DELAY_OUT_TAP22 a_20333_1842# 0.70708f
C30 a_27411_2470# VDD 0.01806f
C31 VDD a_15143_1842# 0.49633f
C32 DELAY_VBIASP a_26413_1842# 0.11222f
C33 a_11343_1842# VDD 0.49633f
C34 DELAY_VBIASP a_8933_1842# 0.11222f
C35 DELAY_VBIASP a_22743_1842# 0.06627f
C36 a_16533_1842# DELAY_OUT_TAP18 0.0114f
C37 DELAY_VBIASP a_6653_1842# 0.11222f
C38 a_9171_1842# a_9063_1842# 0.01163f
C39 a_20571_2470# VDD 0.01806f
C40 a_18291_2470# VDD 0.01806f
C41 a_15013_1842# VDD 0.4916f
C42 DELAY_OUT_TAP26 VDD 0.72899f
C43 a_8303_1842# VDD 0.49633f
C44 a_6023_1842# VDD 0.49633f
C45 a_4611_2470# a_4503_1842# 0.01697f
C46 a_18943_1842# DELAY_OUT_TAP21 0.69646f
C47 DELAY_VBIASN DELAY_OUT_TAP18 0.04353f
C48 a_13731_2470# VDD 0.01806f
C49 a_26413_1842# DELAY_OUT_TAP30 0.70708f
C50 a_18813_1842# DELAY_OUT_TAP20 0.70708f
C51 a_25023_1842# DELAY_OUT_TAP29 0.69646f
C52 DELAY_VBIASP DELAY_OUT_TAP9 0.04137f
C53 a_18813_1842# VDD 0.4916f
C54 DELAY_VBIASN a_4503_1842# 0.07258f
C55 a_25783_1842# a_25653_1842# 0.70845f
C56 a_14383_1842# a_14253_1842# 0.70845f
C57 DELAY_VBIASP DELAY_OUT_TAP3 0.04137f
C58 DELAY_OUT_TAP14 a_13493_1842# 0.0114f
C59 DELAY_VBIASN DELAY_OUT_TAP7 0.04353f
C60 DELAY_VBIASN a_16533_1842# 0.10601f
C61 DELAY_VBIASP DELAY_OUT_TAP20 0.04137f
C62 a_13731_2470# a_13623_1842# 0.01697f
C63 DELAY_VBIASP a_21983_1842# 0.06627f
C64 a_26413_1842# DELAY_OUT_TAP31 0.0114f
C65 DELAY_VBIASP VDD 13.2523f
C66 a_8173_1842# DELAY_OUT_TAP7 0.0114f
C67 a_9823_1842# a_9931_1842# 0.01163f
C68 DELAY_VBIASP a_16663_1842# 0.06627f
C69 DELAY_VBIASN DELAY_OUT_TAP16 0.04353f
C70 DELAY_IN VDD 0.45518f
C71 a_21853_1842# a_21983_1842# 0.70845f
C72 DELAY_OUT_TAP5 a_6653_1842# 0.0114f
C73 a_21853_1842# VDD 0.4916f
C74 VDD DELAY_OUT_TAP1 0.72899f
C75 DELAY_VBIASN a_27173_1842# 0.10602f
C76 VDD a_4373_1842# 0.4916f
C77 a_8173_1842# DELAY_VBIASN 0.10601f
C78 VDD DELAY_OUT_TAP30 0.72899f
C79 DELAY_VBIASP a_13623_1842# 0.06627f
C80 DELAY_VBIASP a_18053_1842# 0.11222f
C81 a_5893_1842# DELAY_OUT_TAP3 0.70708f
C82 DELAY_VBIASN DELAY_OUT_TAP13 0.04353f
C83 VDD a_3743_1842# 0.61241f
C84 a_10583_1842# DELAY_VBIASN 0.07258f
C85 DELAY_OUT_TAP27 DELAY_VBIASP 0.04137f
C86 a_25023_1842# VDD 0.49633f
C87 VDD a_17423_1842# 0.49633f
C88 a_12211_1842# a_12103_1842# 0.01163f
C89 a_22613_1842# a_22743_1842# 0.70845f
C90 a_21223_1842# DELAY_OUT_TAP24 0.69646f
C91 DELAY_VBIASN a_19703_1842# 0.07258f
C92 DELAY_VBIASP a_23503_1842# 0.06627f
C93 a_10691_2470# VDD 0.01806f
C94 a_5893_1842# VDD 0.4916f
C95 a_27737_1842# a_27303_1842# 0.69646f
C96 a_12103_1842# VDD 0.49633f
C97 DELAY_VBIASP DELAY_OUT_TAP6 0.04137f
C98 a_11451_1842# a_11343_1842# 0.01163f
C99 DELAY_OUT_TAP31 VDD 0.72899f
C100 a_26651_2470# VDD 0.01806f
C101 DELAY_OUT_TAP5 VDD 0.72899f
C102 a_9171_2470# VDD 0.01806f
C103 DELAY_VBIASP a_25783_1842# 0.06627f
C104 DELAY_VBIASP a_19573_1842# 0.11222f
C105 a_19051_2470# VDD 0.01806f
C106 DELAY_VBIASN a_24893_1842# 0.10601f
C107 a_21093_1842# DELAY_OUT_TAP23 0.70708f
C108 a_17531_2470# VDD 0.01806f
C109 a_14253_1842# DELAY_OUT_TAP14 0.70708f
C110 DELAY_VBIASN DELAY_OUT_TAP11 0.04353f
C111 a_14383_1842# VDD 0.49633f
C112 a_24371_2470# VDD 0.01806f
C113 DELAY_OUT_TAP25 a_21983_1842# 0.69646f
C114 a_8933_1842# DELAY_OUT_TAP8 0.0114f
C115 DELAY_VBIASP DELAY_OUT_TAP22 0.04137f
C116 DELAY_OUT_TAP25 VDD 0.72899f
C117 DELAY_VBIASN a_13493_1842# 0.10601f
C118 a_22613_1842# VDD 0.4916f
C119 a_12971_2470# VDD 0.01806f
C120 a_25783_1842# DELAY_OUT_TAP30 0.69646f
C121 a_18183_1842# DELAY_OUT_TAP20 0.69646f
C122 a_19811_1842# a_19703_1842# 0.01163f
C123 DELAY_VBIASN a_23373_1842# 0.10601f
C124 a_5133_1842# DELAY_OUT_TAP3 0.0114f
C125 a_18183_1842# VDD 0.49633f
C126 DELAY_OUT_TAP13 a_13493_1842# 0.70708f
C127 DELAY_OUT_TAP18 a_17293_1842# 0.70708f
C128 DELAY_VBIASN a_15903_1842# 0.07258f
C129 DELAY_VBIASP DELAY_OUT_TAP19 0.04137f
C130 a_5133_1842# VDD 0.4916f
C131 DELAY_VBIASN DELAY_OUT_TAP10 0.04353f
C132 a_27411_2470# a_27303_1842# 0.01697f
C133 VDD DELAY_OUT_TAP8 0.72899f
C134 a_18183_1842# a_18053_1842# 0.70845f
C135 DELAY_VBIASN DELAY_OUT_TAP4 0.04353f
C136 DELAY_VBIASN DELAY_OUT_TAP15 0.04353f
C137 DELAY_VBIASP DELAY_OUT_TAP17 0.04137f
C138 a_21223_1842# VDD 0.49633f
C139 a_7543_1842# DELAY_VBIASN 0.07258f
C140 a_25783_1842# a_25891_1842# 0.01163f
C141 a_9823_1842# a_9693_1842# 0.70845f
C142 a_10583_1842# DELAY_OUT_TAP10 0.69646f
C143 a_20463_1842# a_20333_1842# 0.70845f
C144 a_11973_1842# DELAY_OUT_TAP12 0.0114f
C145 a_5263_1842# DELAY_OUT_TAP3 0.69646f
C146 DELAY_VBIASN a_17293_1842# 0.10601f
C147 DELAY_OUT_TAP19 a_17423_1842# 0.69646f
C148 DELAY_VBIASP a_21093_1842# 0.11222f
C149 DELAY_VBIASP a_7413_1842# 0.11222f
C150 a_18813_1842# a_18943_1842# 0.70845f
C151 a_5263_1842# VDD 0.49633f
C152 DELAY_VBIASN DELAY_OUT_TAP24 0.04353f
C153 VDD DELAY_OUT_TAP14 0.72899f
C154 DELAY_VBIASN a_14253_1842# 0.10601f
C155 a_17531_1842# a_17423_1842# 0.01163f
C156 a_14383_1842# a_14491_1842# 0.01163f
C157 a_18813_1842# DELAY_OUT_TAP21 0.0114f
C158 DELAY_VBIASP a_27303_1842# 0.06629f
C159 DELAY_OUT_TAP28 DELAY_VBIASN 0.04353f
C160 a_12733_1842# a_12863_1842# 0.70845f
C161 a_8411_2470# VDD 0.01806f
C162 DELAY_VBIASP a_26543_1842# 0.06627f
C163 DELAY_VBIASP a_18943_1842# 0.06627f
C164 DELAY_VBIASN a_24133_1842# 0.10601f
C165 a_20463_1842# DELAY_OUT_TAP23 0.69646f
C166 a_13623_1842# DELAY_OUT_TAP14 0.69646f
C167 a_8933_1842# DELAY_OUT_TAP7 0.70708f
C168 DELAY_VBIASP DELAY_OUT_TAP21 0.04137f
C169 DELAY_VBIASN a_15773_1842# 0.10601f
C170 a_20333_1842# DELAY_OUT_TAP23 0.0114f
C171 DELAY_VBIASN DELAY_OUT_TAP29 0.04353f
C172 DELAY_OUT_TAP16 a_15773_1842# 0.70708f
C173 DELAY_VBIASP a_9693_1842# 0.11222f
C174 DELAY_VBIASN a_26413_1842# 0.10601f
C175 DELAY_VBIASN a_22743_1842# 0.07258f
C176 DELAY_VBIASN a_8933_1842# 0.10601f
C177 DELAY_VBIASN a_6653_1842# 0.10601f
C178 DELAY_OUT_TAP18 VDD 0.72899f
C179 DELAY_OUT_TAP5 a_7413_1842# 0.70708f
C180 DELAY_OUT_TAP18 a_16663_1842# 0.69646f
C181 a_11213_1842# a_11343_1842# 0.70845f
C182 DELAY_OUT_LAST a_27737_1842# 0.70955f
C183 VDD a_6131_2470# 0.01806f
C184 a_4503_1842# VDD 0.49633f
C185 a_20571_2470# a_20463_1842# 0.01697f
C186 a_10453_1842# DELAY_VBIASP 0.11222f
C187 DELAY_VBIASN DELAY_OUT_TAP9 0.04353f
C188 a_10583_1842# a_10691_1842# 0.01163f
C189 DELAY_VBIASP a_24263_1842# 0.06627f
C190 DELAY_OUT_TAP31 a_26543_1842# 0.69646f
C191 DELAY_OUT_TAP28 a_24893_1842# 0.70708f
C192 VDD DELAY_OUT_TAP7 0.72899f
C193 DELAY_VBIASN DELAY_OUT_TAP3 0.04353f
C194 DELAY_VBIASP a_12863_1842# 0.06627f
C195 a_4611_2470# VDD 0.01806f
C196 a_16533_1842# VDD 0.4916f
C197 a_26651_2470# a_26543_1842# 0.01697f
C198 DELAY_VBIASP a_11973_1842# 0.11222f
C199 a_12733_1842# DELAY_OUT_TAP12 0.70708f
C200 a_15251_2470# a_15143_1842# 0.01697f
C201 a_16533_1842# a_16663_1842# 0.70845f
C202 a_19051_2470# a_18943_1842# 0.01697f
C203 DELAY_VBIASN DELAY_OUT_TAP20 0.04353f
C204 DELAY_VBIASN a_21983_1842# 0.07258f
C205 DELAY_VBIASN VDD 0.85759f
C206 a_24893_1842# DELAY_OUT_TAP29 0.0114f
C207 DELAY_OUT_TAP16 VDD 0.72899f
C208 DELAY_VBIASN a_16663_1842# 0.07258f
C209 a_12103_1842# a_12211_2470# 0.01697f
C210 VDD a_27173_1842# 0.4916f
C211 a_8173_1842# VDD 0.4916f
C212 a_11213_1842# DELAY_VBIASP 0.11222f
C213 DELAY_VBIASP a_20463_1842# 0.06627f
C214 DELAY_VBIASP a_6783_1842# 0.06627f
C215 VDD DELAY_OUT_TAP13 0.72899f
C216 DELAY_VBIASP a_20333_1842# 0.11222f
C217 a_11343_1842# a_11451_2470# 0.01697f
C218 a_10583_1842# VDD 0.49633f
C219 DELAY_VBIASN a_13623_1842# 0.07258f
C220 DELAY_VBIASN a_18053_1842# 0.10601f
C221 DELAY_OUT_TAP15 a_14253_1842# 0.0114f
C222 a_12971_1842# a_12863_1842# 0.01163f
C223 DELAY_VBIASP a_27737_1842# 0.04001f
C224 VDD a_19703_1842# 0.49633f
C225 a_21223_1842# a_21093_1842# 0.70845f
C226 DELAY_OUT_TAP27 DELAY_VBIASN 0.04353f
C227 a_11973_1842# a_12103_1842# 0.70845f
C228 a_26651_1842# a_26543_1842# 0.01163f
C229 a_25131_2470# a_25023_1842# 0.01697f
C230 a_15903_1842# a_15773_1842# 0.70845f
C231 a_6891_1842# a_6783_1842# 0.01163f
C232 a_5263_1842# a_5371_2470# 0.01697f
C233 DELAY_VBIASN a_23503_1842# 0.07258f
C234 a_24371_2470# a_24263_1842# 0.01697f
C235 DELAY_VBIASN DELAY_OUT_TAP6 0.04353f
C236 a_14491_2470# VDD 0.01806f
C237 DELAY_VBIASP DELAY_OUT_TAP2 0.04137f
C238 DELAY_VBIASP DELAY_OUT_TAP12 0.04137f
C239 a_7543_1842# a_7651_2470# 0.01697f
C240 a_15013_1842# a_15143_1842# 0.70845f
C241 a_24893_1842# VDD 0.4916f
C242 DELAY_VBIASP a_9063_1842# 0.06627f
C243 DELAY_VBIASN a_25783_1842# 0.07258f
C244 a_8173_1842# DELAY_OUT_TAP6 0.70708f
C245 VDD DELAY_OUT_TAP11 0.72899f
C246 DELAY_VBIASN a_19573_1842# 0.10601f
C247 a_9693_1842# DELAY_OUT_TAP8 0.70708f
C248 DELAY_VBIASP DELAY_OUT_TAP23 0.04137f
C249 a_6653_1842# DELAY_OUT_TAP4 0.70708f
C250 VDD a_13493_1842# 0.4916f
C251 a_22851_1842# a_22743_1842# 0.01163f
C252 a_12971_2470# a_12863_1842# 0.01697f
C253 a_4373_1842# DELAY_OUT_TAP2 0.0114f
C254 DELAY_VBIASP a_25653_1842# 0.11222f
C255 DELAY_VBIASN DELAY_OUT_TAP22 0.04353f
C256 DELAY_OUT_TAP5 a_6783_1842# 0.69646f
C257 VDD a_23373_1842# 0.4916f
C258 DELAY_VBIASP a_12733_1842# 0.11222f
C259 a_9823_1842# DELAY_VBIASP 0.06627f
C260 DELAY_VBIASP DELAY_OUT_LAST 0.21225f
C261 a_19811_2470# a_19703_1842# 0.01697f
C262 DELAY_OUT_TAP28 a_24133_1842# 0.0114f
C263 a_13623_1842# a_13493_1842# 0.70845f
C264 a_25653_1842# DELAY_OUT_TAP30 0.0114f
C265 a_19573_1842# a_19703_1842# 0.70845f
C266 a_3851_2470# VDD 0.01866f
C267 DELAY_VBIASP a_15143_1842# 0.06627f
C268 a_15903_1842# VDD 0.49633f
C269 DELAY_VBIASP a_11343_1842# 0.06627f
C270 a_12103_1842# DELAY_OUT_TAP12 0.69646f
C271 VDD DELAY_OUT_TAP10 0.72899f
C272 DELAY_OUT_TAP22 a_19703_1842# 0.69646f
C273 DELAY_VBIASN DELAY_OUT_TAP19 0.04353f
C274 DELAY_VBIASP a_15013_1842# 0.11222f
C275 VDD DELAY_OUT_TAP4 0.72899f
C276 DELAY_OUT_TAP26 DELAY_VBIASP 0.04137f
C277 DELAY_VBIASP a_8303_1842# 0.06627f
C278 DELAY_VBIASP a_6023_1842# 0.06627f
C279 a_16533_1842# DELAY_OUT_TAP17 0.70708f
C280 DELAY_OUT_TAP15 VDD 0.72899f
C281 DELAY_OUT_TAP27 a_23373_1842# 0.0114f
C282 a_15903_1842# a_16011_2470# 0.01697f
C283 a_9171_2470# a_9063_1842# 0.01697f
C284 a_21223_1842# a_21331_2470# 0.01697f
C285 a_7543_1842# VDD 0.49633f
C286 DELAY_VBIASN DELAY_OUT_TAP17 0.04353f
C287 a_23503_1842# a_23373_1842# 0.70845f
C288 DELAY_VBIASP a_18813_1842# 0.11222f
C289 VDD a_17293_1842# 0.4916f
C290 a_16771_2470# VDD 0.01806f
C291 VDD DELAY_OUT_TAP24 0.72899f
C292 a_16771_2470# a_16663_1842# 0.01697f
C293 DELAY_VBIASN a_21093_1842# 0.10601f
C294 DELAY_VBIASN a_7413_1842# 0.10601f
C295 VDD a_14253_1842# 0.4916f
C296 a_20463_1842# a_20571_1842# 0.01163f
C297 a_5893_1842# a_6023_1842# 0.70845f
C298 DELAY_OUT_TAP28 VDD 0.72899f
C299 a_5133_1842# DELAY_OUT_TAP2 0.70708f
C300 DELAY_IN DELAY_VBIASP 0.0738f
C301 DELAY_VBIASP a_21853_1842# 0.11222f
C302 DELAY_VBIASP DELAY_OUT_TAP1 0.04137f
C303 DELAY_VBIASN a_27303_1842# 0.07259f
C304 a_8411_1842# a_8303_1842# 0.01163f
C305 DELAY_VBIASP a_4373_1842# 0.11222f
C306 VDD a_24133_1842# 0.4916f
C307 DELAY_VBIASP DELAY_OUT_TAP30 0.04137f
C308 a_7543_1842# DELAY_OUT_TAP6 0.69646f
C309 VDD a_7651_2470# 0.01806f
C310 DELAY_VBIASN a_26543_1842# 0.07258f
C311 a_27303_1842# a_27173_1842# 0.70845f
C312 DELAY_IN DELAY_OUT_TAP1 0.01139f
C313 DELAY_VBIASN a_18943_1842# 0.07258f
C314 a_9063_1842# DELAY_OUT_TAP8 0.69646f
C315 DELAY_VBIASP a_3743_1842# 0.05992f
C316 VDD a_15773_1842# 0.4916f
C317 VDD DELAY_OUT_TAP29 0.72899f
C318 DELAY_VBIASP a_25023_1842# 0.06627f
C319 a_4373_1842# DELAY_OUT_TAP1 0.70708f
C320 DELAY_VBIASP a_17423_1842# 0.06627f
C321 DELAY_VBIASN DELAY_OUT_TAP21 0.04353f
C322 a_26413_1842# VDD 0.4916f
C323 a_6131_1842# a_6023_1842# 0.01163f
C324 DELAY_OUT_TAP26 a_22613_1842# 0.0114f
C325 DELAY_IN a_3743_1842# 0.53924f
C326 a_5893_1842# DELAY_VBIASP 0.11222f
C327 VDD a_22743_1842# 0.49633f
C328 a_8933_1842# VDD 0.4916f
C329 DELAY_VBIASN a_9693_1842# 0.10601f
C330 a_6653_1842# VDD 0.4916f
C331 DELAY_VBIASP a_12103_1842# 0.06627f
C332 a_3743_1842# DELAY_OUT_TAP1 0.69646f
C333 a_18291_2470# a_18183_1842# 0.01697f
C334 DELAY_VBIASP DELAY_OUT_TAP31 0.04137f
C335 a_9931_2470# VDD 0.01806f
C336 DELAY_OUT_TAP27 a_24133_1842# 0.70708f
C337 DELAY_VBIASP DELAY_OUT_TAP5 0.04137f
C338 VDD DELAY_OUT_TAP9 0.72899f
C339 DELAY_VBIASP a_14383_1842# 0.06627f
C340 DELAY_VBIASN a_10453_1842# 0.10601f
C341 DELAY_OUT_TAP25 DELAY_VBIASP 0.04137f
C342 a_15903_1842# DELAY_OUT_TAP17 0.69646f
C343 VDD DELAY_OUT_TAP3 0.72899f
C344 DELAY_VBIASN a_24263_1842# 0.07258f
C345 DELAY_VBIASP a_22613_1842# 0.11222f
C346 a_23611_2470# VDD 0.01806f
C347 DELAY_VBIASN a_12863_1842# 0.07258f
C348 VDD DELAY_OUT_TAP20 0.72899f
C349 DELAY_VBIASN a_11973_1842# 0.10601f
C350 a_21983_1842# VDD 0.49633f
C351 DELAY_OUT_TAP25 a_21853_1842# 0.0114f
C352 a_17293_1842# DELAY_OUT_TAP19 0.0114f
C353 DELAY_VBIASP a_18183_1842# 0.06627f
C354 VDD a_16663_1842# 0.49633f
C355 a_10583_1842# a_10453_1842# 0.70845f
C356 a_17531_2470# a_17423_1842# 0.01697f
C357 DELAY_OUT_TAP13 a_12863_1842# 0.69646f
C358 DELAY_VBIASP a_5133_1842# 0.11222f
C359 a_16011_2470# VDD 0.01806f
C360 DELAY_OUT_TAP20 a_18053_1842# 0.0114f
C361 a_11213_1842# DELAY_VBIASN 0.10601f
C362 DELAY_VBIASN a_20463_1842# 0.07258f
C363 VDD a_13623_1842# 0.49633f
C364 DELAY_VBIASN a_6783_1842# 0.07258f
C365 DELAY_VBIASP DELAY_OUT_TAP8 0.04137f
C366 VDD a_18053_1842# 0.4916f
C367 DELAY_VBIASN a_20333_1842# 0.10601f
C368 a_4503_1842# DELAY_OUT_TAP2 0.69646f
C369 DELAY_OUT_TAP27 VDD 0.72899f
C370 a_23611_2470# a_23503_1842# 0.01697f
C371 a_7543_1842# a_7413_1842# 0.70845f
C372 DELAY_VBIASP a_21223_1842# 0.06627f
C373 DELAY_VBIASN a_27737_1842# 0.04176f
C374 a_8411_2470# a_8303_1842# 0.01697f
C375 VDD a_23503_1842# 0.49633f
C376 VDD a_6891_2470# 0.01806f
C377 a_27737_1842# a_27173_1842# 0.0114f
C378 DELAY_OUT_TAP6 VDD 0.72899f
C379 a_19811_2470# VDD 0.01806f
C380 a_11973_1842# DELAY_OUT_TAP11 0.70708f
C381 a_13731_1842# a_13623_1842# 0.01163f
C382 DELAY_VBIASN DELAY_OUT_TAP2 0.04353f
C383 a_21093_1842# DELAY_OUT_TAP24 0.0114f
C384 a_25783_1842# VDD 0.49633f
C385 DELAY_VBIASN DELAY_OUT_TAP12 0.04353f
C386 a_21223_1842# a_21331_1842# 0.01163f
C387 DELAY_OUT_TAP25 a_22613_1842# 0.70708f
C388 VDD a_19573_1842# 0.4916f
C389 a_5263_1842# DELAY_VBIASP 0.06627f
C390 DELAY_OUT_TAP17 a_15773_1842# 0.0114f
C391 DELAY_VBIASP DELAY_OUT_TAP14 0.04137f
C392 DELAY_VBIASN a_9063_1842# 0.07258f
C393 VDD DELAY_OUT_TAP22 0.72899f
C394 DELAY_VBIASN DELAY_OUT_TAP23 0.04353f
C395 DELAY_OUT_TAP27 a_23503_1842# 0.69646f
C396 DELAY_VBIASN a_25653_1842# 0.10601f
C397 a_10453_1842# DELAY_OUT_TAP10 0.0114f
C398 a_11213_1842# DELAY_OUT_TAP11 0.0114f
C399 a_6023_1842# a_6131_2470# 0.01697f
C400 DELAY_VBIASN a_12733_1842# 0.10601f
C401 DELAY_VBIASN a_9823_1842# 0.07258f
C402 DELAY_VBIASN DELAY_OUT_LAST 0.04786f
C403 a_19051_1842# a_18943_1842# 0.01163f
C404 a_8303_1842# DELAY_OUT_TAP7 0.69646f
C405 a_4611_1842# a_4503_1842# 0.01163f
C406 DELAY_VBIASN a_15143_1842# 0.07258f
C407 DELAY_VBIASN a_11343_1842# 0.07258f
C408 VDD DELAY_OUT_TAP19 0.72899f
C409 DELAY_OUT_TAP16 a_15143_1842# 0.69646f
C410 a_15903_1842# a_16011_1842# 0.01163f
C411 a_12733_1842# DELAY_OUT_TAP13 0.0114f
C412 DELAY_VBIASN a_15013_1842# 0.10601f
C413 DELAY_OUT_TAP16 a_15013_1842# 0.0114f
C414 DELAY_VBIASP DELAY_OUT_TAP18 0.04137f
C415 DELAY_VBIASN a_8303_1842# 0.07258f
C416 DELAY_OUT_TAP26 DELAY_VBIASN 0.04353f
C417 DELAY_VBIASN a_6023_1842# 0.07258f
C418 a_25023_1842# a_25131_1842# 0.01163f
C419 a_26413_1842# a_26543_1842# 0.70845f
C420 DELAY_OUT_TAP17 VDD 0.72899f
C421 a_11213_1842# DELAY_OUT_TAP10 0.70708f
C422 DELAY_VBIASP a_4503_1842# 0.06627f
C423 a_8173_1842# a_8303_1842# 0.70845f
C424 DELAY_OUT_TAP19 a_18053_1842# 0.70708f
C425 VDD a_5371_2470# 0.01806f
C426 DELAY_VBIASN a_18813_1842# 0.10601f
C427 a_19573_1842# DELAY_OUT_TAP22 0.0114f
C428 DELAY_VBIASP DELAY_OUT_TAP7 0.04137f
C429 a_25891_2470# VDD 0.01806f
C430 DELAY_OUT_TAP28 a_24263_1842# 0.69646f
C431 a_16533_1842# DELAY_VBIASP 0.11222f
C432 a_16771_1842# a_16663_1842# 0.01163f
C433 a_4503_1842# a_4373_1842# 0.70845f
C434 a_23503_1842# a_23611_1842# 0.01163f
C435 VDD a_21093_1842# 0.4916f
C436 VDD a_7413_1842# 0.4916f
C437 a_24263_1842# a_24133_1842# 0.70845f
C438 DELAY_VBIASN DELAY_VBIASP 3.50557f
C439 DELAY_VBIASP DELAY_OUT_TAP16 0.04137f
C440 VDD a_27303_1842# 0.49714f
C441 a_22851_2470# a_22743_1842# 0.01697f
C442 DELAY_VBIASP a_27173_1842# 0.11222f
C443 a_8173_1842# DELAY_VBIASP 0.11222f
C444 DELAY_VBIASN DELAY_IN 0.06969f
C445 a_11343_1842# DELAY_OUT_TAP11 0.69646f
C446 a_9693_1842# DELAY_OUT_TAP9 0.0114f
C447 DELAY_VBIASN a_21853_1842# 0.10601f
C448 DELAY_VBIASN DELAY_OUT_TAP1 0.04353f
C449 a_5263_1842# a_5133_1842# 0.70845f
C450 DELAY_VBIASN a_4373_1842# 0.10601f
C451 VDD a_26543_1842# 0.49633f
C452 VDD a_18943_1842# 0.49633f
C453 DELAY_VBIASP DELAY_OUT_TAP13 0.04137f
C454 DELAY_VBIASN DELAY_OUT_TAP30 0.04353f
C455 a_10583_1842# DELAY_VBIASP 0.06627f
C456 VDD DELAY_OUT_TAP21 0.72899f
C457 DELAY_VBIASP a_19703_1842# 0.06627f
C458 DELAY_VBIASN a_3743_1842# 0.0649f
C459 DELAY_VBIASN a_25023_1842# 0.07258f
C460 DELAY_VBIASN a_17423_1842# 0.07258f
C461 a_7543_1842# a_7651_1842# 0.01163f
C462 a_9693_1842# VDD 0.4916f
C463 a_10453_1842# DELAY_OUT_TAP9 0.70708f
C464 DELAY_VBIASN a_5893_1842# 0.10601f
C465 DELAY_OUT_TAP26 a_23373_1842# 0.70708f
C466 a_25891_2470# a_25783_1842# 0.01697f
C467 DELAY_VBIASN a_12103_1842# 0.07258f
C468 DELAY_OUT_TAP6 a_7413_1842# 0.0114f
C469 DELAY_VBIASN DELAY_OUT_TAP31 0.04353f
C470 VDD a_12211_2470# 0.01806f
C471 a_18291_1842# a_18183_1842# 0.01163f
C472 a_22851_2470# VDD 0.01806f
C473 DELAY_VBIASN DELAY_OUT_TAP5 0.04353f
C474 DELAY_VBIASP a_24893_1842# 0.11222f
C475 DELAY_OUT_TAP31 a_27173_1842# 0.70708f
C476 a_24263_1842# a_24371_1842# 0.01163f
C477 DELAY_VBIASP DELAY_OUT_TAP11 0.04137f
C478 a_6653_1842# a_6783_1842# 0.70845f
C479 a_10453_1842# VDD 0.4916f
C480 a_24263_1842# VDD 0.49633f
C481 DELAY_VBIASP a_13493_1842# 0.11222f
C482 a_10583_1842# a_10691_2470# 0.01697f
C483 DELAY_VBIASN a_14383_1842# 0.07258f
C484 DELAY_OUT_TAP15 a_15013_1842# 0.70708f
C485 DELAY_OUT_TAP25 DELAY_VBIASN 0.04353f
C486 VDD a_12863_1842# 0.49633f
C487 a_6023_1842# DELAY_OUT_TAP4 0.69646f
C488 a_11973_1842# VDD 0.4916f
C489 DELAY_VBIASN a_22613_1842# 0.10601f
C490 DELAY_VBIASP a_23373_1842# 0.11222f
C491 a_21331_2470# VDD 0.01806f
C492 a_25023_1842# a_24893_1842# 0.70845f
C493 DELAY_VBIASN a_18183_1842# 0.07258f
C494 a_19573_1842# DELAY_OUT_TAP21 0.70708f
C495 a_25131_2470# VDD 0.01806f
C496 a_5263_1842# a_5371_1842# 0.01163f
C497 a_15903_1842# DELAY_VBIASP 0.06627f
C498 a_25653_1842# DELAY_OUT_TAP29 0.70708f
C499 DELAY_VBIASP DELAY_OUT_TAP10 0.04137f
C500 a_11213_1842# VDD 0.4916f
C501 a_8933_1842# a_9063_1842# 0.70845f
C502 VDD a_20463_1842# 0.49633f
C503 DELAY_VBIASN a_5133_1842# 0.10601f
C504 VDD a_6783_1842# 0.49633f
C505 a_27411_1842# a_27303_1842# 0.01163f
C506 DELAY_VBIASP DELAY_OUT_TAP4 0.04137f
C507 DELAY_VBIASP DELAY_OUT_TAP15 0.04137f
C508 VDD a_20333_1842# 0.4916f
C509 DELAY_VBIASN DELAY_OUT_TAP8 0.04353f
C510 a_21983_1842# a_22091_1842# 0.01163f
C511 VDD a_27737_1842# 0.75775f
C512 a_14491_2470# a_14383_1842# 0.01697f
C513 a_7543_1842# DELAY_VBIASP 0.06627f
C514 DELAY_VBIASN a_21223_1842# 0.07258f
C515 a_3851_2470# a_3743_1842# 0.01697f
C516 DELAY_VBIASP a_17293_1842# 0.11222f
C517 a_15251_2470# VDD 0.01806f
R0 DELAY_VBIASN.n1 DELAY_VBIASN.t31 34.3755
R1 DELAY_VBIASN.n1 DELAY_VBIASN.t30 33.0005
R2 DELAY_VBIASN.n2 DELAY_VBIASN.t29 33.0005
R3 DELAY_VBIASN.n3 DELAY_VBIASN.t28 33.0005
R4 DELAY_VBIASN.n4 DELAY_VBIASN.t27 33.0005
R5 DELAY_VBIASN.n5 DELAY_VBIASN.t26 33.0005
R6 DELAY_VBIASN.n6 DELAY_VBIASN.t25 33.0005
R7 DELAY_VBIASN.n7 DELAY_VBIASN.t24 33.0005
R8 DELAY_VBIASN.n8 DELAY_VBIASN.t23 33.0005
R9 DELAY_VBIASN.n9 DELAY_VBIASN.t22 33.0005
R10 DELAY_VBIASN.n10 DELAY_VBIASN.t21 33.0005
R11 DELAY_VBIASN.n11 DELAY_VBIASN.t20 33.0005
R12 DELAY_VBIASN.n12 DELAY_VBIASN.t19 33.0005
R13 DELAY_VBIASN.n13 DELAY_VBIASN.t18 33.0005
R14 DELAY_VBIASN.n14 DELAY_VBIASN.t17 33.0005
R15 DELAY_VBIASN.n15 DELAY_VBIASN.t16 33.0005
R16 DELAY_VBIASN.n16 DELAY_VBIASN.t15 33.0005
R17 DELAY_VBIASN.n17 DELAY_VBIASN.t14 33.0005
R18 DELAY_VBIASN.n18 DELAY_VBIASN.t13 33.0005
R19 DELAY_VBIASN.n19 DELAY_VBIASN.t12 33.0005
R20 DELAY_VBIASN.n20 DELAY_VBIASN.t11 33.0005
R21 DELAY_VBIASN.n21 DELAY_VBIASN.t10 33.0005
R22 DELAY_VBIASN.n22 DELAY_VBIASN.t9 33.0005
R23 DELAY_VBIASN.n23 DELAY_VBIASN.t8 33.0005
R24 DELAY_VBIASN.n24 DELAY_VBIASN.t7 33.0005
R25 DELAY_VBIASN.n25 DELAY_VBIASN.t6 33.0005
R26 DELAY_VBIASN.n26 DELAY_VBIASN.t5 33.0005
R27 DELAY_VBIASN.n27 DELAY_VBIASN.t4 33.0005
R28 DELAY_VBIASN.n28 DELAY_VBIASN.t3 33.0005
R29 DELAY_VBIASN.n29 DELAY_VBIASN.t2 33.0005
R30 DELAY_VBIASN.n30 DELAY_VBIASN.t1 33.0005
R31 DELAY_VBIASN.n0 DELAY_VBIASN.t0 33.0005
R32 DELAY_VBIASN DELAY_VBIASN.n0 1.55517
R33 DELAY_VBIASN.n0 DELAY_VBIASN.n30 1.3755
R34 DELAY_VBIASN.n30 DELAY_VBIASN.n29 1.3755
R35 DELAY_VBIASN.n29 DELAY_VBIASN.n28 1.3755
R36 DELAY_VBIASN.n28 DELAY_VBIASN.n27 1.3755
R37 DELAY_VBIASN.n27 DELAY_VBIASN.n26 1.3755
R38 DELAY_VBIASN.n26 DELAY_VBIASN.n25 1.3755
R39 DELAY_VBIASN.n25 DELAY_VBIASN.n24 1.3755
R40 DELAY_VBIASN.n24 DELAY_VBIASN.n23 1.3755
R41 DELAY_VBIASN.n23 DELAY_VBIASN.n22 1.3755
R42 DELAY_VBIASN.n22 DELAY_VBIASN.n21 1.3755
R43 DELAY_VBIASN.n21 DELAY_VBIASN.n20 1.3755
R44 DELAY_VBIASN.n20 DELAY_VBIASN.n19 1.3755
R45 DELAY_VBIASN.n19 DELAY_VBIASN.n18 1.3755
R46 DELAY_VBIASN.n18 DELAY_VBIASN.n17 1.3755
R47 DELAY_VBIASN.n17 DELAY_VBIASN.n16 1.3755
R48 DELAY_VBIASN.n16 DELAY_VBIASN.n15 1.3755
R49 DELAY_VBIASN.n15 DELAY_VBIASN.n14 1.3755
R50 DELAY_VBIASN.n14 DELAY_VBIASN.n13 1.3755
R51 DELAY_VBIASN.n13 DELAY_VBIASN.n12 1.3755
R52 DELAY_VBIASN.n12 DELAY_VBIASN.n11 1.3755
R53 DELAY_VBIASN.n11 DELAY_VBIASN.n10 1.3755
R54 DELAY_VBIASN.n10 DELAY_VBIASN.n9 1.3755
R55 DELAY_VBIASN.n9 DELAY_VBIASN.n8 1.3755
R56 DELAY_VBIASN.n8 DELAY_VBIASN.n7 1.3755
R57 DELAY_VBIASN.n7 DELAY_VBIASN.n6 1.3755
R58 DELAY_VBIASN.n6 DELAY_VBIASN.n5 1.3755
R59 DELAY_VBIASN.n5 DELAY_VBIASN.n4 1.3755
R60 DELAY_VBIASN.n4 DELAY_VBIASN.n3 1.3755
R61 DELAY_VBIASN.n3 DELAY_VBIASN.n2 1.3755
R62 DELAY_VBIASN.n2 DELAY_VBIASN.n1 1.3755
R63 DELAY_VBIASP.n1 DELAY_VBIASP.t31 34.3685
R64 DELAY_VBIASP.n1 DELAY_VBIASP.t30 33.0005
R65 DELAY_VBIASP.n2 DELAY_VBIASP.t29 33.0005
R66 DELAY_VBIASP.n3 DELAY_VBIASP.t28 33.0005
R67 DELAY_VBIASP.n4 DELAY_VBIASP.t27 33.0005
R68 DELAY_VBIASP.n5 DELAY_VBIASP.t26 33.0005
R69 DELAY_VBIASP.n6 DELAY_VBIASP.t25 33.0005
R70 DELAY_VBIASP.n7 DELAY_VBIASP.t24 33.0005
R71 DELAY_VBIASP.n8 DELAY_VBIASP.t23 33.0005
R72 DELAY_VBIASP.n9 DELAY_VBIASP.t22 33.0005
R73 DELAY_VBIASP.n10 DELAY_VBIASP.t21 33.0005
R74 DELAY_VBIASP.n11 DELAY_VBIASP.t20 33.0005
R75 DELAY_VBIASP.n12 DELAY_VBIASP.t19 33.0005
R76 DELAY_VBIASP.n13 DELAY_VBIASP.t18 33.0005
R77 DELAY_VBIASP.n14 DELAY_VBIASP.t17 33.0005
R78 DELAY_VBIASP.n15 DELAY_VBIASP.t16 33.0005
R79 DELAY_VBIASP.n16 DELAY_VBIASP.t15 33.0005
R80 DELAY_VBIASP.n17 DELAY_VBIASP.t14 33.0005
R81 DELAY_VBIASP.n18 DELAY_VBIASP.t13 33.0005
R82 DELAY_VBIASP.n19 DELAY_VBIASP.t12 33.0005
R83 DELAY_VBIASP.n20 DELAY_VBIASP.t11 33.0005
R84 DELAY_VBIASP.n21 DELAY_VBIASP.t10 33.0005
R85 DELAY_VBIASP.n22 DELAY_VBIASP.t9 33.0005
R86 DELAY_VBIASP.n23 DELAY_VBIASP.t8 33.0005
R87 DELAY_VBIASP.n24 DELAY_VBIASP.t7 33.0005
R88 DELAY_VBIASP.n25 DELAY_VBIASP.t6 33.0005
R89 DELAY_VBIASP.n26 DELAY_VBIASP.t5 33.0005
R90 DELAY_VBIASP.n27 DELAY_VBIASP.t4 33.0005
R91 DELAY_VBIASP.n28 DELAY_VBIASP.t3 33.0005
R92 DELAY_VBIASP.n29 DELAY_VBIASP.t2 33.0005
R93 DELAY_VBIASP.n30 DELAY_VBIASP.t1 33.0005
R94 DELAY_VBIASP.n0 DELAY_VBIASP.t0 33.0005
R95 DELAY_VBIASP DELAY_VBIASP.n0 1.70586
R96 DELAY_VBIASP.n0 DELAY_VBIASP.n30 1.36852
R97 DELAY_VBIASP.n30 DELAY_VBIASP.n29 1.36852
R98 DELAY_VBIASP.n29 DELAY_VBIASP.n28 1.36852
R99 DELAY_VBIASP.n28 DELAY_VBIASP.n27 1.36852
R100 DELAY_VBIASP.n27 DELAY_VBIASP.n26 1.36852
R101 DELAY_VBIASP.n26 DELAY_VBIASP.n25 1.36852
R102 DELAY_VBIASP.n25 DELAY_VBIASP.n24 1.36852
R103 DELAY_VBIASP.n24 DELAY_VBIASP.n23 1.36852
R104 DELAY_VBIASP.n23 DELAY_VBIASP.n22 1.36852
R105 DELAY_VBIASP.n22 DELAY_VBIASP.n21 1.36852
R106 DELAY_VBIASP.n21 DELAY_VBIASP.n20 1.36852
R107 DELAY_VBIASP.n20 DELAY_VBIASP.n19 1.36852
R108 DELAY_VBIASP.n19 DELAY_VBIASP.n18 1.36852
R109 DELAY_VBIASP.n18 DELAY_VBIASP.n17 1.36852
R110 DELAY_VBIASP.n17 DELAY_VBIASP.n16 1.36852
R111 DELAY_VBIASP.n16 DELAY_VBIASP.n15 1.36852
R112 DELAY_VBIASP.n15 DELAY_VBIASP.n14 1.36852
R113 DELAY_VBIASP.n14 DELAY_VBIASP.n13 1.36852
R114 DELAY_VBIASP.n13 DELAY_VBIASP.n12 1.36852
R115 DELAY_VBIASP.n12 DELAY_VBIASP.n11 1.36852
R116 DELAY_VBIASP.n11 DELAY_VBIASP.n10 1.36852
R117 DELAY_VBIASP.n10 DELAY_VBIASP.n9 1.36852
R118 DELAY_VBIASP.n9 DELAY_VBIASP.n8 1.36852
R119 DELAY_VBIASP.n8 DELAY_VBIASP.n7 1.36852
R120 DELAY_VBIASP.n7 DELAY_VBIASP.n6 1.36852
R121 DELAY_VBIASP.n6 DELAY_VBIASP.n5 1.36852
R122 DELAY_VBIASP.n5 DELAY_VBIASP.n4 1.36852
R123 DELAY_VBIASP.n4 DELAY_VBIASP.n3 1.36852
R124 DELAY_VBIASP.n3 DELAY_VBIASP.n2 1.36852
R125 DELAY_VBIASP.n2 DELAY_VBIASP.n1 1.36852
R126 VDD.t0 VDD.t83 15.1333
R127 VDD.t0 VDD.t86 15.0005
R128 VDD.n30 VDD.t78 15.0005
R129 VDD.n31 VDD 1.59504
R130 VDD.t0 VDD.t9 6.09923
R131 VDD.t0 VDD.t49 6.09923
R132 VDD.t0 VDD.t4 6.09923
R133 VDD.t0 VDD.t2 6.09923
R134 VDD.t0 VDD.t7 6.09923
R135 VDD.t0 VDD.t10 6.09923
R136 VDD.n29 VDD.t58 6.09923
R137 VDD.n53 VDD.t57 6.09923
R138 VDD.n23 VDD.t55 6.09923
R139 VDD.n45 VDD.t1 6.09923
R140 VDD.n37 VDD.t60 6.09923
R141 VDD.t0 VDD.t5 6.09923
R142 VDD.t0 VDD.t47 6.09923
R143 VDD.t0 VDD.t3 6.09923
R144 VDD.n39 VDD.t8 6.09923
R145 VDD.n21 VDD.t14 6.09923
R146 VDD.n41 VDD.t48 6.09923
R147 VDD.n25 VDD.t91 6.09923
R148 VDD.n47 VDD.t51 6.09923
R149 VDD.n43 VDD.t11 6.09923
R150 VDD.t0 VDD.t61 6.09923
R151 VDD.n49 VDD.t64 6.09923
R152 VDD.n19 VDD.t63 6.09923
R153 VDD.n35 VDD.t62 6.09923
R154 VDD.n27 VDD.t74 6.09923
R155 VDD.n51 VDD.t72 6.09923
R156 VDD.n17 VDD.t70 6.09923
R157 VDD.n17 VDD.t6 6.09923
R158 VDD.t0 VDD.t95 6.09923
R159 VDD.t0 VDD.t71 6.09923
R160 VDD.n33 VDD.t99 6.09923
R161 VDD.t0 VDD.t12 6.09923
R162 VDD.t0 VDD.n23 0.609161
R163 VDD.t0 VDD.n37 0.470722
R164 VDD.n13 VDD.n21 0.111389
R165 VDD.t0 VDD.n25 0.609174
R166 VDD.t0 VDD.n27 0.609184
R167 VDD.t0 VDD.n17 0.581199
R168 VDD.n30 VDD.t79 5.60969
R169 VDD.t0 VDD.t88 5.60347
R170 VDD.n7 VDD.t24 5.59675
R171 VDD.n4 VDD.t28 5.59675
R172 VDD.n9 VDD.t23 5.59675
R173 VDD.n8 VDD.t26 5.59675
R174 VDD.n5 VDD.t29 5.59675
R175 VDD.n10 VDD.t30 5.59675
R176 VDD.n28 VDD.t31 5.59675
R177 VDD.n52 VDD.t32 5.59675
R178 VDD.n22 VDD.t25 5.59675
R179 VDD.n44 VDD.t33 5.59675
R180 VDD.n36 VDD.t19 5.59675
R181 VDD.n6 VDD.t15 5.59675
R182 VDD.n11 VDD.t20 5.59675
R183 VDD.n3 VDD.t34 5.59675
R184 VDD.n38 VDD.t36 5.59675
R185 VDD.n20 VDD.t35 5.59675
R186 VDD.n40 VDD.t37 5.59675
R187 VDD.n24 VDD.t21 5.59675
R188 VDD.n46 VDD.t22 5.59675
R189 VDD.n42 VDD.t38 5.59675
R190 VDD.n2 VDD.t17 5.59675
R191 VDD.n48 VDD.t41 5.59675
R192 VDD.n18 VDD.t42 5.59675
R193 VDD.n34 VDD.t40 5.59675
R194 VDD.n26 VDD.t39 5.59675
R195 VDD.n50 VDD.t27 5.59675
R196 VDD.n16 VDD.t43 5.59675
R197 VDD.n15 VDD.t18 5.59675
R198 VDD.n0 VDD.t44 5.59675
R199 VDD.n1 VDD.t16 5.59675
R200 VDD.n32 VDD.t45 5.59675
R201 VDD.n31 VDD.n30 0.71648
R202 VDD VDD.n31 1.59504
R203 VDD.n30 VDD.n112 0.313477
R204 VDD.n53 VDD.n23 0.4099
R205 VDD.n35 VDD.n27 0.409347
R206 VDD.n39 VDD.n13 0.225376
R207 VDD.n41 VDD.n25 0.409438
R208 VDD.n12 VDD.n19 0.11148
R209 VDD.n45 VDD.n37 0.409614
R210 VDD.n47 VDD.n43 0.409614
R211 VDD.t0 VDD.n67 1.55402
R212 VDD.t0 VDD.n78 1.55387
R213 VDD.t0 VDD.n57 1.55371
R214 VDD.t0 VDD.n74 1.55371
R215 VDD.t0 VDD.n81 1.55369
R216 VDD.t0 VDD.n76 1.55365
R217 VDD.t0 VDD.n64 1.55361
R218 VDD.t0 VDD.n68 1.55361
R219 VDD.t0 VDD.n77 1.55361
R220 VDD.t0 VDD.n80 1.55353
R221 VDD.t0 VDD.n55 1.5535
R222 VDD.t0 VDD.n66 1.5535
R223 VDD.t0 VDD.n71 1.5535
R224 VDD.t0 VDD.n61 1.5535
R225 VDD.t0 VDD.n72 1.5535
R226 VDD.t0 VDD.n73 1.5535
R227 VDD.t0 VDD.n79 1.5535
R228 VDD.t0 VDD.n70 1.55344
R229 VDD.t0 VDD.n82 1.55344
R230 VDD.t0 VDD.n54 1.55342
R231 VDD.t0 VDD.n62 1.55341
R232 VDD.t0 VDD.n75 1.55334
R233 VDD.t0 VDD.n63 1.55334
R234 VDD.t0 VDD.n60 1.55333
R235 VDD.t0 VDD.n56 1.55327
R236 VDD.t0 VDD.n58 1.55327
R237 VDD.t0 VDD.n59 1.55327
R238 VDD.t0 VDD.n65 1.55327
R239 VDD.t0 VDD.n69 1.55325
R240 VDD.n30 VDD.t80 6.01456
R241 VDD.n7 VDD.n112 0.495398
R242 VDD.n4 VDD.n111 0.495398
R243 VDD.n9 VDD.n110 0.495398
R244 VDD.n8 VDD.n109 0.495398
R245 VDD.n5 VDD.n108 0.495398
R246 VDD.n10 VDD.n107 0.495398
R247 VDD.n28 VDD.n106 0.495398
R248 VDD.n52 VDD.n105 0.495398
R249 VDD.n22 VDD.n104 0.495398
R250 VDD.n44 VDD.n103 0.495398
R251 VDD.n36 VDD.n102 0.495398
R252 VDD.n6 VDD.n101 0.495398
R253 VDD.n11 VDD.n100 0.495398
R254 VDD.n3 VDD.n99 0.495398
R255 VDD.n38 VDD.n98 0.495398
R256 VDD.n20 VDD.n97 0.495398
R257 VDD.n40 VDD.n96 0.495398
R258 VDD.n24 VDD.n95 0.495398
R259 VDD.n46 VDD.n94 0.495398
R260 VDD.n42 VDD.n93 0.495398
R261 VDD.n2 VDD.n92 0.495398
R262 VDD.n48 VDD.n91 0.495398
R263 VDD.n18 VDD.n90 0.495398
R264 VDD.n34 VDD.n89 0.495398
R265 VDD.n26 VDD.n88 0.495398
R266 VDD.n50 VDD.n87 0.495398
R267 VDD.n16 VDD.n86 0.495398
R268 VDD.n15 VDD.n85 0.495398
R269 VDD.n0 VDD.n84 0.495398
R270 VDD.n1 VDD.n83 0.495398
R271 VDD.n32 VDD.n14 0.626363
R272 VDD.t0 VDD.n7 0.478641
R273 VDD.t0 VDD.n4 0.478641
R274 VDD.t0 VDD.n9 0.478641
R275 VDD.t0 VDD.n8 0.478641
R276 VDD.t0 VDD.n5 0.478641
R277 VDD.t0 VDD.n10 0.478641
R278 VDD.n29 VDD.n28 0.478641
R279 VDD.n53 VDD.n52 0.478641
R280 VDD.n23 VDD.n22 0.478641
R281 VDD.n45 VDD.n44 0.478641
R282 VDD.n37 VDD.n36 0.478641
R283 VDD.t0 VDD.n6 0.478641
R284 VDD.t0 VDD.n11 0.478641
R285 VDD.t0 VDD.n3 0.478641
R286 VDD.n39 VDD.n38 0.478641
R287 VDD.n21 VDD.n20 0.478641
R288 VDD.n41 VDD.n40 0.478641
R289 VDD.n25 VDD.n24 0.478641
R290 VDD.n47 VDD.n46 0.478641
R291 VDD.n43 VDD.n42 0.478641
R292 VDD.t0 VDD.n2 0.478641
R293 VDD.n49 VDD.n48 0.478641
R294 VDD.n19 VDD.n18 0.478641
R295 VDD.n35 VDD.n34 0.478641
R296 VDD.n27 VDD.n26 0.478641
R297 VDD.n51 VDD.n50 0.478641
R298 VDD.n17 VDD.n16 0.478641
R299 VDD.n17 VDD.n15 0.478641
R300 VDD.t0 VDD.n0 0.478641
R301 VDD.t0 VDD.n1 0.478641
R302 VDD.n33 VDD.n32 0.478641
R303 VDD.t0 VDD.t46 5.75932
R304 VDD.t0 VDD.t84 6.19118
R305 VDD.n99 VDD.n67 0.467635
R306 VDD.n88 VDD.n78 0.467485
R307 VDD.n109 VDD.n57 0.467258
R308 VDD.n92 VDD.n74 0.467258
R309 VDD.n102 VDD.n64 0.467143
R310 VDD.n98 VDD.n68 0.467143
R311 VDD.n89 VDD.n77 0.467143
R312 VDD.n85 VDD.n81 0.467052
R313 VDD.n86 VDD.n80 0.466916
R314 VDD.n104 VDD.n62 0.466909
R315 VDD.n111 VDD.n55 0.466867
R316 VDD.n84 VDD.n82 0.466798
R317 VDD.n103 VDD.n63 0.466741
R318 VDD.n90 VDD.n76 0.466709
R319 VDD.n91 VDD.n75 0.466699
R320 VDD.n95 VDD.n71 0.466677
R321 VDD.n100 VDD.n66 0.466677
R322 VDD.n97 VDD.n69 0.466592
R323 VDD.n106 VDD.n60 0.466589
R324 VDD.n101 VDD.n65 0.466464
R325 VDD.n110 VDD.n56 0.466439
R326 VDD.n108 VDD.n58 0.466439
R327 VDD.n107 VDD.n59 0.466439
R328 VDD.n105 VDD.n61 0.466426
R329 VDD.n94 VDD.n72 0.466426
R330 VDD.n93 VDD.n73 0.466426
R331 VDD.n112 VDD.n54 0.466273
R332 VDD.n87 VDD.n79 0.466226
R333 VDD.n96 VDD.n70 0.466129
R334 VDD.n83 VDD.n14 0.715183
R335 VDD.n95 VDD.n70 0.451798
R336 VDD.n86 VDD.n79 0.451677
R337 VDD.n111 VDD.n54 0.451619
R338 VDD.n104 VDD.n61 0.451477
R339 VDD.n92 VDD.n73 0.451477
R340 VDD.n93 VDD.n72 0.451477
R341 VDD.n109 VDD.n56 0.451469
R342 VDD.n107 VDD.n58 0.451469
R343 VDD.n106 VDD.n59 0.451469
R344 VDD.n100 VDD.n65 0.451456
R345 VDD.n105 VDD.n60 0.451368
R346 VDD.n96 VDD.n69 0.451294
R347 VDD.n90 VDD.n75 0.451252
R348 VDD.n99 VDD.n66 0.451226
R349 VDD.n94 VDD.n71 0.451226
R350 VDD.n102 VDD.n63 0.451193
R351 VDD.n89 VDD.n76 0.451182
R352 VDD.n83 VDD.n82 0.451129
R353 VDD.n110 VDD.n55 0.451074
R354 VDD.n103 VDD.n62 0.451022
R355 VDD.n85 VDD.n80 0.451012
R356 VDD.n84 VDD.n81 0.450861
R357 VDD.n101 VDD.n64 0.450828
R358 VDD.n97 VDD.n68 0.450828
R359 VDD.n88 VDD.n77 0.450828
R360 VDD.n108 VDD.n57 0.450729
R361 VDD.n91 VDD.n74 0.450729
R362 VDD.n87 VDD.n78 0.450539
R363 VDD.n98 VDD.n67 0.450381
R364 VDD.t82 VDD.n30 5.71158
R365 VDD.t0 VDD.t85 5.77017
R366 VDD.n30 VDD.t81 15.0661
R367 VDD.t0 VDD.n43 1.40663
R368 VDD.n51 VDD.n17 1.33792
R369 VDD.t0 VDD.n12 1.32168
R370 VDD.t0 VDD.n13 1.31611
R371 VDD.n14 VDD.t0 1.25835
R372 VDD.t0 VDD.n33 0.521456
R373 VDD.n19 VDD.n35 1.2377
R374 VDD.n21 VDD.n41 1.23757
R375 VDD.n25 VDD.n47 1.23755
R376 VDD.n23 VDD.n45 1.23753
R377 VDD.n27 VDD.n51 1.2374
R378 VDD.n29 VDD.n53 1.23739
R379 VDD.n12 VDD.n49 0.225502
R380 VDD.t0 VDD.n30 1.03493
R381 VDD.t0 VDD.n29 1.01828
R382 VSS.n238 VSS.t130 108.746
R383 VSS.n236 VSS.t131 108.746
R384 VSS.t129 VSS.n5 108.746
R385 VSS.n234 VSS.t128 108.746
R386 VSS.t125 VSS.n11 108.746
R387 VSS.n231 VSS.t133 108.746
R388 VSS.t134 VSS.n15 108.746
R389 VSS.t127 VSS.n17 108.746
R390 VSS.n227 VSS.t123 108.746
R391 VSS.t139 VSS.n20 108.746
R392 VSS.n225 VSS.t126 108.746
R393 VSS.n221 VSS.t135 108.746
R394 VSS.n217 VSS.t136 108.746
R395 VSS.t124 VSS.n29 108.746
R396 VSS.n215 VSS.t145 108.746
R397 VSS.n214 VSS.t144 108.746
R398 VSS.t141 VSS.n34 108.746
R399 VSS.n209 VSS.t147 108.746
R400 VSS.t149 VSS.n40 108.746
R401 VSS.t143 VSS.n42 108.746
R402 VSS.t152 VSS.n44 108.746
R403 VSS.t153 VSS.n47 108.746
R404 VSS.t142 VSS.n49 108.746
R405 VSS.t154 VSS.n51 108.746
R406 VSS.n199 VSS.t155 108.746
R407 VSS.n197 VSS.t150 108.746
R408 VSS.n233 VSS.t132 108.746
R409 VSS.n223 VSS.t138 108.746
R410 VSS.n219 VSS.t137 108.746
R411 VSS.n211 VSS.t140 108.746
R412 VSS.n207 VSS.t148 108.746
R413 VSS.n205 VSS.t146 108.746
R414 VSS.n240 VSS.t42 106.056
R415 VSS.n235 VSS.t167 106.056
R416 VSS.n232 VSS.t0 106.056
R417 VSS.n220 VSS.t33 106.056
R418 VSS.n218 VSS.t39 106.056
R419 VSS.n210 VSS.t170 106.056
R420 VSS.n208 VSS.t87 106.056
R421 VSS.n206 VSS.t84 106.056
R422 VSS.n202 VSS.t157 106.056
R423 VSS.n200 VSS.t160 106.056
R424 VSS.n237 VSS.t18 106.056
R425 VSS.t57 VSS.n7 106.056
R426 VSS.t56 VSS.n9 106.056
R427 VSS.t53 VSS.n13 106.056
R428 VSS.n230 VSS.t52 106.056
R429 VSS.n229 VSS.t51 106.056
R430 VSS.n228 VSS.t54 106.056
R431 VSS.n226 VSS.t12 106.056
R432 VSS.t107 VSS.n22 106.056
R433 VSS.n224 VSS.t63 106.056
R434 VSS.n222 VSS.t5 106.056
R435 VSS.t19 VSS.n28 106.056
R436 VSS.n216 VSS.t81 106.056
R437 VSS.t173 VSS.n32 106.056
R438 VSS.n213 VSS.t168 106.056
R439 VSS.n212 VSS.t34 106.056
R440 VSS.n204 VSS.t156 106.056
R441 VSS.n203 VSS.t117 106.056
R442 VSS.t165 VSS.n46 106.056
R443 VSS.n201 VSS.t17 106.056
R444 VSS.t169 VSS.n53 106.056
R445 VSS.n198 VSS.t164 106.056
R446 VSS.t70 VSS.t67 99.7537
R447 VSS.t22 VSS.n76 94.1709
R448 VSS.t40 VSS.n80 94.1709
R449 VSS.n83 VSS.t8 94.1709
R450 VSS.n87 VSS.t3 94.1709
R451 VSS.t15 VSS.n91 94.1709
R452 VSS.n95 VSS.t24 94.1709
R453 VSS.t94 VSS.n99 94.1709
R454 VSS.t93 VSS.n103 94.1709
R455 VSS.t92 VSS.n106 94.1709
R456 VSS.t91 VSS.n110 94.1709
R457 VSS.n113 VSS.t90 94.1709
R458 VSS.t10 VSS.n117 94.1709
R459 VSS.t35 VSS.n121 94.1709
R460 VSS.t118 VSS.n125 94.1709
R461 VSS.t113 VSS.n128 94.1709
R462 VSS.n132 VSS.t119 94.1709
R463 VSS.t112 VSS.n135 94.1709
R464 VSS.n138 VSS.t110 94.1709
R465 VSS.t109 VSS.n141 94.1709
R466 VSS.t108 VSS.n145 94.1709
R467 VSS.t106 VSS.n149 94.1709
R468 VSS.t114 VSS.n153 94.1709
R469 VSS.t101 VSS.n156 94.1709
R470 VSS.t104 VSS.n160 94.1709
R471 VSS.t102 VSS.n164 94.1709
R472 VSS.t99 VSS.n168 94.1709
R473 VSS.n172 VSS.t95 94.1709
R474 VSS.t120 VSS.n176 94.1709
R475 VSS.t115 VSS.n180 94.1709
R476 VSS.n184 VSS.t97 94.1709
R477 VSS.t121 VSS.n187 94.1709
R478 VSS.t166 VSS.n189 94.1709
R479 VSS.n233 VSS.t30 67.0429
R480 VSS.n223 VSS.t105 67.0429
R481 VSS.n219 VSS.t20 67.0429
R482 VSS.n211 VSS.t79 67.0429
R483 VSS.n207 VSS.t85 67.0429
R484 VSS.n205 VSS.t82 67.0429
R485 VSS.n238 VSS.t46 67.0426
R486 VSS.n236 VSS.t43 67.0426
R487 VSS.t48 VSS.n5 67.0426
R488 VSS.n234 VSS.t47 67.0426
R489 VSS.t62 VSS.n11 67.0426
R490 VSS.n231 VSS.t60 67.0426
R491 VSS.t58 VSS.n15 67.0426
R492 VSS.t49 VSS.n17 67.0426
R493 VSS.n227 VSS.t1 67.0426
R494 VSS.t64 VSS.n20 67.0426
R495 VSS.n225 VSS.t55 67.0426
R496 VSS.n221 VSS.t6 67.0426
R497 VSS.n217 VSS.t31 67.0426
R498 VSS.t37 VSS.n29 67.0426
R499 VSS.n215 VSS.t171 67.0426
R500 VSS.n214 VSS.t44 67.0426
R501 VSS.t26 VSS.n34 67.0426
R502 VSS.n209 VSS.t88 67.0426
R503 VSS.t172 VSS.n40 67.0426
R504 VSS.t161 VSS.n42 67.0426
R505 VSS.t163 VSS.n44 67.0426
R506 VSS.t13 VSS.n47 67.0426
R507 VSS.t159 VSS.n49 67.0426
R508 VSS.t162 VSS.n51 67.0426
R509 VSS.n199 VSS.t158 67.0426
R510 VSS.n197 VSS.t28 67.0426
R511 VSS.t78 VSS.n59 62.4463
R512 VSS.t74 VSS.n59 59.7564
R513 VSS.n190 VSS.t74 57.6669
R514 VSS.t46 VSS.n76 43.0498
R515 VSS.t43 VSS.n80 43.0498
R516 VSS.n83 VSS.t48 43.0498
R517 VSS.t47 VSS.n87 43.0498
R518 VSS.t30 VSS.n91 43.0498
R519 VSS.n95 VSS.t62 43.0498
R520 VSS.t60 VSS.n99 43.0498
R521 VSS.n103 VSS.t58 43.0498
R522 VSS.n106 VSS.t49 43.0498
R523 VSS.t1 VSS.n110 43.0498
R524 VSS.n113 VSS.t64 43.0498
R525 VSS.t55 VSS.n117 43.0498
R526 VSS.t105 VSS.n121 43.0498
R527 VSS.t6 VSS.n125 43.0498
R528 VSS.t20 VSS.n128 43.0498
R529 VSS.t31 VSS.n132 43.0498
R530 VSS.n135 VSS.t37 43.0498
R531 VSS.t171 VSS.n138 43.0498
R532 VSS.t44 VSS.n141 43.0498
R533 VSS.n145 VSS.t26 43.0498
R534 VSS.t79 VSS.n149 43.0498
R535 VSS.t88 VSS.n153 43.0498
R536 VSS.t85 VSS.n156 43.0498
R537 VSS.t82 VSS.n160 43.0498
R538 VSS.n164 VSS.t172 43.0498
R539 VSS.n168 VSS.t161 43.0498
R540 VSS.n172 VSS.t163 43.0498
R541 VSS.n176 VSS.t13 43.0498
R542 VSS.n180 VSS.t159 43.0498
R543 VSS.n184 VSS.t162 43.0498
R544 VSS.t158 VSS.n187 43.0498
R545 VSS.t28 VSS.n189 43.0498
R546 VSS.n246 VSS.n70 17.0005
R547 VSS.n246 VSS.n1 17.0005
R548 VSS.n246 VSS.n239 17.0005
R549 VSS.n190 VSS.t166 15.9618
R550 VSS.n237 VSS.t22 15.9213
R551 VSS.t8 VSS.n7 15.9213
R552 VSS.t3 VSS.n9 15.9213
R553 VSS.t24 VSS.n13 15.9213
R554 VSS.n230 VSS.t94 15.9213
R555 VSS.n229 VSS.t93 15.9213
R556 VSS.n228 VSS.t92 15.9213
R557 VSS.n226 VSS.t91 15.9213
R558 VSS.t90 VSS.n22 15.9213
R559 VSS.n224 VSS.t10 15.9213
R560 VSS.n222 VSS.t35 15.9213
R561 VSS.t119 VSS.n28 15.9213
R562 VSS.n216 VSS.t112 15.9213
R563 VSS.t110 VSS.n32 15.9213
R564 VSS.n213 VSS.t109 15.9213
R565 VSS.n212 VSS.t108 15.9213
R566 VSS.n204 VSS.t104 15.9213
R567 VSS.n203 VSS.t102 15.9213
R568 VSS.t95 VSS.n46 15.9213
R569 VSS.n201 VSS.t120 15.9213
R570 VSS.t97 VSS.n53 15.9213
R571 VSS.n198 VSS.t121 15.9213
R572 VSS.n235 VSS.t40 15.9203
R573 VSS.n232 VSS.t15 15.9203
R574 VSS.n220 VSS.t118 15.9203
R575 VSS.n218 VSS.t113 15.9203
R576 VSS.n210 VSS.t106 15.9203
R577 VSS.n208 VSS.t114 15.9203
R578 VSS.n206 VSS.t101 15.9203
R579 VSS.n202 VSS.t99 15.9203
R580 VSS.n200 VSS.t115 15.9203
R581 VSS.n240 VSS.t70 13.2297
R582 VSS.t42 VSS.n73 11.8854
R583 VSS.t167 VSS.n69 11.8854
R584 VSS.n84 VSS.t57 11.8854
R585 VSS.t0 VSS.n92 11.8854
R586 VSS.n96 VSS.t53 11.8854
R587 VSS.t52 VSS.n100 11.8854
R588 VSS.t51 VSS.n68 11.8854
R589 VSS.t12 VSS.n67 11.8854
R590 VSS.t33 VSS.n66 11.8854
R591 VSS.n65 VSS.t19 11.8854
R592 VSS.t81 VSS.n64 11.8854
R593 VSS.n63 VSS.t173 11.8854
R594 VSS.t34 VSS.n146 11.8854
R595 VSS.t170 VSS.n150 11.8854
R596 VSS.t87 VSS.n62 11.8854
R597 VSS.t84 VSS.n157 11.8854
R598 VSS.n173 VSS.t165 11.8854
R599 VSS.t17 VSS.n177 11.8854
R600 VSS.t160 VSS.n181 11.8854
R601 VSS.n61 VSS.t169 11.8854
R602 VSS.t164 VSS.n60 11.8854
R603 VSS.t18 VSS.n77 11.8844
R604 VSS.n88 VSS.t56 11.8844
R605 VSS.t54 VSS.n107 11.8844
R606 VSS.n114 VSS.t107 11.8844
R607 VSS.t63 VSS.n118 11.8844
R608 VSS.t5 VSS.n122 11.8844
R609 VSS.t39 VSS.n129 11.8844
R610 VSS.t168 VSS.n142 11.8844
R611 VSS.t156 VSS.n161 11.8844
R612 VSS.t117 VSS.n165 11.8844
R613 VSS.t157 VSS.n169 11.8844
R614 VSS.t131 VSS.n77 9.19536
R615 VSS.t132 VSS.n88 9.19536
R616 VSS.t123 VSS.n107 9.19536
R617 VSS.t126 VSS.n114 9.19536
R618 VSS.t138 VSS.n118 9.19536
R619 VSS.t135 VSS.n122 9.19536
R620 VSS.t136 VSS.n129 9.19536
R621 VSS.n142 VSS.t141 9.19536
R622 VSS.n161 VSS.t149 9.19536
R623 VSS.n165 VSS.t143 9.19536
R624 VSS.n169 VSS.t152 9.19536
R625 VSS.t130 VSS.n73 9.19506
R626 VSS.n69 VSS.t129 9.19506
R627 VSS.t128 VSS.n84 9.19506
R628 VSS.n92 VSS.t125 9.19506
R629 VSS.t133 VSS.n96 9.19506
R630 VSS.n100 VSS.t134 9.19506
R631 VSS.n68 VSS.t127 9.19506
R632 VSS.n67 VSS.t139 9.19506
R633 VSS.t137 VSS.n66 9.19506
R634 VSS.n65 VSS.t124 9.19506
R635 VSS.t145 VSS.n64 9.19506
R636 VSS.t144 VSS.n63 9.19506
R637 VSS.t140 VSS.n146 9.19506
R638 VSS.t147 VSS.n150 9.19506
R639 VSS.t148 VSS.n62 9.19506
R640 VSS.t146 VSS.n157 9.19506
R641 VSS.n173 VSS.t153 9.19506
R642 VSS.n177 VSS.t142 9.19506
R643 VSS.n181 VSS.t154 9.19506
R644 VSS.t155 VSS.n61 9.19506
R645 VSS.t150 VSS.n60 9.19506
R646 VSS.n246 VSS.n76 8.5005
R647 VSS.n246 VSS.n80 8.5005
R648 VSS.n246 VSS.n83 8.5005
R649 VSS.n246 VSS.n87 8.5005
R650 VSS.n246 VSS.n91 8.5005
R651 VSS.n246 VSS.n95 8.5005
R652 VSS.n246 VSS.n99 8.5005
R653 VSS.n246 VSS.n103 8.5005
R654 VSS.n246 VSS.n106 8.5005
R655 VSS.n246 VSS.n110 8.5005
R656 VSS.n246 VSS.n113 8.5005
R657 VSS.n246 VSS.n117 8.5005
R658 VSS.n246 VSS.n121 8.5005
R659 VSS.n246 VSS.n125 8.5005
R660 VSS.n246 VSS.n128 8.5005
R661 VSS.n246 VSS.n132 8.5005
R662 VSS.n246 VSS.n135 8.5005
R663 VSS.n246 VSS.n138 8.5005
R664 VSS.n246 VSS.n141 8.5005
R665 VSS.n246 VSS.n145 8.5005
R666 VSS.n246 VSS.n149 8.5005
R667 VSS.n246 VSS.n153 8.5005
R668 VSS.n246 VSS.n156 8.5005
R669 VSS.n246 VSS.n160 8.5005
R670 VSS.n246 VSS.n164 8.5005
R671 VSS.n246 VSS.n168 8.5005
R672 VSS.n246 VSS.n172 8.5005
R673 VSS.n246 VSS.n176 8.5005
R674 VSS.n246 VSS.n180 8.5005
R675 VSS.n246 VSS.n184 8.5005
R676 VSS.n246 VSS.n187 8.5005
R677 VSS.n246 VSS.n189 8.5005
R678 VSS.n246 VSS.n71 8.47732
R679 VSS.n246 VSS.t73 8.47732
R680 VSS.n246 VSS.n57 8.47732
R681 VSS.n246 VSS.n245 8.47732
R682 VSS.n246 VSS.n191 8.47732
R683 VSS.n246 VSS.n193 8.47732
R684 VSS.n246 VSS.n58 5.63777
R685 VSS.n246 VSS.t67 5.00032
R686 VSS.n0 VSS.t78 54.979
R687 VSS.n246 VSS.n195 4.20662
R688 VSS VSS.n248 2.9705
R689 VSS.n246 VSS.n2 2.74446
R690 VSS.n246 VSS.n55 2.74446
R691 VSS.n246 VSS.n72 2.74446
R692 VSS.n247 VSS.n246 2.74412
R693 VSS.n246 VSS.t29 2.74394
R694 VSS.n246 VSS.n3 1.55465
R695 VSS.n246 VSS.n4 1.55465
R696 VSS.n246 VSS.n6 1.55465
R697 VSS.n246 VSS.n8 1.55465
R698 VSS.n246 VSS.n10 1.55465
R699 VSS.n246 VSS.n12 1.55465
R700 VSS.n246 VSS.n14 1.55465
R701 VSS.n246 VSS.n16 1.55465
R702 VSS.n246 VSS.n18 1.55465
R703 VSS.n246 VSS.n19 1.55465
R704 VSS.n246 VSS.n21 1.55465
R705 VSS.n246 VSS.n23 1.55465
R706 VSS.n246 VSS.n24 1.55465
R707 VSS.n246 VSS.n25 1.55465
R708 VSS.n246 VSS.n26 1.55465
R709 VSS.n246 VSS.n27 1.55465
R710 VSS.n246 VSS.n30 1.55465
R711 VSS.n246 VSS.n31 1.55465
R712 VSS.n246 VSS.n33 1.55465
R713 VSS.n246 VSS.n35 1.55465
R714 VSS.n246 VSS.n36 1.55465
R715 VSS.n246 VSS.n37 1.55465
R716 VSS.n246 VSS.n38 1.55465
R717 VSS.n246 VSS.n39 1.55465
R718 VSS.n246 VSS.n41 1.55465
R719 VSS.n246 VSS.n43 1.55465
R720 VSS.n246 VSS.n45 1.55465
R721 VSS.n246 VSS.n48 1.55465
R722 VSS.n246 VSS.n50 1.55465
R723 VSS.n246 VSS.n52 1.55465
R724 VSS.n246 VSS.n54 1.55465
R725 VSS.n246 VSS.n74 1.55388
R726 VSS.n246 VSS.n78 1.55388
R727 VSS.n246 VSS.n81 1.55388
R728 VSS.n246 VSS.n85 1.55388
R729 VSS.n246 VSS.n89 1.55388
R730 VSS.n246 VSS.n93 1.55388
R731 VSS.n246 VSS.n97 1.55388
R732 VSS.n246 VSS.n101 1.55388
R733 VSS.n246 VSS.n104 1.55388
R734 VSS.n246 VSS.n108 1.55388
R735 VSS.n246 VSS.n111 1.55388
R736 VSS.n246 VSS.n115 1.55388
R737 VSS.n246 VSS.n119 1.55388
R738 VSS.n246 VSS.n123 1.55388
R739 VSS.n246 VSS.n126 1.55388
R740 VSS.n246 VSS.n130 1.55388
R741 VSS.n246 VSS.n133 1.55388
R742 VSS.n246 VSS.n136 1.55388
R743 VSS.n246 VSS.n139 1.55388
R744 VSS.n246 VSS.n143 1.55388
R745 VSS.n246 VSS.n147 1.55388
R746 VSS.n246 VSS.n151 1.55388
R747 VSS.n246 VSS.n154 1.55388
R748 VSS.n246 VSS.n158 1.55388
R749 VSS.n246 VSS.n162 1.55388
R750 VSS.n246 VSS.n166 1.55388
R751 VSS.n246 VSS.n170 1.55388
R752 VSS.n246 VSS.n174 1.55388
R753 VSS.n246 VSS.n178 1.55388
R754 VSS.n246 VSS.n182 1.55388
R755 VSS.n246 VSS.n185 1.55388
R756 VSS.t66 VSS.t69 0.806856
R757 VSS.t41 VSS.n79 0.802775
R758 VSS.t9 VSS.n82 0.802775
R759 VSS.t4 VSS.n86 0.802775
R760 VSS.t16 VSS.n90 0.802775
R761 VSS.t25 VSS.n94 0.802775
R762 VSS.t61 VSS.n98 0.802775
R763 VSS.t59 VSS.n102 0.802775
R764 VSS.t50 VSS.n105 0.802775
R765 VSS.t2 VSS.n109 0.802775
R766 VSS.t65 VSS.n112 0.802775
R767 VSS.t11 VSS.n116 0.802775
R768 VSS.t36 VSS.n120 0.802775
R769 VSS.t7 VSS.n124 0.802775
R770 VSS.t21 VSS.n127 0.802775
R771 VSS.t32 VSS.n131 0.802775
R772 VSS.t38 VSS.n134 0.802775
R773 VSS.t111 VSS.n137 0.802775
R774 VSS.t45 VSS.n140 0.802775
R775 VSS.t27 VSS.n144 0.802775
R776 VSS.t80 VSS.n148 0.802775
R777 VSS.t89 VSS.n152 0.802775
R778 VSS.t86 VSS.n155 0.802775
R779 VSS.t83 VSS.n159 0.802775
R780 VSS.t103 VSS.n163 0.802775
R781 VSS.t100 VSS.n167 0.802775
R782 VSS.t96 VSS.n171 0.802775
R783 VSS.t14 VSS.n175 0.802775
R784 VSS.t116 VSS.n179 0.802775
R785 VSS.t98 VSS.n183 0.802775
R786 VSS.t122 VSS.n186 0.802775
R787 VSS.t151 VSS.n188 0.802775
R788 VSS.t76 VSS.n56 0.802775
R789 VSS.t23 VSS.n75 0.802775
R790 VSS.n194 VSS.t77 0.723599
R791 VSS.t75 VSS.n192 0.723599
R792 VSS.n246 VSS.n59 0.607264
R793 VSS.n244 VSS.t68 0.595317
R794 VSS.t72 VSS.n243 0.595317
R795 VSS.n185 VSS.t122 0.47671
R796 VSS.n182 VSS.t98 0.47671
R797 VSS.n178 VSS.t116 0.47671
R798 VSS.n174 VSS.t14 0.47671
R799 VSS.n170 VSS.t96 0.47671
R800 VSS.n166 VSS.t100 0.47671
R801 VSS.n162 VSS.t103 0.47671
R802 VSS.n158 VSS.t83 0.47671
R803 VSS.n154 VSS.t86 0.47671
R804 VSS.n151 VSS.t89 0.47671
R805 VSS.n147 VSS.t80 0.47671
R806 VSS.n143 VSS.t27 0.47671
R807 VSS.n139 VSS.t45 0.47671
R808 VSS.n136 VSS.t111 0.47671
R809 VSS.n133 VSS.t38 0.47671
R810 VSS.n130 VSS.t32 0.47671
R811 VSS.n126 VSS.t21 0.47671
R812 VSS.n123 VSS.t7 0.47671
R813 VSS.n119 VSS.t36 0.47671
R814 VSS.n115 VSS.t11 0.47671
R815 VSS.n111 VSS.t65 0.47671
R816 VSS.n108 VSS.t2 0.47671
R817 VSS.n104 VSS.t50 0.47671
R818 VSS.n101 VSS.t59 0.47671
R819 VSS.n97 VSS.t61 0.47671
R820 VSS.n93 VSS.t25 0.47671
R821 VSS.n89 VSS.t16 0.47671
R822 VSS.n85 VSS.t4 0.47671
R823 VSS.n81 VSS.t9 0.47671
R824 VSS.n78 VSS.t41 0.47671
R825 VSS.n74 VSS.t23 0.47671
R826 VSS.n75 VSS.n3 0.46466
R827 VSS.n79 VSS.n4 0.46466
R828 VSS.n82 VSS.n6 0.46466
R829 VSS.n86 VSS.n8 0.46466
R830 VSS.n90 VSS.n10 0.46466
R831 VSS.n94 VSS.n12 0.46466
R832 VSS.n98 VSS.n14 0.46466
R833 VSS.n102 VSS.n16 0.46466
R834 VSS.n105 VSS.n18 0.46466
R835 VSS.n109 VSS.n19 0.46466
R836 VSS.n112 VSS.n21 0.46466
R837 VSS.n116 VSS.n23 0.46466
R838 VSS.n120 VSS.n24 0.46466
R839 VSS.n124 VSS.n25 0.46466
R840 VSS.n127 VSS.n26 0.46466
R841 VSS.n131 VSS.n27 0.46466
R842 VSS.n134 VSS.n30 0.46466
R843 VSS.n137 VSS.n31 0.46466
R844 VSS.n140 VSS.n33 0.46466
R845 VSS.n144 VSS.n35 0.46466
R846 VSS.n148 VSS.n36 0.46466
R847 VSS.n152 VSS.n37 0.46466
R848 VSS.n155 VSS.n38 0.46466
R849 VSS.n159 VSS.n39 0.46466
R850 VSS.n163 VSS.n41 0.46466
R851 VSS.n167 VSS.n43 0.46466
R852 VSS.n171 VSS.n45 0.46466
R853 VSS.n175 VSS.n48 0.46466
R854 VSS.n179 VSS.n50 0.46466
R855 VSS.n183 VSS.n52 0.46466
R856 VSS.n186 VSS.n54 0.46466
R857 VSS.n79 VSS.n3 0.45349
R858 VSS.n82 VSS.n4 0.45349
R859 VSS.n86 VSS.n6 0.45349
R860 VSS.n90 VSS.n8 0.45349
R861 VSS.n94 VSS.n10 0.45349
R862 VSS.n98 VSS.n12 0.45349
R863 VSS.n102 VSS.n14 0.45349
R864 VSS.n105 VSS.n16 0.45349
R865 VSS.n109 VSS.n18 0.45349
R866 VSS.n112 VSS.n19 0.45349
R867 VSS.n116 VSS.n21 0.45349
R868 VSS.n120 VSS.n23 0.45349
R869 VSS.n124 VSS.n24 0.45349
R870 VSS.n127 VSS.n25 0.45349
R871 VSS.n131 VSS.n26 0.45349
R872 VSS.n134 VSS.n27 0.45349
R873 VSS.n137 VSS.n30 0.45349
R874 VSS.n140 VSS.n31 0.45349
R875 VSS.n144 VSS.n33 0.45349
R876 VSS.n148 VSS.n35 0.45349
R877 VSS.n152 VSS.n36 0.45349
R878 VSS.n155 VSS.n37 0.45349
R879 VSS.n159 VSS.n38 0.45349
R880 VSS.n163 VSS.n39 0.45349
R881 VSS.n167 VSS.n41 0.45349
R882 VSS.n171 VSS.n43 0.45349
R883 VSS.n175 VSS.n45 0.45349
R884 VSS.n179 VSS.n48 0.45349
R885 VSS.n183 VSS.n50 0.45349
R886 VSS.n186 VSS.n52 0.45349
R887 VSS.n188 VSS.n54 0.45349
R888 VSS.n74 VSS.t41 0.441374
R889 VSS.n78 VSS.t9 0.441374
R890 VSS.n81 VSS.t4 0.441374
R891 VSS.n85 VSS.t16 0.441374
R892 VSS.n89 VSS.t25 0.441374
R893 VSS.n93 VSS.t61 0.441374
R894 VSS.n97 VSS.t59 0.441374
R895 VSS.n101 VSS.t50 0.441374
R896 VSS.n104 VSS.t2 0.441374
R897 VSS.n108 VSS.t65 0.441374
R898 VSS.n111 VSS.t11 0.441374
R899 VSS.n115 VSS.t36 0.441374
R900 VSS.n119 VSS.t7 0.441374
R901 VSS.n123 VSS.t21 0.441374
R902 VSS.n126 VSS.t32 0.441374
R903 VSS.n130 VSS.t38 0.441374
R904 VSS.n133 VSS.t111 0.441374
R905 VSS.n136 VSS.t45 0.441374
R906 VSS.n139 VSS.t27 0.441374
R907 VSS.n143 VSS.t80 0.441374
R908 VSS.n147 VSS.t89 0.441374
R909 VSS.n151 VSS.t86 0.441374
R910 VSS.n154 VSS.t83 0.441374
R911 VSS.n158 VSS.t103 0.441374
R912 VSS.n162 VSS.t100 0.441374
R913 VSS.n166 VSS.t96 0.441374
R914 VSS.n170 VSS.t14 0.441374
R915 VSS.n174 VSS.t116 0.441374
R916 VSS.n178 VSS.t98 0.441374
R917 VSS.n182 VSS.t122 0.441374
R918 VSS.n185 VSS.t151 0.441374
R919 VSS.n247 VSS.t69 0.334469
R920 VSS.n248 VSS.n247 0.330494
R921 VSS.t29 VSS.t151 0.301976
R922 VSS.n188 VSS.n55 0.290049
R923 VSS.n75 VSS.n2 0.276768
R924 VSS.n242 VSS.n2 0.271299
R925 VSS.n243 VSS.n72 0.271299
R926 VSS.t23 VSS.n72 0.265518
R927 VSS.n196 VSS.n195 0.259448
R928 VSS.t29 VSS.t76 0.254814
R929 VSS.n56 VSS.n55 0.244268
R930 VSS.n196 VSS.n58 0.206787
R931 VSS.t68 VSS.t72 0.1875
R932 VSS.n195 VSS.n194 0.177116
R933 VSS.t77 VSS.n58 0.141022
R934 VSS.n56 VSS.t73 0.135868
R935 VSS.t76 VSS.n191 0.124618
R936 VSS.n192 VSS.t73 0.122118
R937 VSS.t75 VSS.n191 0.122118
R938 VSS.t66 VSS.n1 0.08925
R939 VSS.n246 VSS.n0 0.00100788
R940 VSS.t68 VSS.n241 0.0851154
R941 VSS.t72 VSS.n242 0.0851154
R942 VSS.t77 VSS.n57 0.0771176
R943 VSS.n194 VSS.n193 0.0771176
R944 VSS.n241 VSS.n71 0.0746176
R945 VSS.n245 VSS.n244 0.0746176
R946 VSS.n192 VSS.n57 0.0696176
R947 VSS.n193 VSS.t75 0.0696176
R948 VSS.n241 VSS.n70 0.06925
R949 VSS.n244 VSS.n239 0.06925
R950 VSS.n242 VSS.n70 0.05925
R951 VSS.n243 VSS.n239 0.05925
R952 VSS.n71 VSS.t69 0.0546176
R953 VSS.n245 VSS.t66 0.0546176
R954 VSS.n246 VSS.n240 0.0444724
R955 VSS.n246 VSS.n77 0.0444724
R956 VSS.n246 VSS.n235 0.0444724
R957 VSS.n246 VSS.n88 0.0444724
R958 VSS.n246 VSS.n233 0.0444724
R959 VSS.n246 VSS.n232 0.0444724
R960 VSS.n246 VSS.n107 0.0444724
R961 VSS.n246 VSS.n114 0.0444724
R962 VSS.n246 VSS.n118 0.0444724
R963 VSS.n246 VSS.n223 0.0444724
R964 VSS.n246 VSS.n122 0.0444724
R965 VSS.n246 VSS.n220 0.0444724
R966 VSS.n246 VSS.n219 0.0444724
R967 VSS.n246 VSS.n218 0.0444724
R968 VSS.n246 VSS.n129 0.0444724
R969 VSS.n246 VSS.n142 0.0444724
R970 VSS.n246 VSS.n211 0.0444724
R971 VSS.n246 VSS.n210 0.0444724
R972 VSS.n246 VSS.n208 0.0444724
R973 VSS.n246 VSS.n207 0.0444724
R974 VSS.n246 VSS.n206 0.0444724
R975 VSS.n246 VSS.n205 0.0444724
R976 VSS.n246 VSS.n161 0.0444724
R977 VSS.n246 VSS.n165 0.0444724
R978 VSS.n246 VSS.n202 0.0444724
R979 VSS.n246 VSS.n169 0.0444724
R980 VSS.n246 VSS.n200 0.0444724
R981 VSS.n246 VSS.n69 0.0444549
R982 VSS.n246 VSS.n5 0.0444549
R983 VSS.n246 VSS.n7 0.0444549
R984 VSS.n246 VSS.n9 0.0444549
R985 VSS.n246 VSS.n11 0.0444549
R986 VSS.n246 VSS.n13 0.0444549
R987 VSS.n246 VSS.n15 0.0444549
R988 VSS.n246 VSS.n68 0.0444549
R989 VSS.n246 VSS.n17 0.0444549
R990 VSS.n246 VSS.n67 0.0444549
R991 VSS.n246 VSS.n20 0.0444549
R992 VSS.n246 VSS.n22 0.0444549
R993 VSS.n246 VSS.n66 0.0444549
R994 VSS.n246 VSS.n28 0.0444549
R995 VSS.n246 VSS.n65 0.0444549
R996 VSS.n246 VSS.n29 0.0444549
R997 VSS.n246 VSS.n64 0.0444549
R998 VSS.n246 VSS.n32 0.0444549
R999 VSS.n246 VSS.n63 0.0444549
R1000 VSS.n246 VSS.n34 0.0444549
R1001 VSS.n246 VSS.n62 0.0444549
R1002 VSS.n246 VSS.n40 0.0444549
R1003 VSS.n246 VSS.n42 0.0444549
R1004 VSS.n246 VSS.n44 0.0444549
R1005 VSS.n246 VSS.n46 0.0444549
R1006 VSS.n246 VSS.n47 0.0444549
R1007 VSS.n246 VSS.n49 0.0444549
R1008 VSS.n246 VSS.n51 0.0444549
R1009 VSS.n246 VSS.n53 0.0444549
R1010 VSS.n246 VSS.n61 0.0444549
R1011 VSS.n246 VSS.n60 0.0444549
R1012 VSS.n246 VSS.n73 0.0444549
R1013 VSS.n246 VSS.n238 0.0444549
R1014 VSS.n246 VSS.n237 0.0444549
R1015 VSS.n246 VSS.n236 0.0444549
R1016 VSS.n246 VSS.n84 0.0444549
R1017 VSS.n246 VSS.n234 0.0444549
R1018 VSS.n246 VSS.n92 0.0444549
R1019 VSS.n246 VSS.n96 0.0444549
R1020 VSS.n246 VSS.n231 0.0444549
R1021 VSS.n246 VSS.n230 0.0444549
R1022 VSS.n246 VSS.n100 0.0444549
R1023 VSS.n246 VSS.n229 0.0444549
R1024 VSS.n246 VSS.n228 0.0444549
R1025 VSS.n246 VSS.n227 0.0444549
R1026 VSS.n246 VSS.n226 0.0444549
R1027 VSS.n246 VSS.n225 0.0444549
R1028 VSS.n246 VSS.n224 0.0444549
R1029 VSS.n246 VSS.n222 0.0444549
R1030 VSS.n246 VSS.n221 0.0444549
R1031 VSS.n246 VSS.n217 0.0444549
R1032 VSS.n246 VSS.n216 0.0444549
R1033 VSS.n246 VSS.n215 0.0444549
R1034 VSS.n246 VSS.n214 0.0444549
R1035 VSS.n246 VSS.n213 0.0444549
R1036 VSS.n246 VSS.n212 0.0444549
R1037 VSS.n246 VSS.n146 0.0444549
R1038 VSS.n246 VSS.n150 0.0444549
R1039 VSS.n246 VSS.n209 0.0444549
R1040 VSS.n246 VSS.n157 0.0444549
R1041 VSS.n246 VSS.n204 0.0444549
R1042 VSS.n246 VSS.n203 0.0444549
R1043 VSS.n246 VSS.n173 0.0444549
R1044 VSS.n246 VSS.n201 0.0444549
R1045 VSS.n246 VSS.n177 0.0444549
R1046 VSS.n246 VSS.n181 0.0444549
R1047 VSS.n246 VSS.n199 0.0444549
R1048 VSS.n246 VSS.n198 0.0444549
R1049 VSS.n246 VSS.n197 0.0444549
R1050 VSS.n248 VSS.n1 0.00675
R1051 VSS.n246 VSS.n190 0.00413369
R1052 VSS.n0 VSS.n196 8.48048
C518 DELAY_VBIASN VSS 16.43641f
C519 DELAY_OUT_LAST VSS 0.40486f
C520 DELAY_OUT_TAP31 VSS 0.6437f
C521 DELAY_OUT_TAP30 VSS 0.6437f
C522 DELAY_OUT_TAP29 VSS 0.6437f
C523 DELAY_OUT_TAP28 VSS 0.6437f
C524 DELAY_OUT_TAP27 VSS 0.6437f
C525 DELAY_OUT_TAP26 VSS 0.6437f
C526 DELAY_OUT_TAP25 VSS 0.6437f
C527 DELAY_OUT_TAP24 VSS 0.6437f
C528 DELAY_OUT_TAP23 VSS 0.6437f
C529 DELAY_OUT_TAP22 VSS 0.6437f
C530 DELAY_OUT_TAP21 VSS 0.6437f
C531 DELAY_OUT_TAP20 VSS 0.6437f
C532 DELAY_OUT_TAP19 VSS 0.6437f
C533 DELAY_OUT_TAP18 VSS 0.6437f
C534 DELAY_OUT_TAP17 VSS 0.6437f
C535 DELAY_OUT_TAP16 VSS 0.6437f
C536 DELAY_OUT_TAP15 VSS 0.6437f
C537 DELAY_OUT_TAP14 VSS 0.6437f
C538 DELAY_OUT_TAP13 VSS 0.6437f
C539 DELAY_OUT_TAP12 VSS 0.6437f
C540 DELAY_OUT_TAP11 VSS 0.6437f
C541 DELAY_OUT_TAP10 VSS 0.6437f
C542 DELAY_OUT_TAP9 VSS 0.6437f
C543 DELAY_OUT_TAP8 VSS 0.6437f
C544 DELAY_OUT_TAP7 VSS 0.6437f
C545 DELAY_OUT_TAP6 VSS 0.6437f
C546 DELAY_OUT_TAP5 VSS 0.6437f
C547 DELAY_OUT_TAP4 VSS 0.6437f
C548 DELAY_OUT_TAP3 VSS 0.6437f
C549 DELAY_OUT_TAP2 VSS 0.6437f
C550 DELAY_OUT_TAP1 VSS 0.64371f
C551 DELAY_VBIASP VSS 4.15787f
C552 DELAY_IN VSS 0.57171f
C553 VDD VSS 20.97692f
C554 a_27411_1842# VSS 0.01336f ; **FLOATING
C555 a_26651_1842# VSS 0.01336f ; **FLOATING
C556 a_25891_1842# VSS 0.01336f ; **FLOATING
C557 a_25131_1842# VSS 0.01336f ; **FLOATING
C558 a_24371_1842# VSS 0.01336f ; **FLOATING
C559 a_23611_1842# VSS 0.01336f ; **FLOATING
C560 a_22851_1842# VSS 0.01336f ; **FLOATING
C561 a_22091_1842# VSS 0.01336f ; **FLOATING
C562 a_21331_1842# VSS 0.01336f ; **FLOATING
C563 a_20571_1842# VSS 0.01336f ; **FLOATING
C564 a_19811_1842# VSS 0.01336f ; **FLOATING
C565 a_19051_1842# VSS 0.01336f ; **FLOATING
C566 a_18291_1842# VSS 0.01336f ; **FLOATING
C567 a_17531_1842# VSS 0.01336f ; **FLOATING
C568 a_16771_1842# VSS 0.01336f ; **FLOATING
C569 a_16011_1842# VSS 0.01336f ; **FLOATING
C570 a_15251_1842# VSS 0.01336f ; **FLOATING
C571 a_14491_1842# VSS 0.01336f ; **FLOATING
C572 a_13731_1842# VSS 0.01336f ; **FLOATING
C573 a_12971_1842# VSS 0.01336f ; **FLOATING
C574 a_12211_1842# VSS 0.01336f ; **FLOATING
C575 a_11451_1842# VSS 0.01336f ; **FLOATING
C576 a_10691_1842# VSS 0.01336f ; **FLOATING
C577 a_9931_1842# VSS 0.01336f ; **FLOATING
C578 a_9171_1842# VSS 0.01336f ; **FLOATING
C579 a_8411_1842# VSS 0.01336f ; **FLOATING
C580 a_7651_1842# VSS 0.01336f ; **FLOATING
C581 a_6891_1842# VSS 0.01336f ; **FLOATING
C582 a_6131_1842# VSS 0.01336f ; **FLOATING
C583 a_5371_1842# VSS 0.01336f ; **FLOATING
C584 a_4611_1842# VSS 0.01336f ; **FLOATING
C585 a_3851_1842# VSS 0.0139f ; **FLOATING
C586 a_27303_1842# VSS 0.54306f ; **FLOATING
C587 a_27737_1842# VSS 0.67217f ; **FLOATING
C588 a_27173_1842# VSS 0.48844f ; **FLOATING
C589 a_26543_1842# VSS 0.54063f ; **FLOATING
C590 a_26413_1842# VSS 0.48844f ; **FLOATING
C591 a_25783_1842# VSS 0.54063f ; **FLOATING
C592 a_25653_1842# VSS 0.48844f ; **FLOATING
C593 a_25023_1842# VSS 0.54063f ; **FLOATING
C594 a_24893_1842# VSS 0.48844f ; **FLOATING
C595 a_24263_1842# VSS 0.54063f ; **FLOATING
C596 a_24133_1842# VSS 0.48844f ; **FLOATING
C597 a_23503_1842# VSS 0.54063f ; **FLOATING
C598 a_23373_1842# VSS 0.48844f ; **FLOATING
C599 a_22743_1842# VSS 0.54063f ; **FLOATING
C600 a_22613_1842# VSS 0.48844f ; **FLOATING
C601 a_21983_1842# VSS 0.54063f ; **FLOATING
C602 a_21853_1842# VSS 0.48844f ; **FLOATING
C603 a_21223_1842# VSS 0.54063f ; **FLOATING
C604 a_21093_1842# VSS 0.48844f ; **FLOATING
C605 a_20463_1842# VSS 0.54063f ; **FLOATING
C606 a_20333_1842# VSS 0.48844f ; **FLOATING
C607 a_19703_1842# VSS 0.54063f ; **FLOATING
C608 a_19573_1842# VSS 0.48844f ; **FLOATING
C609 a_18943_1842# VSS 0.54063f ; **FLOATING
C610 a_18813_1842# VSS 0.48844f ; **FLOATING
C611 a_18183_1842# VSS 0.54063f ; **FLOATING
C612 a_18053_1842# VSS 0.48844f ; **FLOATING
C613 a_17423_1842# VSS 0.54063f ; **FLOATING
C614 a_17293_1842# VSS 0.48844f ; **FLOATING
C615 a_16663_1842# VSS 0.54063f ; **FLOATING
C616 a_16533_1842# VSS 0.48844f ; **FLOATING
C617 a_15903_1842# VSS 0.54063f ; **FLOATING
C618 a_15773_1842# VSS 0.48844f ; **FLOATING
C619 a_15143_1842# VSS 0.54063f ; **FLOATING
C620 a_15013_1842# VSS 0.48844f ; **FLOATING
C621 a_14383_1842# VSS 0.54063f ; **FLOATING
C622 a_14253_1842# VSS 0.48844f ; **FLOATING
C623 a_13623_1842# VSS 0.54063f ; **FLOATING
C624 a_13493_1842# VSS 0.48844f ; **FLOATING
C625 a_12863_1842# VSS 0.54063f ; **FLOATING
C626 a_12733_1842# VSS 0.48844f ; **FLOATING
C627 a_12103_1842# VSS 0.54063f ; **FLOATING
C628 a_11973_1842# VSS 0.48844f ; **FLOATING
C629 a_11343_1842# VSS 0.54063f ; **FLOATING
C630 a_11213_1842# VSS 0.48844f ; **FLOATING
C631 a_10583_1842# VSS 0.54063f ; **FLOATING
C632 a_10453_1842# VSS 0.48844f ; **FLOATING
C633 a_9823_1842# VSS 0.54063f ; **FLOATING
C634 a_9693_1842# VSS 0.48844f ; **FLOATING
C635 a_9063_1842# VSS 0.54063f ; **FLOATING
C636 a_8933_1842# VSS 0.48844f ; **FLOATING
C637 a_8303_1842# VSS 0.54063f ; **FLOATING
C638 a_8173_1842# VSS 0.48844f ; **FLOATING
C639 a_7543_1842# VSS 0.54063f ; **FLOATING
C640 a_7413_1842# VSS 0.48844f ; **FLOATING
C641 a_6783_1842# VSS 0.54063f ; **FLOATING
C642 a_6653_1842# VSS 0.48844f ; **FLOATING
C643 a_6023_1842# VSS 0.54063f ; **FLOATING
C644 a_5893_1842# VSS 0.48844f ; **FLOATING
C645 a_5263_1842# VSS 0.54063f ; **FLOATING
C646 a_5133_1842# VSS 0.48844f ; **FLOATING
C647 a_4503_1842# VSS 0.54063f ; **FLOATING
C648 a_4373_1842# VSS 0.48844f ; **FLOATING
C649 a_3743_1842# VSS 0.61828f ; **FLOATING
C650 VDD.n0 VSS 0.02735f ; **FLOATING
C651 VDD.n1 VSS 0.02735f ; **FLOATING
C652 VDD.n2 VSS 0.02735f ; **FLOATING
C653 VDD.n3 VSS 0.02735f ; **FLOATING
C654 VDD.n4 VSS 0.02735f ; **FLOATING
C655 VDD.n5 VSS 0.02735f ; **FLOATING
C656 VDD.n6 VSS 0.02735f ; **FLOATING
C657 VDD.n7 VSS 0.02735f ; **FLOATING
C658 VDD.n8 VSS 0.02735f ; **FLOATING
C659 VDD.n9 VSS 0.02735f ; **FLOATING
C660 VDD.n10 VSS 0.02735f ; **FLOATING
C661 VDD.n11 VSS 0.02735f ; **FLOATING
C662 VDD.t0 VSS 54.253f ; **FLOATING
C663 VDD.n14 VSS 0.16039f ; **FLOATING
C664 VDD.t46 VSS 0.03766f ; **FLOATING
C665 VDD.t85 VSS 0.04209f ; **FLOATING
C666 VDD.n15 VSS 0.02735f ; **FLOATING
C667 VDD.n16 VSS 0.02735f ; **FLOATING
C668 VDD.n17 VSS 0.41307f ; **FLOATING
C669 VDD.n18 VSS 0.02735f ; **FLOATING
C670 VDD.n19 VSS 0.21406f ; **FLOATING
C671 VDD.n20 VSS 0.02735f ; **FLOATING
C672 VDD.n21 VSS 0.21414f ; **FLOATING
C673 VDD.n22 VSS 0.02735f ; **FLOATING
C674 VDD.n23 VSS 0.21407f ; **FLOATING
C675 VDD.n24 VSS 0.02735f ; **FLOATING
C676 VDD.n25 VSS 0.21413f ; **FLOATING
C677 VDD.n26 VSS 0.02735f ; **FLOATING
C678 VDD.n27 VSS 0.21414f ; **FLOATING
C679 VDD.n28 VSS 0.02735f ; **FLOATING
C680 VDD.n29 VSS 0.21414f ; **FLOATING
C681 VDD.t84 VSS 0.03951f ; **FLOATING
C682 VDD.n30 VSS 1.05792f ; **FLOATING
C683 VDD.t80 VSS 0.04253f ; **FLOATING
C684 VDD.n32 VSS 0.06014f ; **FLOATING
C685 VDD.n33 VSS 0.21414f ; **FLOATING
C686 VDD.n34 VSS 0.02735f ; **FLOATING
C687 VDD.n35 VSS 0.21418f ; **FLOATING
C688 VDD.n36 VSS 0.02735f ; **FLOATING
C689 VDD.n37 VSS 0.2141f ; **FLOATING
C690 VDD.n38 VSS 0.02735f ; **FLOATING
C691 VDD.n39 VSS 0.21414f ; **FLOATING
C692 VDD.n40 VSS 0.02735f ; **FLOATING
C693 VDD.n41 VSS 0.21414f ; **FLOATING
C694 VDD.n42 VSS 0.02735f ; **FLOATING
C695 VDD.n43 VSS 0.2141f ; **FLOATING
C696 VDD.n44 VSS 0.02735f ; **FLOATING
C697 VDD.n45 VSS 0.21418f ; **FLOATING
C698 VDD.n46 VSS 0.02735f ; **FLOATING
C699 VDD.n47 VSS 0.2142f ; **FLOATING
C700 VDD.n48 VSS 0.02735f ; **FLOATING
C701 VDD.n49 VSS 0.21414f ; **FLOATING
C702 VDD.n50 VSS 0.02735f ; **FLOATING
C703 VDD.n51 VSS 0.21418f ; **FLOATING
C704 VDD.n52 VSS 0.02735f ; **FLOATING
C705 VDD.n53 VSS 0.21421f ; **FLOATING
C706 VDD.t81 VSS 0.02172f ; **FLOATING
C707 VDD.n54 VSS 0.05602f ; **FLOATING
C708 VDD.n55 VSS 0.05607f ; **FLOATING
C709 VDD.n56 VSS 0.05609f ; **FLOATING
C710 VDD.n57 VSS 0.05606f ; **FLOATING
C711 VDD.n58 VSS 0.05609f ; **FLOATING
C712 VDD.n59 VSS 0.05609f ; **FLOATING
C713 VDD.n60 VSS 0.05615f ; **FLOATING
C714 VDD.n61 VSS 0.05601f ; **FLOATING
C715 VDD.n62 VSS 0.05608f ; **FLOATING
C716 VDD.n63 VSS 0.05611f ; **FLOATING
C717 VDD.n64 VSS 0.05607f ; **FLOATING
C718 VDD.n65 VSS 0.05611f ; **FLOATING
C719 VDD.n66 VSS 0.05601f ; **FLOATING
C720 VDD.n67 VSS 0.056f ; **FLOATING
C721 VDD.n68 VSS 0.05607f ; **FLOATING
C722 VDD.n69 VSS 0.05606f ; **FLOATING
C723 VDD.n70 VSS 0.05607f ; **FLOATING
C724 VDD.n71 VSS 0.05601f ; **FLOATING
C725 VDD.n72 VSS 0.05601f ; **FLOATING
C726 VDD.n73 VSS 0.05601f ; **FLOATING
C727 VDD.n74 VSS 0.05606f ; **FLOATING
C728 VDD.n75 VSS 0.05614f ; **FLOATING
C729 VDD.n76 VSS 0.05593f ; **FLOATING
C730 VDD.n77 VSS 0.05607f ; **FLOATING
C731 VDD.n78 VSS 0.05607f ; **FLOATING
C732 VDD.n79 VSS 0.05601f ; **FLOATING
C733 VDD.n80 VSS 0.05603f ; **FLOATING
C734 VDD.n81 VSS 0.05595f ; **FLOATING
C735 VDD.n82 VSS 0.05606f ; **FLOATING
C736 VDD.t83 VSS 0.07737f ; **FLOATING
C737 VDD.t88 VSS 0.03688f ; **FLOATING
C738 VDD.t86 VSS 0.03564f ; **FLOATING
C739 VDD.t12 VSS 0.04326f ; **FLOATING
C740 VDD.t99 VSS 0.04326f ; **FLOATING
C741 VDD.t45 VSS 0.03688f ; **FLOATING
C742 VDD.t71 VSS 0.04326f ; **FLOATING
C743 VDD.t16 VSS 0.03688f ; **FLOATING
C744 VDD.n83 VSS 0.14077f ; **FLOATING
C745 VDD.t95 VSS 0.04326f ; **FLOATING
C746 VDD.t44 VSS 0.03688f ; **FLOATING
C747 VDD.n84 VSS 0.12126f ; **FLOATING
C748 VDD.t6 VSS 0.04326f ; **FLOATING
C749 VDD.t18 VSS 0.03688f ; **FLOATING
C750 VDD.n85 VSS 0.12126f ; **FLOATING
C751 VDD.t70 VSS 0.04326f ; **FLOATING
C752 VDD.t43 VSS 0.03688f ; **FLOATING
C753 VDD.n86 VSS 0.12121f ; **FLOATING
C754 VDD.t72 VSS 0.04326f ; **FLOATING
C755 VDD.t27 VSS 0.03688f ; **FLOATING
C756 VDD.n87 VSS 0.12127f ; **FLOATING
C757 VDD.t74 VSS 0.04326f ; **FLOATING
C758 VDD.t39 VSS 0.03688f ; **FLOATING
C759 VDD.n88 VSS 0.12117f ; **FLOATING
C760 VDD.t62 VSS 0.04326f ; **FLOATING
C761 VDD.t40 VSS 0.03688f ; **FLOATING
C762 VDD.n89 VSS 0.12125f ; **FLOATING
C763 VDD.t63 VSS 0.04326f ; **FLOATING
C764 VDD.t42 VSS 0.03688f ; **FLOATING
C765 VDD.n90 VSS 0.12121f ; **FLOATING
C766 VDD.t64 VSS 0.04326f ; **FLOATING
C767 VDD.t41 VSS 0.03688f ; **FLOATING
C768 VDD.n91 VSS 0.12118f ; **FLOATING
C769 VDD.t61 VSS 0.04326f ; **FLOATING
C770 VDD.t17 VSS 0.03688f ; **FLOATING
C771 VDD.n92 VSS 0.12119f ; **FLOATING
C772 VDD.t11 VSS 0.04326f ; **FLOATING
C773 VDD.t38 VSS 0.03688f ; **FLOATING
C774 VDD.n93 VSS 0.12125f ; **FLOATING
C775 VDD.t51 VSS 0.04326f ; **FLOATING
C776 VDD.t22 VSS 0.03688f ; **FLOATING
C777 VDD.n94 VSS 0.12126f ; **FLOATING
C778 VDD.t91 VSS 0.04326f ; **FLOATING
C779 VDD.t21 VSS 0.03688f ; **FLOATING
C780 VDD.n95 VSS 0.1212f ; **FLOATING
C781 VDD.t48 VSS 0.04326f ; **FLOATING
C782 VDD.t37 VSS 0.03688f ; **FLOATING
C783 VDD.n96 VSS 0.12121f ; **FLOATING
C784 VDD.t14 VSS 0.04326f ; **FLOATING
C785 VDD.t35 VSS 0.03688f ; **FLOATING
C786 VDD.n97 VSS 0.12121f ; **FLOATING
C787 VDD.t8 VSS 0.04326f ; **FLOATING
C788 VDD.t36 VSS 0.03688f ; **FLOATING
C789 VDD.n98 VSS 0.12124f ; **FLOATING
C790 VDD.t3 VSS 0.04326f ; **FLOATING
C791 VDD.t34 VSS 0.03688f ; **FLOATING
C792 VDD.n99 VSS 0.12121f ; **FLOATING
C793 VDD.t47 VSS 0.04326f ; **FLOATING
C794 VDD.t20 VSS 0.03688f ; **FLOATING
C795 VDD.n100 VSS 0.12119f ; **FLOATING
C796 VDD.t5 VSS 0.04326f ; **FLOATING
C797 VDD.t15 VSS 0.03688f ; **FLOATING
C798 VDD.n101 VSS 0.12119f ; **FLOATING
C799 VDD.t60 VSS 0.04326f ; **FLOATING
C800 VDD.t19 VSS 0.03688f ; **FLOATING
C801 VDD.n102 VSS 0.12115f ; **FLOATING
C802 VDD.t1 VSS 0.04326f ; **FLOATING
C803 VDD.t33 VSS 0.03688f ; **FLOATING
C804 VDD.n103 VSS 0.12117f ; **FLOATING
C805 VDD.t55 VSS 0.04326f ; **FLOATING
C806 VDD.t25 VSS 0.03688f ; **FLOATING
C807 VDD.n104 VSS 0.1212f ; **FLOATING
C808 VDD.t57 VSS 0.04326f ; **FLOATING
C809 VDD.t32 VSS 0.03688f ; **FLOATING
C810 VDD.n105 VSS 0.12118f ; **FLOATING
C811 VDD.t58 VSS 0.04326f ; **FLOATING
C812 VDD.t31 VSS 0.03688f ; **FLOATING
C813 VDD.n106 VSS 0.12113f ; **FLOATING
C814 VDD.t10 VSS 0.04326f ; **FLOATING
C815 VDD.t30 VSS 0.03688f ; **FLOATING
C816 VDD.n107 VSS 0.12116f ; **FLOATING
C817 VDD.t7 VSS 0.04326f ; **FLOATING
C818 VDD.t29 VSS 0.03688f ; **FLOATING
C819 VDD.n108 VSS 0.12121f ; **FLOATING
C820 VDD.t2 VSS 0.04326f ; **FLOATING
C821 VDD.t26 VSS 0.03688f ; **FLOATING
C822 VDD.n109 VSS 0.12115f ; **FLOATING
C823 VDD.t4 VSS 0.04326f ; **FLOATING
C824 VDD.t23 VSS 0.03688f ; **FLOATING
C825 VDD.n110 VSS 0.12119f ; **FLOATING
C826 VDD.t49 VSS 0.04326f ; **FLOATING
C827 VDD.t28 VSS 0.03688f ; **FLOATING
C828 VDD.n111 VSS 0.1212f ; **FLOATING
C829 VDD.t9 VSS 0.04326f ; **FLOATING
C830 VDD.t24 VSS 0.03688f ; **FLOATING
C831 VDD.n112 VSS 0.10402f ; **FLOATING
C832 VDD.t82 VSS 0.0373f ; **FLOATING
C833 VDD.t79 VSS 0.03688f ; **FLOATING
C834 VDD.t78 VSS 0.02663f ; **FLOATING
C835 DELAY_VBIASP.n0 VSS 0.14347f ; **FLOATING
C836 DELAY_VBIASP.t31 VSS 0.36739f ; **FLOATING
C837 DELAY_VBIASP.t30 VSS 0.35917f ; **FLOATING
C838 DELAY_VBIASP.n1 VSS 0.64365f ; **FLOATING
C839 DELAY_VBIASP.t29 VSS 0.35917f ; **FLOATING
C840 DELAY_VBIASP.n2 VSS 0.44541f ; **FLOATING
C841 DELAY_VBIASP.t28 VSS 0.35917f ; **FLOATING
C842 DELAY_VBIASP.n3 VSS 0.44541f ; **FLOATING
C843 DELAY_VBIASP.t27 VSS 0.35917f ; **FLOATING
C844 DELAY_VBIASP.n4 VSS 0.44541f ; **FLOATING
C845 DELAY_VBIASP.t26 VSS 0.35917f ; **FLOATING
C846 DELAY_VBIASP.n5 VSS 0.44541f ; **FLOATING
C847 DELAY_VBIASP.t25 VSS 0.35917f ; **FLOATING
C848 DELAY_VBIASP.n6 VSS 0.44541f ; **FLOATING
C849 DELAY_VBIASP.t24 VSS 0.35917f ; **FLOATING
C850 DELAY_VBIASP.n7 VSS 0.44541f ; **FLOATING
C851 DELAY_VBIASP.t23 VSS 0.35917f ; **FLOATING
C852 DELAY_VBIASP.n8 VSS 0.44541f ; **FLOATING
C853 DELAY_VBIASP.t22 VSS 0.35917f ; **FLOATING
C854 DELAY_VBIASP.n9 VSS 0.44541f ; **FLOATING
C855 DELAY_VBIASP.t21 VSS 0.35917f ; **FLOATING
C856 DELAY_VBIASP.n10 VSS 0.44541f ; **FLOATING
C857 DELAY_VBIASP.t20 VSS 0.35917f ; **FLOATING
C858 DELAY_VBIASP.n11 VSS 0.44541f ; **FLOATING
C859 DELAY_VBIASP.t19 VSS 0.35917f ; **FLOATING
C860 DELAY_VBIASP.n12 VSS 0.44541f ; **FLOATING
C861 DELAY_VBIASP.t18 VSS 0.35917f ; **FLOATING
C862 DELAY_VBIASP.n13 VSS 0.44541f ; **FLOATING
C863 DELAY_VBIASP.t17 VSS 0.35917f ; **FLOATING
C864 DELAY_VBIASP.n14 VSS 0.44541f ; **FLOATING
C865 DELAY_VBIASP.t16 VSS 0.35917f ; **FLOATING
C866 DELAY_VBIASP.n15 VSS 0.44541f ; **FLOATING
C867 DELAY_VBIASP.t15 VSS 0.35917f ; **FLOATING
C868 DELAY_VBIASP.n16 VSS 0.44541f ; **FLOATING
C869 DELAY_VBIASP.t14 VSS 0.35917f ; **FLOATING
C870 DELAY_VBIASP.n17 VSS 0.44541f ; **FLOATING
C871 DELAY_VBIASP.t13 VSS 0.35917f ; **FLOATING
C872 DELAY_VBIASP.n18 VSS 0.44541f ; **FLOATING
C873 DELAY_VBIASP.t12 VSS 0.35917f ; **FLOATING
C874 DELAY_VBIASP.n19 VSS 0.44541f ; **FLOATING
C875 DELAY_VBIASP.t11 VSS 0.35917f ; **FLOATING
C876 DELAY_VBIASP.n20 VSS 0.44541f ; **FLOATING
C877 DELAY_VBIASP.t10 VSS 0.35917f ; **FLOATING
C878 DELAY_VBIASP.n21 VSS 0.44541f ; **FLOATING
C879 DELAY_VBIASP.t9 VSS 0.35917f ; **FLOATING
C880 DELAY_VBIASP.n22 VSS 0.44541f ; **FLOATING
C881 DELAY_VBIASP.t8 VSS 0.35917f ; **FLOATING
C882 DELAY_VBIASP.n23 VSS 0.44541f ; **FLOATING
C883 DELAY_VBIASP.t7 VSS 0.35917f ; **FLOATING
C884 DELAY_VBIASP.n24 VSS 0.44541f ; **FLOATING
C885 DELAY_VBIASP.t6 VSS 0.35917f ; **FLOATING
C886 DELAY_VBIASP.n25 VSS 0.44541f ; **FLOATING
C887 DELAY_VBIASP.t5 VSS 0.35917f ; **FLOATING
C888 DELAY_VBIASP.n26 VSS 0.44541f ; **FLOATING
C889 DELAY_VBIASP.t4 VSS 0.35917f ; **FLOATING
C890 DELAY_VBIASP.n27 VSS 0.44541f ; **FLOATING
C891 DELAY_VBIASP.t3 VSS 0.35917f ; **FLOATING
C892 DELAY_VBIASP.n28 VSS 0.44541f ; **FLOATING
C893 DELAY_VBIASP.t2 VSS 0.35917f ; **FLOATING
C894 DELAY_VBIASP.n29 VSS 0.44541f ; **FLOATING
C895 DELAY_VBIASP.t1 VSS 0.35917f ; **FLOATING
C896 DELAY_VBIASP.n30 VSS 0.44541f ; **FLOATING
C897 DELAY_VBIASP.t0 VSS 0.35917f ; **FLOATING
C898 DELAY_VBIASN.n0 VSS 0.25441f ; **FLOATING
C899 DELAY_VBIASN.t31 VSS 0.15177f ; **FLOATING
C900 DELAY_VBIASN.t30 VSS 0.14732f ; **FLOATING
C901 DELAY_VBIASN.n1 VSS 0.34864f ; **FLOATING
C902 DELAY_VBIASN.t29 VSS 0.14732f ; **FLOATING
C903 DELAY_VBIASN.n2 VSS 0.24183f ; **FLOATING
C904 DELAY_VBIASN.t28 VSS 0.14732f ; **FLOATING
C905 DELAY_VBIASN.n3 VSS 0.24183f ; **FLOATING
C906 DELAY_VBIASN.t27 VSS 0.14732f ; **FLOATING
C907 DELAY_VBIASN.n4 VSS 0.24183f ; **FLOATING
C908 DELAY_VBIASN.t26 VSS 0.14732f ; **FLOATING
C909 DELAY_VBIASN.n5 VSS 0.24183f ; **FLOATING
C910 DELAY_VBIASN.t25 VSS 0.14732f ; **FLOATING
C911 DELAY_VBIASN.n6 VSS 0.24183f ; **FLOATING
C912 DELAY_VBIASN.t24 VSS 0.14732f ; **FLOATING
C913 DELAY_VBIASN.n7 VSS 0.24183f ; **FLOATING
C914 DELAY_VBIASN.t23 VSS 0.14732f ; **FLOATING
C915 DELAY_VBIASN.n8 VSS 0.24183f ; **FLOATING
C916 DELAY_VBIASN.t22 VSS 0.14732f ; **FLOATING
C917 DELAY_VBIASN.n9 VSS 0.24183f ; **FLOATING
C918 DELAY_VBIASN.t21 VSS 0.14732f ; **FLOATING
C919 DELAY_VBIASN.n10 VSS 0.24183f ; **FLOATING
C920 DELAY_VBIASN.t20 VSS 0.14732f ; **FLOATING
C921 DELAY_VBIASN.n11 VSS 0.24183f ; **FLOATING
C922 DELAY_VBIASN.t19 VSS 0.14732f ; **FLOATING
C923 DELAY_VBIASN.n12 VSS 0.24183f ; **FLOATING
C924 DELAY_VBIASN.t18 VSS 0.14732f ; **FLOATING
C925 DELAY_VBIASN.n13 VSS 0.24183f ; **FLOATING
C926 DELAY_VBIASN.t17 VSS 0.14732f ; **FLOATING
C927 DELAY_VBIASN.n14 VSS 0.24183f ; **FLOATING
C928 DELAY_VBIASN.t16 VSS 0.14732f ; **FLOATING
C929 DELAY_VBIASN.n15 VSS 0.24183f ; **FLOATING
C930 DELAY_VBIASN.t15 VSS 0.14732f ; **FLOATING
C931 DELAY_VBIASN.n16 VSS 0.24183f ; **FLOATING
C932 DELAY_VBIASN.t14 VSS 0.14732f ; **FLOATING
C933 DELAY_VBIASN.n17 VSS 0.24183f ; **FLOATING
C934 DELAY_VBIASN.t13 VSS 0.14732f ; **FLOATING
C935 DELAY_VBIASN.n18 VSS 0.24183f ; **FLOATING
C936 DELAY_VBIASN.t12 VSS 0.14732f ; **FLOATING
C937 DELAY_VBIASN.n19 VSS 0.24183f ; **FLOATING
C938 DELAY_VBIASN.t11 VSS 0.14732f ; **FLOATING
C939 DELAY_VBIASN.n20 VSS 0.24183f ; **FLOATING
C940 DELAY_VBIASN.t10 VSS 0.14732f ; **FLOATING
C941 DELAY_VBIASN.n21 VSS 0.24183f ; **FLOATING
C942 DELAY_VBIASN.t9 VSS 0.14732f ; **FLOATING
C943 DELAY_VBIASN.n22 VSS 0.24183f ; **FLOATING
C944 DELAY_VBIASN.t8 VSS 0.14732f ; **FLOATING
C945 DELAY_VBIASN.n23 VSS 0.24183f ; **FLOATING
C946 DELAY_VBIASN.t7 VSS 0.14732f ; **FLOATING
C947 DELAY_VBIASN.n24 VSS 0.24183f ; **FLOATING
C948 DELAY_VBIASN.t6 VSS 0.14732f ; **FLOATING
C949 DELAY_VBIASN.n25 VSS 0.24183f ; **FLOATING
C950 DELAY_VBIASN.t5 VSS 0.14732f ; **FLOATING
C951 DELAY_VBIASN.n26 VSS 0.24183f ; **FLOATING
C952 DELAY_VBIASN.t4 VSS 0.14732f ; **FLOATING
C953 DELAY_VBIASN.n27 VSS 0.24183f ; **FLOATING
C954 DELAY_VBIASN.t3 VSS 0.14732f ; **FLOATING
C955 DELAY_VBIASN.n28 VSS 0.24183f ; **FLOATING
C956 DELAY_VBIASN.t2 VSS 0.14732f ; **FLOATING
C957 DELAY_VBIASN.n29 VSS 0.24183f ; **FLOATING
C958 DELAY_VBIASN.t1 VSS 0.14732f ; **FLOATING
C959 DELAY_VBIASN.n30 VSS 0.24183f ; **FLOATING
C960 DELAY_VBIASN.t0 VSS 0.14732f ; **FLOATING
.ends
