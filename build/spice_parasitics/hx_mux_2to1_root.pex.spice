* NGSPICE file created from hx_mux_2to1_root.ext - technology: ihp-sg13g2

.subckt hx_mux_2to1_root VSS VDD MUX_OUT MUX_SEL MUX_IN1 MUX_IN0
X0 MUX_OUT a_1155_182# VSS VSS.t3 sg13_lv_nmos ad=0.1406p pd=1.12u as=0.1371p ps=1.12u w=0.74u l=0.13u
X1 VSS a_1155_182# MUX_OUT VSS.t4 sg13_lv_nmos ad=0.2516p pd=2.16u as=0.1406p ps=1.12u w=0.74u l=0.13u
X2 a_268_162# a_69_336# MUX_IN0 VSS sg13_lv_nmos ad=0.2183p pd=1.33u as=0.2516p ps=2.16u w=0.74u l=0.13u
X3 VSS a_268_162# a_1155_182# VSS.t2 sg13_lv_nmos ad=0.1371p pd=1.12u as=0.2176p ps=1.96u w=0.64u l=0.13u
X4 MUX_IN1 a_69_336# a_268_162# VDD sg13_lv_pmos ad=0.3808p pd=2.92u as=0.3304p ps=1.71u w=1.12u l=0.13u
X5 VDD a_268_162# a_1155_182# VDD sg13_lv_pmos ad=0.2086p pd=1.5u as=0.34p ps=2.68u w=1u l=0.13u
X6 VSS MUX_SEL a_69_336# VSS.t1 sg13_lv_nmos ad=0.2516p pd=2.16u as=0.2516p ps=2.16u w=0.74u l=0.13u
X7 VDD MUX_SEL a_69_336# VDD sg13_lv_pmos ad=0.3808p pd=2.92u as=0.3808p ps=2.92u w=1.12u l=0.13u
X8 MUX_IN1 MUX_SEL a_268_162# VSS.t0 sg13_lv_nmos ad=0.2516p pd=2.16u as=0.2183p ps=1.33u w=0.74u l=0.13u
X9 MUX_OUT a_1155_182# VDD VDD sg13_lv_pmos ad=0.2128p pd=1.5u as=0.2086p ps=1.5u w=1.12u l=0.13u
X10 VDD a_1155_182# MUX_OUT VDD sg13_lv_pmos ad=0.7336p pd=3.55u as=0.2128p ps=1.5u w=1.12u l=0.13u
X11 a_268_162# MUX_SEL MUX_IN0 VDD sg13_lv_pmos ad=0.3304p pd=1.71u as=0.3808p ps=2.92u w=1.12u l=0.13u
C0 a_268_162# a_69_336# 0.16267f
C1 MUX_OUT a_1155_182# 0.44958f
C2 a_268_162# a_1155_182# 0.16855f
C3 MUX_SEL MUX_IN0 0.01227f
C4 MUX_IN1 MUX_SEL 0.01631f
C5 a_268_162# MUX_SEL 0.06527f
C6 MUX_SEL a_69_336# 0.164f
C7 VDD MUX_IN0 0.05009f
C8 VDD MUX_IN1 0.03906f
C9 VDD MUX_OUT 0.0154f
C10 VDD a_268_162# 0.29084f
C11 VDD a_69_336# 0.35363f
C12 VDD a_1155_182# 0.4957f
C13 VDD MUX_SEL 0.22548f
C14 a_268_162# MUX_IN0 0.27735f
C15 a_268_162# MUX_IN1 0.30621f
C16 a_69_336# MUX_IN0 0.13903f
C17 MUX_IN1 a_69_336# 0.31466f
R0 VSS VSS.t1 22.9462
R1 VSS.t0 VSS 60.3317
R2 VSS.t3 VSS.t4 423.505
R3 VSS VSS.t3 163.863
R4 VSS.t2 VSS 54.1884
R5 VSS VSS.t4 7.80367
C18 MUX_OUT VSS 0.20833f
C19 MUX_IN1 VSS 0.05042f
C20 MUX_IN0 VSS 0.11099f
C21 MUX_SEL VSS 0.38591f
C22 VDD VSS 0.36345f
C23 a_1155_182# VSS 0.42986f ; **FLOATING
C24 a_268_162# VSS 0.38713f ; **FLOATING
C25 a_69_336# VSS 0.4527f ; **FLOATING
.ends
