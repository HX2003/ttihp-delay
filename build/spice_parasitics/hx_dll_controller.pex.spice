* NGSPICE file created from hx_dll_controller.ext - technology: ihp-sg13g2

.subckt hx_dll_controller VDD VSS DLL_RESETN DELAY_OUT_LAST DELAY_IN DELAY_VBIASN
+ DELAY_VBIASP
X0 VSS.t82 a_12849_3240# a_13400_3678# VSS.t81 sg13_lv_nmos ad=0.1626p pd=1.415u as=60.89999f ps=0.71u w=0.42u l=0.13u
X1 VSS.t148 VSS.t148 VSS.t150 VSS.t149 sg13_lv_nmos ad=0.1406p pd=1.12u as=0 ps=0 w=0.74u l=0.13u
X2 VSS.t89 a_14851_2555# a_15688_2776# VSS.t94 sg13_lv_nmos ad=0.1406p pd=1.12u as=0.2516p ps=2.16u w=0.74u l=0.13u
X3 a_6854_2827# a_6326_1963# VDD.t10 VDD.t0 sg13_lv_pmos ad=0.38p pd=2.38u as=0.38p ps=2.38u w=2u l=1u
X4 VSS.t108 a_9444_1963# a_9444_1285# VSS.t101 sg13_lv_nmos ad=0.68p pd=4.68u as=0.38p ps=2.38u w=2u l=1u
X5 VDD.t12 a_6326_1963# a_6126_1189# VDD.t0 sg13_lv_pmos ad=0.38p pd=2.38u as=0.38p ps=2.38u w=2u l=1u
X6 a_9946_3678# a_9772_3216# VDD.t22 VDD.t0 sg13_lv_pmos ad=79.8f pd=0.8u as=0.1428p ps=1.52u w=0.42u l=0.13u
X7 a_9712_1285# a_6854_2827# a_9444_1285# VSS.t14 sg13_lv_nmos ad=0.38p pd=2.38u as=0.68p ps=4.68u w=2u l=1u
X8 a_6854_3359# a_15304_1978# DELAY_VBIASN VDD.t31 sg13_lv_pmos ad=0.136p pd=1.14u as=0.158p ps=1.245u w=0.4u l=0.2u
X9 a_9444_1285# a_9444_1963# VSS.t107 VSS.t99 sg13_lv_nmos ad=0.38p pd=2.38u as=0.68p ps=4.68u w=2u l=1u
X10 a_6326_1963# a_6126_1189# a_5778_740# VSS.t3 sg13_lv_nmos ad=0.38p pd=2.38u as=0.68p ps=4.68u w=2u l=1u
X11 a_6854_2827# a_6326_1963# VDD.t7 VDD.t0 sg13_lv_pmos ad=0.38p pd=2.38u as=0.38p ps=2.38u w=2u l=1u
X12 VSS.t89 a_15108_2698# a_14757_2555# VSS.t122 sg13_lv_nmos ad=79.8f pd=0.8u as=0.1428p ps=1.52u w=0.42u l=0.13u
X13 a_14009_3251# DELAY_IN VSS.t24 VSS.t116 sg13_lv_nmos ad=0.2516p pd=2.16u as=1.9998p ps=12.915u w=0.74u l=0.13u
X14 VSS.t58 DELAY_VBIASN VSS.t56 VSS.t41 sg13_lv_nmos ad=1.33p pd=7.38u as=0 ps=0 w=7u l=7u
X15 a_9746_3178# a_9547_3315# VSS.t24 VSS.t25 sg13_lv_nmos ad=0.27427p pd=2.28u as=2.39977p ps=15.495u w=0.795u l=0.13u
X16 VSS.t19 DLL_RESETN a_10040_3678# VSS.t18 sg13_lv_nmos ad=0.1626p pd=1.415u as=60.89999f ps=0.71u w=0.42u l=0.13u
X17 a_13949_2869# a_13592_2796# VDD.t42 VDD.t0 sg13_lv_pmos ad=63f pd=0.72u as=0.1563p ps=1.22u w=0.42u l=0.13u
X18 VSS.t134 VSS.t132 VSS.t132 VSS.t133 sg13_lv_nmos ad=0.68p pd=4.68u as=0 ps=0 w=2u l=1u
X19 a_9772_3216# a_9746_3178# VDD.t18 VDD.t0 sg13_lv_pmos ad=0.3927p pd=2.99u as=1.10612p ps=6.66u w=1.155u l=0.13u
X20 a_13121_3204# a_15688_3240# VDD.t34 VDD.t0 sg13_lv_pmos ad=0.3808p pd=2.92u as=0.2128p ps=1.5u w=1.12u l=0.13u
X21 a_15108_3482# a_14851_3601# a_15270_3678# VSS.t76 sg13_lv_nmos ad=0.1428p pd=1.52u as=37.8f ps=0.6u w=0.42u l=0.13u
X22 VSS.t73 a_12907_2559# a_12907_2559# VSS.t117 sg13_lv_nmos ad=1.45407p pd=9.445u as=0.111p ps=1.34u w=0.3u l=0.13u
X23 VDD.t79 VDD.t77 VDD.t78 VDD.t31 sg13_lv_pmos ad=0.3808p pd=2.92u as=0 ps=0 w=1.12u l=0.13u
X24 VSS.t137 VSS.t129 VSS.t129 VSS.t130 sg13_lv_nmos ad=0.68p pd=4.68u as=0 ps=0 w=2u l=1u
X25 a_15108_2698# a_12849_3240# VDD.t18 VDD.t0 sg13_lv_pmos ad=79.8f pd=0.8u as=1.03698p ps=6.245u w=0.42u l=0.13u
X26 a_13121_3204# a_15688_3240# VSS.t80 VSS.t91 sg13_lv_nmos ad=0.2516p pd=2.16u as=0.1406p ps=1.12u w=0.74u l=0.13u
X27 VDD.t74 VDD.t75 VDD.t76 VDD.t31 sg13_lv_pmos ad=0.2128p pd=1.5u as=0 ps=0 w=1.12u l=0.13u
X28 a_5974_3096# a_6126_1189# VSS.t11 VSS.t0 sg13_lv_nmos ad=0.38p pd=2.38u as=0.68p ps=4.68u w=2u l=1u
X29 VDD.t17 a_5974_3096# a_5974_3096# VDD.t0 sg13_lv_pmos ad=0.2448p pd=2.08u as=0.2826p ps=2.29u w=0.36u l=2u
X30 VSS.t21 a_11748_3482# a_11397_3601# VSS.t2 sg13_lv_nmos ad=79.8f pd=0.8u as=0.1428p ps=1.52u w=0.42u l=0.13u
X31 VSS.t60 DELAY_VBIASN VSS.t58 VSS.t43 sg13_lv_nmos ad=1.33p pd=7.38u as=0 ps=0 w=7u l=7u
X32 a_6326_1963# a_6126_1189# a_5778_740# VSS.t3 sg13_lv_nmos ad=0.38p pd=2.38u as=0.68p ps=4.68u w=2u l=1u
X33 VDD.t69 VDD.t61 VDD.t10 VDD.t0 sg13_lv_pmos ad=0.68p pd=4.68u as=0 ps=0 w=2u l=1u
X34 VSS.t36 DELAY_VBIASN VSS.t38 VSS.t37 sg13_lv_nmos ad=1.33p pd=7.38u as=0 ps=0 w=7u l=7u
X35 a_13306_2478# a_13132_2793# VDD.t84 VDD.t0 sg13_lv_pmos ad=79.8f pd=0.8u as=0.1428p ps=1.52u w=0.42u l=0.13u
X36 a_6126_1189# a_6126_1189# VSS.t5 VSS.t3 sg13_lv_nmos ad=0.38p pd=2.38u as=0.68p ps=4.68u w=2u l=1u
X37 a_6326_1963# a_6326_1963# VDD.t2 VDD.t0 sg13_lv_pmos ad=0.38p pd=2.38u as=0.38p ps=2.38u w=2u l=1u
X38 a_13592_3244# a_13566_3208# VSS.t82 VSS.t81 sg13_lv_nmos ad=0.2516p pd=2.16u as=0.1626p ps=1.415u w=0.74u l=0.13u
X39 VSS.t54 DELAY_VBIASN VSS.t52 VSS.t37 sg13_lv_nmos ad=1.33p pd=7.38u as=0 ps=0 w=7u l=7u
X40 VDD.t7 a_6326_1963# a_6126_1189# VDD.t0 sg13_lv_pmos ad=0.38p pd=2.38u as=0.38p ps=2.38u w=2u l=1u
X41 VDD.t18 a_11491_3601# a_11748_3482# VDD.t0 sg13_lv_pmos ad=1.10612p pd=6.66u as=79.8f ps=0.8u w=0.42u l=0.13u
X42 VSS.t50 DELAY_VBIASN VSS.t48 VSS.t33 sg13_lv_nmos ad=1.33p pd=7.38u as=0 ps=0 w=7u l=7u
X43 VDD.t83 DELAY_VBIASP DELAY_VBIASP VDD.t31 sg13_lv_pmos ad=0.3808p pd=2.92u as=1.0304p ps=4.08u w=1.12u l=0.6u
X44 VSS.t42 DELAY_VBIASN VSS.t44 VSS.t43 sg13_lv_nmos ad=1.33p pd=7.38u as=0 ps=0 w=7u l=7u
X45 VDD.t2 a_6326_1963# a_6854_3359# VDD.t0 sg13_lv_pmos ad=0.38p pd=2.38u as=0.38p ps=2.38u w=2u l=1u
X46 a_13132_2793# a_13106_2730# VDD.t18 VDD.t0 sg13_lv_pmos ad=0.3927p pd=2.99u as=1.10612p ps=6.66u w=1.155u l=0.13u
X47 a_14009_3251# DELAY_IN VDD.t18 VDD.t0 sg13_lv_pmos ad=0.4088p pd=2.97u as=1.03698p ps=6.245u w=1.12u l=0.13u
X48 a_15108_3482# a_12849_3240# VDD.t18 VDD.t0 sg13_lv_pmos ad=79.8f pd=0.8u as=1.03698p ps=6.245u w=0.42u l=0.13u
X49 VSS.t56 DELAY_VBIASN VSS.t54 VSS.t39 sg13_lv_nmos ad=1.33p pd=7.38u as=0 ps=0 w=7u l=7u
X50 VDD.t21 a_11491_3601# a_12158_3240# VDD.t0 sg13_lv_pmos ad=0.2128p pd=1.5u as=0.3864p ps=2.93u w=1.12u l=0.13u
X51 a_5778_740# VSS.t125 VSS.t124 rppd l=32u w=1u
X52 VSS.t106 a_9444_1963# a_9444_1285# VSS.t105 sg13_lv_nmos ad=0.68p pd=4.68u as=0.38p ps=2.38u w=2u l=1u
X53 a_13880_2491# a_14111_2600# a_13566_2701# VSS.t127 sg13_lv_nmos ad=0.2373p pd=1.97u as=79.8f ps=0.8u w=0.42u l=0.13u
X54 VSS.t21 a_11491_3601# a_12158_3240# VSS.t20 sg13_lv_nmos ad=0.1406p pd=1.12u as=0.2516p ps=2.16u w=0.74u l=0.13u
X55 a_11693_3363# a_10751_3251# a_11491_3601# VDD.t0 sg13_lv_pmos ad=93.45f pd=0.865u as=0.2048p ps=1.63u w=0.42u l=0.13u
X56 a_13306_3678# a_12355_3240# VDD.t27 VDD.t0 sg13_lv_pmos ad=79.8f pd=0.8u as=0.1428p ps=1.52u w=0.42u l=0.13u
X57 VDD.t18 a_12907_2559# a_12907_2793# VDD.t0 sg13_lv_pmos ad=1.10612p pd=6.66u as=0.2442p ps=2.06u w=0.66u l=0.13u
X58 a_13566_2701# a_14009_2457# a_13949_2869# VDD.t0 sg13_lv_pmos ad=79.8f pd=0.8u as=63f ps=0.72u w=0.42u l=0.13u
X59 a_13306_3678# a_14111_3251# a_13566_3208# VDD.t0 sg13_lv_pmos ad=0.1428p pd=1.52u as=79.8f ps=0.8u w=0.42u l=0.13u
X60 a_13106_2730# a_12907_2793# VSS.t73 VSS.t96 sg13_lv_nmos ad=0.27427p pd=2.28u as=1.45407p ps=9.445u w=0.795u l=0.13u
X61 VSS.t46 DELAY_VBIASN VSS.t45 VSS.t28 sg13_lv_nmos ad=2.38p pd=14.68u as=0 ps=0 w=7u l=7u
X62 a_13566_3208# a_14009_3251# a_13306_3678# VSS.t74 sg13_lv_nmos ad=79.8f pd=0.8u as=0.1296p ps=1.52u w=0.42u l=0.13u
X63 a_13019_3204# a_15688_2776# VSS.t89 VSS.t97 sg13_lv_nmos ad=0.2516p pd=2.16u as=0.1406p ps=1.12u w=0.74u l=0.13u
X64 VDD.t19 DLL_RESETN a_9946_3678# VDD.t0 sg13_lv_pmos ad=0.36237p pd=2.605u as=79.8f ps=0.8u w=0.42u l=0.13u
X65 a_6326_1963# a_5974_3096# a_6126_1189# VSS.t0 sg13_lv_nmos ad=0.38p pd=2.38u as=0.68p ps=4.68u w=2u l=1u
X66 a_5778_740# a_6126_1189# a_6326_1963# VSS.t3 sg13_lv_nmos ad=0.68p pd=4.68u as=0.38p ps=2.38u w=2u l=1u
X67 a_9444_1285# a_6854_2827# a_9712_1285# VSS.t17 sg13_lv_nmos ad=0.68p pd=4.68u as=0.38p ps=2.38u w=2u l=1u
X68 a_6854_3359# a_6326_1963# VDD.t1 VDD.t0 sg13_lv_pmos ad=0.38p pd=2.38u as=0.38p ps=2.38u w=2u l=1u
X69 a_9712_1285# a_13019_3204# DELAY_VBIASN VSS.t64 sg13_lv_nmos ad=0.136p pd=1.14u as=0.232p ps=2.08u w=0.4u l=0.2u
X70 a_13818_2491# a_12849_3240# VSS.t85 VSS.t87 sg13_lv_nmos ad=37.8f pd=0.6u as=0.1701p ps=1.65u w=0.42u l=0.13u
X71 VDD.t4 a_6326_1963# a_6326_1963# VDD.t0 sg13_lv_pmos ad=0.38p pd=2.38u as=0.38p ps=2.38u w=2u l=1u
X72 VDD.t42 a_12849_3240# a_13566_2701# VDD.t0 sg13_lv_pmos ad=0.1563p pd=1.22u as=0.147p ps=1.54u w=0.42u l=0.13u
X73 VSS.t32 DELAY_VBIASN VSS.t34 VSS.t33 sg13_lv_nmos ad=1.33p pd=7.38u as=0 ps=0 w=7u l=7u
X74 a_15270_2478# a_12849_3240# VSS.t89 VSS.t88 sg13_lv_nmos ad=37.8f pd=0.6u as=79.8f ps=0.8u w=0.42u l=0.13u
X75 a_15304_1978# a_14851_3601# VDD.t35 VDD.t0 sg13_lv_pmos ad=0.4312p pd=3.01u as=0.2639p ps=1.81u w=1.12u l=0.13u
X76 a_15304_1978# a_14851_3601# VSS.t78 VSS.t77 sg13_lv_nmos ad=0.2849p pd=2.25u as=0.2516p ps=2.16u w=0.74u l=0.13u
X77 a_9444_1285# a_9444_1963# VSS.t104 VSS.t103 sg13_lv_nmos ad=0.38p pd=2.38u as=0.68p ps=4.68u w=2u l=1u
X78 VDD.t45 a_14851_2555# a_15108_2698# VDD.t0 sg13_lv_pmos ad=0.2639p pd=1.81u as=79.8f ps=0.8u w=0.42u l=0.13u
X79 a_13400_2478# a_13132_2793# a_13306_2478# VSS.t126 sg13_lv_nmos ad=60.89999f pd=0.71u as=0.1428p ps=1.52u w=0.42u l=0.13u
X80 a_11910_3678# DLL_RESETN VSS.t21 VSS.t2 sg13_lv_nmos ad=37.8f pd=0.6u as=79.8f ps=0.8u w=0.42u l=0.13u
X81 a_12849_3240# a_12656_3237# VSS.t21 VSS.t65 sg13_lv_nmos ad=0.1406p pd=1.12u as=0.2516p ps=2.16u w=0.74u l=0.13u
X82 a_5974_3096# a_6126_1189# VSS.t7 VSS.t0 sg13_lv_nmos ad=0.38p pd=2.38u as=0.68p ps=4.68u w=2u l=1u
X83 a_13880_3665# a_13592_3244# a_13818_3665# VSS.t151 sg13_lv_nmos ad=0.1428p pd=1.52u as=37.8f ps=0.6u w=0.42u l=0.13u
X84 VSS.t48 DELAY_VBIASN VSS.t46 VSS.t31 sg13_lv_nmos ad=1.33p pd=7.38u as=0 ps=0 w=7u l=7u
X85 a_5974_3096# a_6126_1189# VSS.t9 VSS.t0 sg13_lv_nmos ad=0.38p pd=2.38u as=0.68p ps=4.68u w=2u l=1u
X86 a_13592_2796# a_13566_2701# VSS.t85 VSS.t118 sg13_lv_nmos ad=0.2516p pd=2.16u as=0.1626p ps=1.415u w=0.74u l=0.13u
X87 a_12656_3237# DLL_RESETN VSS.t21 VSS.t114 sg13_lv_nmos ad=0.2516p pd=2.16u as=0.2516p ps=2.16u w=0.74u l=0.13u
X88 a_14851_3601# a_14009_3251# a_14757_3601# VSS.t76 sg13_lv_nmos ad=0.12665p pd=1.145u as=0.1428p ps=1.52u w=0.42u l=0.13u
X89 a_9712_1285# a_6854_2827# a_9444_1285# VSS.t16 sg13_lv_nmos ad=0.38p pd=2.38u as=0.68p ps=4.68u w=2u l=1u
X90 VDD.t63 VDD.t61 VDD.t1 VDD.t0 sg13_lv_pmos ad=0.68p pd=4.68u as=0 ps=0 w=2u l=1u
X91 VDD.t26 a_13019_3204# a_12943_3240# VDD.t0 sg13_lv_pmos ad=0.2128p pd=1.5u as=0.2128p ps=1.5u w=1.12u l=0.13u
X92 VSS.t78 a_15108_3482# a_14757_3601# VSS.t76 sg13_lv_nmos ad=79.8f pd=0.8u as=0.1428p ps=1.52u w=0.42u l=0.13u
X93 VDD.t41 a_12849_3240# a_13306_2478# VDD.t0 sg13_lv_pmos ad=0.36237p pd=2.605u as=79.8f ps=0.8u w=0.42u l=0.13u
X94 a_10520_3665# a_10232_3244# a_10458_3665# VSS.t61 sg13_lv_nmos ad=0.1428p pd=1.52u as=37.8f ps=0.6u w=0.42u l=0.13u
X95 a_15053_2793# a_14111_2600# a_14851_2555# VDD.t0 sg13_lv_pmos ad=93.45f pd=0.865u as=0.2048p ps=1.63u w=0.42u l=0.13u
X96 a_12656_3237# DLL_RESETN VDD.t54 VDD.t0 sg13_lv_pmos ad=0.3808p pd=2.92u as=0.3808p ps=2.92u w=1.12u l=0.13u
X97 a_11491_3601# a_10649_3251# a_11397_3601# VSS.t2 sg13_lv_nmos ad=0.12665p pd=1.145u as=0.1428p ps=1.52u w=0.42u l=0.13u
X98 VSS.t21 a_13121_3204# a_13045_3588# VSS.t71 sg13_lv_nmos ad=0.2516p pd=2.16u as=0.1406p ps=1.12u w=0.74u l=0.13u
X99 VDD.t47 a_14851_2555# a_15688_2776# VDD.t0 sg13_lv_pmos ad=0.2128p pd=1.5u as=0.3864p ps=2.93u w=1.12u l=0.13u
X100 a_14009_2457# DELAY_OUT_LAST VSS.t73 VSS.t72 sg13_lv_nmos ad=0.2516p pd=2.16u as=1.45407p ps=9.445u w=0.74u l=0.13u
X101 VDD.t35 a_14851_3601# a_15108_3482# VDD.t0 sg13_lv_pmos ad=0.2639p pd=1.81u as=79.8f ps=0.8u w=0.42u l=0.13u
X102 a_13592_2796# a_13566_2701# VDD.t41 VDD.t0 sg13_lv_pmos ad=0.34p pd=2.68u as=0.36237p ps=2.605u w=1u l=0.13u
X103 VSS.t110 a_9444_1963# a_9444_1963# VSS.t105 sg13_lv_nmos ad=0.68p pd=4.68u as=0.38p ps=2.38u w=2u l=1u
X104 a_12355_3240# a_12158_3240# VDD.t21 VDD.t0 sg13_lv_pmos ad=0.3808p pd=2.92u as=0.2128p ps=1.5u w=1.12u l=0.13u
X105 VSS.t38 DELAY_VBIASN VSS.t40 VSS.t39 sg13_lv_nmos ad=1.33p pd=7.38u as=0 ps=0 w=7u l=7u
X106 a_14009_2457# DELAY_OUT_LAST VDD.t18 VDD.t0 sg13_lv_pmos ad=0.4088p pd=2.97u as=1.10612p ps=6.66u w=1.12u l=0.13u
X107 a_10206_3208# a_10649_3251# a_10589_3287# VDD.t0 sg13_lv_pmos ad=79.8f pd=0.8u as=63f ps=0.72u w=0.42u l=0.13u
X108 a_12355_3240# a_12158_3240# VSS.t21 VSS.t69 sg13_lv_nmos ad=0.2516p pd=2.16u as=0.1406p ps=1.12u w=0.74u l=0.13u
X109 VDD.t37 a_12849_3240# a_13306_3678# VDD.t0 sg13_lv_pmos ad=0.36237p pd=2.605u as=79.8f ps=0.8u w=0.42u l=0.13u
X110 a_10040_3678# a_9772_3216# a_9946_3678# VSS.t22 sg13_lv_nmos ad=60.89999f pd=0.71u as=0.1428p ps=1.52u w=0.42u l=0.13u
X111 a_10520_3665# a_10751_3251# a_10206_3208# VSS.t1 sg13_lv_nmos ad=0.2373p pd=1.97u as=79.8f ps=0.8u w=0.42u l=0.13u
X112 VSS.t34 DELAY_VBIASN VSS.t36 VSS.t35 sg13_lv_nmos ad=1.33p pd=7.38u as=0 ps=0 w=7u l=7u
X113 a_15464_1057# a_14851_2555# VSS.t89 VSS.t95 sg13_lv_nmos ad=0.2849p pd=2.25u as=0.2516p ps=2.16u w=0.74u l=0.13u
X114 a_6126_1189# a_5974_3096# a_6326_1963# VSS.t0 sg13_lv_nmos ad=0.68p pd=4.68u as=0.38p ps=2.38u w=2u l=1u
X115 VSS.t24 a_14009_3251# a_14111_3251# VSS.t75 sg13_lv_nmos ad=2.39977p pd=15.495u as=0.2516p ps=2.16u w=0.74u l=0.13u
X116 a_9444_1963# a_6854_2827# a_6854_2827# VSS.t17 sg13_lv_nmos ad=0.68p pd=4.68u as=0.38p ps=2.38u w=2u l=1u
X117 a_13592_2796# a_14111_2600# a_14851_2555# VSS.t128 sg13_lv_nmos ad=0.3473p pd=2.71u as=0.12665p ps=1.145u w=0.74u l=0.13u
X118 VSS.t148 VSS.t145 VSS.t147 VSS.t146 sg13_lv_nmos ad=0.2516p pd=2.16u as=0 ps=0 w=0.74u l=0.13u
X119 VSS.t142 VSS.t142 VSS.t144 VSS.t143 sg13_lv_nmos ad=0.1406p pd=1.12u as=0 ps=0 w=0.74u l=0.13u
X120 a_15053_3363# a_14111_3251# a_14851_3601# VDD.t0 sg13_lv_pmos ad=93.45f pd=0.865u as=0.2048p ps=1.63u w=0.42u l=0.13u
X121 VDD.t18 a_9547_3545# a_9547_3315# VDD.t0 sg13_lv_pmos ad=1.10612p pd=6.66u as=0.2442p ps=2.06u w=0.66u l=0.13u
X122 VSS.t24 a_10649_3251# a_10751_3251# VSS.t68 sg13_lv_nmos ad=2.39977p pd=15.495u as=0.2516p ps=2.16u w=0.74u l=0.13u
X123 VSS.t52 DELAY_VBIASN VSS.t50 VSS.t35 sg13_lv_nmos ad=1.33p pd=7.38u as=0 ps=0 w=7u l=7u
X124 a_9444_1963# a_9444_1963# VSS.t109 VSS.t103 sg13_lv_nmos ad=0.38p pd=2.38u as=0.68p ps=4.68u w=2u l=1u
X125 a_14851_2555# a_14009_2457# a_14757_2555# VSS.t121 sg13_lv_nmos ad=0.12665p pd=1.145u as=0.1428p ps=1.52u w=0.42u l=0.13u
X126 VDD.t5 VDD.t64 VDD.t71 VDD.t0 sg13_lv_pmos ad=0.38p pd=2.38u as=0 ps=0 w=2u l=1u
X127 a_14851_2555# a_14009_2457# a_13592_2796# VDD.t0 sg13_lv_pmos ad=0.2048p pd=1.63u as=0.34p ps=2.68u w=1u l=0.13u
X128 VSS.t30 DELAY_VBIASN VSS.t29 VSS.t28 sg13_lv_nmos ad=2.38p pd=14.68u as=0 ps=0 w=7u l=7u
X129 VSS.t27 DELAY_VBIASN DELAY_VBIASP VSS.t26 sg13_lv_nmos ad=0.2516p pd=2.16u as=0.6808p ps=3.32u w=0.74u l=0.6u
X130 DELAY_VBIASN DLL_RESETN VDD.t52 VDD.t31 sg13_lv_pmos ad=0.158p pd=1.245u as=0.272p ps=2.28u w=0.8u l=0.2u
X131 VDD.t74 VDD.t72 VDD.t73 VDD.t31 sg13_lv_pmos ad=0.3808p pd=2.92u as=0 ps=0 w=1.12u l=0.13u
X132 a_13949_3287# a_13592_3244# VDD.t38 VDD.t0 sg13_lv_pmos ad=63f pd=0.72u as=0.1563p ps=1.22u w=0.42u l=0.13u
X133 VDD.t79 VDD.t80 VDD.t81 VDD.t31 sg13_lv_pmos ad=0.2128p pd=1.5u as=0 ps=0 w=1.12u l=0.13u
X134 a_10232_3244# a_10206_3208# VDD.t19 VDD.t0 sg13_lv_pmos ad=0.34p pd=2.68u as=0.36237p ps=2.605u w=1u l=0.13u
X135 VSS.t70 a_13121_3204# a_6854_3359# VDD.t31 sg13_lv_pmos ad=0.232p pd=2.08u as=0.136p ps=1.14u w=0.4u l=0.2u
X136 a_5778_740# a_6126_1189# a_6326_1963# VSS.t3 sg13_lv_nmos ad=0.68p pd=4.68u as=0.38p ps=2.38u w=2u l=1u
X137 VDD.t24 DLL_RESETN a_10206_3208# VDD.t0 sg13_lv_pmos ad=0.1563p pd=1.22u as=0.147p ps=1.54u w=0.42u l=0.13u
X138 a_13592_3244# a_14111_3251# a_14851_3601# VSS.t76 sg13_lv_nmos ad=0.3473p pd=2.71u as=0.12665p ps=1.145u w=0.74u l=0.13u
X139 a_6854_2827# a_6854_2827# a_9444_1963# VSS.t16 sg13_lv_nmos ad=0.38p pd=2.38u as=0.68p ps=4.68u w=2u l=1u
X140 a_5778_740# a_6126_1189# a_6326_1963# VSS.t3 sg13_lv_nmos ad=0.68p pd=4.68u as=0.38p ps=2.38u w=2u l=1u
X141 VSS.t29 DELAY_VBIASN VSS.t32 VSS.t31 sg13_lv_nmos ad=1.33p pd=7.38u as=0 ps=0 w=7u l=7u
X142 a_10589_3287# a_10232_3244# VDD.t24 VDD.t0 sg13_lv_pmos ad=63f pd=0.72u as=0.1563p ps=1.22u w=0.42u l=0.13u
X143 a_15270_3678# a_12849_3240# VSS.t78 VSS.t76 sg13_lv_nmos ad=37.8f pd=0.6u as=79.8f ps=0.8u w=0.42u l=0.13u
X144 VDD.t18 a_14009_3251# a_14111_3251# VDD.t0 sg13_lv_pmos ad=1.10612p pd=6.66u as=0.3864p ps=2.93u w=1.12u l=0.13u
X145 a_6326_1963# a_6126_1189# a_5778_740# VSS.t3 sg13_lv_nmos ad=0.42p pd=2.42u as=0.68p ps=4.68u w=2u l=1u
X146 a_6326_1963# a_6326_1963# VDD.t12 VDD.t0 sg13_lv_pmos ad=0.38p pd=2.38u as=0.38p ps=2.38u w=2u l=1u
X147 a_10232_3244# a_10751_3251# a_11491_3601# VSS.t2 sg13_lv_nmos ad=0.3473p pd=2.71u as=0.12665p ps=1.145u w=0.74u l=0.13u
X148 VDD.t5 a_6326_1963# a_6854_3359# VDD.t0 sg13_lv_pmos ad=0.38p pd=2.38u as=0.38p ps=2.38u w=2u l=1u
X149 VDD.t18 a_11748_3482# a_11693_3363# VDD.t0 sg13_lv_pmos ad=1.10612p pd=6.66u as=93.45f ps=0.865u w=0.42u l=0.13u
X150 VSS.t85 a_12849_3240# a_13400_2478# VSS.t84 sg13_lv_nmos ad=0.1626p pd=1.415u as=60.89999f ps=0.71u w=0.42u l=0.13u
X151 a_13400_3678# a_12355_3240# a_13306_3678# VSS.t66 sg13_lv_nmos ad=60.89999f pd=0.71u as=0.1428p ps=1.52u w=0.42u l=0.13u
X152 a_13019_3204# a_15688_2776# VDD.t47 VDD.t0 sg13_lv_pmos ad=0.3808p pd=2.92u as=0.2128p ps=1.5u w=1.12u l=0.13u
X153 VDD.t18 a_10649_3251# a_10751_3251# VDD.t0 sg13_lv_pmos ad=1.10612p pd=6.66u as=0.3864p ps=2.93u w=1.12u l=0.13u
X154 a_9444_1963# a_6854_2827# a_6854_2827# VSS.t15 sg13_lv_nmos ad=0.68p pd=4.68u as=0.38p ps=2.38u w=2u l=1u
X155 a_10458_3665# DLL_RESETN VSS.t19 VSS.t113 sg13_lv_nmos ad=37.8f pd=0.6u as=0.1701p ps=1.65u w=0.42u l=0.13u
X156 a_13566_2701# a_14009_2457# a_13306_2478# VSS.t119 sg13_lv_nmos ad=79.8f pd=0.8u as=0.1296p ps=1.52u w=0.42u l=0.13u
X157 a_13306_2478# a_14111_2600# a_13566_2701# VDD.t0 sg13_lv_pmos ad=0.1428p pd=1.52u as=79.8f ps=0.8u w=0.42u l=0.13u
X158 a_6326_1963# a_6126_1189# a_5778_740# VSS.t3 sg13_lv_nmos ad=0.38p pd=2.38u as=0.68p ps=4.68u w=2u l=1u
X159 a_13880_2491# a_13592_2796# a_13818_2491# VSS.t123 sg13_lv_nmos ad=0.1428p pd=1.52u as=37.8f ps=0.6u w=0.42u l=0.13u
X160 a_15108_2698# a_14851_2555# a_15270_2478# VSS.t93 sg13_lv_nmos ad=0.1428p pd=1.52u as=37.8f ps=0.6u w=0.42u l=0.13u
X161 a_13566_3208# a_14009_3251# a_13949_3287# VDD.t0 sg13_lv_pmos ad=79.8f pd=0.8u as=63f ps=0.72u w=0.42u l=0.13u
X162 a_11491_3601# a_10649_3251# a_10232_3244# VDD.t0 sg13_lv_pmos ad=0.2048p pd=1.63u as=0.34p ps=2.68u w=1u l=0.13u
X163 a_5778_740# a_6126_1189# a_6326_1963# VSS.t3 sg13_lv_nmos ad=0.68p pd=4.68u as=0.42p ps=2.42u w=2u l=1u
X164 a_13880_3665# a_14111_3251# a_13566_3208# VSS.t92 sg13_lv_nmos ad=0.2373p pd=1.97u as=79.8f ps=0.8u w=0.42u l=0.13u
X165 VSS.t6 a_6126_1189# a_6126_1189# VSS.t3 sg13_lv_nmos ad=0.68p pd=4.68u as=0.38p ps=2.38u w=2u l=1u
X166 a_6854_3359# a_6326_1963# VDD.t15 VDD.t0 sg13_lv_pmos ad=0.38p pd=2.38u as=0.38p ps=2.38u w=2u l=1u
X167 a_11748_3482# a_11491_3601# a_11910_3678# VSS.t2 sg13_lv_nmos ad=0.1428p pd=1.52u as=37.8f ps=0.6u w=0.42u l=0.13u
X168 VSS.t102 a_9444_1963# a_9444_1963# VSS.t101 sg13_lv_nmos ad=0.68p pd=4.68u as=0.38p ps=2.38u w=2u l=1u
X169 a_12943_3240# a_12656_3237# a_12849_3240# VDD.t0 sg13_lv_pmos ad=0.2128p pd=1.5u as=0.3808p ps=2.92u w=1.12u l=0.13u
X170 a_13592_3244# a_13566_3208# VDD.t37 VDD.t0 sg13_lv_pmos ad=0.34p pd=2.68u as=0.36237p ps=2.605u w=1u l=0.13u
X171 a_6854_2827# a_6854_2827# a_9444_1963# VSS.t14 sg13_lv_nmos ad=0.38p pd=2.38u as=0.68p ps=4.68u w=2u l=1u
X172 VDD.t38 a_12849_3240# a_13566_3208# VDD.t0 sg13_lv_pmos ad=0.1563p pd=1.22u as=0.147p ps=1.54u w=0.42u l=0.13u
X173 a_9444_1963# a_9444_1963# VSS.t100 VSS.t99 sg13_lv_nmos ad=0.38p pd=2.38u as=0.68p ps=4.68u w=2u l=1u
X174 VDD.t34 a_14851_3601# a_15688_3240# VDD.t0 sg13_lv_pmos ad=0.2128p pd=1.5u as=0.3864p ps=2.93u w=1.12u l=0.13u
X175 VSS.t9 a_6126_1189# a_5974_3096# VSS.t0 sg13_lv_nmos ad=0.68p pd=4.68u as=0.38p ps=2.38u w=2u l=1u
X176 VDD.t66 VDD.t64 VDD.t9 VDD.t0 sg13_lv_pmos ad=0.38p pd=2.38u as=0 ps=0 w=2u l=1u
X177 VSS.t80 a_14851_3601# a_15688_3240# VSS.t79 sg13_lv_nmos ad=0.1406p pd=1.12u as=0.2516p ps=2.16u w=0.74u l=0.13u
X178 VDD.t49 a_15464_1057# a_9712_1285# VSS.t98 sg13_lv_nmos ad=0.232p pd=2.08u as=0.136p ps=1.14u w=0.4u l=0.2u
X179 VSS.t134 VSS.t132 VSS.t132 VSS.t133 sg13_lv_nmos ad=0.68p pd=4.68u as=0 ps=0 w=2u l=1u
X180 VDD.t18 a_15108_2698# a_15053_2793# VDD.t0 sg13_lv_pmos ad=1.10612p pd=6.66u as=93.45f ps=0.865u w=0.42u l=0.13u
X181 VSS.t40 DELAY_VBIASN VSS.t42 VSS.t41 sg13_lv_nmos ad=1.33p pd=7.38u as=0 ps=0 w=7u l=7u
X182 a_10649_3251# DELAY_IN VSS.t24 VSS.t115 sg13_lv_nmos ad=0.2516p pd=2.16u as=1.9998p ps=12.915u w=0.74u l=0.13u
X183 VSS.t7 a_6126_1189# a_5974_3096# VSS.t0 sg13_lv_nmos ad=0.68p pd=4.68u as=0.38p ps=2.38u w=2u l=1u
X184 VSS.t129 VSS.t129 VSS.t131 VSS.t130 sg13_lv_nmos ad=0.68p pd=4.68u as=0 ps=0 w=2u l=1u
X185 VSS.t73 a_14009_2457# a_14111_2600# VSS.t120 sg13_lv_nmos ad=1.45407p pd=9.445u as=0.2516p ps=2.16u w=0.74u l=0.13u
X186 a_6126_1189# a_6326_1963# VDD.t11 VDD.t0 sg13_lv_pmos ad=0.38p pd=2.38u as=0.38p ps=2.38u w=2u l=1u
X187 VDD.t15 a_6326_1963# a_6326_1963# VDD.t0 sg13_lv_pmos ad=0.38p pd=2.38u as=0.38p ps=2.38u w=2u l=1u
X188 a_12943_3240# a_13121_3204# VDD.t26 VDD.t0 sg13_lv_pmos ad=0.3808p pd=2.92u as=0.2128p ps=1.5u w=1.12u l=0.13u
X189 VDD.t18 a_14009_2457# a_14111_2600# VDD.t0 sg13_lv_pmos ad=1.10612p pd=6.66u as=0.3864p ps=2.93u w=1.12u l=0.13u
X190 VDD.t11 a_6326_1963# a_6854_2827# VDD.t0 sg13_lv_pmos ad=0.38p pd=2.38u as=0.38p ps=2.38u w=2u l=1u
X191 a_11748_3482# DLL_RESETN VDD.t18 VDD.t0 sg13_lv_pmos ad=79.8f pd=0.8u as=1.10612p ps=6.66u w=0.42u l=0.13u
X192 a_13818_3665# a_12849_3240# VSS.t82 VSS.t86 sg13_lv_nmos ad=37.8f pd=0.6u as=0.1701p ps=1.65u w=0.42u l=0.13u
X193 a_15464_1057# a_14851_2555# VDD.t45 VDD.t0 sg13_lv_pmos ad=0.4312p pd=3.01u as=0.2639p ps=1.81u w=1.12u l=0.13u
X194 a_9444_1285# a_6854_2827# a_9712_1285# VSS.t15 sg13_lv_nmos ad=0.68p pd=4.68u as=0.38p ps=2.38u w=2u l=1u
X195 a_6126_1189# a_6326_1963# VDD.t4 VDD.t0 sg13_lv_pmos ad=0.38p pd=2.38u as=0.38p ps=2.38u w=2u l=1u
X196 VSS.t24 a_9547_3545# a_9547_3545# VSS.t23 sg13_lv_nmos ad=2.39977p pd=15.495u as=0.111p ps=1.34u w=0.3u l=0.13u
X197 VDD.t9 a_6326_1963# a_6854_2827# VDD.t0 sg13_lv_pmos ad=0.38p pd=2.38u as=0.38p ps=2.38u w=2u l=1u
X198 a_13045_3588# a_13019_3204# a_12849_3240# VSS.t63 sg13_lv_nmos ad=0.1406p pd=1.12u as=0.1406p ps=1.12u w=0.74u l=0.13u
X199 a_10232_3244# a_10206_3208# VSS.t19 VSS.t18 sg13_lv_nmos ad=0.2516p pd=2.16u as=0.1626p ps=1.415u w=0.74u l=0.13u
X200 VDD.t18 a_15108_3482# a_15053_3363# VDD.t0 sg13_lv_pmos ad=1.10612p pd=6.66u as=93.45f ps=0.865u w=0.42u l=0.13u
X201 a_5974_3096# a_6126_1189# VSS.t4 VSS.t0 sg13_lv_nmos ad=0.38p pd=2.38u as=0.68p ps=4.68u w=2u l=1u
X202 a_9946_3678# a_10751_3251# a_10206_3208# VDD.t0 sg13_lv_pmos ad=0.1428p pd=1.52u as=79.8f ps=0.8u w=0.42u l=0.13u
X203 a_14851_3601# a_14009_3251# a_13592_3244# VDD.t0 sg13_lv_pmos ad=0.2048p pd=1.63u as=0.34p ps=2.68u w=1u l=0.13u
X204 a_10206_3208# a_10649_3251# a_9946_3678# VSS.t67 sg13_lv_nmos ad=79.8f pd=0.8u as=0.1296p ps=1.52u w=0.42u l=0.13u
X205 VSS.t13 a_6126_1189# a_5974_3096# VSS.t0 sg13_lv_nmos ad=0.68p pd=4.68u as=0.38p ps=2.38u w=2u l=1u
X206 a_10649_3251# DELAY_IN VDD.t18 VDD.t0 sg13_lv_pmos ad=0.4088p pd=2.97u as=1.03698p ps=6.245u w=1.12u l=0.13u
X207 VSS.t142 VSS.t140 VSS.t140 VSS.t141 sg13_lv_nmos ad=0.2516p pd=2.16u as=0 ps=0 w=0.74u l=0.13u
X208 VSS.t11 a_6126_1189# a_5974_3096# VSS.t0 sg13_lv_nmos ad=0.76p pd=4.76u as=0.38p ps=2.38u w=2u l=1u
C0 a_14851_2555# a_12849_3240# 0.13376f
C1 DELAY_VBIASP DELAY_VBIASN 5.10609f
C2 a_10751_3251# a_11748_3482# 0.03061f
C3 a_14111_3251# DELAY_IN 0.02263f
C4 VDD a_12656_3237# 0.26066f
C5 a_13121_3204# a_6854_3359# 0.10056f
C6 a_13306_3678# a_13880_3665# 0.31978f
C7 DLL_RESETN a_12849_3240# 0.3501f
C8 a_14009_3251# VDD 0.23872f
C9 VDD a_12158_3240# 0.37862f
C10 a_13592_3244# DELAY_IN 0.11539f
C11 DELAY_IN a_13132_2793# 0.02025f
C12 VDD a_15464_1057# 0.52426f
C13 VDD a_9946_3678# 0.77198f
C14 a_14851_3601# a_12849_3240# 0.13392f
C15 a_12907_2559# a_13106_2730# 0.02437f
C16 a_13566_2701# a_13592_2796# 0.36952f
C17 VDD a_9547_3315# 0.1511f
C18 a_10232_3244# a_11491_3601# 0.01529f
C19 DELAY_OUT_LAST a_15464_1057# 0.02565f
C20 a_10232_3244# DLL_RESETN 0.39088f
C21 a_6854_3359# DELAY_IN 0.05061f
C22 VDD DELAY_VBIASN 0.23309f
C23 DELAY_OUT_LAST DELAY_VBIASN 3.14505f
C24 a_14111_3251# a_13592_3244# 0.34102f
C25 VDD a_12943_3240# 0.29479f
C26 DLL_RESETN a_10206_3208# 0.27343f
C27 a_10232_3244# a_10751_3251# 0.34102f
C28 a_13566_2701# a_12849_3240# 0.26617f
C29 a_12907_2793# DLL_RESETN 0.04234f
C30 a_14009_3251# a_14757_3601# 0.01058f
C31 VDD a_13306_3678# 0.77573f
C32 VDD a_5974_3096# 0.91576f
C33 VDD a_15108_3482# 0.1349f
C34 a_13592_2796# DELAY_IN 0.03445f
C35 a_6854_3359# a_13132_2793# 0.01367f
C36 a_13019_3204# a_12849_3240# 0.12838f
C37 a_13106_2730# a_13132_2793# 0.1657f
C38 VDD a_15108_2698# 0.13728f
C39 DELAY_IN a_11748_3482# 0.0148f
C40 VDD a_15688_2776# 0.30345f
C41 a_13121_3204# a_12849_3240# 0.55272f
C42 a_14009_3251# a_13306_3678# 0.02432f
C43 VDD a_15304_1978# 0.72158f
C44 DELAY_OUT_LAST a_15108_2698# 0.01399f
C45 DELAY_OUT_LAST a_15688_2776# 0.01699f
C46 DELAY_OUT_LAST a_15304_1978# 0.05582f
C47 VDD a_6126_1189# 0.81494f
C48 a_9444_1963# a_6126_1189# 0.03029f
C49 DELAY_VBIASP DLL_RESETN 0.05659f
C50 VDD a_6326_1963# 7.53039f
C51 a_9444_1963# a_6326_1963# 0.01269f
C52 a_10520_3665# a_9946_3678# 0.31978f
C53 a_10232_3244# a_11397_3601# 0.43239f
C54 a_14009_2457# a_14757_2555# 0.01058f
C55 a_12355_3240# VDD 0.37639f
C56 DELAY_IN a_12849_3240# 0.26382f
C57 a_15108_2698# a_15464_1057# 0.12158f
C58 a_15464_1057# a_15688_2776# 0.1999f
C59 VDD a_6854_2827# 1.03678f
C60 a_9444_1963# a_6854_2827# 1.25013f
C61 a_12355_3240# a_12656_3237# 0.03277f
C62 a_13121_3204# a_13566_3208# 0.01158f
C63 VDD a_14851_2555# 0.26676f
C64 VDD a_11491_3601# 0.16753f
C65 a_10232_3244# a_10649_3251# 0.37583f
C66 a_10232_3244# DELAY_IN 0.08086f
C67 a_12355_3240# a_12158_3240# 0.12454f
C68 a_13592_2796# a_14111_2600# 0.34114f
C69 DELAY_OUT_LAST a_14851_2555# 0.02109f
C70 a_13566_2701# a_14009_2457# 0.02242f
C71 a_13592_2796# a_6854_3359# 0.01958f
C72 VDD a_15688_3240# 0.30345f
C73 VDD DLL_RESETN 2.28901f
C74 DLL_RESETN a_9444_1963# 0.10275f
C75 a_15304_1978# DELAY_VBIASN 0.07802f
C76 a_14111_3251# a_12849_3240# 0.42174f
C77 a_12907_2793# a_12907_2559# 0.1117f
C78 VDD a_14851_3601# 0.25326f
C79 a_10649_3251# a_10206_3208# 0.02242f
C80 a_13306_2478# a_13566_2701# 0.75507f
C81 a_13592_3244# a_12849_3240# 0.38817f
C82 a_13566_3208# DELAY_IN 0.01538f
C83 a_11491_3601# a_12158_3240# 0.0894f
C84 a_14111_2600# a_13880_2491# 0.12701f
C85 a_13132_2793# a_12849_3240# 0.06758f
C86 DLL_RESETN a_12656_3237# 0.11782f
C87 a_15464_1057# a_14851_2555# 0.04797f
C88 VDD a_10751_3251# 0.20377f
C89 DLL_RESETN a_12158_3240# 0.02442f
C90 a_14111_2600# a_12849_3240# 0.42064f
C91 DELAY_VBIASP a_9712_1285# 0.11086f
C92 a_15304_1978# a_15108_3482# 0.17528f
C93 DLL_RESETN a_9946_3678# 0.09997f
C94 a_6854_3359# a_12849_3240# 0.06216f
C95 DELAY_VBIASP a_13019_3204# 0.02377f
C96 a_9772_3216# a_9746_3178# 0.1657f
C97 a_5974_3096# a_6126_1189# 1.74589f
C98 VDD a_13566_2701# 0.0947f
C99 a_15304_1978# a_15108_2698# 0.01986f
C100 a_5974_3096# a_6326_1963# 0.33136f
C101 a_12355_3240# a_13306_3678# 0.26489f
C102 a_10751_3251# a_9946_3678# 0.097f
C103 DELAY_VBIASN DLL_RESETN 0.12904f
C104 a_13566_3208# a_13592_3244# 0.36952f
C105 DLL_RESETN a_12943_3240# 0.03616f
C106 a_14757_3601# a_14851_3601# 0.28931f
C107 a_5974_3096# a_6854_2827# 0.01757f
C108 a_9547_3545# a_9746_3178# 0.02437f
C109 a_13592_2796# a_13880_2491# 0.43707f
C110 VDD a_9712_1285# 0.22552f
C111 a_9712_1285# a_9444_1963# 0.39071f
C112 a_13306_2478# DELAY_IN 0.06166f
C113 a_12907_2793# a_13132_2793# 0.02416f
C114 VDD a_13019_3204# 0.4182f
C115 VDD a_13121_3204# 0.99724f
C116 DELAY_OUT_LAST a_13019_3204# 0.08017f
C117 a_13592_2796# a_12849_3240# 0.38497f
C118 a_6326_1963# a_6126_1189# 2.84014f
C119 a_14111_3251# a_13880_3665# 0.12701f
C120 DLL_RESETN a_5974_3096# 0.02002f
C121 a_9444_1285# a_9444_1963# 2.20289f
C122 DELAY_OUT_LAST a_13121_3204# 0.13178f
C123 a_13592_3244# a_13880_3665# 0.43707f
C124 a_12907_2559# VDD 0.06323f
C125 a_15108_2698# a_14851_2555# 0.29858f
C126 a_15688_2776# a_14851_2555# 0.08776f
C127 a_12907_2793# a_13106_2730# 0.14994f
C128 a_13019_3204# a_12656_3237# 0.04193f
C129 a_14851_3601# a_15108_3482# 0.29858f
C130 a_15304_1978# a_14851_2555# 0.05156f
C131 a_6854_2827# a_6126_1189# 0.22705f
C132 a_15464_1057# a_9712_1285# 0.01237f
C133 a_9444_1963# a_5864_740# 0.06832f
C134 a_14009_3251# a_13121_3204# 0.01604f
C135 a_15304_1978# a_15688_3240# 0.19136f
C136 a_13019_3204# a_15464_1057# 0.59875f
C137 a_6854_2827# a_6326_1963# 1.25249f
C138 a_15304_1978# DLL_RESETN 0.03137f
C139 VDD a_10649_3251# 0.23431f
C140 VDD DELAY_IN 0.28486f
C141 a_13121_3204# a_15464_1057# 0.33256f
C142 a_10751_3251# a_10520_3665# 0.12701f
C143 a_15304_1978# a_14851_3601# 0.12139f
C144 DLL_RESETN a_6126_1189# 0.06398f
C145 a_14009_2457# a_14111_2600# 0.47622f
C146 a_13306_2478# a_13132_2793# 0.27179f
C147 DELAY_VBIASN a_9712_1285# 0.22281f
C148 a_15304_1978# a_14757_2555# 0.02225f
C149 DELAY_IN a_12656_3237# 0.01215f
C150 a_12355_3240# DLL_RESETN 0.04879f
C151 DELAY_VBIASN a_13019_3204# 1.23663f
C152 a_5778_740# a_9444_1963# 0.19787f
C153 a_12158_3240# DELAY_IN 0.01309f
C154 a_14009_3251# DELAY_IN 0.25847f
C155 DELAY_VBIASP a_6854_3359# 0.01478f
C156 a_13306_2478# a_14111_2600# 0.097f
C157 a_13019_3204# a_12943_3240# 0.03346f
C158 a_10649_3251# a_9946_3678# 0.02432f
C159 DLL_RESETN a_6854_2827# 0.03626f
C160 VDD a_14111_3251# 0.21331f
C161 a_13121_3204# a_12943_3240# 0.09118f
C162 VDD a_13592_3244# 0.07242f
C163 DLL_RESETN a_11491_3601# 0.14622f
C164 a_5974_3096# a_9712_1285# 0.01152f
C165 VDD a_13132_2793# 0.23863f
C166 a_13566_3208# a_12849_3240# 0.27346f
C167 a_13121_3204# a_13306_3678# 0.01008f
C168 a_13121_3204# a_15108_3482# 0.03701f
C169 a_14757_2555# a_14851_2555# 0.28931f
C170 a_14009_3251# a_14111_3251# 0.47795f
C171 VDD a_14111_2600# 0.33926f
C172 a_15688_3240# a_14851_3601# 0.08776f
C173 a_14009_2457# a_13592_2796# 0.3749f
C174 VDD a_6854_3359# 1.20794f
C175 a_6854_3359# a_9444_1963# 0.02502f
C176 a_11491_3601# a_10751_3251# 0.26905f
C177 a_14009_3251# a_13592_3244# 0.37583f
C178 a_13106_2730# VDD 0.09228f
C179 DELAY_OUT_LAST a_14111_2600# 0.02024f
C180 a_13019_3204# a_15688_2776# 0.1287f
C181 DELAY_OUT_LAST a_6854_3359# 0.08491f
C182 DLL_RESETN a_10751_3251# 0.45018f
C183 a_15304_1978# a_13019_3204# 0.07025f
C184 a_13121_3204# a_15108_2698# 0.05903f
C185 a_10232_3244# a_10206_3208# 0.36952f
C186 a_13121_3204# a_15688_2776# 0.01441f
C187 a_13306_2478# a_13592_2796# 0.41329f
C188 a_5974_3096# a_5864_740# 0.01697f
C189 a_15304_1978# a_13121_3204# 0.40921f
C190 DELAY_IN a_13306_3678# 0.05059f
C191 a_14009_2457# a_13880_2491# 0.01562f
C192 a_9712_1285# a_6326_1963# 0.04741f
C193 a_10649_3251# a_10520_3665# 0.01562f
C194 a_12355_3240# a_13019_3204# 0.3846f
C195 a_9444_1285# a_6126_1189# 0.25721f
C196 a_13592_3244# a_14757_3601# 0.43239f
C197 a_14009_2457# a_12849_3240# 0.03463f
C198 a_13306_2478# a_13880_2491# 0.31978f
C199 a_12355_3240# a_13121_3204# 0.05795f
C200 a_9712_1285# a_6854_2827# 0.6789f
C201 VDD a_9746_3178# 0.0918f
C202 a_5974_3096# a_5778_740# 2.88221f
C203 a_15304_1978# DELAY_IN 0.01066f
C204 VDD a_9772_3216# 0.24701f
C205 a_5864_740# a_6126_1189# 0.23738f
C206 VDD a_13592_2796# 0.11685f
C207 a_13306_2478# a_12849_3240# 0.10976f
C208 a_5864_740# a_6326_1963# 0.01889f
C209 DELAY_VBIASN a_6854_3359# 0.15808f
C210 a_14111_3251# a_13306_3678# 0.097f
C211 DELAY_OUT_LAST a_13592_2796# 0.08062f
C212 VDD a_11748_3482# 0.16819f
C213 a_9444_1285# a_6854_2827# 0.8486f
C214 DLL_RESETN a_9712_1285# 0.4243f
C215 a_14111_3251# a_15108_3482# 0.03093f
C216 a_13121_3204# a_14851_2555# 0.03337f
C217 a_11397_3601# a_11491_3601# 0.28931f
C218 a_15688_3240# a_13019_3204# 0.0195f
C219 DLL_RESETN a_13019_3204# 0.01429f
C220 a_13592_3244# a_13306_3678# 0.41329f
C221 a_12355_3240# DELAY_IN 1.0042f
C222 a_13121_3204# a_15688_3240# 0.17255f
C223 DLL_RESETN a_13121_3204# 0.04337f
C224 VDD a_13880_2491# 0.02994f
C225 a_5864_740# a_6854_2827# 0.03661f
C226 a_13019_3204# a_14851_3601# 0.01651f
C227 a_9444_1285# DLL_RESETN 0.03031f
C228 VDD a_9547_3545# 0.08695f
C229 a_5778_740# a_6126_1189# 1.6143f
C230 a_9547_3315# a_9746_3178# 0.14994f
C231 a_12907_2559# DLL_RESETN 0.02177f
C232 a_9772_3216# a_9946_3678# 0.27179f
C233 a_15304_1978# a_14111_3251# 0.01811f
C234 a_12158_3240# a_11748_3482# 0.10373f
C235 a_13121_3204# a_14851_3601# 0.03404f
C236 a_5778_740# a_6326_1963# 0.8779f
C237 a_9772_3216# a_9547_3315# 0.02416f
C238 a_5974_3096# a_6854_3359# 0.029f
C239 VDD a_12849_3240# 2.56972f
C240 a_11491_3601# DELAY_IN 0.01827f
C241 DLL_RESETN a_5864_740# 0.1727f
C242 DELAY_OUT_LAST a_12849_3240# 0.01791f
C243 a_10649_3251# DLL_RESETN 0.05713f
C244 DLL_RESETN DELAY_IN 10.4683f
C245 a_15108_2698# a_14111_2600# 0.03012f
C246 a_5778_740# a_6854_2827# 0.02695f
C247 a_12656_3237# a_12849_3240# 0.33075f
C248 a_15304_1978# a_14111_2600# 0.01761f
C249 a_15304_1978# a_6854_3359# 0.08165f
C250 VDD a_10232_3244# 0.07206f
C251 a_14009_3251# a_12849_3240# 0.03525f
C252 a_9547_3315# a_9547_3545# 0.1117f
C253 DLL_RESETN a_5778_740# 0.01215f
C254 a_10649_3251# a_10751_3251# 0.47795f
C255 a_10751_3251# DELAY_IN 0.01931f
C256 a_6854_3359# a_6126_1189# 0.18536f
C257 a_6854_3359# a_6326_1963# 1.31745f
C258 VDD a_10206_3208# 0.09392f
C259 VDD a_13566_3208# 0.09466f
C260 a_13045_3588# a_13019_3204# 0.01249f
C261 a_13019_3204# a_9712_1285# 0.03275f
C262 a_13306_2478# a_14009_2457# 0.02454f
C263 a_12907_2793# VDD 0.07751f
C264 a_10232_3244# a_9946_3678# 0.41329f
C265 a_6854_3359# a_6854_2827# 0.30378f
C266 a_14111_3251# a_14851_3601# 0.26905f
C267 a_13566_2701# DELAY_IN 0.01093f
C268 a_9444_1285# a_9712_1285# 0.72189f
C269 a_13121_3204# a_13019_3204# 0.56469f
C270 DLL_RESETN a_13132_2793# 0.01689f
C271 a_14851_2555# a_14111_2600# 0.26905f
C272 a_12943_3240# a_12849_3240# 0.16706f
C273 a_13592_3244# a_14851_3601# 0.01529f
C274 a_14009_3251# a_13566_3208# 0.02242f
C275 a_15304_1978# a_13592_2796# 0.01817f
C276 a_10206_3208# a_9946_3678# 0.75507f
C277 DLL_RESETN a_6854_3359# 0.50331f
C278 a_13106_2730# DLL_RESETN 0.01263f
C279 a_9712_1285# DELAY_IN 0.06562f
C280 a_13306_3678# a_12849_3240# 0.12097f
C281 a_15108_3482# a_12849_3240# 0.10225f
C282 a_13019_3204# DELAY_IN 0.35409f
C283 VDD a_14009_2457# 0.31815f
C284 a_11397_3601# a_10649_3251# 0.01058f
C285 a_9444_1285# a_5864_740# 0.02483f
C286 a_13121_3204# DELAY_IN 1.40135f
C287 DELAY_OUT_LAST a_14009_2457# 0.25594f
C288 VDD DELAY_VBIASP 1.07078f
C289 a_14009_3251# a_13880_3665# 0.01562f
C290 a_15108_2698# a_12849_3240# 0.10521f
C291 a_13306_2478# VDD 0.79678f
C292 a_15304_1978# a_12849_3240# 0.0606f
C293 DELAY_OUT_LAST DELAY_VBIASP 0.82908f
C294 a_13592_2796# a_14851_2555# 0.01529f
C295 a_10232_3244# a_10520_3665# 0.43707f
C296 a_10649_3251# DELAY_IN 0.25484f
C297 DLL_RESETN a_9772_3216# 0.06592f
C298 a_11491_3601# a_11748_3482# 0.34468f
C299 a_13566_3208# a_13306_3678# 0.75507f
C300 a_12355_3240# a_12849_3240# 0.07687f
C301 a_13592_3244# a_13019_3204# 0.04178f
C302 a_14111_3251# a_13121_3204# 0.0235f
C303 DLL_RESETN a_11748_3482# 0.11133f
C304 a_5778_740# a_5864_740# 0.07306f
C305 a_13121_3204# a_13592_3244# 0.01445f
C306 VDD a_9444_1963# 0.01443f
C307 a_13592_2796# a_14757_2555# 0.43239f
C308 DELAY_OUT_LAST VDD 0.17745f
C309 a_6854_3359# a_9712_1285# 0.83268f
R0 VDD.n21 VDD.t24 17.3693
R1 VDD.n10 VDD.t42 17.3693
R2 VDD.n10 VDD.t38 17.3693
R3 VDD.n22 VDD.t22 17.3517
R4 VDD.n13 VDD.t84 17.3517
R5 VDD.n12 VDD.t27 17.3517
R6 VDD.n16 VDD.t26 17.2247
R7 VDD.n22 VDD.t19 17.0005
R8 VDD.n13 VDD.t41 17.0005
R9 VDD.n12 VDD.t37 17.0005
R10 VDD.t31 VDD.t72 15.0005
R11 VDD.t31 VDD.t77 15.0005
R12 VDD.t31 VDD.t80 15.0005
R13 VDD.t31 VDD.t49 17.9449
R14 VDD.n32 VDD.t17 9.02285
R15 VDD.t31 VDD.t52 8.95516
R16 VDD.n6 VDD.t45 8.76054
R17 VDD.n6 VDD.t35 8.76054
R18 VDD.n0 VDD.t0 1.78925
R19 VDD.n20 VDD.t21 5.9886
R20 VDD.n4 VDD.t47 5.97675
R21 VDD.n4 VDD.t34 5.97675
R22 VDD.n18 VDD.t54 5.96478
R23 VDD.t0 VDD.n33 5.62581
R24 VDD.t18 VDD.n15 5.61485
R25 VDD.t18 VDD.n19 5.61485
R26 VDD.t31 VDD.t73 5.71133
R27 VDD.t31 VDD.t79 5.59179
R28 VDD.n2 VDD.t64 4.9462
R29 VDD.n42 VDD.t61 4.9462
R30 VDD.n8 VDD.t31 7.13279
R31 VDD.t0 VDD.n26 4.19238
R32 VDD.t0 VDD.n34 4.19225
R33 VDD.t0 VDD.n62 4.19225
R34 VDD.t0 VDD.n31 4.19225
R35 VDD.t18 VDD.n17 3.31208
R36 VDD.t18 VDD.n9 3.30706
R37 VDD.t18 VDD.n11 3.30706
R38 VDD.t18 VDD.n24 3.30688
R39 VDD.t18 VDD.n5 2.7751
R40 VDD.t18 VDD 1.47683
R41 VDD.n69 VDD.t66 2.69937
R42 VDD.n40 VDD.t69 2.69937
R43 VDD.n38 VDD.t63 2.69937
R44 VDD.n1 VDD.t71 2.69937
R45 VDD.n67 VDD.t5 2.6992
R46 VDD.n65 VDD.t9 2.6992
R47 VDD.n36 VDD.t10 2.6992
R48 VDD.n44 VDD.t1 2.6992
R49 VDD.n49 VDD.t2 2.6992
R50 VDD.n48 VDD.t11 2.6992
R51 VDD.n54 VDD.t4 2.6992
R52 VDD.n53 VDD.t12 2.6992
R53 VDD.n59 VDD.t7 2.6992
R54 VDD.n58 VDD.t15 2.6992
R55 VDD.t0 VDD.n56 2.32439
R56 VDD.t0 VDD.n29 2.32439
R57 VDD.t0 VDD.n61 2.32417
R58 VDD.t0 VDD.n30 2.32417
R59 VDD.t0 VDD.n27 2.32417
R60 VDD.t0 VDD.n46 2.32406
R61 VDD.t0 VDD.n51 2.00629
R62 VDD.t0 VDD.n28 2.0061
R63 VDD.t0 VDD.n71 1.75938
R64 VDD.t18 VDD.n7 1.20461
R65 VDD.n49 VDD.n48 1.11007
R66 VDD.n54 VDD.n53 1.11007
R67 VDD.n59 VDD.n58 1.11007
R68 VDD.n21 VDD.n3 0.975304
R69 VDD.n39 VDD.n25 0.895319
R70 VDD.n32 VDD.n25 0.881249
R71 VDD.n3 VDD.n20 0.817678
R72 VDD.n8 VDD.n7 0.671512
R73 VDD.n7 VDD.n6 0.6645
R74 VDD.n70 VDD.n69 0.570444
R75 VDD.n38 VDD.n37 0.570444
R76 VDD.n65 VDD.n64 0.570274
R77 VDD.n45 VDD.n44 0.570274
R78 VDD.n50 VDD.n49 0.570274
R79 VDD.n55 VDD.n54 0.570274
R80 VDD.n60 VDD.n59 0.570274
R81 VDD.n67 VDD.n66 0.569912
R82 VDD.n36 VDD.n35 0.569912
R83 VDD.n48 VDD.n47 0.569912
R84 VDD.n53 VDD.n52 0.569912
R85 VDD.n58 VDD.n57 0.569912
R86 VDD.n40 VDD.n39 0.569733
R87 VDD.n1 VDD.n63 0.569733
R88 VDD.t18 VDD.n3 0.49685
R89 VDD.n41 VDD.n40 0.492175
R90 VDD VDD.n1 0.492175
R91 VDD.n68 VDD.n67 0.492005
R92 VDD.n43 VDD.n36 0.492005
R93 VDD.n68 VDD.n65 0.491643
R94 VDD.n44 VDD.n43 0.491643
R95 VDD.n69 VDD 0.491464
R96 VDD.n41 VDD.n38 0.491464
R97 VDD.t0 VDD.n25 0.487357
R98 VDD.t31 VDD.t83 6.06111
R99 VDD.n71 VDD.n70 0.43335
R100 VDD.n71 VDD 0.403558
R101 VDD.t0 VDD.t18 0.383639
R102 VDD.n56 VDD.n55 0.372952
R103 VDD.n52 VDD.n29 0.372952
R104 VDD.n50 VDD.n46 0.355071
R105 VDD.n47 VDD.n27 0.354692
R106 VDD.n61 VDD.n60 0.347655
R107 VDD.n57 VDD.n30 0.347655
R108 VDD.n51 VDD.n50 0.347442
R109 VDD.n47 VDD.n28 0.347254
R110 VDD.n24 VDD.n21 0.335799
R111 VDD.n11 VDD.n10 0.335496
R112 VDD.n66 VDD.n30 0.334692
R113 VDD.n64 VDD.n61 0.334692
R114 VDD.n14 VDD.n11 0.332368
R115 VDD.n24 VDD.n23 0.332058
R116 VDD.n63 VDD.n0 0.383516
R117 VDD.n52 VDD.n28 0.328947
R118 VDD.n55 VDD.n51 0.32875
R119 VDD.n35 VDD.n27 0.327655
R120 VDD.n18 VDD.n17 0.327354
R121 VDD.n46 VDD.n45 0.327271
R122 VDD.n60 VDD.n56 0.309405
R123 VDD.n57 VDD.n29 0.309405
R124 VDD.n6 VDD.n5 0.306614
R125 VDD.n23 VDD 0.423614
R126 VDD.n9 VDD.n8 0.298721
R127 VDD.n17 VDD.n16 0.282297
R128 VDD.n10 VDD.n9 0.260496
R129 VDD.n2 VDD.n68 0.253639
R130 VDD.n42 VDD.n41 0.253639
R131 VDD.n43 VDD.n42 0.253298
R132 VDD.n20 VDD.n19 0.202075
R133 VDD.n45 VDD.n34 0.191924
R134 VDD.n35 VDD.n26 0.191793
R135 VDD.n64 VDD.n62 0.184424
R136 VDD.n66 VDD.n31 0.184424
R137 VDD.n37 VDD.n33 0.179888
R138 VDD.n19 VDD.n18 0.175486
R139 VDD.n16 VDD.n15 0.171736
R140 VDD.n63 VDD.n31 0.161924
R141 VDD.n70 VDD.n62 0.161924
R142 VDD.n39 VDD.n26 0.154552
R143 VDD.n37 VDD.n34 0.154424
R144 VDD.n23 VDD.n22 0.152808
R145 VDD.n14 VDD.n13 0.152808
R146 VDD.n14 VDD.n12 0.152808
R147 VDD.n15 VDD.n14 0.147075
R148 VDD.n5 VDD.n4 0.127628
R149 VDD.n33 VDD.n32 0.11705
R150 VDD.t31 VDD.t75 15.0334
R151 VDD.t78 VDD.t31 5.76644
R152 VDD VDD.n2 0.612395
R153 VDD VDD.n0 0.543771
R154 VDD.t81 VDD.t31 5.75163
R155 VDD.t76 VDD.t31 5.77389
R156 VDD.t31 VDD.t74 5.59179
R157 VSS.n152 VSS.n151 22369.4
R158 VSS.t81 VSS.n51 310.202
R159 VSS.n48 VSS.t73 11.5048
R160 VSS.n182 VSS.n176 572.005
R161 VSS.t3 VSS.t0 571.348
R162 VSS.n4 VSS.t114 21.4432
R163 VSS.t24 VSS.n3 0.467955
R164 VSS.n185 VSS.t77 550.193
R165 VSS.n38 VSS.t128 30.9845
R166 VSS.t63 VSS.n189 532.819
R167 VSS.t73 VSS.n8 0.404835
R168 VSS.t23 VSS.n23 211.945
R169 VSS.t71 VSS.n188 514.091
R170 VSS.n193 VSS.t68 504.839
R171 VSS.n1 VSS.t75 504.839
R172 VSS.n6 VSS.t121 491.87
R173 VSS.n190 VSS.t69 474.904
R174 VSS.t122 VSS.n39 82.4058
R175 VSS.n191 VSS.t20 456.175
R176 VSS.n24 VSS.t22 107.465
R177 VSS.n188 VSS.t66 427.219
R178 VSS.n43 VSS.t116 380.483
R179 VSS.t115 VSS.n41 380.483
R180 VSS.t72 VSS.n6 401.591
R181 VSS.t95 VSS.n48 263.087
R182 VSS.t81 VSS.n186 363.339
R183 VSS.t18 VSS.n196 363.339
R184 VSS.t88 VSS.t93 359.769
R185 VSS.n183 VSS.t91 347.49
R186 VSS.n184 VSS.t79 329.238
R187 VSS.n14 VSS.t3 328.173
R188 VSS.n9 VSS.t119 320.288
R189 VSS.t86 VSS.t151 304.42
R190 VSS.t74 VSS.n181 304.42
R191 VSS.t113 VSS.t61 304.42
R192 VSS.t67 VSS.n194 304.42
R193 VSS.n9 VSS.t73 9.81708
R194 VSS.n1 VSS.t92 291.37
R195 VSS.t1 VSS.n193 291.37
R196 VSS.t66 VSS.n51 148.06
R197 VSS.n24 VSS.t18 313.596
R198 VSS.t79 VSS.n183 243.244
R199 VSS.t91 VSS.n182 224.516
R200 VSS.n8 VSS.t72 208.897
R201 VSS.n9 VSS.t127 116.847
R202 VSS.n2 VSS.t116 202.071
R203 VSS.n192 VSS.t115 202.071
R204 VSS.t92 VSS.n181 196.399
R205 VSS.n194 VSS.t1 196.399
R206 VSS.t119 VSS.n7 187.895
R207 VSS.n118 VSS.n19 3.52241
R208 VSS.t2 VSS.n191 183.975
R209 VSS.n0 VSS.t74 182.797
R210 VSS.n195 VSS.t67 182.797
R211 VSS.t76 VSS.n185 167.954
R212 VSS.n55 VSS.n152 157.912
R213 VSS.n59 VSS.t95 154.968
R214 VSS.n52 VSS.t98 143.137
R215 VSS.t0 VSS.t130 142.417
R216 VSS.t151 VSS.n0 138.607
R217 VSS.t61 VSS.n195 138.607
R218 VSS.n154 VSS.t141 123.18
R219 VSS.n164 VSS.t146 123.18
R220 VSS.n152 VSS.n7 122.129
R221 VSS.n39 VSS.t88 135.388
R222 VSS.n176 VSS.n175 118.993
R223 VSS.t64 VSS.n58 118.9
R224 VSS.t20 VSS.n190 115.831
R225 VSS.t73 VSS.n39 2.98148
R226 VSS.n54 VSS.t26 101.45
R227 VSS.t96 VSS.n129 99.4847
R228 VSS.n5 VSS.t126 93.1365
R229 VSS.t120 VSS.n8 75.5111
R230 VSS.n204 VSS.t118 87.3255
R231 VSS.t75 VSS.n2 85.7923
R232 VSS.t68 VSS.n192 85.7923
R233 VSS.t121 VSS.n38 96.7735
R234 VSS.n53 VSS.t149 79.5949
R235 VSS.n54 VSS.t143 79.5939
R236 VSS.t143 VSS.n154 79.4707
R237 VSS.t149 VSS.n164 79.4707
R238 VSS.t93 VSS.n48 80.7021
R239 VSS.t14 VSS.n21 75.2892
R240 VSS.n224 VSS.t117 68.534
R241 VSS.t123 VSS.t87 68.534
R242 VSS.n199 VSS.t97 66.3233
R243 VSS.t26 VSS.n57 65.6876
R244 VSS.t84 VSS.n130 65.2179
R245 VSS.n151 VSS.n131 65.2179
R246 VSS.t16 VSS.n17 15.3714
R247 VSS.n189 VSS.t71 57.9156
R248 VSS.n151 VSS.n134 53.7749
R249 VSS.n175 VSS.t97 52.6695
R250 VSS.t25 VSS.n23 45.3134
R251 VSS.t99 VSS.n12 19.4628
R252 VSS.n21 VSS.t130 53.5944
R253 VSS.n53 VSS.t64 47.8071
R254 VSS.t94 VSS.n199 46.4264
R255 VSS.t133 VSS.n15 20.8257
R256 VSS.n186 VSS.t86 44.1903
R257 VSS.n196 VSS.t113 44.1903
R258 VSS.t15 VSS.n16 21.1008
R259 VSS.n14 VSS.n17 0.00229759
R260 VSS.n204 VSS.t84 40.8995
R261 VSS.t103 VSS.n20 45.7304
R262 VSS.n129 VSS.t117 37.5834
R263 VSS.t146 VSS.n57 35.8838
R264 VSS.t141 VSS.n55 35.8827
R265 VSS.t37 VSS.n34 43.1123
R266 VSS.n19 VSS.t130 28.2736
R267 VSS.n38 VSS.t73 0.977035
R268 VSS.n14 VSS.n16 0.00202543
R269 VSS.t17 VSS.n17 21.1017
R270 VSS.n14 VSS.n15 0.00705887
R271 VSS.t126 VSS.n130 27.635
R272 VSS.t65 VSS.n3 26.2882
R273 VSS.t98 VSS.n58 23.5351
R274 VSS.t87 VSS.n134 22.8243
R275 VSS.t101 VSS.n12 27.9779
R276 VSS.t77 VSS.n184 22.2881
R277 VSS.n4 VSS.t24 0.00314878
R278 VSS.n5 VSS.t96 21.2859
R279 VSS.n32 VSS.t39 10.4734
R280 VSS.t43 VSS.n35 10.9073
R281 VSS.t118 VSS.n131 18.792
R282 VSS.t95 VSS.t94 17.6866
R283 VSS.n30 VSS.t39 60.9199
R284 VSS.n28 VSS.n32 0.00103281
R285 VSS.n28 VSS.n34 0.00103327
R286 VSS.n31 VSS.t31 43.1137
R287 VSS.n33 VSS.t28 10.4728
R288 VSS.n14 VSS.n120 17.0005
R289 VSS.n14 VSS.n20 0.00145333
R290 VSS.n219 VSS.n14 17.0005
R291 VSS.n224 VSS.t73 17.0005
R292 VSS.t73 VSS.n129 17.0005
R293 VSS.t73 VSS.n130 17.0005
R294 VSS.t73 VSS.n204 17.0005
R295 VSS.t73 VSS.n131 17.0005
R296 VSS.n199 VSS.t73 17.0005
R297 VSS.n23 VSS.t24 1.47886
R298 VSS.n24 VSS.t24 9.80382
R299 VSS.n196 VSS.t24 17.0005
R300 VSS.n194 VSS.t24 17.0005
R301 VSS.n41 VSS.t24 8.26554
R302 VSS.n190 VSS.t24 17.0005
R303 VSS.n189 VSS.t24 17.0005
R304 VSS.n51 VSS.t24 13.5064
R305 VSS.t24 VSS.n186 17.0005
R306 VSS.t24 VSS.n181 17.0005
R307 VSS.t24 VSS.n43 8.26554
R308 VSS.n185 VSS.t24 17.0005
R309 VSS.n183 VSS.t24 17.0005
R310 VSS.t33 VSS.n31 52.0154
R311 VSS.n14 VSS.n124 17.0005
R312 VSS.n62 VSS.n142 17.0005
R313 VSS.n62 VSS.n143 17.0005
R314 VSS.n62 VSS.n146 17.0005
R315 VSS.n62 VSS.n153 17.0005
R316 VSS.n62 VSS.n163 17.0005
R317 VSS.n62 VSS.n171 17.0005
R318 VSS.n44 VSS.t23 375.567
R319 VSS.n13 VSS.t103 39.8102
R320 VSS.t35 VSS.n29 19.3745
R321 VSS.n13 VSS.t105 14.2788
R322 VSS.n34 VSS.t35 52.0204
R323 VSS.t37 VSS.n32 28.2755
R324 VSS.n93 VSS.n92 9.81769
R325 VSS.n93 VSS.n83 9.53935
R326 VSS.n94 VSS.n93 9.39094
R327 VSS.n173 VSS.t70 9.08698
R328 VSS.t70 VSS.n172 9.0445
R329 VSS.n202 VSS.n136 9.0005
R330 VSS.n147 VSS.n137 9.0005
R331 VSS.n139 VSS.n137 9.0005
R332 VSS.n202 VSS.n201 9.0005
R333 VSS.n19 VSS.n14 0.649366
R334 VSS.n118 VSS.n64 2.83417
R335 VSS.n64 VSS.n63 0.00166658
R336 VSS.n63 VSS.n65 0.00149997
R337 VSS.n118 VSS.n66 2.42956
R338 VSS.n118 VSS.n70 4.251
R339 VSS.n70 VSS.n69 0.00149997
R340 VSS.n118 VSS.n71 3.40102
R341 VSS.n118 VSS.n74 2.83417
R342 VSS.n74 VSS.n73 0.00166658
R343 VSS.n73 VSS.n75 0.00149997
R344 VSS.n118 VSS.n76 3.40102
R345 VSS.n118 VSS.n79 2.83428
R346 VSS.n79 VSS.n80 0.00249992
R347 VSS.n176 VSS.n26 99.0666
R348 VSS.t2 VSS.n41 205.169
R349 VSS.n43 VSS.t76 205.169
R350 VSS.n59 VSS.n52 7.82325
R351 VSS.n14 VSS.n21 0.0258785
R352 VSS.n16 VSS.t14 10.2269
R353 VSS.n62 VSS.n154 8.5005
R354 VSS.n62 VSS.n164 8.5005
R355 VSS.n62 VSS.n149 8.48883
R356 VSS.n62 VSS.n56 8.48883
R357 VSS.t60 VSS.n37 0.996749
R358 VSS.n14 VSS.n84 8.47732
R359 VSS.t137 VSS.n18 0.141982
R360 VSS.t4 VSS.n63 8.47732
R361 VSS.n111 VSS.n65 8.47732
R362 VSS.t7 VSS.n67 8.47732
R363 VSS.n108 VSS.n68 8.47732
R364 VSS.n112 VSS.n107 8.47732
R365 VSS.n106 VSS.n69 8.47732
R366 VSS.n104 VSS.n72 8.47732
R367 VSS.n113 VSS.n103 8.47732
R368 VSS.n102 VSS.n73 8.47732
R369 VSS.t11 VSS.n75 8.47732
R370 VSS.n114 VSS.n77 8.47732
R371 VSS.n98 VSS.n99 8.47732
R372 VSS.t13 VSS.n78 8.47732
R373 VSS.n97 VSS.n80 8.47732
R374 VSS.n96 VSS.n10 8.47732
R375 VSS.n14 VSS.n122 8.47732
R376 VSS.n14 VSS.n86 8.47732
R377 VSS.n14 VSS.n85 8.47732
R378 VSS.t131 VSS.n22 0.716222
R379 VSS.n22 VSS.n14 0.601638
R380 VSS.n22 VSS.t5 0.911351
R381 VSS.n25 VSS.n14 2.0061
R382 VSS.t5 VSS.n25 0.277329
R383 VSS.t6 VSS.n40 1.03134
R384 VSS.n40 VSS.n216 1.1751
R385 VSS.n209 VSS.n14 8.47732
R386 VSS.n197 VSS.n28 8.47732
R387 VSS.n62 VSS.n141 8.47732
R388 VSS.n62 VSS.n145 8.47732
R389 VSS.n62 VSS.n150 8.47732
R390 VSS.n62 VSS.n155 8.47732
R391 VSS.n62 VSS.n162 8.47732
R392 VSS.n62 VSS.n165 8.47732
R393 VSS.n198 VSS.n36 0.565949
R394 VSS.t21 VSS.n50 0.866001
R395 VSS.t78 VSS.n46 0.501203
R396 VSS.n223 VSS.n14 8.46924
R397 VSS.n14 VSS.t124 8.1859
R398 VSS.n118 VSS.t124 8.1722
R399 VSS.t101 VSS.n20 57.5631
R400 VSS.n44 VSS.t130 119325
R401 VSS.n66 VSS.n110 0.00249991
R402 VSS.n71 VSS.n105 0.00229996
R403 VSS.n76 VSS.n100 0.00229996
R404 VSS.n118 VSS.n117 5.66778
R405 VSS.n37 VSS.n28 0.190472
R406 VSS.n14 VSS.n18 3.32615
R407 VSS.n109 VSS.n110 5.62581
R408 VSS.t9 VSS.n105 5.62581
R409 VSS.n101 VSS.n100 5.62581
R410 VSS.n116 VSS.n115 5.62581
R411 VSS.n40 VSS.n14 0.16312
R412 VSS.n62 VSS.n174 5.62581
R413 VSS.n36 VSS.n28 1.24463
R414 VSS.n203 VSS.n135 5.13648
R415 VSS.n137 VSS.n81 4.63796
R416 VSS.t85 VSS.n203 4.4712
R417 VSS.n152 VSS.t123 4.42202
R418 VSS.n14 VSS.n126 4.19639
R419 VSS.n205 VSS.n14 4.19244
R420 VSS.n14 VSS.n123 4.19225
R421 VSS.n62 VSS.n170 4.19225
R422 VSS.n47 VSS.t89 0.777874
R423 VSS.n14 VSS.t125 3.37895
R424 VSS.n200 VSS.n62 3.32697
R425 VSS.n14 VSS.n95 3.32615
R426 VSS.n14 VSS.n127 3.32615
R427 VSS.n62 VSS.n160 3.32615
R428 VSS.t24 VSS.n187 3.30696
R429 VSS.n35 VSS.t41 37.1815
R430 VSS.n30 VSS.t41 34.2123
R431 VSS.n28 VSS.n30 0.00100001
R432 VSS.n35 VSS.n28 0.00110028
R433 VSS.n29 VSS.n28 0.00100392
R434 VSS.t33 VSS.n29 19.3765
R435 VSS.n31 VSS.n28 0.00100007
R436 VSS.t31 VSS.n33 28.2796
R437 VSS.n33 VSS.n28 0.00100006
R438 VSS.t28 VSS.n26 60.9182
R439 VSS.t45 VSS.n81 2.7456
R440 VSS.n62 VSS.n144 2.74414
R441 VSS.n221 VSS.n14 2.32483
R442 VSS.n14 VSS.n121 2.32432
R443 VSS.t73 VSS.n134 2.06357
R444 VSS.t73 VSS.n175 2.06357
R445 VSS.n14 VSS.n128 2.01633
R446 VSS.n217 VSS.n14 2.00687
R447 VSS.n14 VSS.n119 2.00604
R448 VSS.n49 VSS.t24 1.51816
R449 VSS.t19 VSS.n45 0.432133
R450 VSS VSS.n81 1.77935
R451 VSS.n14 VSS.n87 1.7562
R452 VSS.n14 VSS.n91 1.75596
R453 VSS.n62 VSS.n140 1.7546
R454 VSS.n46 VSS.t24 1.34781
R455 VSS.n201 VSS.n138 1.66925
R456 VSS.n28 VSS.n179 1.55041
R457 VSS.n210 VSS.t132 1.43372
R458 VSS.n206 VSS.t134 1.43372
R459 VSS.t134 VSS.n207 1.42949
R460 VSS.t132 VSS.n211 1.42949
R461 VSS.t106 VSS.t110 1.41892
R462 VSS.t104 VSS.t109 1.41892
R463 VSS.t102 VSS.t108 1.41892
R464 VSS.t100 VSS.t107 1.41892
R465 VSS.t129 VSS.n88 1.37661
R466 VSS.t129 VSS.n89 1.37661
R467 VSS.n225 VSS.n83 1.32707
R468 VSS.n82 VSS.n225 1.30246
R469 VSS.t44 VSS.n42 1.09017
R470 VSS.t58 VSS.t60 1.25614
R471 VSS.t50 VSS.t48 1.18726
R472 VSS.t32 VSS.t34 1.18293
R473 VSS.t36 VSS.t34 1.17925
R474 VSS.t50 VSS.t52 1.17786
R475 VSS.t29 VSS.t30 1.1778
R476 VSS.t40 VSS.t38 1.17383
R477 VSS.t56 VSS.t54 1.17241
R478 VSS.t42 VSS.t40 1.16726
R479 VSS.t58 VSS.t56 1.16468
R480 VSS.t46 VSS.t45 1.16092
R481 VSS.t46 VSS.t48 1.12501
R482 VSS.t85 VSS.n47 1.02114
R483 VSS.t52 VSS.t54 1.11752
R484 VSS.t38 VSS.t36 1.11317
R485 VSS.t32 VSS.t29 1.10881
R486 VSS.t73 VSS.n132 1.09664
R487 VSS.n45 VSS.t24 0.452198
R488 VSS.t82 VSS.n50 1.10955
R489 VSS.n132 VSS.n133 1.02454
R490 VSS.n96 VSS.n11 0.911352
R491 VSS.n215 VSS.n11 0.84534
R492 VSS.n180 VSS.n27 0.832641
R493 VSS.t145 VSS.t147 0.806856
R494 VSS.n148 VSS.t140 0.806855
R495 VSS.t27 VSS.n161 0.802775
R496 VSS.n14 VSS.n12 0.00250647
R497 VSS.n14 VSS.n13 0.00282714
R498 VSS.n224 VSS.n15 370.173
R499 VSS.t21 VSS.n45 1.13704
R500 VSS.n180 VSS.t80 0.745491
R501 VSS.t73 VSS.n47 0.505538
R502 VSS.n222 VSS.t106 0.722582
R503 VSS.n220 VSS.t104 0.722582
R504 VSS.n218 VSS.t102 0.722582
R505 VSS.n216 VSS.t100 0.722582
R506 VSS.t110 VSS.n212 0.72222
R507 VSS.t109 VSS.n213 0.72222
R508 VSS.t108 VSS.n214 0.72222
R509 VSS.t107 VSS.n215 0.72222
R510 VSS.n198 VSS.n27 0.710589
R511 VSS.t85 VSS.n132 0.699997
R512 VSS.n178 VSS.n177 0.6955
R513 VSS.n50 VSS.t24 0.552548
R514 VSS.t80 VSS.n46 0.102709
R515 VSS.n28 VSS.n26 0.00100084
R516 VSS.n14 VSS.n11 0.601638
R517 VSS.n28 VSS.n27 0.600028
R518 VSS.n166 VSS.t150 0.595317
R519 VSS.t148 VSS.n168 0.595317
R520 VSS.n156 VSS.t144 0.595317
R521 VSS.t142 VSS.n158 0.595317
R522 VSS.n49 VSS.n135 0.571406
R523 VSS.n195 VSS.t24 0.572871
R524 VSS.t24 VSS.n0 0.572871
R525 VSS.t73 VSS.n7 0.557126
R526 VSS.n60 VSS.n140 0.522552
R527 VSS.t132 VSS.t134 0.492336
R528 VSS.n191 VSS.t24 0.490843
R529 VSS.t63 VSS.n3 39.2108
R530 VSS.n188 VSS.t24 0.490843
R531 VSS.n182 VSS.t24 0.490843
R532 VSS.n192 VSS.t24 0.489061
R533 VSS.t24 VSS.n2 0.489061
R534 VSS.t45 VSS.n179 0.47741
R535 VSS.t73 VSS.n6 0.477286
R536 VSS.n198 VSS.t89 0.464894
R537 VSS.n179 VSS.n178 0.460744
R538 VSS.n167 VSS.n140 0.446627
R539 VSS.n62 VSS.n58 0.431438
R540 VSS.n62 VSS.n52 0.0337254
R541 VSS.n90 VSS.n87 0.417336
R542 VSS.n94 VSS.n91 0.417043
R543 VSS.n91 VSS.n90 0.416074
R544 VSS.n92 VSS.n87 0.415796
R545 VSS.n203 VSS.n202 0.41014
R546 VSS.n44 VSS.t24 0.102856
R547 VSS.n222 VSS.n221 0.376066
R548 VSS.n212 VSS.n121 0.374483
R549 VSS.n208 VSS.n128 0.36227
R550 VSS.n215 VSS.n119 0.339196
R551 VSS.n218 VSS.n217 0.338265
R552 VSS.n217 VSS.n216 0.338019
R553 VSS.n214 VSS.n119 0.336981
R554 VSS.n157 VSS.n144 0.31249
R555 VSS.n213 VSS.n121 0.307886
R556 VSS.n221 VSS.n220 0.306341
R557 VSS.n187 VSS.n135 0.298621
R558 VSS.n200 VSS.n139 0.291601
R559 VSS.n201 VSS.n200 0.287886
R560 VSS.t27 VSS.n160 0.2761
R561 VSS.n36 VSS.n178 0.454252
R562 VSS.n95 VSS.n94 0.266107
R563 VSS.n160 VSS.n156 0.266107
R564 VSS.n95 VSS.n83 0.2636
R565 VSS.n133 VSS.n128 0.248324
R566 VSS.t78 VSS.n49 0.692963
R567 VSS.n114 VSS.n101 0.239006
R568 VSS.n115 VSS.n96 0.239006
R569 VSS.t7 VSS.n109 0.239006
R570 VSS.n18 VSS.n88 0.253607
R571 VSS.n104 VSS.t9 0.239006
R572 VSS.n109 VSS.n111 0.238668
R573 VSS.n115 VSS.n97 0.238668
R574 VSS.t9 VSS.n106 0.238668
R575 VSS.n101 VSS.t11 0.238668
R576 VSS.n161 VSS.n144 0.238044
R577 VSS.n208 VSS.n127 0.2361
R578 VSS.n37 VSS.t44 1.18372
R579 VSS.n172 VSS.n170 0.225674
R580 VSS.n170 VSS.n166 0.219424
R581 VSS.n202 VSS.n137 0.20686
R582 VSS.n138 VSS.n127 0.197357
R583 VSS.n111 VSS.t4 0.191235
R584 VSS.n112 VSS.n108 0.191235
R585 VSS.n106 VSS.n112 0.191235
R586 VSS.n113 VSS.n104 0.191235
R587 VSS.n102 VSS.n113 0.191235
R588 VSS.t11 VSS.n102 0.191235
R589 VSS.n98 VSS.n114 0.191235
R590 VSS.t13 VSS.n98 0.191235
R591 VSS.t131 VSS.n85 0.191235
R592 VSS.n60 VSS.n150 0.191235
R593 VSS.t6 VSS.n25 0.468871
R594 VSS.n108 VSS.t7 0.191235
R595 VSS.t4 VSS.t137 0.191235
R596 VSS.n97 VSS.t13 0.191235
R597 VSS.t150 VSS.t148 0.1875
R598 VSS.t144 VSS.t142 0.1875
R599 VSS.n126 VSS.n125 0.185168
R600 VSS.n211 VSS.n123 0.181924
R601 VSS.n205 VSS.n210 0.181543
R602 VSS.t82 VSS.n187 0.177814
R603 VSS.n90 VSS.t129 0.167615
R604 VSS.n206 VSS.n205 0.164808
R605 VSS.n207 VSS.n123 0.164424
R606 VSS.n177 VSS.n174 0.156138
R607 VSS.n28 VSS.t50 0.150099
R608 VSS.t34 VSS.n28 0.149428
R609 VSS.n125 VSS.t125 0.146613
R610 VSS.t125 VSS.n82 0.145809
R611 VSS.n133 VSS.n223 0.142012
R612 VSS.n28 VSS.t54 0.139355
R613 VSS.t29 VSS.n28 0.138705
R614 VSS.t38 VSS.n28 0.1387
R615 VSS.n223 VSS.n206 0.138262
R616 VSS.n138 VSS.n126 0.126532
R617 VSS.n28 VSS.t46 0.119905
R618 VSS.t134 VSS.n208 0.1171
R619 VSS.n89 VSS.n85 0.112118
R620 VSS.n211 VSS.n122 0.104618
R621 VSS.n210 VSS.n209 0.104618
R622 VSS.n28 VSS.t58 0.103851
R623 VSS.t145 VSS.n162 0.0971176
R624 VSS.n177 VSS.n150 0.0971176
R625 VSS.t42 VSS.n42 0.0132809
R626 VSS.n174 VSS.n173 0.0958002
R627 VSS.n173 VSS.n171 0.0955
R628 VSS.n161 VSS.n143 0.093
R629 VSS.t142 VSS.n159 0.0851154
R630 VSS.t144 VSS.n157 0.0851154
R631 VSS.t148 VSS.n169 0.0851154
R632 VSS.t150 VSS.n167 0.0851154
R633 VSS.n197 VSS.n180 0.0846176
R634 VSS.n214 VSS.n120 0.08425
R635 VSS.n219 VSS.n218 0.08425
R636 VSS.n158 VSS.n153 0.08175
R637 VSS.n168 VSS.n163 0.08175
R638 VSS.n159 VSS.n146 0.08175
R639 VSS.n169 VSS.n142 0.08175
R640 VSS.n125 VSS.n124 0.0805
R641 VSS.n88 VSS.n84 0.0796176
R642 VSS.n89 VSS.n86 0.0796176
R643 VSS.n94 VSS.n84 0.0758676
R644 VSS.n92 VSS.n86 0.0758676
R645 VSS.n207 VSS.n124 0.07425
R646 VSS.t140 VSS.n56 0.0740901
R647 VSS.n149 VSS.n148 0.0740901
R648 VSS.t30 VSS.n197 0.0708676
R649 VSS.n213 VSS.n120 0.06925
R650 VSS.n220 VSS.n219 0.06925
R651 VSS.n156 VSS.n155 0.0671176
R652 VSS.n166 VSS.n165 0.0671176
R653 VSS.n157 VSS.n145 0.0671176
R654 VSS.n167 VSS.n141 0.0671176
R655 VSS.n158 VSS.n155 0.0621177
R656 VSS.n168 VSS.n165 0.0621177
R657 VSS.n159 VSS.n145 0.0621177
R658 VSS.n169 VSS.n141 0.0621177
R659 VSS.n162 VSS.t27 0.0571176
R660 VSS VSS.n82 0.0555
R661 VSS.n212 VSS.n122 0.0496177
R662 VSS.n209 VSS.n222 0.0496177
R663 VSS.t147 VSS.n143 0.04925
R664 VSS.n163 VSS.t145 0.04675
R665 VSS.t147 VSS.n142 0.04675
R666 VSS.n153 VSS.n136 0.0305
R667 VSS.n147 VSS.n146 0.0305
R668 VSS.n149 VSS.n139 0.0253401
R669 VSS.n201 VSS.n56 0.0253401
R670 VSS.n193 VSS.t24 0.0184075
R671 VSS.t24 VSS.n1 0.0184075
R672 VSS.t140 VSS.n136 0.01675
R673 VSS.n148 VSS.n147 0.01675
R674 VSS.n184 VSS.t24 0.0151406
R675 VSS.n172 VSS.n171 0.013
R676 VSS.n225 VSS.n14 0.00994139
R677 VSS.n62 VSS.n55 0.0039408
R678 VSS.n67 VSS.n68 0.00299994
R679 VSS.n74 VSS.n103 0.00283308
R680 VSS.n64 VSS.n14 0.00283308
R681 VSS.n62 VSS.n57 0.00237245
R682 VSS.n61 VSS.n59 5.6686
R683 VSS.n67 VSS.n66 0.00149995
R684 VSS.n72 VSS.n71 0.00169993
R685 VSS.n77 VSS.n76 0.00169993
R686 VSS.n117 VSS.n10 0.00166667
R687 VSS.n117 VSS.n116 0.00133332
R688 VSS.n62 VSS.n61 0.00127777
R689 VSS.n62 VSS.n53 0.00105762
R690 VSS.n62 VSS.n54 0.00105761
R691 VSS.n110 VSS.n65 0.001
R692 VSS.n107 VSS.n68 0.001
R693 VSS.n105 VSS.n69 0.001
R694 VSS.n100 VSS.n75 0.001
R695 VSS.n116 VSS.n80 0.001
R696 VSS.n14 VSS.n10 0.0015
R697 VSS.n79 VSS.n78 0.00199984
R698 VSS.n99 VSS.n78 0.0015
R699 VSS.n99 VSS.n77 0.0015
R700 VSS.n103 VSS.n72 0.0015
R701 VSS.n70 VSS.n107 0.00199997
R702 VSS.n61 VSS.n60 8.47821
R703 VSS.t73 VSS.n5 0.287534
R704 VSS.n42 VSS.n28 0.0981496
R705 VSS.t69 VSS.n4 97.6328
C310 DELAY_VBIASP VSS 4.41492f
C311 DELAY_OUT_LAST VSS 2.65853f
C312 DELAY_VBIASN VSS 99.4221f
C313 DELAY_IN VSS 3.31101f
C314 DLL_RESETN VSS 4.6876f
C315 VDD VSS 14.20096f
C316 a_9712_1285# VSS 1.59068f ; **FLOATING
C317 a_9444_1285# VSS 2.15703f ; **FLOATING
C318 a_5778_740# VSS 5.33396f ; **FLOATING
C319 a_15464_1057# VSS 0.75544f ; **FLOATING
C320 a_14757_2555# VSS 0.09495f ; **FLOATING
C321 a_13880_2491# VSS 0.06985f ; **FLOATING
C322 a_15688_2776# VSS 0.26291f ; **FLOATING
C323 a_15108_2698# VSS 0.24458f ; **FLOATING
C324 a_14851_2555# VSS 0.38123f ; **FLOATING
C325 a_9444_1963# VSS 6.08462f ; **FLOATING
C326 a_14111_2600# VSS 0.19866f ; **FLOATING
C327 a_14009_2457# VSS 0.44622f ; **FLOATING
C328 a_13592_2796# VSS 1.57456f ; **FLOATING
C329 a_13306_2478# VSS 0.30095f ; **FLOATING
C330 a_13566_2701# VSS 0.15441f ; **FLOATING
C331 a_13132_2793# VSS 0.13036f ; **FLOATING
C332 a_12907_2793# VSS 0.14377f ; **FLOATING
C333 a_12907_2559# VSS 0.14861f ; **FLOATING
C334 a_13106_2730# VSS 0.06343f ; **FLOATING
C335 a_15304_1978# VSS 0.37009f ; **FLOATING
C336 a_14757_3601# VSS 0.09586f ; **FLOATING
C337 a_15688_3240# VSS 0.26405f ; **FLOATING
C338 a_14851_3601# VSS 0.39588f ; **FLOATING
C339 a_15108_3482# VSS 0.24582f ; **FLOATING
C340 a_14111_3251# VSS 0.21915f ; **FLOATING
C341 a_13880_3665# VSS 0.07345f ; **FLOATING
C342 a_14009_3251# VSS 0.48187f ; **FLOATING
C343 a_13592_3244# VSS 1.58208f ; **FLOATING
C344 a_13566_3208# VSS 0.15442f ; **FLOATING
C345 a_13045_3588# VSS 0.01124f ; **FLOATING
C346 a_13306_3678# VSS 0.31701f ; **FLOATING
C347 a_12849_3240# VSS 1.40248f ; **FLOATING
C348 a_13121_3204# VSS 0.80439f ; **FLOATING
C349 a_13019_3204# VSS 2.18888f ; **FLOATING
C350 a_12656_3237# VSS 0.28393f ; **FLOATING
C351 a_12355_3240# VSS 0.62262f ; **FLOATING
C352 a_11397_3601# VSS 0.09495f ; **FLOATING
C353 a_12158_3240# VSS 0.25874f ; **FLOATING
C354 a_11491_3601# VSS 0.30073f ; **FLOATING
C355 a_11748_3482# VSS 0.17021f ; **FLOATING
C356 a_10751_3251# VSS 0.19918f ; **FLOATING
C357 a_10520_3665# VSS 0.03671f ; **FLOATING
C358 a_10649_3251# VSS 0.47308f ; **FLOATING
C359 a_10232_3244# VSS 1.52123f ; **FLOATING
C360 a_10206_3208# VSS 0.08466f ; **FLOATING
C361 a_9946_3678# VSS 0.18126f ; **FLOATING
C362 a_9772_3216# VSS 0.12435f ; **FLOATING
C363 a_9746_3178# VSS 0.06613f ; **FLOATING
C364 a_9547_3545# VSS 0.16037f ; **FLOATING
C365 a_9547_3315# VSS 0.11966f ; **FLOATING
C366 a_6854_2827# VSS 3.66026f ; **FLOATING
C367 a_6126_1189# VSS 13.8075f ; **FLOATING
C368 a_6854_3359# VSS 1.21519f ; **FLOATING
C369 a_5974_3096# VSS 2.40124f ; **FLOATING
C370 a_6326_1963# VSS 1.03474f ; **FLOATING
C371 VSS.t125 VSS 3.31349f ; **FLOATING
C372 VDD.t31 VSS 4.06872f ; **FLOATING
C373 VDD.t83 VSS 0.02685f ; **FLOATING
C374 VDD.n0 VSS 0.02184f ; **FLOATING
C375 VDD.n1 VSS 0.01769f ; **FLOATING
C376 VDD.n2 VSS 0.01158f ; **FLOATING
C377 VDD.t75 VSS 0.01495f ; **FLOATING
C378 VDD.n3 VSS 0.10534f ; **FLOATING
C379 VDD.t18 VSS 6.61111f ; **FLOATING
C380 VDD.t34 VSS 0.02947f ; **FLOATING
C381 VDD.t47 VSS 0.02947f ; **FLOATING
C382 VDD.n4 VSS 0.10062f ; **FLOATING
C383 VDD.n5 VSS 0.01266f ; **FLOATING
C384 VDD.t35 VSS 0.03564f ; **FLOATING
C385 VDD.t45 VSS 0.03564f ; **FLOATING
C386 VDD.n6 VSS 0.11347f ; **FLOATING
C387 VDD.n7 VSS 0.06006f ; **FLOATING
C388 VDD.t73 VSS 0.02571f ; **FLOATING
C389 VDD.t72 VSS 0.01834f ; **FLOATING
C390 VDD.t74 VSS 0.02839f ; **FLOATING
C391 VDD.t76 VSS 0.02585f ; **FLOATING
C392 VDD.t78 VSS 0.02587f ; **FLOATING
C393 VDD.t77 VSS 0.01834f ; **FLOATING
C394 VDD.t79 VSS 0.02839f ; **FLOATING
C395 VDD.t80 VSS 0.01494f ; **FLOATING
C396 VDD.t81 VSS 0.02579f ; **FLOATING
C397 VDD.t49 VSS 0.02789f ; **FLOATING
C398 VDD.t52 VSS 0.01897f ; **FLOATING
C399 VDD.n8 VSS 0.2546f ; **FLOATING
C400 VDD.n9 VSS 0.02182f ; **FLOATING
C401 VDD.t38 VSS 0.02095f ; **FLOATING
C402 VDD.t42 VSS 0.02095f ; **FLOATING
C403 VDD.n10 VSS 0.06221f ; **FLOATING
C404 VDD.n11 VSS 0.02952f ; **FLOATING
C405 VDD.t37 VSS 0.04835f ; **FLOATING
C406 VDD.n12 VSS 0.01958f ; **FLOATING
C407 VDD.t41 VSS 0.04835f ; **FLOATING
C408 VDD.n13 VSS 0.01958f ; **FLOATING
C409 VDD.n14 VSS 0.04323f ; **FLOATING
C410 VDD.n15 VSS 0.01149f ; **FLOATING
C411 VDD.t26 VSS 0.02848f ; **FLOATING
C412 VDD.n16 VSS 0.05121f ; **FLOATING
C413 VDD.n17 VSS 0.02816f ; **FLOATING
C414 VDD.t54 VSS 0.0263f ; **FLOATING
C415 VDD.n18 VSS 0.06102f ; **FLOATING
C416 VDD.n19 VSS 0.01606f ; **FLOATING
C417 VDD.t21 VSS 0.02947f ; **FLOATING
C418 VDD.n20 VSS 0.13166f ; **FLOATING
C419 VDD.t24 VSS 0.02095f ; **FLOATING
C420 VDD.n21 VSS 0.11792f ; **FLOATING
C421 VDD.t19 VSS 0.04835f ; **FLOATING
C422 VDD.n22 VSS 0.01958f ; **FLOATING
C423 VDD.n23 VSS 0.05893f ; **FLOATING
C424 VDD.n24 VSS 0.02954f ; **FLOATING
C425 VDD.n25 VSS 1.40352f ; **FLOATING
C426 VDD.n26 VSS 0.01247f ; **FLOATING
C427 VDD.n27 VSS 0.02859f ; **FLOATING
C428 VDD.n28 VSS 0.02492f ; **FLOATING
C429 VDD.n29 VSS 0.02846f ; **FLOATING
C430 VDD.n30 VSS 0.0286f ; **FLOATING
C431 VDD.n31 VSS 0.01258f ; **FLOATING
C432 VDD.t17 VSS 0.01735f ; **FLOATING
C433 VDD.n32 VSS 1.37879f ; **FLOATING
C434 VDD.n33 VSS 0.01227f ; **FLOATING
C435 VDD.n34 VSS 0.01252f ; **FLOATING
C436 VDD.n35 VSS 0.05421f ; **FLOATING
C437 VDD.t10 VSS 0.0507f ; **FLOATING
C438 VDD.n36 VSS 0.0177f ; **FLOATING
C439 VDD.n37 VSS 0.03966f ; **FLOATING
C440 VDD.t63 VSS 0.04536f ; **FLOATING
C441 VDD.n38 VSS 0.01768f ; **FLOATING
C442 VDD.t69 VSS 0.04536f ; **FLOATING
C443 VDD.n39 VSS 0.91491f ; **FLOATING
C444 VDD.n40 VSS 0.01769f ; **FLOATING
C445 VDD.n41 VSS 0.03582f ; **FLOATING
C446 VDD.t61 VSS 0.28686f ; **FLOATING
C447 VDD.n42 VSS 0.01158f ; **FLOATING
C448 VDD.n43 VSS 0.03581f ; **FLOATING
C449 VDD.t1 VSS 0.0507f ; **FLOATING
C450 VDD.n44 VSS 0.0177f ; **FLOATING
C451 VDD.n45 VSS 0.05418f ; **FLOATING
C452 VDD.n46 VSS 0.0286f ; **FLOATING
C453 VDD.n47 VSS 0.06896f ; **FLOATING
C454 VDD.t11 VSS 0.0507f ; **FLOATING
C455 VDD.n48 VSS 0.03289f ; **FLOATING
C456 VDD.t2 VSS 0.0507f ; **FLOATING
C457 VDD.n49 VSS 0.0329f ; **FLOATING
C458 VDD.n50 VSS 0.06896f ; **FLOATING
C459 VDD.n51 VSS 0.02485f ; **FLOATING
C460 VDD.n52 VSS 0.06913f ; **FLOATING
C461 VDD.t12 VSS 0.0507f ; **FLOATING
C462 VDD.n53 VSS 0.03289f ; **FLOATING
C463 VDD.t4 VSS 0.0507f ; **FLOATING
C464 VDD.n54 VSS 0.0329f ; **FLOATING
C465 VDD.n55 VSS 0.06918f ; **FLOATING
C466 VDD.n56 VSS 0.02846f ; **FLOATING
C467 VDD.n57 VSS 0.06534f ; **FLOATING
C468 VDD.t15 VSS 0.0507f ; **FLOATING
C469 VDD.n58 VSS 0.03289f ; **FLOATING
C470 VDD.t7 VSS 0.0507f ; **FLOATING
C471 VDD.n59 VSS 0.0329f ; **FLOATING
C472 VDD.n60 VSS 0.06534f ; **FLOATING
C473 VDD.n61 VSS 0.0286f ; **FLOATING
C474 VDD.n62 VSS 0.01258f ; **FLOATING
C475 VDD.t0 VSS 9.98751f ; **FLOATING
C476 VDD.t66 VSS 0.04536f ; **FLOATING
C477 VDD.t71 VSS 0.04536f ; **FLOATING
C478 VDD.n63 VSS 0.05877f ; **FLOATING
C479 VDD.t9 VSS 0.0507f ; **FLOATING
C480 VDD.n64 VSS 0.05419f ; **FLOATING
C481 VDD.n65 VSS 0.0177f ; **FLOATING
C482 VDD.n66 VSS 0.05419f ; **FLOATING
C483 VDD.t5 VSS 0.0507f ; **FLOATING
C484 VDD.n67 VSS 0.0177f ; **FLOATING
C485 VDD.n68 VSS 0.03581f ; **FLOATING
C486 VDD.t64 VSS 0.28686f ; **FLOATING
C487 VDD.n69 VSS 0.01768f ; **FLOATING
C488 VDD.n70 VSS 0.06456f ; **FLOATING
C489 VDD.n71 VSS 0.0376f ; **FLOATING
.ends
