* NGSPICE file created from hx_dll_controller.ext - technology: ihp-sg13g2

.subckt hx_dll_controller VDD DLL_RESETN DELAY_OUT_LAST VSS DELAY_IN DELAY_VBIASN
+ DELAY_VBIASP
X0 a_10458_3750# DLL_RESETN VSS.t121 VSS.t120 sg13_lv_nmos ad=37.8f pd=0.6u as=0.1701p ps=1.65u w=0.42u l=0.13u
X1 a_10649_3336# DELAY_IN VDD.t18 VDD.t0 sg13_lv_pmos ad=0.4088p pd=2.97u as=1.03698p ps=6.245u w=1.12u l=0.13u
X2 VSS.t158 VSS.t158 VSS.t160 VSS.t159 sg13_lv_nmos ad=0.1406p pd=1.12u as=0 ps=0 w=0.74u l=0.13u
X3 a_13566_2786# a_14009_2542# a_13306_2563# VSS.t128 sg13_lv_nmos ad=79.8f pd=0.8u as=0.1296p ps=1.52u w=0.42u l=0.13u
X4 a_9946_3763# a_9772_3301# VDD.t22 VDD.t0 sg13_lv_pmos ad=79.8f pd=0.8u as=0.1428p ps=1.52u w=0.42u l=0.13u
X5 a_13306_2563# a_14111_2685# a_13566_2786# VDD.t0 sg13_lv_pmos ad=0.1428p pd=1.52u as=79.8f ps=0.8u w=0.42u l=0.13u
X6 a_15108_2783# a_14851_2640# a_15270_2563# VSS.t99 sg13_lv_nmos ad=0.1428p pd=1.52u as=37.8f ps=0.6u w=0.42u l=0.13u
X7 a_13566_3293# a_14009_3336# a_13949_3372# VDD.t0 sg13_lv_pmos ad=79.8f pd=0.8u as=63f ps=0.72u w=0.42u l=0.13u
X8 a_11491_3686# a_10649_3336# a_10232_3329# VDD.t0 sg13_lv_pmos ad=0.2048p pd=1.63u as=0.34p ps=2.68u w=1u l=0.13u
X9 VSS.t58 DELAY_VBIASN VSS.t56 VSS.t41 sg13_lv_nmos ad=1.33p pd=7.38u as=0 ps=0 w=7u l=7u
X10 a_9746_3263# a_9547_3400# VSS.t24 VSS.t25 sg13_lv_nmos ad=0.27427p pd=2.28u as=2.39977p ps=15.495u w=0.795u l=0.13u
X11 a_14009_3336# DELAY_IN VSS.t79 VSS.t125 sg13_lv_nmos ad=0.2516p pd=2.16u as=1.9998p ps=12.915u w=0.74u l=0.13u
X12 a_13121_3289# a_15688_3325# VDD.t34 VDD.t0 sg13_lv_pmos ad=0.3808p pd=2.92u as=0.2128p ps=1.5u w=1.12u l=0.13u
X13 a_6854_3444# a_6326_2048# VDD.t15 VDD.t0 sg13_lv_pmos ad=0.38p pd=2.38u as=0.38p ps=2.38u w=2u l=1u
X14 VSS.t84 a_14851_3686# a_15688_3325# VSS.t83 sg13_lv_nmos ad=0.1406p pd=1.12u as=0.2516p ps=2.16u w=0.74u l=0.13u
X15 VDD.t79 VDD.t77 VDD.t78 VDD.t31 sg13_lv_pmos ad=0.3808p pd=2.92u as=0 ps=0 w=1.12u l=0.13u
X16 VDD.t74 VDD.t75 VDD.t76 VDD.t31 sg13_lv_pmos ad=0.2128p pd=1.5u as=0 ps=0 w=1.12u l=0.13u
X17 a_6326_2048# a_6126_1274# a_5778_825# VSS.t3 sg13_lv_nmos ad=0.38p pd=2.38u as=0.68p ps=4.68u w=2u l=1u
X18 a_15108_2783# a_12849_3325# VDD.t18 VDD.t0 sg13_lv_pmos ad=79.8f pd=0.8u as=1.03698p ps=6.245u w=0.42u l=0.13u
X19 a_11748_3567# a_11491_3686# a_11910_3763# VSS.t2 sg13_lv_nmos ad=0.1428p pd=1.52u as=37.8f ps=0.6u w=0.42u l=0.13u
X20 VDD.t38 a_12849_3325# a_13566_3293# VDD.t0 sg13_lv_pmos ad=0.1563p pd=1.22u as=0.147p ps=1.54u w=0.42u l=0.13u
X21 VSS.t60 DELAY_VBIASN VSS.t58 VSS.t43 sg13_lv_nmos ad=1.33p pd=7.38u as=0 ps=0 w=7u l=7u
X22 VDD.t66 VDD.t64 VDD.t9 VDD.t0 sg13_lv_pmos ad=0.38p pd=2.38u as=0 ps=0 w=2u l=1u
X23 VSS.t9 a_6126_1274# a_5974_3181# VSS.t0 sg13_lv_nmos ad=0.68p pd=4.68u as=0.38p ps=2.38u w=2u l=1u
X24 VSS.t54 DELAY_VBIASN VSS.t52 VSS.t37 sg13_lv_nmos ad=1.33p pd=7.38u as=0 ps=0 w=7u l=7u
X25 VSS.t7 a_6126_1274# a_5974_3181# VSS.t0 sg13_lv_nmos ad=0.68p pd=4.68u as=0.38p ps=2.38u w=2u l=1u
X26 VSS.t40 DELAY_VBIASN VSS.t42 VSS.t41 sg13_lv_nmos ad=1.33p pd=7.38u as=0 ps=0 w=7u l=7u
X27 VDD.t18 a_11491_3686# a_11748_3567# VDD.t0 sg13_lv_pmos ad=1.10612p pd=6.66u as=79.8f ps=0.8u w=0.42u l=0.13u
X28 VDD.t83 DELAY_VBIASP DELAY_VBIASP VDD.t31 sg13_lv_pmos ad=0.3808p pd=2.92u as=1.0304p ps=4.08u w=1.12u l=0.6u
X29 VSS.t50 DELAY_VBIASN VSS.t48 VSS.t33 sg13_lv_nmos ad=1.33p pd=7.38u as=0 ps=0 w=7u l=7u
X30 a_6326_2048# a_6126_1274# a_5778_825# VSS.t3 sg13_lv_nmos ad=0.38p pd=2.38u as=0.68p ps=4.68u w=2u l=1u
X31 a_6126_1274# a_6326_2048# VDD.t11 VDD.t0 sg13_lv_pmos ad=0.38p pd=2.38u as=0.38p ps=2.38u w=2u l=1u
X32 VSS.t76 a_14009_2542# a_14111_2685# VSS.t129 sg13_lv_nmos ad=1.45407p pd=9.445u as=0.2516p ps=2.16u w=0.74u l=0.13u
X33 VDD.t15 a_6326_2048# a_6326_2048# VDD.t0 sg13_lv_pmos ad=0.38p pd=2.38u as=0.38p ps=2.38u w=2u l=1u
X34 a_13132_2878# a_13106_2815# VDD.t18 VDD.t0 sg13_lv_pmos ad=0.3927p pd=2.99u as=1.10612p ps=6.66u w=1.155u l=0.13u
X35 a_6126_1274# a_6126_1274# VSS.t5 VSS.t3 sg13_lv_nmos ad=0.38p pd=2.38u as=0.68p ps=4.68u w=2u l=1u
X36 a_15108_3567# a_12849_3325# VDD.t18 VDD.t0 sg13_lv_pmos ad=79.8f pd=0.8u as=1.03698p ps=6.245u w=0.42u l=0.13u
X37 VSS.t56 DELAY_VBIASN VSS.t54 VSS.t39 sg13_lv_nmos ad=1.33p pd=7.38u as=0 ps=0 w=7u l=7u
X38 a_15464_1142# a_14851_2640# VDD.t45 VDD.t0 sg13_lv_pmos ad=0.4312p pd=3.01u as=0.2639p ps=1.81u w=1.12u l=0.13u
X39 VDD.t11 a_6326_2048# a_6854_2912# VDD.t0 sg13_lv_pmos ad=0.38p pd=2.38u as=0.38p ps=2.38u w=2u l=1u
X40 VDD.t21 a_11491_3686# a_12158_3325# VDD.t0 sg13_lv_pmos ad=0.2128p pd=1.5u as=0.3864p ps=2.93u w=1.12u l=0.13u
X41 a_13818_3750# a_12849_3325# VSS.t91 VSS.t90 sg13_lv_nmos ad=37.8f pd=0.6u as=0.1701p ps=1.65u w=0.42u l=0.13u
X42 a_14009_3336# DELAY_IN VDD.t18 VDD.t0 sg13_lv_pmos ad=0.4088p pd=2.97u as=1.03698p ps=6.245u w=1.12u l=0.13u
X43 a_5778_825# VSS.t134 VSS.t133 rppd l=32u w=1u
X44 a_9444_1370# a_6854_2912# a_9712_1370# VSS.t15 sg13_lv_nmos ad=0.68p pd=4.68u as=0.38p ps=2.38u w=2u l=1u
X45 a_6126_1274# a_6326_2048# VDD.t4 VDD.t0 sg13_lv_pmos ad=0.38p pd=2.38u as=0.38p ps=2.38u w=2u l=1u
X46 a_13045_3673# a_13019_3289# a_12849_3325# VSS.t63 sg13_lv_nmos ad=0.1406p pd=1.12u as=0.1406p ps=1.12u w=0.74u l=0.13u
X47 a_11693_3448# a_10751_3336# a_11491_3686# VDD.t0 sg13_lv_pmos ad=93.45f pd=0.865u as=0.2048p ps=1.63u w=0.42u l=0.13u
X48 a_13306_3763# a_12355_3325# VDD.t27 VDD.t0 sg13_lv_pmos ad=79.8f pd=0.8u as=0.1428p ps=1.52u w=0.42u l=0.13u
X49 VDD.t18 a_12907_2644# a_12907_2878# VDD.t0 sg13_lv_pmos ad=1.10612p pd=6.66u as=0.2442p ps=2.06u w=0.66u l=0.13u
X50 VDD.t9 a_6326_2048# a_6854_2912# VDD.t0 sg13_lv_pmos ad=0.38p pd=2.38u as=0.38p ps=2.38u w=2u l=1u
X51 a_10232_3329# a_10206_3293# VSS.t19 VSS.t18 sg13_lv_nmos ad=0.2516p pd=2.16u as=0.1626p ps=1.415u w=0.74u l=0.13u
X52 a_13106_2815# a_12907_2878# VSS.t76 VSS.t103 sg13_lv_nmos ad=0.27427p pd=2.28u as=1.45407p ps=9.445u w=0.795u l=0.13u
X53 VSS.t46 DELAY_VBIASN VSS.t45 VSS.t28 sg13_lv_nmos ad=2.38p pd=14.68u as=0 ps=0 w=7u l=7u
X54 a_14851_3686# a_14009_3336# a_13592_3329# VDD.t0 sg13_lv_pmos ad=0.2048p pd=1.63u as=0.34p ps=2.68u w=1u l=0.13u
X55 a_5974_3181# a_6126_1274# VSS.t4 VSS.t0 sg13_lv_nmos ad=0.38p pd=2.38u as=0.68p ps=4.68u w=2u l=1u
X56 VDD.t19 DLL_RESETN a_9946_3763# VDD.t0 sg13_lv_pmos ad=0.36237p pd=2.605u as=79.8f ps=0.8u w=0.42u l=0.13u
X57 a_9946_3763# a_10751_3336# a_10206_3293# VDD.t0 sg13_lv_pmos ad=0.1428p pd=1.52u as=79.8f ps=0.8u w=0.42u l=0.13u
X58 a_13566_3293# a_14009_3336# a_13306_3763# VSS.t77 sg13_lv_nmos ad=79.8f pd=0.8u as=0.1296p ps=1.52u w=0.42u l=0.13u
X59 VSS.t113 a_9444_2048# a_9444_1370# VSS.t112 sg13_lv_nmos ad=0.68p pd=4.68u as=0.38p ps=2.38u w=2u l=1u
X60 a_9712_1370# a_13019_3289# DELAY_VBIASN VSS.t64 sg13_lv_nmos ad=0.136p pd=1.14u as=0.232p ps=2.08u w=0.4u l=0.2u
X61 VSS.t13 a_6126_1274# a_5974_3181# VSS.t0 sg13_lv_nmos ad=0.68p pd=4.68u as=0.38p ps=2.38u w=2u l=1u
X62 a_13818_2576# a_12849_3325# VSS.t93 VSS.t92 sg13_lv_nmos ad=37.8f pd=0.6u as=0.1701p ps=1.65u w=0.42u l=0.13u
X63 a_15304_2063# a_14851_3686# VDD.t35 VDD.t0 sg13_lv_pmos ad=0.4312p pd=3.01u as=0.2639p ps=1.81u w=1.12u l=0.13u
X64 VSS.t11 a_6126_1274# a_5974_3181# VSS.t0 sg13_lv_nmos ad=0.76p pd=4.76u as=0.38p ps=2.38u w=2u l=1u
X65 a_6854_2912# a_6326_2048# VDD.t10 VDD.t0 sg13_lv_pmos ad=0.38p pd=2.38u as=0.38p ps=2.38u w=2u l=1u
X66 VSS.t86 a_12849_3325# a_13400_3763# VSS.t85 sg13_lv_nmos ad=0.1626p pd=1.415u as=60.89999f ps=0.71u w=0.42u l=0.13u
X67 VSS.t115 a_9444_2048# a_9444_1370# VSS.t108 sg13_lv_nmos ad=0.68p pd=4.68u as=0.38p ps=2.38u w=2u l=1u
X68 VSS.t101 a_14851_2640# a_15688_2861# VSS.t100 sg13_lv_nmos ad=0.1406p pd=1.12u as=0.2516p ps=2.16u w=0.74u l=0.13u
X69 a_5778_825# a_6126_1274# a_6326_2048# VSS.t3 sg13_lv_nmos ad=0.68p pd=4.68u as=0.38p ps=2.38u w=2u l=1u
X70 VDD.t12 a_6326_2048# a_6126_1274# VDD.t0 sg13_lv_pmos ad=0.38p pd=2.38u as=0.38p ps=2.38u w=2u l=1u
X71 a_13121_3289# a_15688_3325# VSS.t84 VSS.t97 sg13_lv_nmos ad=0.2516p pd=2.16u as=0.1406p ps=1.12u w=0.74u l=0.13u
X72 a_9444_1370# a_6854_2912# a_9712_1370# VSS.t17 sg13_lv_nmos ad=0.68p pd=4.68u as=0.38p ps=2.38u w=2u l=1u
X73 VDD.t45 a_14851_2640# a_15108_2783# VDD.t0 sg13_lv_pmos ad=0.2639p pd=1.81u as=79.8f ps=0.8u w=0.42u l=0.13u
X74 a_9712_1370# a_6854_2912# a_9444_1370# VSS.t14 sg13_lv_nmos ad=0.38p pd=2.38u as=0.68p ps=4.68u w=2u l=1u
X75 a_6854_3444# a_15304_2063# DELAY_VBIASN VDD.t31 sg13_lv_pmos ad=0.136p pd=1.14u as=0.158p ps=1.245u w=0.4u l=0.2u
X76 a_9444_1370# a_9444_2048# VSS.t114 VSS.t106 sg13_lv_nmos ad=0.38p pd=2.38u as=0.68p ps=4.68u w=2u l=1u
X77 VSS.t95 a_15108_2783# a_14757_2640# VSS.t131 sg13_lv_nmos ad=79.8f pd=0.8u as=0.1428p ps=1.52u w=0.42u l=0.13u
X78 a_6854_2912# a_6326_2048# VDD.t7 VDD.t0 sg13_lv_pmos ad=0.38p pd=2.38u as=0.38p ps=2.38u w=2u l=1u
X79 VSS.t48 DELAY_VBIASN VSS.t46 VSS.t31 sg13_lv_nmos ad=1.33p pd=7.38u as=0 ps=0 w=7u l=7u
X80 VSS.t19 DLL_RESETN a_10040_3763# VSS.t18 sg13_lv_nmos ad=0.1626p pd=1.415u as=60.89999f ps=0.71u w=0.42u l=0.13u
X81 a_9772_3301# a_9746_3263# VDD.t18 VDD.t0 sg13_lv_pmos ad=0.3927p pd=2.99u as=1.10612p ps=6.66u w=1.155u l=0.13u
X82 a_13949_2954# a_13592_2881# VDD.t42 VDD.t0 sg13_lv_pmos ad=63f pd=0.72u as=0.1563p ps=1.22u w=0.42u l=0.13u
X83 VSS.t143 VSS.t141 VSS.t141 VSS.t142 sg13_lv_nmos ad=0.68p pd=4.68u as=0 ps=0 w=2u l=1u
X84 a_13592_2881# a_13566_2786# VSS.t89 VSS.t127 sg13_lv_nmos ad=0.2516p pd=2.16u as=0.1626p ps=1.415u w=0.74u l=0.13u
X85 VSS.t146 VSS.t138 VSS.t138 VSS.t139 sg13_lv_nmos ad=0.68p pd=4.68u as=0 ps=0 w=2u l=1u
X86 a_15108_3567# a_14851_3686# a_15270_3763# VSS.t80 sg13_lv_nmos ad=0.1428p pd=1.52u as=37.8f ps=0.6u w=0.42u l=0.13u
X87 VSS.t76 a_12907_2644# a_12907_2644# VSS.t126 sg13_lv_nmos ad=1.45407p pd=9.445u as=0.111p ps=1.34u w=0.3u l=0.13u
X88 a_9444_1370# a_9444_2048# VSS.t111 VSS.t110 sg13_lv_nmos ad=0.38p pd=2.38u as=0.68p ps=4.68u w=2u l=1u
X89 VDD.t26 a_13019_3289# a_12943_3325# VDD.t0 sg13_lv_pmos ad=0.2128p pd=1.5u as=0.2128p ps=1.5u w=1.12u l=0.13u
X90 a_5974_3181# a_6126_1274# VSS.t12 VSS.t0 sg13_lv_nmos ad=0.38p pd=2.38u as=0.68p ps=4.68u w=2u l=1u
X91 VDD.t17 a_5974_3181# a_5974_3181# VDD.t0 sg13_lv_pmos ad=0.2448p pd=2.08u as=0.2826p ps=2.29u w=0.36u l=2u
X92 a_15053_2878# a_14111_2685# a_14851_2640# VDD.t0 sg13_lv_pmos ad=93.45f pd=0.865u as=0.2048p ps=1.63u w=0.42u l=0.13u
X93 VSS.t62 a_11748_3567# a_11397_3686# VSS.t2 sg13_lv_nmos ad=79.8f pd=0.8u as=0.1428p ps=1.52u w=0.42u l=0.13u
X94 VDD.t69 VDD.t61 VDD.t10 VDD.t0 sg13_lv_pmos ad=0.68p pd=4.68u as=0 ps=0 w=2u l=1u
X95 VSS.t36 DELAY_VBIASN VSS.t38 VSS.t37 sg13_lv_nmos ad=1.33p pd=7.38u as=0 ps=0 w=7u l=7u
X96 a_9712_1370# a_6854_2912# a_9444_1370# VSS.t16 sg13_lv_nmos ad=0.38p pd=2.38u as=0.68p ps=4.68u w=2u l=1u
X97 a_6326_2048# a_6326_2048# VDD.t2 VDD.t0 sg13_lv_pmos ad=0.38p pd=2.38u as=0.38p ps=2.38u w=2u l=1u
X98 a_13592_3329# a_13566_3293# VSS.t86 VSS.t85 sg13_lv_nmos ad=0.2516p pd=2.16u as=0.1626p ps=1.415u w=0.74u l=0.13u
X99 VDD.t35 a_14851_3686# a_15108_3567# VDD.t0 sg13_lv_pmos ad=0.2639p pd=1.81u as=79.8f ps=0.8u w=0.42u l=0.13u
X100 a_13306_2563# a_13132_2878# VDD.t84 VDD.t0 sg13_lv_pmos ad=79.8f pd=0.8u as=0.1428p ps=1.52u w=0.42u l=0.13u
X101 VDD.t7 a_6326_2048# a_6126_1274# VDD.t0 sg13_lv_pmos ad=0.38p pd=2.38u as=0.38p ps=2.38u w=2u l=1u
X102 a_12355_3325# a_12158_3325# VDD.t21 VDD.t0 sg13_lv_pmos ad=0.3808p pd=2.92u as=0.2128p ps=1.5u w=1.12u l=0.13u
X103 VSS.t42 DELAY_VBIASN VSS.t44 VSS.t43 sg13_lv_nmos ad=1.33p pd=7.38u as=0 ps=0 w=7u l=7u
X104 a_14009_2542# DELAY_OUT_LAST VDD.t18 VDD.t0 sg13_lv_pmos ad=0.4088p pd=2.97u as=1.10612p ps=6.66u w=1.12u l=0.13u
X105 VSS.t21 a_11491_3686# a_12158_3325# VSS.t20 sg13_lv_nmos ad=0.1406p pd=1.12u as=0.2516p ps=2.16u w=0.74u l=0.13u
X106 VDD.t37 a_12849_3325# a_13306_3763# VDD.t0 sg13_lv_pmos ad=0.36237p pd=2.605u as=79.8f ps=0.8u w=0.42u l=0.13u
X107 VDD.t2 a_6326_2048# a_6854_3444# VDD.t0 sg13_lv_pmos ad=0.38p pd=2.38u as=0.38p ps=2.38u w=2u l=1u
X108 a_10520_3750# a_10751_3336# a_10206_3293# VSS.t1 sg13_lv_nmos ad=0.2373p pd=1.97u as=79.8f ps=0.8u w=0.42u l=0.13u
X109 VSS.t79 a_14009_3336# a_14111_3336# VSS.t78 sg13_lv_nmos ad=2.39977p pd=15.495u as=0.2516p ps=2.16u w=0.74u l=0.13u
X110 VSS.t158 VSS.t155 VSS.t157 VSS.t156 sg13_lv_nmos ad=0.2516p pd=2.16u as=0 ps=0 w=0.74u l=0.13u
X111 VSS.t152 VSS.t152 VSS.t154 VSS.t153 sg13_lv_nmos ad=0.1406p pd=1.12u as=0 ps=0 w=0.74u l=0.13u
X112 a_13592_2881# a_14111_2685# a_14851_2640# VSS.t137 sg13_lv_nmos ad=0.3473p pd=2.71u as=0.12665p ps=1.145u w=0.74u l=0.13u
X113 a_15053_3448# a_14111_3336# a_14851_3686# VDD.t0 sg13_lv_pmos ad=93.45f pd=0.865u as=0.2048p ps=1.63u w=0.42u l=0.13u
X114 a_13566_2786# a_14009_2542# a_13949_2954# VDD.t0 sg13_lv_pmos ad=79.8f pd=0.8u as=63f ps=0.72u w=0.42u l=0.13u
X115 a_13880_2576# a_14111_2685# a_13566_2786# VSS.t136 sg13_lv_nmos ad=0.2373p pd=1.97u as=79.8f ps=0.8u w=0.42u l=0.13u
X116 VSS.t70 a_10649_3336# a_10751_3336# VSS.t69 sg13_lv_nmos ad=2.39977p pd=15.495u as=0.2516p ps=2.16u w=0.74u l=0.13u
X117 a_13306_3763# a_14111_3336# a_13566_3293# VDD.t0 sg13_lv_pmos ad=0.1428p pd=1.52u as=79.8f ps=0.8u w=0.42u l=0.13u
X118 a_15304_2063# a_14851_3686# VSS.t82 VSS.t81 sg13_lv_nmos ad=0.2849p pd=2.25u as=0.2516p ps=2.16u w=0.74u l=0.13u
X119 a_13019_3289# a_15688_2861# VSS.t101 VSS.t104 sg13_lv_nmos ad=0.2516p pd=2.16u as=0.1406p ps=1.12u w=0.74u l=0.13u
X120 VSS.t52 DELAY_VBIASN VSS.t50 VSS.t35 sg13_lv_nmos ad=1.33p pd=7.38u as=0 ps=0 w=7u l=7u
X121 a_6326_2048# a_5974_3181# a_6126_1274# VSS.t0 sg13_lv_nmos ad=0.38p pd=2.38u as=0.68p ps=4.68u w=2u l=1u
X122 a_14851_2640# a_14009_2542# a_13592_2881# VDD.t0 sg13_lv_pmos ad=0.2048p pd=1.63u as=0.34p ps=2.68u w=1u l=0.13u
X123 DELAY_VBIASN DLL_RESETN VDD.t52 VDD.t31 sg13_lv_pmos ad=0.158p pd=1.245u as=0.272p ps=2.28u w=0.8u l=0.2u
X124 VDD.t74 VDD.t72 VDD.t73 VDD.t31 sg13_lv_pmos ad=0.3808p pd=2.92u as=0 ps=0 w=1.12u l=0.13u
X125 a_6854_3444# a_6326_2048# VDD.t1 VDD.t0 sg13_lv_pmos ad=0.38p pd=2.38u as=0.38p ps=2.38u w=2u l=1u
X126 VDD.t42 a_12849_3325# a_13566_2786# VDD.t0 sg13_lv_pmos ad=0.1563p pd=1.22u as=0.147p ps=1.54u w=0.42u l=0.13u
X127 VSS.t27 DELAY_VBIASN DELAY_VBIASP VSS.t26 sg13_lv_nmos ad=0.2516p pd=2.16u as=0.6808p ps=3.32u w=0.74u l=0.6u
X128 VDD.t79 VDD.t80 VDD.t81 VDD.t31 sg13_lv_pmos ad=0.2128p pd=1.5u as=0 ps=0 w=1.12u l=0.13u
X129 VSS.t32 DELAY_VBIASN VSS.t34 VSS.t33 sg13_lv_nmos ad=1.33p pd=7.38u as=0 ps=0 w=7u l=7u
X130 VDD.t4 a_6326_2048# a_6326_2048# VDD.t0 sg13_lv_pmos ad=0.38p pd=2.38u as=0.38p ps=2.38u w=2u l=1u
X131 a_15270_2563# a_12849_3325# VSS.t95 VSS.t94 sg13_lv_nmos ad=37.8f pd=0.6u as=79.8f ps=0.8u w=0.42u l=0.13u
X132 a_10232_3329# a_10206_3293# VDD.t19 VDD.t0 sg13_lv_pmos ad=0.34p pd=2.68u as=0.36237p ps=2.605u w=1u l=0.13u
X133 a_14851_3686# a_14009_3336# a_14757_3686# VSS.t80 sg13_lv_nmos ad=0.12665p pd=1.145u as=0.1428p ps=1.52u w=0.42u l=0.13u
X134 a_12656_3322# DLL_RESETN VSS.t123 VSS.t122 sg13_lv_nmos ad=0.2516p pd=2.16u as=0.2516p ps=2.16u w=0.74u l=0.13u
X135 a_13400_2563# a_13132_2878# a_13306_2563# VSS.t135 sg13_lv_nmos ad=60.89999f pd=0.71u as=0.1428p ps=1.52u w=0.42u l=0.13u
X136 a_12849_3325# a_12656_3322# VSS.t66 VSS.t65 sg13_lv_nmos ad=0.1406p pd=1.12u as=0.2516p ps=2.16u w=0.74u l=0.13u
X137 a_5974_3181# a_6126_1274# VSS.t8 VSS.t0 sg13_lv_nmos ad=0.38p pd=2.38u as=0.68p ps=4.68u w=2u l=1u
X138 a_11910_3763# DLL_RESETN VSS.t62 VSS.t2 sg13_lv_nmos ad=37.8f pd=0.6u as=79.8f ps=0.8u w=0.42u l=0.13u
X139 a_13880_3750# a_13592_3329# a_13818_3750# VSS.t161 sg13_lv_nmos ad=0.1428p pd=1.52u as=37.8f ps=0.6u w=0.42u l=0.13u
X140 VDD.t18 a_14009_3336# a_14111_3336# VDD.t0 sg13_lv_pmos ad=1.10612p pd=6.66u as=0.3864p ps=2.93u w=1.12u l=0.13u
X141 a_5778_825# a_6126_1274# a_6326_2048# VSS.t3 sg13_lv_nmos ad=0.68p pd=4.68u as=0.38p ps=2.38u w=2u l=1u
X142 VDD.t18 a_11748_3567# a_11693_3448# VDD.t0 sg13_lv_pmos ad=1.10612p pd=6.66u as=93.45f ps=0.865u w=0.42u l=0.13u
X143 a_5974_3181# a_6126_1274# VSS.t10 VSS.t0 sg13_lv_nmos ad=0.38p pd=2.38u as=0.68p ps=4.68u w=2u l=1u
X144 a_11491_3686# a_10649_3336# a_11397_3686# VSS.t2 sg13_lv_nmos ad=0.12665p pd=1.145u as=0.1428p ps=1.52u w=0.42u l=0.13u
X145 a_5778_825# a_6126_1274# a_6326_2048# VSS.t3 sg13_lv_nmos ad=0.68p pd=4.68u as=0.38p ps=2.38u w=2u l=1u
X146 VDD.t63 VDD.t61 VDD.t1 VDD.t0 sg13_lv_pmos ad=0.68p pd=4.68u as=0 ps=0 w=2u l=1u
X147 VDD.t41 a_12849_3325# a_13306_2563# VDD.t0 sg13_lv_pmos ad=0.36237p pd=2.605u as=79.8f ps=0.8u w=0.42u l=0.13u
X148 VDD.t18 a_10649_3336# a_10751_3336# VDD.t0 sg13_lv_pmos ad=1.10612p pd=6.66u as=0.3864p ps=2.93u w=1.12u l=0.13u
X149 VSS.t87 a_15108_3567# a_14757_3686# VSS.t80 sg13_lv_nmos ad=79.8f pd=0.8u as=0.1428p ps=1.52u w=0.42u l=0.13u
X150 a_10520_3750# a_10232_3329# a_10458_3750# VSS.t61 sg13_lv_nmos ad=0.1428p pd=1.52u as=37.8f ps=0.6u w=0.42u l=0.13u
X151 a_6326_2048# a_6126_1274# a_5778_825# VSS.t3 sg13_lv_nmos ad=0.42p pd=2.42u as=0.68p ps=4.68u w=2u l=1u
X152 a_12355_3325# a_12158_3325# VSS.t21 VSS.t71 sg13_lv_nmos ad=0.2516p pd=2.16u as=0.1406p ps=1.12u w=0.74u l=0.13u
X153 a_12656_3322# DLL_RESETN VDD.t54 VDD.t0 sg13_lv_pmos ad=0.3808p pd=2.92u as=0.3808p ps=2.92u w=1.12u l=0.13u
X154 a_13880_2576# a_13592_2881# a_13818_2576# VSS.t132 sg13_lv_nmos ad=0.1428p pd=1.52u as=37.8f ps=0.6u w=0.42u l=0.13u
X155 VSS.t74 a_13121_3289# a_13045_3673# VSS.t73 sg13_lv_nmos ad=0.2516p pd=2.16u as=0.1406p ps=1.12u w=0.74u l=0.13u
X156 VDD.t47 a_14851_2640# a_15688_2861# VDD.t0 sg13_lv_pmos ad=0.2128p pd=1.5u as=0.3864p ps=2.93u w=1.12u l=0.13u
X157 a_13592_2881# a_13566_2786# VDD.t41 VDD.t0 sg13_lv_pmos ad=0.34p pd=2.68u as=0.36237p ps=2.605u w=1u l=0.13u
X158 VSS.t117 a_9444_2048# a_9444_2048# VSS.t112 sg13_lv_nmos ad=0.68p pd=4.68u as=0.38p ps=2.38u w=2u l=1u
X159 a_9444_2048# a_6854_2912# a_6854_2912# VSS.t15 sg13_lv_nmos ad=0.68p pd=4.68u as=0.38p ps=2.38u w=2u l=1u
X160 a_14009_2542# DELAY_OUT_LAST VSS.t76 VSS.t75 sg13_lv_nmos ad=0.2516p pd=2.16u as=1.45407p ps=9.445u w=0.74u l=0.13u
X161 VSS.t38 DELAY_VBIASN VSS.t40 VSS.t39 sg13_lv_nmos ad=1.33p pd=7.38u as=0 ps=0 w=7u l=7u
X162 a_10206_3293# a_10649_3336# a_10589_3372# VDD.t0 sg13_lv_pmos ad=79.8f pd=0.8u as=63f ps=0.72u w=0.42u l=0.13u
X163 a_13880_3750# a_14111_3336# a_13566_3293# VSS.t98 sg13_lv_nmos ad=0.2373p pd=1.97u as=79.8f ps=0.8u w=0.42u l=0.13u
X164 a_10040_3763# a_9772_3301# a_9946_3763# VSS.t22 sg13_lv_nmos ad=60.89999f pd=0.71u as=0.1428p ps=1.52u w=0.42u l=0.13u
X165 a_6326_2048# a_6126_1274# a_5778_825# VSS.t3 sg13_lv_nmos ad=0.38p pd=2.38u as=0.68p ps=4.68u w=2u l=1u
X166 a_15464_1142# a_14851_2640# VSS.t95 VSS.t102 sg13_lv_nmos ad=0.2849p pd=2.25u as=0.2516p ps=2.16u w=0.74u l=0.13u
X167 VSS.t34 DELAY_VBIASN VSS.t36 VSS.t35 sg13_lv_nmos ad=1.33p pd=7.38u as=0 ps=0 w=7u l=7u
X168 a_6126_1274# a_5974_3181# a_6326_2048# VSS.t0 sg13_lv_nmos ad=0.68p pd=4.68u as=0.38p ps=2.38u w=2u l=1u
X169 a_13592_3329# a_13566_3293# VDD.t37 VDD.t0 sg13_lv_pmos ad=0.34p pd=2.68u as=0.36237p ps=2.605u w=1u l=0.13u
X170 a_9444_2048# a_6854_2912# a_6854_2912# VSS.t17 sg13_lv_nmos ad=0.68p pd=4.68u as=0.38p ps=2.38u w=2u l=1u
X171 a_12943_3325# a_12656_3322# a_12849_3325# VDD.t0 sg13_lv_pmos ad=0.2128p pd=1.5u as=0.3808p ps=2.92u w=1.12u l=0.13u
X172 a_5778_825# a_6126_1274# a_6326_2048# VSS.t3 sg13_lv_nmos ad=0.68p pd=4.68u as=0.42p ps=2.42u w=2u l=1u
X173 VDD.t34 a_14851_3686# a_15688_3325# VDD.t0 sg13_lv_pmos ad=0.2128p pd=1.5u as=0.3864p ps=2.93u w=1.12u l=0.13u
X174 VSS.t6 a_6126_1274# a_6126_1274# VSS.t3 sg13_lv_nmos ad=0.68p pd=4.68u as=0.38p ps=2.38u w=2u l=1u
X175 VDD.t18 a_15108_2783# a_15053_2878# VDD.t0 sg13_lv_pmos ad=1.10612p pd=6.66u as=93.45f ps=0.865u w=0.42u l=0.13u
X176 VDD.t18 a_9547_3630# a_9547_3400# VDD.t0 sg13_lv_pmos ad=1.10612p pd=6.66u as=0.2442p ps=2.06u w=0.66u l=0.13u
X177 VDD.t49 a_15464_1142# a_9712_1370# VSS.t105 sg13_lv_nmos ad=0.232p pd=2.08u as=0.136p ps=1.14u w=0.4u l=0.2u
X178 VSS.t109 a_9444_2048# a_9444_2048# VSS.t108 sg13_lv_nmos ad=0.68p pd=4.68u as=0.38p ps=2.38u w=2u l=1u
X179 a_13592_3329# a_14111_3336# a_14851_3686# VSS.t80 sg13_lv_nmos ad=0.3473p pd=2.71u as=0.12665p ps=1.145u w=0.74u l=0.13u
X180 a_9444_2048# a_9444_2048# VSS.t116 VSS.t110 sg13_lv_nmos ad=0.38p pd=2.38u as=0.68p ps=4.68u w=2u l=1u
X181 a_14851_2640# a_14009_2542# a_14757_2640# VSS.t130 sg13_lv_nmos ad=0.12665p pd=1.145u as=0.1428p ps=1.52u w=0.42u l=0.13u
X182 VDD.t5 VDD.t64 VDD.t71 VDD.t0 sg13_lv_pmos ad=0.38p pd=2.38u as=0 ps=0 w=2u l=1u
X183 a_10649_3336# DELAY_IN VSS.t70 VSS.t124 sg13_lv_nmos ad=0.2516p pd=2.16u as=1.9998p ps=12.915u w=0.74u l=0.13u
X184 a_6854_2912# a_6854_2912# a_9444_2048# VSS.t14 sg13_lv_nmos ad=0.38p pd=2.38u as=0.68p ps=4.68u w=2u l=1u
X185 a_9444_2048# a_9444_2048# VSS.t107 VSS.t106 sg13_lv_nmos ad=0.38p pd=2.38u as=0.68p ps=4.68u w=2u l=1u
X186 VSS.t30 DELAY_VBIASN VSS.t29 VSS.t28 sg13_lv_nmos ad=2.38p pd=14.68u as=0 ps=0 w=7u l=7u
X187 a_13949_3372# a_13592_3329# VDD.t38 VDD.t0 sg13_lv_pmos ad=63f pd=0.72u as=0.1563p ps=1.22u w=0.42u l=0.13u
X188 VSS.t143 VSS.t141 VSS.t141 VSS.t142 sg13_lv_nmos ad=0.68p pd=4.68u as=0 ps=0 w=2u l=1u
X189 a_10232_3329# a_10751_3336# a_11491_3686# VSS.t2 sg13_lv_nmos ad=0.3473p pd=2.71u as=0.12665p ps=1.145u w=0.74u l=0.13u
X190 a_12943_3325# a_13121_3289# VDD.t26 VDD.t0 sg13_lv_pmos ad=0.3808p pd=2.92u as=0.2128p ps=1.5u w=1.12u l=0.13u
X191 VDD.t18 a_14009_2542# a_14111_2685# VDD.t0 sg13_lv_pmos ad=1.10612p pd=6.66u as=0.3864p ps=2.93u w=1.12u l=0.13u
X192 VDD.t24 DLL_RESETN a_10206_3293# VDD.t0 sg13_lv_pmos ad=0.1563p pd=1.22u as=0.147p ps=1.54u w=0.42u l=0.13u
X193 VSS.t72 a_13121_3289# a_6854_3444# VDD.t31 sg13_lv_pmos ad=0.232p pd=2.08u as=0.136p ps=1.14u w=0.4u l=0.2u
X194 a_6854_2912# a_6854_2912# a_9444_2048# VSS.t16 sg13_lv_nmos ad=0.38p pd=2.38u as=0.68p ps=4.68u w=2u l=1u
X195 VSS.t138 VSS.t138 VSS.t140 VSS.t139 sg13_lv_nmos ad=0.68p pd=4.68u as=0 ps=0 w=2u l=1u
X196 a_11748_3567# DLL_RESETN VDD.t18 VDD.t0 sg13_lv_pmos ad=79.8f pd=0.8u as=1.10612p ps=6.66u w=0.42u l=0.13u
X197 VSS.t24 a_9547_3630# a_9547_3630# VSS.t23 sg13_lv_nmos ad=2.39977p pd=15.495u as=0.111p ps=1.34u w=0.3u l=0.13u
X198 VSS.t29 DELAY_VBIASN VSS.t32 VSS.t31 sg13_lv_nmos ad=1.33p pd=7.38u as=0 ps=0 w=7u l=7u
X199 a_10589_3372# a_10232_3329# VDD.t24 VDD.t0 sg13_lv_pmos ad=63f pd=0.72u as=0.1563p ps=1.22u w=0.42u l=0.13u
X200 a_15270_3763# a_12849_3325# VSS.t87 VSS.t80 sg13_lv_nmos ad=37.8f pd=0.6u as=79.8f ps=0.8u w=0.42u l=0.13u
X201 a_6326_2048# a_6326_2048# VDD.t12 VDD.t0 sg13_lv_pmos ad=0.38p pd=2.38u as=0.38p ps=2.38u w=2u l=1u
X202 VDD.t18 a_15108_3567# a_15053_3448# VDD.t0 sg13_lv_pmos ad=1.10612p pd=6.66u as=93.45f ps=0.865u w=0.42u l=0.13u
X203 VDD.t5 a_6326_2048# a_6854_3444# VDD.t0 sg13_lv_pmos ad=0.38p pd=2.38u as=0.38p ps=2.38u w=2u l=1u
X204 a_10206_3293# a_10649_3336# a_9946_3763# VSS.t68 sg13_lv_nmos ad=79.8f pd=0.8u as=0.1296p ps=1.52u w=0.42u l=0.13u
X205 VSS.t89 a_12849_3325# a_13400_2563# VSS.t88 sg13_lv_nmos ad=0.1626p pd=1.415u as=60.89999f ps=0.71u w=0.42u l=0.13u
X206 a_13400_3763# a_12355_3325# a_13306_3763# VSS.t67 sg13_lv_nmos ad=60.89999f pd=0.71u as=0.1428p ps=1.52u w=0.42u l=0.13u
X207 a_13019_3289# a_15688_2861# VDD.t47 VDD.t0 sg13_lv_pmos ad=0.3808p pd=2.92u as=0.2128p ps=1.5u w=1.12u l=0.13u
X208 VSS.t152 VSS.t149 VSS.t151 VSS.t150 sg13_lv_nmos ad=0.2516p pd=2.16u as=0 ps=0 w=0.74u l=0.13u
C0 a_12907_2644# a_12907_2878# 0.1117f
C1 a_13106_2815# a_13132_2878# 0.1657f
C2 DELAY_VBIASP a_9712_1370# 0.11086f
C3 a_11491_3686# a_10751_3336# 0.26905f
C4 a_10232_3329# a_10649_3336# 0.37583f
C5 a_11748_3567# a_10751_3336# 0.03061f
C6 a_13592_3329# a_14757_3686# 0.43239f
C7 DELAY_OUT_LAST DELAY_VBIASP 1.05783f
C8 a_6326_2048# a_9712_1370# 0.04737f
C9 a_5974_3181# a_5864_825# 0.01697f
C10 VDD a_12907_2644# 0.0643f
C11 a_15464_1142# VDD 0.53655f
C12 a_12943_3325# a_13019_3289# 0.03346f
C13 a_14851_2640# a_12849_3325# 0.13376f
C14 a_13566_3293# a_13592_3329# 0.36952f
C15 VDD a_10232_3329# 0.09601f
C16 a_15688_3325# VDD 0.31235f
C17 VDD a_14851_2640# 0.27539f
C18 a_13592_3329# a_13121_3289# 0.01445f
C19 a_13566_3293# a_12849_3325# 0.27346f
C20 DELAY_OUT_LAST a_15688_2861# 0.01699f
C21 a_13121_3289# a_12849_3325# 0.54766f
C22 a_13566_3293# VDD 0.09483f
C23 a_6126_1274# a_6854_2912# 0.19098f
C24 a_9547_3400# a_9772_3301# 0.02416f
C25 a_9547_3630# a_9746_3263# 0.02437f
C26 VDD a_13121_3289# 1.4119f
C27 DELAY_IN a_13132_2878# 0.02025f
C28 a_6126_1274# VDD 0.9531f
C29 a_15304_2063# DLL_RESETN 0.03137f
C30 a_14111_2685# a_13306_2563# 0.097f
C31 a_9547_3630# VDD 0.09227f
C32 a_9444_1370# DLL_RESETN 0.02134f
C33 a_5778_825# a_9444_2048# 0.19787f
C34 a_5864_825# DLL_RESETN 0.01688f
C35 a_15304_2063# a_15108_3567# 0.17528f
C36 a_14009_2542# a_14111_2685# 0.47622f
C37 a_14009_2542# a_13306_2563# 0.02454f
C38 a_13106_2815# a_12907_2878# 0.14994f
C39 a_13592_2881# a_14111_2685# 0.34114f
C40 a_13592_2881# a_13306_2563# 0.41329f
C41 DELAY_OUT_LAST a_14111_2685# 0.02024f
C42 a_14009_3336# DELAY_IN 0.25847f
C43 a_13592_2881# a_14009_2542# 0.3749f
C44 a_11397_3686# a_10649_3336# 0.01058f
C45 a_15464_1142# a_14851_2640# 0.04597f
C46 DELAY_OUT_LAST a_14009_2542# 0.25594f
C47 DELAY_IN a_13306_3763# 0.05059f
C48 a_10206_3293# a_10649_3336# 0.02242f
C49 a_9946_3763# DLL_RESETN 0.09997f
C50 a_14757_2640# a_14851_2640# 0.28931f
C51 VDD DELAY_VBIASN 0.23736f
C52 DELAY_OUT_LAST a_13592_2881# 0.08062f
C53 a_15464_1142# a_13121_3289# 0.31727f
C54 a_14111_2685# a_15108_2783# 0.03012f
C55 a_5974_3181# a_5778_825# 2.87939f
C56 VDD a_13106_2815# 0.10008f
C57 a_15688_3325# a_13121_3289# 0.17255f
C58 a_14851_2640# a_13121_3289# 0.02878f
C59 VDD a_10206_3293# 0.11162f
C60 a_13566_3293# a_13121_3289# 0.01158f
C61 a_13592_3329# a_13019_3289# 0.04178f
C62 DELAY_OUT_LAST a_15108_2783# 0.01399f
C63 a_13019_3289# a_12849_3325# 0.12838f
C64 a_6854_3444# a_6854_2912# 0.27156f
C65 a_9547_3400# a_9746_3263# 0.14994f
C66 VDD a_13019_3289# 0.48803f
C67 DLL_RESETN a_13132_2878# 0.01689f
C68 a_6854_3444# VDD 2.86504f
C69 a_14111_2685# a_15304_2063# 0.01761f
C70 a_9547_3400# VDD 0.16041f
C71 VDD a_13880_2576# 0.03137f
C72 a_13566_2786# a_13306_2563# 0.75507f
C73 a_15304_2063# a_14111_3336# 0.01811f
C74 a_9444_1370# a_9712_1370# 0.80775f
C75 DELAY_IN a_10649_3336# 0.25484f
C76 a_13880_3750# a_14111_3336# 0.12701f
C77 a_14009_2542# a_13566_2786# 0.02242f
C78 DLL_RESETN a_12943_3325# 0.03616f
C79 a_13106_2815# a_12907_2644# 0.02437f
C80 a_13592_2881# a_13566_2786# 0.36952f
C81 a_13592_2881# a_15304_2063# 0.01817f
C82 a_10520_3750# a_10751_3336# 0.12701f
C83 a_13592_3329# DELAY_IN 0.11539f
C84 DELAY_OUT_LAST a_15304_2063# 0.05183f
C85 a_11397_3686# a_10232_3329# 0.43239f
C86 a_13592_3329# a_14851_3686# 0.01529f
C87 DELAY_IN a_12849_3325# 0.25718f
C88 a_10206_3293# a_10232_3329# 0.36952f
C89 a_6854_2912# a_9444_2048# 1.24089f
C90 a_9772_3301# DLL_RESETN 0.06592f
C91 a_14851_3686# a_12849_3325# 0.13392f
C92 VDD DELAY_IN 0.38958f
C93 a_9444_2048# VDD 0.01023f
C94 VDD a_14851_3686# 0.25849f
C95 a_15464_1142# a_13019_3289# 0.59356f
C96 a_9946_3763# a_10751_3336# 0.097f
C97 a_6326_2048# a_5778_825# 0.87631f
C98 a_15304_2063# a_15108_2783# 0.01986f
C99 a_15688_3325# a_13019_3289# 0.0195f
C100 VDD a_12158_3325# 0.39251f
C101 a_13019_3289# a_13121_3289# 0.54957f
C102 a_12355_3325# a_13306_3763# 0.26489f
C103 a_12656_3322# a_12849_3325# 0.33075f
C104 a_6854_3444# a_13121_3289# 0.07016f
C105 a_6854_3444# a_6126_1274# 0.11771f
C106 a_5974_3181# a_6854_2912# 0.01501f
C107 a_9547_3400# a_9547_3630# 0.1117f
C108 VDD a_12656_3322# 0.27069f
C109 DLL_RESETN a_12907_2878# 0.04234f
C110 a_5974_3181# VDD 1.02019f
C111 a_13132_2878# a_13306_2563# 0.27179f
C112 a_14757_3686# a_14851_3686# 0.28931f
C113 DELAY_IN a_10232_3329# 0.08086f
C114 DLL_RESETN a_10649_3336# 0.05713f
C115 a_15688_3325# a_14851_3686# 0.08776f
C116 a_13566_3293# DELAY_IN 0.01538f
C117 a_14009_3336# a_14111_3336# 0.47795f
C118 DELAY_IN a_13121_3289# 1.40135f
C119 DLL_RESETN a_12849_3325# 0.34367f
C120 DELAY_VBIASN a_13019_3289# 1.23663f
C121 a_6854_2912# DLL_RESETN 0.0112f
C122 a_6126_1274# a_9444_2048# 0.03029f
C123 a_6854_3444# DELAY_VBIASN 0.15808f
C124 a_14851_3686# a_13121_3289# 0.03404f
C125 a_14111_3336# a_13306_3763# 0.097f
C126 a_15108_3567# a_12849_3325# 0.10225f
C127 VDD DLL_RESETN 2.81183f
C128 VDD a_15108_3567# 0.13564f
C129 a_9946_3763# a_10520_3750# 0.31978f
C130 VDD a_11491_3686# 0.18135f
C131 DELAY_VBIASP VDD 1.07142f
C132 VDD a_11748_3567# 0.1754f
C133 a_12355_3325# a_12849_3325# 0.07687f
C134 a_13045_3673# a_13019_3289# 0.01249f
C135 a_6326_2048# a_6854_2912# 1.24805f
C136 a_5974_3181# a_6126_1274# 1.74557f
C137 VDD a_12355_3325# 0.40041f
C138 DLL_RESETN a_12907_2644# 0.02177f
C139 a_6326_2048# VDD 8.12264f
C140 VDD a_15688_2861# 0.31892f
C141 DLL_RESETN a_10232_3329# 0.39088f
C142 a_5778_825# a_5864_825# 0.07051f
C143 a_10649_3336# a_10751_3336# 0.47795f
C144 a_11491_3686# a_10232_3329# 0.01529f
C145 DELAY_IN a_13019_3289# 0.35409f
C146 DLL_RESETN a_13121_3289# 0.04337f
C147 a_14009_3336# a_13880_3750# 0.01562f
C148 a_13592_3329# a_14111_3336# 0.34102f
C149 a_14111_2685# a_12849_3325# 0.42064f
C150 a_6854_3444# DELAY_IN 0.04054f
C151 a_13306_2563# a_12849_3325# 0.10675f
C152 a_15108_3567# a_13121_3289# 0.03701f
C153 a_14111_3336# a_12849_3325# 0.42174f
C154 a_13880_3750# a_13306_3763# 0.31978f
C155 a_14851_3686# a_13019_3289# 0.01651f
C156 a_6854_2912# a_9712_1370# 0.67825f
C157 a_14111_2685# VDD 0.35469f
C158 a_14009_2542# a_12849_3325# 0.03463f
C159 VDD a_13306_2563# 0.80534f
C160 a_9712_1370# VDD 0.21208f
C161 VDD a_14111_3336# 0.22908f
C162 a_14009_2542# VDD 0.33745f
C163 a_13592_2881# a_12849_3325# 0.38072f
C164 VDD a_10751_3336# 0.23078f
C165 a_15464_1142# a_15688_2861# 0.19544f
C166 DELAY_OUT_LAST a_12849_3325# 0.01467f
C167 a_13592_2881# VDD 0.13283f
C168 DELAY_OUT_LAST VDD 0.30789f
C169 a_14851_2640# a_15688_2861# 0.08776f
C170 DLL_RESETN DELAY_VBIASN 0.12904f
C171 a_9772_3301# a_9946_3763# 0.27179f
C172 a_12656_3322# a_13019_3289# 0.04193f
C173 a_12355_3325# a_13121_3289# 0.05795f
C174 a_5974_3181# a_6854_3444# 0.02579f
C175 a_6326_2048# a_6126_1274# 2.74106f
C176 a_15108_2783# a_12849_3325# 0.10521f
C177 DLL_RESETN a_13106_2815# 0.01263f
C178 VDD a_15108_2783# 0.14081f
C179 DELAY_IN a_12158_3325# 0.01309f
C180 DLL_RESETN a_10206_3293# 0.27343f
C181 a_15464_1142# a_9712_1370# 0.01237f
C182 DELAY_VBIASP DELAY_VBIASN 5.10528f
C183 a_14111_2685# a_14851_2640# 0.26905f
C184 a_10232_3329# a_10751_3336# 0.34102f
C185 a_10649_3336# a_10520_3750# 0.01562f
C186 a_14757_2640# a_14009_2542# 0.01058f
C187 a_11491_3686# a_11397_3686# 0.28931f
C188 DELAY_OUT_LAST a_15464_1142# 0.01937f
C189 a_13592_3329# a_13880_3750# 0.43707f
C190 DLL_RESETN a_13019_3289# 0.01429f
C191 DELAY_IN a_12656_3322# 0.01215f
C192 a_14757_2640# a_13592_2881# 0.43239f
C193 a_6854_3444# DLL_RESETN 0.28237f
C194 a_13592_2881# a_14851_2640# 0.01529f
C195 a_13566_2786# a_12849_3325# 0.26312f
C196 a_15304_2063# a_12849_3325# 0.0606f
C197 a_14111_3336# a_13121_3289# 0.0235f
C198 DELAY_OUT_LAST a_14851_2640# 0.02109f
C199 a_6854_2912# a_9444_1370# 0.84817f
C200 VDD a_13566_2786# 0.09979f
C201 a_15304_2063# VDD 0.77714f
C202 a_6854_2912# a_5864_825# 0.03661f
C203 a_9946_3763# a_10649_3336# 0.02432f
C204 a_15464_1142# a_15108_2783# 0.12158f
C205 DELAY_VBIASP a_13019_3289# 0.02377f
C206 DELAY_OUT_LAST a_13121_3289# 0.04358f
C207 a_6854_3444# DELAY_VBIASP 0.01478f
C208 a_14009_3336# a_13306_3763# 0.02432f
C209 a_14851_2640# a_15108_2783# 0.29858f
C210 a_9444_2048# DLL_RESETN 0.01688f
C211 DLL_RESETN DELAY_IN 2.75059f
C212 a_12355_3325# a_13019_3289# 0.3846f
C213 a_9946_3763# VDD 0.81635f
C214 a_9712_1370# DELAY_VBIASN 0.22281f
C215 a_6326_2048# a_6854_3444# 1.17368f
C216 a_15108_2783# a_13121_3289# 0.05714f
C217 a_15688_2861# a_13019_3289# 0.12862f
C218 a_15108_3567# a_14851_3686# 0.29858f
C219 a_12907_2878# a_13132_2878# 0.02416f
C220 DLL_RESETN a_12158_3325# 0.02442f
C221 DELAY_IN a_11491_3686# 0.01827f
C222 DELAY_OUT_LAST DELAY_VBIASN 3.13021f
C223 a_15688_3325# a_15304_2063# 0.19136f
C224 DELAY_IN a_11748_3567# 0.0148f
C225 a_14757_2640# a_15304_2063# 0.02225f
C226 a_15304_2063# a_14851_2640# 0.05156f
C227 a_10232_3329# a_10520_3750# 0.43707f
C228 a_11491_3686# a_12158_3325# 0.0894f
C229 DLL_RESETN a_12656_3322# 0.11782f
C230 DELAY_IN a_12355_3325# 1.0042f
C231 a_11748_3567# a_12158_3325# 0.10373f
C232 a_13132_2878# a_12849_3325# 0.06256f
C233 a_6326_2048# a_9444_2048# 0.01269f
C234 a_15304_2063# a_13121_3289# 0.40633f
C235 a_9712_1370# a_13019_3289# 0.03275f
C236 a_14111_2685# a_13880_2576# 0.12701f
C237 a_6854_3444# a_9712_1370# 0.03156f
C238 a_6126_1274# a_9444_1370# 0.25721f
C239 a_6854_2912# a_5778_825# 0.02497f
C240 a_13306_2563# a_13880_2576# 0.31978f
C241 VDD a_13132_2878# 0.25347f
C242 a_6126_1274# a_5864_825# 0.12761f
C243 a_12943_3325# a_12849_3325# 0.16706f
C244 a_14009_2542# a_13880_2576# 0.01562f
C245 a_9946_3763# a_10232_3329# 0.41329f
C246 a_12355_3325# a_12158_3325# 0.12454f
C247 a_13592_3329# a_14009_3336# 0.37583f
C248 DELAY_OUT_LAST a_13019_3289# 0.07707f
C249 VDD a_12943_3325# 0.3011f
C250 a_13592_2881# a_13880_2576# 0.43707f
C251 a_14009_3336# a_12849_3325# 0.03525f
C252 a_13592_3329# a_13306_3763# 0.41329f
C253 a_12849_3325# a_13306_3763# 0.12097f
C254 a_14009_3336# VDD 0.25176f
C255 VDD a_13306_3763# 0.78103f
C256 a_9746_3263# a_9772_3301# 0.1657f
C257 a_12355_3325# a_12656_3322# 0.03277f
C258 a_15304_2063# DELAY_VBIASN 0.07802f
C259 DELAY_IN a_13306_2563# 0.06166f
C260 a_9772_3301# VDD 0.26362f
C261 a_9712_1370# DELAY_IN 0.04752f
C262 DELAY_IN a_14111_3336# 0.02263f
C263 a_9712_1370# a_9444_2048# 0.57573f
C264 a_6326_2048# a_5974_3181# 0.32939f
C265 DELAY_IN a_10751_3336# 0.01931f
C266 a_14111_3336# a_14851_3686# 0.26905f
C267 DLL_RESETN a_11491_3686# 0.14622f
C268 a_13592_2881# DELAY_IN 0.03445f
C269 DELAY_VBIASP DLL_RESETN 0.05659f
C270 DLL_RESETN a_11748_3567# 0.11133f
C271 a_14009_3336# a_14757_3686# 0.01058f
C272 DLL_RESETN a_12355_3325# 0.04879f
C273 a_11748_3567# a_11491_3686# 0.34468f
C274 a_15304_2063# a_13019_3289# 0.07025f
C275 a_6854_3444# a_15304_2063# 0.07441f
C276 a_6126_1274# a_5778_825# 1.6143f
C277 a_5974_3181# a_9712_1370# 0.01152f
C278 VDD a_12907_2878# 0.08229f
C279 a_12943_3325# a_13121_3289# 0.09118f
C280 a_9946_3763# a_10206_3293# 0.75507f
C281 a_13566_3293# a_14009_3336# 0.02242f
C282 VDD a_10649_3336# 0.24968f
C283 a_13592_3329# a_12849_3325# 0.38817f
C284 a_13566_3293# a_13306_3763# 0.75507f
C285 a_14009_3336# a_13121_3289# 0.01604f
C286 a_13121_3289# a_13306_3763# 0.01008f
C287 a_13592_3329# VDD 0.07868f
C288 VDD a_12849_3325# 2.97867f
C289 a_6854_2912# VDD 1.80901f
C290 DELAY_IN a_13566_2786# 0.01093f
C291 a_15304_2063# DELAY_IN 0.01066f
C292 a_9746_3263# VDD 0.0996f
C293 a_9444_1370# a_9444_2048# 2.19613f
C294 a_9712_1370# DLL_RESETN 0.39633f
C295 a_5864_825# DELAY_IN 0.01659f
C296 a_9444_2048# a_5864_825# 0.04218f
C297 a_15304_2063# a_14851_3686# 0.12139f
C298 DLL_RESETN a_10751_3336# 0.45018f
C299 a_14111_3336# a_15108_3567# 0.03093f
R0 VDD VDD.t24 17.3693
R1 VDD.n71 VDD.t42 17.3693
R2 VDD.n71 VDD.t38 17.3693
R3 VDD VDD.t22 17.3517
R4 VDD.n63 VDD.t84 17.3517
R5 VDD.n62 VDD.t27 17.3517
R6 VDD.n64 VDD.t26 17.2247
R7 VDD.n12 VDD.n11 0.322004
R8 VDD VDD.t19 17.0005
R9 VDD.n63 VDD.t41 17.0005
R10 VDD.n62 VDD.t37 17.0005
R11 VDD.n23 VDD 0.631801
R12 VDD.t0 VDD.n23 0.5725
R13 VDD.n23 VDD.n18 0.378219
R14 VDD.t0 VDD.n16 0.569748
R15 VDD.t31 VDD.t72 15.0005
R16 VDD.t31 VDD.t77 15.0005
R17 VDD.n1 VDD.n152 12.3334
R18 VDD.n152 VDD.n151 9.51387
R19 VDD.t31 VDD.t49 18.1043
R20 VDD.n1 VDD.t17 9.02285
R21 VDD.n40 VDD 4.46488
R22 VDD.n130 VDD.n40 0.073243
R23 VDD.n129 VDD 9.0005
R24 VDD.n73 VDD.n50 0.073243
R25 VDD.n50 VDD 4.46488
R26 VDD VDD.n49 4.46488
R27 VDD.n124 VDD.n49 0.073243
R28 VDD VDD.n41 4.46488
R29 VDD.n120 VDD.n41 0.073243
R30 VDD.n48 VDD.n52 0.073243
R31 VDD.n48 VDD 4.46488
R32 VDD VDD.n47 4.46488
R33 VDD.n115 VDD.n47 0.073243
R34 VDD.n46 VDD.n54 0.073243
R35 VDD.n46 VDD.n17 4.46488
R36 VDD.n17 VDD.n45 4.46488
R37 VDD.n110 VDD.n45 0.073243
R38 VDD.n44 VDD.n56 0.073243
R39 VDD.n44 VDD.n17 4.46488
R40 VDD.n17 VDD.n43 4.46488
R41 VDD.n105 VDD.n43 0.073243
R42 VDD.n42 VDD.n58 0.073243
R43 VDD.n42 VDD.n17 4.46488
R44 VDD.n79 VDD.t18 9.0005
R45 VDD.n100 VDD.n39 0.073243
R46 VDD.n39 VDD.t18 4.46488
R47 VDD.n98 VDD.t18 9.0005
R48 VDD.n67 VDD.t18 4.46488
R49 VDD.n94 VDD.n67 0.073243
R50 VDD.t18 VDD.n66 9.0005
R51 VDD.n93 VDD.n60 0.073243
R52 VDD.n68 VDD.n64 4.46488
R53 VDD.n89 VDD.n68 0.073243
R54 VDD.n88 VDD.n64 9.0005
R55 VDD.n31 VDD.n33 0.134609
R56 VDD.n33 VDD.n11 1.38505
R57 VDD.n11 VDD.n30 9.0005
R58 VDD.t18 VDD.n60 4.46488
R59 VDD.n130 VDD.n72 9.0005
R60 VDD.n129 VDD.n128 9.0005
R61 VDD.n127 VDD.n73 9.0005
R62 VDD.n126 VDD.n125 9.0005
R63 VDD.n51 VDD.n74 9.0005
R64 VDD.n124 VDD.n123 9.0005
R65 VDD.n122 VDD.n69 9.0005
R66 VDD.n121 VDD.n120 9.0005
R67 VDD.n52 VDD.n75 9.0005
R68 VDD.n119 VDD.n118 9.0005
R69 VDD.n117 VDD.n53 9.0005
R70 VDD.n116 VDD.n115 9.0005
R71 VDD.n54 VDD.n76 9.0005
R72 VDD.n114 VDD.n113 9.0005
R73 VDD.n112 VDD.n55 9.0005
R74 VDD.n111 VDD.n110 9.0005
R75 VDD.n56 VDD.n77 9.0005
R76 VDD.n109 VDD.n108 9.0005
R77 VDD.n107 VDD.n57 9.0005
R78 VDD.n106 VDD.n105 9.0005
R79 VDD.n58 VDD.n78 9.0005
R80 VDD.n104 VDD.n103 9.0005
R81 VDD.n102 VDD.n79 9.0005
R82 VDD.n101 VDD.n100 9.0005
R83 VDD.n99 VDD.n80 9.0005
R84 VDD.n98 VDD.n97 9.0005
R85 VDD.n96 VDD.n81 9.0005
R86 VDD.n95 VDD.n94 9.0005
R87 VDD.n66 VDD.n82 9.0005
R88 VDD.n93 VDD.n92 9.0005
R89 VDD.n91 VDD.n60 9.07324
R90 VDD.n89 VDD.n83 9.0005
R91 VDD.n88 VDD.n87 9.0005
R92 VDD.n86 VDD.n85 9.0005
R93 VDD.n30 VDD.n84 9.0005
R94 VDD.n2 VDD.n1 1.90691
R95 VDD.n150 VDD.n65 0.114852
R96 VDD.n26 VDD.n6 4.44407
R97 VDD.n166 VDD.n26 0.114852
R98 VDD.n34 VDD.n6 4.44407
R99 VDD.n34 VDD.n168 0.114852
R100 VDD.n27 VDD.n6 9.0005
R101 VDD.n143 VDD.n6 9.0005
R102 VDD.n159 VDD.n35 0.114852
R103 VDD.n35 VDD.n6 4.44407
R104 VDD.n24 VDD.n6 4.44407
R105 VDD.n162 VDD.n24 0.114852
R106 VDD.n164 VDD.n6 9.0005
R107 VDD.n65 VDD.n6 4.44407
R108 VDD.n15 VDD.n14 1.52771
R109 VDD.n133 VDD.n59 0.114852
R110 VDD.n59 VDD.n18 4.44407
R111 VDD.n25 VDD.n18 4.44407
R112 VDD.n22 VDD.n18 4.44407
R113 VDD.n146 VDD.n22 0.114852
R114 VDD.n144 VDD.n133 9.0005
R115 VDD.n170 VDD.n132 9.0005
R116 VDD.n171 VDD.n131 9.0005
R117 VDD.n25 VDD.n29 0.423064
R118 VDD.n146 VDD.n145 9.0005
R119 VDD.n18 VDD.n15 4.86976
R120 VDD.n150 VDD.n149 9.0005
R121 VDD.n165 VDD.n137 9.0005
R122 VDD.n166 VDD.n136 9.0005
R123 VDD.n167 VDD.n135 9.0005
R124 VDD.n168 VDD.n134 9.0005
R125 VDD.n28 VDD.n27 0.360353
R126 VDD.n20 VDD.n28 1.90691
R127 VDD.n148 VDD.n143 9.0005
R128 VDD.n159 VDD.n142 9.0005
R129 VDD.n160 VDD.n141 9.0005
R130 VDD.n161 VDD.n140 9.0005
R131 VDD.n162 VDD.n139 9.0005
R132 VDD.n164 VDD.n138 9.0005
R133 VDD.t31 VDD.t52 8.95516
R134 VDD.n70 VDD.t45 8.76054
R135 VDD.n70 VDD.t35 8.76054
R136 VDD.t0 VDD.n7 0.124463
R137 VDD.n16 VDD.n14 0.228108
R138 VDD.n61 VDD.t0 0.191535
R139 VDD.t18 VDD.n9 0.407433
R140 VDD.n9 VDD.n17 0.206655
R141 VDD.t18 VDD.n10 0.398063
R142 VDD.t18 VDD.n36 2.89281
R143 VDD.t18 VDD.t21 5.9886
R144 VDD.n37 VDD.t47 5.97675
R145 VDD.n37 VDD.t34 5.97675
R146 VDD.t18 VDD.t54 5.96478
R147 VDD.t0 VDD.n0 0.638303
R148 VDD.n7 VDD.n1 0.486161
R149 VDD.t31 VDD.t73 5.70952
R150 VDD.t31 VDD.t74 5.59179
R151 VDD.t31 VDD.t79 5.59179
R152 VDD VDD.t64 4.9462
R153 VDD.n156 VDD.t61 4.9462
R154 VDD.n32 VDD.n31 1.69009
R155 VDD VDD.n61 0.889941
R156 VDD.n11 VDD.n71 0.509383
R157 VDD.n152 VDD 3.16098
R158 VDD.n8 VDD.t5 2.6992
R159 VDD.n19 VDD.t9 2.6992
R160 VDD.n154 VDD.t69 2.6992
R161 VDD.n13 VDD.t10 2.6992
R162 VDD.n5 VDD.t1 2.6992
R163 VDD.n153 VDD.t63 2.6992
R164 VDD.n158 VDD.t11 2.6992
R165 VDD.n4 VDD.t2 2.6992
R166 VDD.n163 VDD.t12 2.6992
R167 VDD.n3 VDD.t4 2.6992
R168 VDD.n21 VDD.t15 2.6992
R169 VDD.n169 VDD.t7 2.6992
R170 VDD VDD.t71 2.87115
R171 VDD.t18 VDD.n12 0.726746
R172 VDD.n4 VDD.n158 1.11007
R173 VDD.n3 VDD.n163 1.11007
R174 VDD.n21 VDD.n169 1.11007
R175 VDD.n0 VDD.n151 0.765061
R176 VDD VDD.n8 0.570274
R177 VDD.n154 VDD.n14 0.570274
R178 VDD.n158 VDD.n14 0.570274
R179 VDD.n163 VDD.n18 0.570274
R180 VDD.n20 VDD.n19 0.569912
R181 VDD.n14 VDD.n13 0.569912
R182 VDD.n6 VDD.n5 0.569912
R183 VDD.n153 VDD.n1 0.569912
R184 VDD.n6 VDD.n4 0.569912
R185 VDD.n6 VDD.n3 0.569912
R186 VDD.n169 VDD.n6 0.569912
R187 VDD.n19 VDD 0.492005
R188 VDD.n13 VDD.n157 0.492005
R189 VDD.n157 VDD.n5 0.492005
R190 VDD.n155 VDD.n153 0.492005
R191 VDD.n155 VDD.n154 0.491643
R192 VDD.t31 VDD.t83 5.73451
R193 VDD.n15 VDD.n147 1.89696
R194 VDD.n91 VDD.n90 0.437466
R195 VDD.t78 VDD.t31 5.72603
R196 VDD.n12 VDD.n70 0.890665
R197 VDD.n10 VDD.n71 0.601376
R198 VDD.n64 VDD.n10 0.0408519
R199 VDD.n157 VDD.n156 0.253639
R200 VDD.t81 VDD.t31 5.6952
R201 VDD.n156 VDD.n155 0.253298
R202 VDD.n147 VDD.n22 9.11485
R203 VDD.n146 VDD.n133 0.231121
R204 VDD.n170 VDD.n59 0.114852
R205 VDD.n171 VDD.n170 0.231121
R206 VDD.n25 VDD.n171 0.114852
R207 VDD.n147 VDD.n145 0.231121
R208 VDD.n145 VDD.n144 0.231121
R209 VDD.n144 VDD.n132 0.231121
R210 VDD.n132 VDD.n131 0.231121
R211 VDD.n131 VDD.n29 2.22013
R212 VDD.n29 VDD 2.35072
R213 VDD.n2 VDD.n65 0.474705
R214 VDD.n150 VDD.n143 0.231121
R215 VDD.n159 VDD.n143 0.231121
R216 VDD.n160 VDD.n35 0.114852
R217 VDD.n161 VDD.n160 0.231121
R218 VDD.n24 VDD.n161 0.114852
R219 VDD.n164 VDD.n162 0.231121
R220 VDD.n165 VDD.n164 0.231121
R221 VDD.n26 VDD.n165 0.114852
R222 VDD.n167 VDD.n166 0.231121
R223 VDD.n34 VDD.n167 0.114852
R224 VDD.n168 VDD.n27 0.231121
R225 VDD.n2 VDD.n149 1.97933
R226 VDD.n149 VDD.n148 0.231121
R227 VDD.n148 VDD.n142 0.231121
R228 VDD.n142 VDD.n141 0.231121
R229 VDD.n141 VDD.n140 0.231121
R230 VDD.n140 VDD.n139 0.231121
R231 VDD.n139 VDD.n138 0.231121
R232 VDD.n138 VDD.n137 0.231121
R233 VDD.n137 VDD.n136 0.231121
R234 VDD.n136 VDD.n135 0.231121
R235 VDD.n135 VDD.n134 0.231121
R236 VDD.n134 VDD.n28 1.97933
R237 VDD.n87 VDD.n32 1.73963
R238 VDD.n64 VDD.n63 0.152808
R239 VDD.n64 VDD.n62 0.152808
R240 VDD.n38 VDD 3.07226
R241 VDD.n38 VDD.n40 0.24663
R242 VDD.n130 VDD.n129 0.146155
R243 VDD.n129 VDD.n73 0.146155
R244 VDD.n125 VDD.n50 0.073243
R245 VDD.n125 VDD.n51 0.146155
R246 VDD.n51 VDD.n49 0.073243
R247 VDD.n124 VDD.n69 0.146155
R248 VDD.n41 VDD.n69 0.073243
R249 VDD.n120 VDD.n52 0.146155
R250 VDD.n48 VDD.n119 0.073243
R251 VDD.n119 VDD.n53 0.146155
R252 VDD.n47 VDD.n53 0.073243
R253 VDD.n115 VDD.n54 0.146155
R254 VDD.n46 VDD.n114 0.073243
R255 VDD.n114 VDD.n55 0.146155
R256 VDD.n45 VDD.n55 0.073243
R257 VDD.n110 VDD.n56 0.146155
R258 VDD.n44 VDD.n109 0.073243
R259 VDD.n109 VDD.n57 0.146155
R260 VDD.n43 VDD.n57 0.073243
R261 VDD.n105 VDD.n58 0.146155
R262 VDD.n42 VDD.n104 0.073243
R263 VDD.n104 VDD.n79 0.146155
R264 VDD.n100 VDD.n79 0.146155
R265 VDD.n39 VDD.n99 0.073243
R266 VDD.n99 VDD.n98 0.146155
R267 VDD.n98 VDD.n81 0.146155
R268 VDD.n67 VDD.n81 0.073243
R269 VDD.n94 VDD.n66 0.146155
R270 VDD.n66 VDD.n93 0.146155
R271 VDD.n38 VDD.n72 2.46741
R272 VDD.n128 VDD.n72 0.146155
R273 VDD.n128 VDD.n127 0.146155
R274 VDD.n127 VDD.n126 0.146155
R275 VDD.n126 VDD.n74 0.146155
R276 VDD.n123 VDD.n74 0.146155
R277 VDD.n123 VDD.n122 0.146155
R278 VDD.n122 VDD.n121 0.146155
R279 VDD.n121 VDD.n75 0.146155
R280 VDD.n118 VDD.n75 0.146155
R281 VDD.n118 VDD.n117 0.146155
R282 VDD.n117 VDD.n116 0.146155
R283 VDD.n116 VDD.n76 0.146155
R284 VDD.n113 VDD.n76 0.146155
R285 VDD.n113 VDD.n112 0.146155
R286 VDD.n112 VDD.n111 0.146155
R287 VDD.n111 VDD.n77 0.146155
R288 VDD.n108 VDD.n77 0.146155
R289 VDD.n108 VDD.n107 0.146155
R290 VDD.n107 VDD.n106 0.146155
R291 VDD.n106 VDD.n78 0.146155
R292 VDD.n103 VDD.n78 0.146155
R293 VDD.n103 VDD.n102 0.146155
R294 VDD.n102 VDD.n101 0.146155
R295 VDD.n101 VDD.n80 0.146155
R296 VDD.n97 VDD.n80 0.146155
R297 VDD.n97 VDD.n96 0.146155
R298 VDD.n96 VDD.n95 0.146155
R299 VDD.n95 VDD.n82 0.146155
R300 VDD.n92 VDD.n82 0.146155
R301 VDD.n92 VDD.n91 0.146155
R302 VDD.n90 VDD.n83 0.146155
R303 VDD.n87 VDD.n83 0.146155
R304 VDD.n32 VDD.n86 0.427453
R305 VDD.n86 VDD.n84 0.146155
R306 VDD.n84 VDD.n36 5.73431
R307 VDD.n37 VDD.n36 0.236091
R308 VDD.n85 VDD.n33 0.344925
R309 VDD.n85 VDD.n30 0.146155
R310 VDD.n90 VDD.n68 9.07324
R311 VDD.n89 VDD.n88 0.146155
R312 VDD.n70 VDD.n37 0.125789
R313 VDD.t31 VDD.t75 15.0334
R314 VDD.t80 VDD.t31 15.0334
R315 VDD.t76 VDD.t31 5.76869
R316 VDD.t66 VDD 2.91382
R317 VDD.n31 VDD.t31 2.88043
R318 VDD VDD.n8 1.37694
R319 VDD.n6 VDD.n20 1.27693
R320 VDD.n20 VDD 1.26732
R321 VDD.n7 VDD.n6 0.22237
R322 VDD.n9 VDD 0.652946
R323 VDD.n18 VDD.n21 1.02817
R324 VDD.n151 VDD.n14 0.902262
R325 VDD.n16 VDD.n18 1.21526
R326 VDD.n1 VDD.n0 1.17897
R327 VDD.n61 VDD.t18 1.0354
R328 VSS.n1170 VSS.t139 119321
R329 VSS.n336 VSS.n335 22369.4
R330 VSS.n1149 VSS.n1011 1028.14
R331 VSS.n1165 VSS.n1143 1028.14
R332 VSS.t102 VSS.n312 849.322
R333 VSS.n1239 VSS.n1238 572.005
R334 VSS.t3 VSS.t0 571.348
R335 VSS.n1155 VSS.t122 566.691
R336 VSS.n1154 VSS.t65 560.899
R337 VSS.n746 VSS.t81 550.193
R338 VSS.n314 VSS.t137 539.653
R339 VSS.t63 VSS.n1152 532.819
R340 VSS.t129 VSS.n306 522.509
R341 VSS.n1168 VSS.t25 521.236
R342 VSS.t73 VSS.n1151 514.091
R343 VSS.n1161 VSS.t69 504.839
R344 VSS.n1020 VSS.t78 504.839
R345 VSS.t130 VSS.n308 491.87
R346 VSS.n1156 VSS.t71 474.904
R347 VSS.n313 VSS.t131 470.019
R348 VSS.n1157 VSS.t20 456.175
R349 VSS.n1167 VSS.t22 427.695
R350 VSS.n1151 VSS.t67 427.219
R351 VSS.n1231 VSS.n1230 412.791
R352 VSS.n1159 VSS.n1158 412.791
R353 VSS.n1232 VSS.n1231 404.192
R354 VSS.n1158 VSS.n1148 404.192
R355 VSS.n308 VSS.t75 401.591
R356 VSS.t102 VSS.n310 388.781
R357 VSS.n1169 VSS.t23 375.276
R358 VSS.n1230 VSS.t125 372.094
R359 VSS.t124 VSS.n1159 372.094
R360 VSS.t85 VSS.n1023 363.339
R361 VSS.t18 VSS.n1164 363.339
R362 VSS.t94 VSS.t99 359.769
R363 VSS.n1561 VSS.n1555 359.05
R364 VSS.n745 VSS.t97 347.49
R365 VSS.t83 VSS.n741 329.238
R366 VSS.n1586 VSS.t3 327.81
R367 VSS.n317 VSS.t128 313.659
R368 VSS.t90 VSS.t161 304.42
R369 VSS.t77 VSS.n1013 304.42
R370 VSS.t120 VSS.t61 304.42
R371 VSS.t68 VSS.n1162 304.42
R372 VSS.t136 VSS.n306 299.733
R373 VSS.n1020 VSS.t98 291.37
R374 VSS.t1 VSS.n1161 291.37
R375 VSS.n1150 VSS.n1149 249.036
R376 VSS.n1166 VSS.n1165 249.036
R377 VSS.n745 VSS.t83 243.244
R378 VSS.n1238 VSS.t97 224.516
R379 VSS.n1962 VSS.t133 215.731
R380 VSS.n1820 VSS.t133 215.731
R381 VSS.t75 VSS.n307 208.828
R382 VSS.n317 VSS.t136 202.362
R383 VSS.n1019 VSS.t125 202.071
R384 VSS.n1160 VSS.t124 202.071
R385 VSS.t23 VSS.n1168 196.911
R386 VSS.t98 VSS.n1013 196.399
R387 VSS.n1162 VSS.t1 196.399
R388 VSS.t128 VSS.n305 187.895
R389 VSS.t2 VSS.n1157 183.975
R390 VSS.n1021 VSS.t77 182.797
R391 VSS.n1163 VSS.t68 182.797
R392 VSS.t0 VSS.t139 178.653
R393 VSS.t80 VSS.n746 167.954
R394 VSS.n2 VSS.n336 149.637
R395 VSS.n1820 VSS.t139 149.157
R396 VSS.n0 VSS.t102 146.708
R397 VSS.t67 VSS.n1150 144.788
R398 VSS.t22 VSS.n1166 144.788
R399 VSS.t161 VSS.n1021 138.607
R400 VSS.t61 VSS.n1163 138.607
R401 VSS.n336 VSS.n305 122.129
R402 VSS.n313 VSS.t94 121.858
R403 VSS.n345 VSS.t150 116.615
R404 VSS.n355 VSS.t156 116.615
R405 VSS.t20 VSS.n1156 115.831
R406 VSS.n1239 VSS.n368 115.672
R407 VSS.n7 VSS.t64 112.927
R408 VSS.n1149 VSS.t85 112.361
R409 VSS.n1165 VSS.t18 112.361
R410 VSS.t131 VSS.n309 103.54
R411 VSS.t71 VSS.n1155 97.5777
R412 VSS.n1246 VSS.n1239 96.6341
R413 VSS.t103 VSS.n299 96.4635
R414 VSS.t26 VSS.n5 96.4504
R415 VSS.n322 VSS.t135 90.6901
R416 VSS.n307 VSS.t129 88.3462
R417 VSS.t78 VSS.n1019 85.7923
R418 VSS.t69 VSS.n1160 85.7923
R419 VSS.n319 VSS.t127 84.6736
R420 VSS.n314 VSS.t130 81.2384
R421 VSS.n5 VSS.t153 75.7618
R422 VSS.t159 VSS.n4 75.7611
R423 VSS.t99 VSS.n310 75.4357
R424 VSS.t153 VSS.n345 75.2356
R425 VSS.n355 VSS.t159 75.2356
R426 VSS.t14 VSS.n90 68.1169
R427 VSS.n1555 VSS.t126 66.4528
R428 VSS.t132 VSS.t92 66.4528
R429 VSS.n1536 VSS.t104 64.3092
R430 VSS.t88 VSS.n300 63.2374
R431 VSS.n335 VSS.n301 63.2374
R432 VSS.n6 VSS.t26 62.5941
R433 VSS.t112 VSS.n107 60.4418
R434 VSS.n154 VSS.t16 58.523
R435 VSS.n1152 VSS.t73 57.9156
R436 VSS.n335 VSS.n303 52.4358
R437 VSS.t28 VSS.n511 52.3134
R438 VSS.n691 VSS.t39 52.3134
R439 VSS.n368 VSS.t104 51.364
R440 VSS.t25 VSS.n1167 51.2456
R441 VSS.n136 VSS.t108 50.848
R442 VSS.t43 VSS.n669 49.4071
R443 VSS.t106 VSS.n99 48.9292
R444 VSS.n89 VSS.t139 47.0104
R445 VSS.t64 VSS.n4 45.667
R446 VSS.t100 VSS.n1536 45.0166
R447 VSS.n1023 VSS.t90 44.1903
R448 VSS.n1164 VSS.t120 44.1903
R449 VSS.n714 VSS.t33 43.5946
R450 VSS.t35 VSS.n559 43.5946
R451 VSS.n118 VSS.t142 43.1729
R452 VSS.t15 VSS.n92 41.2541
R453 VSS.t17 VSS.n97 41.2541
R454 VSS.n319 VSS.t88 39.6575
R455 VSS.n130 VSS.t110 39.3353
R456 VSS.n1153 VSS.t63 39.1873
R457 VSS.n299 VSS.t126 36.4421
R458 VSS.n735 VSS.t31 34.8758
R459 VSS.t37 VSS.n587 34.8758
R460 VSS.t156 VSS.n6 34.3796
R461 VSS.t150 VSS.n2 34.3794
R462 VSS.t137 VSS.n309 33.9057
R463 VSS.t110 VSS.n105 33.579
R464 VSS.n2001 VSS.t139 33.5195
R465 VSS.n160 VSS.t15 31.6602
R466 VSS.n149 VSS.t17 31.6602
R467 VSS.t142 VSS.n109 29.7415
R468 VSS.t41 VSS.n626 29.0632
R469 VSS.t65 VSS.n1153 27.6043
R470 VSS.t135 VSS.n300 26.7958
R471 VSS.n671 VSS.t41 26.157
R472 VSS.n141 VSS.t106 23.9851
R473 VSS.t105 VSS.n7 22.6455
R474 VSS.t92 VSS.n303 22.4251
R475 VSS.t81 VSS.n741 22.2881
R476 VSS.t122 VSS.n1154 22.2881
R477 VSS.t108 VSS.n101 22.0664
R478 VSS.n660 VSS.n659 21.0446
R479 VSS.n662 VSS.n661 21.0446
R480 VSS.n664 VSS.n663 21.0446
R481 VSS.n666 VSS.n665 21.0446
R482 VSS.n668 VSS.n667 21.0446
R483 VSS.n652 VSS.n651 21.0446
R484 VSS.n648 VSS.n646 21.0446
R485 VSS.n646 VSS.n645 21.0446
R486 VSS.n642 VSS.n640 21.0446
R487 VSS.n640 VSS.n639 21.0446
R488 VSS.n638 VSS.n637 21.0446
R489 VSS.n635 VSS.n634 21.0446
R490 VSS.n632 VSS.n631 21.0446
R491 VSS.n629 VSS.n628 21.0446
R492 VSS.n673 VSS.n672 21.0446
R493 VSS.n675 VSS.n674 21.0446
R494 VSS.n677 VSS.n676 21.0446
R495 VSS.n680 VSS.n679 21.0446
R496 VSS.n682 VSS.n681 21.0446
R497 VSS.n684 VSS.n683 21.0446
R498 VSS.n686 VSS.n685 21.0446
R499 VSS.n687 VSS.n686 21.0446
R500 VSS.n689 VSS.n688 21.0446
R501 VSS.n615 VSS.n614 21.0446
R502 VSS.n612 VSS.n611 21.0446
R503 VSS.n609 VSS.n608 21.0446
R504 VSS.n606 VSS.n605 21.0446
R505 VSS.n603 VSS.n602 21.0446
R506 VSS.n601 VSS.n600 21.0446
R507 VSS.n597 VSS.n595 21.0446
R508 VSS.n595 VSS.n594 21.0446
R509 VSS.n592 VSS.n591 21.0446
R510 VSS.n584 VSS.n582 21.0446
R511 VSS.n581 VSS.n579 21.0446
R512 VSS.n579 VSS.n578 21.0446
R513 VSS.n576 VSS.n575 21.0446
R514 VSS.n572 VSS.n571 21.0446
R515 VSS.n570 VSS.n568 21.0446
R516 VSS.n568 VSS.n567 21.0446
R517 VSS.n564 VSS.n562 21.0446
R518 VSS.n562 VSS.n561 21.0446
R519 VSS.n695 VSS.n694 21.0446
R520 VSS.n698 VSS.n697 21.0446
R521 VSS.n699 VSS.n698 21.0446
R522 VSS.n702 VSS.n701 21.0446
R523 VSS.n704 VSS.n703 21.0446
R524 VSS.n705 VSS.n704 21.0446
R525 VSS.n707 VSS.n706 21.0446
R526 VSS.n709 VSS.n708 21.0446
R527 VSS.n711 VSS.n710 21.0446
R528 VSS.n716 VSS.n715 21.0446
R529 VSS.n718 VSS.n717 21.0446
R530 VSS.n721 VSS.n720 21.0446
R531 VSS.n723 VSS.n721 21.0446
R532 VSS.n726 VSS.n725 21.0446
R533 VSS.n728 VSS.n727 21.0446
R534 VSS.n729 VSS.n728 21.0446
R535 VSS.n732 VSS.n731 21.0446
R536 VSS.n538 VSS.n536 21.0446
R537 VSS.n535 VSS.n533 21.0446
R538 VSS.n532 VSS.n530 21.0446
R539 VSS.n529 VSS.n527 21.0446
R540 VSS.n526 VSS.n525 21.0446
R541 VSS.n525 VSS.n524 21.0446
R542 VSS.n521 VSS.n519 21.0446
R543 VSS.n519 VSS.n518 21.0446
R544 VSS.n515 VSS.n513 21.0446
R545 VSS.n508 VSS.n506 21.0446
R546 VSS.n505 VSS.n503 21.0446
R547 VSS.n503 VSS.n502 21.0446
R548 VSS.n500 VSS.n499 21.0446
R549 VSS.n497 VSS.n496 21.0446
R550 VSS.n499 VSS.n497 21.0446
R551 VSS.n502 VSS.n500 21.0446
R552 VSS.n506 VSS.n505 21.0446
R553 VSS.n509 VSS.n508 21.0446
R554 VSS.n516 VSS.n515 21.0446
R555 VSS.n518 VSS.n516 21.0446
R556 VSS.n522 VSS.n521 21.0446
R557 VSS.n524 VSS.n522 21.0446
R558 VSS.n527 VSS.n526 21.0446
R559 VSS.n530 VSS.n529 21.0446
R560 VSS.n533 VSS.n532 21.0446
R561 VSS.n536 VSS.n535 21.0446
R562 VSS.n539 VSS.n538 21.0446
R563 VSS.n733 VSS.n732 21.0446
R564 VSS.n731 VSS.n730 21.0446
R565 VSS.n730 VSS.n729 21.0446
R566 VSS.n727 VSS.n726 21.0446
R567 VSS.n725 VSS.n724 21.0446
R568 VSS.n724 VSS.n723 21.0446
R569 VSS.n720 VSS.n719 21.0446
R570 VSS.n719 VSS.n718 21.0446
R571 VSS.n717 VSS.n716 21.0446
R572 VSS.n712 VSS.n711 21.0446
R573 VSS.n710 VSS.n709 21.0446
R574 VSS.n708 VSS.n707 21.0446
R575 VSS.n706 VSS.n705 21.0446
R576 VSS.n703 VSS.n702 21.0446
R577 VSS.n701 VSS.n700 21.0446
R578 VSS.n700 VSS.n699 21.0446
R579 VSS.n697 VSS.n696 21.0446
R580 VSS.n696 VSS.n695 21.0446
R581 VSS.n565 VSS.n564 21.0446
R582 VSS.n567 VSS.n565 21.0446
R583 VSS.n571 VSS.n570 21.0446
R584 VSS.n573 VSS.n572 21.0446
R585 VSS.n575 VSS.n573 21.0446
R586 VSS.n578 VSS.n576 21.0446
R587 VSS.n582 VSS.n581 21.0446
R588 VSS.n585 VSS.n584 21.0446
R589 VSS.n591 VSS.n589 21.0446
R590 VSS.n594 VSS.n592 21.0446
R591 VSS.n598 VSS.n597 21.0446
R592 VSS.n600 VSS.n598 21.0446
R593 VSS.n602 VSS.n601 21.0446
R594 VSS.n605 VSS.n603 21.0446
R595 VSS.n608 VSS.n606 21.0446
R596 VSS.n611 VSS.n609 21.0446
R597 VSS.n614 VSS.n612 21.0446
R598 VSS.n688 VSS.n687 21.0446
R599 VSS.n685 VSS.n684 21.0446
R600 VSS.n683 VSS.n682 21.0446
R601 VSS.n681 VSS.n680 21.0446
R602 VSS.n679 VSS.n678 21.0446
R603 VSS.n678 VSS.n677 21.0446
R604 VSS.n676 VSS.n675 21.0446
R605 VSS.n674 VSS.n673 21.0446
R606 VSS.n631 VSS.n629 21.0446
R607 VSS.n634 VSS.n632 21.0446
R608 VSS.n637 VSS.n635 21.0446
R609 VSS.n639 VSS.n638 21.0446
R610 VSS.n643 VSS.n642 21.0446
R611 VSS.n645 VSS.n643 21.0446
R612 VSS.n649 VSS.n648 21.0446
R613 VSS.n651 VSS.n649 21.0446
R614 VSS.n667 VSS.n666 21.0446
R615 VSS.n665 VSS.n664 21.0446
R616 VSS.n663 VSS.n662 21.0446
R617 VSS.n661 VSS.n660 21.0446
R618 VSS.n659 VSS.n658 21.0446
R619 VSS.n322 VSS.t103 21.0214
R620 VSS.t31 VSS.n734 20.3444
R621 VSS.n588 VSS.t37 20.3444
R622 VSS.n496 VSS.n495 19.5682
R623 VSS.t127 VSS.n301 18.2213
R624 VSS.n2005 VSS.n2004 18.0005
R625 VSS.t102 VSS.t100 17.1495
R626 VSS.n1787 VSS.n1786 17.0005
R627 VSS.n1811 VSS.n1806 17.0005
R628 VSS.n1856 VSS.n89 17.0005
R629 VSS.n1856 VSS.n168 17.0005
R630 VSS.n1856 VSS.n90 17.0005
R631 VSS.n1856 VSS.n165 17.0005
R632 VSS.n1856 VSS.n91 17.0005
R633 VSS.n1856 VSS.n163 17.0005
R634 VSS.n1856 VSS.n92 17.0005
R635 VSS.n1856 VSS.n160 17.0005
R636 VSS.n1856 VSS.n93 17.0005
R637 VSS.n1856 VSS.n157 17.0005
R638 VSS.n1856 VSS.n94 17.0005
R639 VSS.n1856 VSS.n154 17.0005
R640 VSS.n1856 VSS.n95 17.0005
R641 VSS.n1856 VSS.n152 17.0005
R642 VSS.n1856 VSS.n96 17.0005
R643 VSS.n1856 VSS.n149 17.0005
R644 VSS.n1856 VSS.n97 17.0005
R645 VSS.n1856 VSS.n147 17.0005
R646 VSS.n1856 VSS.n98 17.0005
R647 VSS.n1856 VSS.n144 17.0005
R648 VSS.n1856 VSS.n99 17.0005
R649 VSS.n1856 VSS.n141 17.0005
R650 VSS.n1856 VSS.n100 17.0005
R651 VSS.n1856 VSS.n139 17.0005
R652 VSS.n1856 VSS.n101 17.0005
R653 VSS.n1856 VSS.n136 17.0005
R654 VSS.n1856 VSS.n102 17.0005
R655 VSS.n1856 VSS.n133 17.0005
R656 VSS.n1856 VSS.n131 17.0005
R657 VSS.n1856 VSS.n103 17.0005
R658 VSS.n1856 VSS.n130 17.0005
R659 VSS.n1856 VSS.n105 17.0005
R660 VSS.n1856 VSS.n129 17.0005
R661 VSS.n1856 VSS.n106 17.0005
R662 VSS.n1856 VSS.n126 17.0005
R663 VSS.n1856 VSS.n107 17.0005
R664 VSS.n1856 VSS.n124 17.0005
R665 VSS.n1856 VSS.n108 17.0005
R666 VSS.n1856 VSS.n121 17.0005
R667 VSS.n1856 VSS.n109 17.0005
R668 VSS.n1856 VSS.n118 17.0005
R669 VSS.n1856 VSS.n110 17.0005
R670 VSS.n1856 VSS.n116 17.0005
R671 VSS.n1856 VSS.n114 17.0005
R672 VSS.n1943 VSS.n62 17.0005
R673 VSS.n1953 VSS.n53 17.0005
R674 VSS.n1924 VSS.n48 17.0005
R675 VSS.n90 VSS.n48 17.0005
R676 VSS.n165 VSS.n48 17.0005
R677 VSS.n92 VSS.n48 17.0005
R678 VSS.n154 VSS.n48 17.0005
R679 VSS.n95 VSS.n48 17.0005
R680 VSS.n149 VSS.n48 17.0005
R681 VSS.n99 VSS.n48 17.0005
R682 VSS.n141 VSS.n48 17.0005
R683 VSS.n101 VSS.n48 17.0005
R684 VSS.n130 VSS.n48 17.0005
R685 VSS.n105 VSS.n48 17.0005
R686 VSS.n126 VSS.n48 17.0005
R687 VSS.n109 VSS.n48 17.0005
R688 VSS.n118 VSS.n48 17.0005
R689 VSS.n2001 VSS.n24 17.0005
R690 VSS.n2001 VSS.n29 17.0005
R691 VSS.n1858 VSS.n48 17.0005
R692 VSS.n1857 VSS.n1856 17.0005
R693 VSS.t60 VSS.n396 17.0005
R694 VSS.n669 VSS.n396 17.0005
R695 VSS.n671 VSS.n396 17.0005
R696 VSS.n690 VSS.n396 17.0005
R697 VSS.n1371 VSS.n396 17.0005
R698 VSS.n588 VSS.n396 17.0005
R699 VSS.n587 VSS.n396 17.0005
R700 VSS.t52 VSS.n396 17.0005
R701 VSS.n693 VSS.n396 17.0005
R702 VSS.n713 VSS.n396 17.0005
R703 VSS.n714 VSS.n396 17.0005
R704 VSS.n416 VSS.n396 17.0005
R705 VSS.n734 VSS.n396 17.0005
R706 VSS.t46 VSS.n396 17.0005
R707 VSS.n512 VSS.n396 17.0005
R708 VSS.n511 VSS.n396 17.0005
R709 VSS.n9 VSS.n334 17.0005
R710 VSS.n9 VSS.n344 17.0005
R711 VSS.n9 VSS.n354 17.0005
R712 VSS.n9 VSS.n362 17.0005
R713 VSS.n9 VSS.n341 17.0005
R714 VSS.n9 VSS.n340 17.0005
R715 VSS.n9 VSS.n3 17.0005
R716 VSS.n1555 VSS.t76 17.0005
R717 VSS.t76 VSS.n299 17.0005
R718 VSS.t76 VSS.n300 17.0005
R719 VSS.t76 VSS.n319 17.0005
R720 VSS.t76 VSS.n301 17.0005
R721 VSS.t76 VSS.n304 17.0005
R722 VSS.t76 VSS.n317 17.0005
R723 VSS.t76 VSS.n314 17.0005
R724 VSS.t76 VSS.n313 17.0005
R725 VSS.t76 VSS.n310 17.0005
R726 VSS.n1536 VSS.n1535 17.0005
R727 VSS.n1535 VSS.t101 17.0005
R728 VSS.n1168 VSS.t24 17.0005
R729 VSS.n1166 VSS.t24 17.0005
R730 VSS.n1164 VSS.t70 17.0005
R731 VSS.n1126 VSS.t70 17.0005
R732 VSS.n1162 VSS.t70 17.0005
R733 VSS.n1159 VSS.t70 17.0005
R734 VSS.t62 VSS.n1065 17.0005
R735 VSS.n1156 VSS.n1065 17.0005
R736 VSS.n1088 VSS.n1065 17.0005
R737 VSS.n1081 VSS.n1065 17.0005
R738 VSS.n1073 VSS.n1065 17.0005
R739 VSS.n1152 VSS.n1065 17.0005
R740 VSS.n1150 VSS.n1065 17.0005
R741 VSS.t79 VSS.n1023 17.0005
R742 VSS.t79 VSS.n1022 17.0005
R743 VSS.t79 VSS.n1013 17.0005
R744 VSS.n1230 VSS.t79 17.0005
R745 VSS.n1237 VSS.t87 17.0005
R746 VSS.n1237 VSS.n746 17.0005
R747 VSS.n1237 VSS.n745 17.0005
R748 VSS.n1248 VSS.t29 17.0005
R749 VSS.n1248 VSS.n735 17.0005
R750 VSS.n1248 VSS.n722 17.0005
R751 VSS.n1248 VSS.n559 17.0005
R752 VSS.n1248 VSS.t36 17.0005
R753 VSS.n1248 VSS.n692 17.0005
R754 VSS.n1248 VSS.n691 17.0005
R755 VSS.n1248 VSS.n626 17.0005
R756 VSS.n1248 VSS.n670 17.0005
R757 VSS.n1248 VSS.t44 17.0005
R758 VSS.n1248 VSS.n489 17.0005
R759 VSS.n1663 VSS.n1642 17.0005
R760 VSS.n1684 VSS.n1609 17.0005
R761 VSS.n1697 VSS.n1587 17.0005
R762 VSS.n1573 VSS.n89 17.0005
R763 VSS.n1573 VSS.n160 17.0005
R764 VSS.n1573 VSS.n97 17.0005
R765 VSS.n1573 VSS.n186 17.0005
R766 VSS.n1573 VSS.n136 17.0005
R767 VSS.n1573 VSS.n208 17.0005
R768 VSS.n1573 VSS.n107 17.0005
R769 VSS.n1573 VSS.n218 17.0005
R770 VSS.n1170 VSS.n1169 16.2018
R771 VSS.n8 VSS.t105 135.924
R772 VSS.t16 VSS.n95 14.3913
R773 VSS.n1654 VSS.n1653 14.1929
R774 VSS.n126 VSS.t112 12.4725
R775 VSS.t33 VSS.n713 11.6256
R776 VSS.n693 VSS.t35 11.6256
R777 VSS.n167 VSS.n89 11.5948
R778 VSS.n162 VSS.n91 11.5948
R779 VSS.n159 VSS.n93 11.5948
R780 VSS.n156 VSS.n94 11.5948
R781 VSS.n152 VSS.n151 11.5948
R782 VSS.n147 VSS.n146 11.5948
R783 VSS.n144 VSS.n143 11.5948
R784 VSS.n138 VSS.n100 11.5948
R785 VSS.n135 VSS.n102 11.5948
R786 VSS.n132 VSS.n103 11.5948
R787 VSS.n128 VSS.n106 11.5948
R788 VSS.n123 VSS.n107 11.5948
R789 VSS.n121 VSS.n120 11.5948
R790 VSS.n116 VSS.n115 11.5948
R791 VSS.n192 VSS.n90 11.5948
R792 VSS.n193 VSS.n91 11.5948
R793 VSS.n194 VSS.n92 11.5948
R794 VSS.n195 VSS.n157 11.5948
R795 VSS.n196 VSS.n154 11.5948
R796 VSS.n197 VSS.n152 11.5948
R797 VSS.n198 VSS.n149 11.5948
R798 VSS.n199 VSS.n98 11.5948
R799 VSS.n200 VSS.n99 11.5948
R800 VSS.n203 VSS.n100 11.5948
R801 VSS.n205 VSS.n101 11.5948
R802 VSS.n207 VSS.n133 11.5948
R803 VSS.n209 VSS.n130 11.5948
R804 VSS.n211 VSS.n129 11.5948
R805 VSS.n213 VSS.n126 11.5948
R806 VSS.n215 VSS.n108 11.5948
R807 VSS.n217 VSS.n109 11.5948
R808 VSS.n220 VSS.n110 11.5948
R809 VSS.n168 VSS.n167 11.5948
R810 VSS.n192 VSS.n168 11.5948
R811 VSS.n193 VSS.n165 11.5948
R812 VSS.n163 VSS.n162 11.5948
R813 VSS.n194 VSS.n163 11.5948
R814 VSS.n160 VSS.n159 11.5948
R815 VSS.n195 VSS.n93 11.5948
R816 VSS.n157 VSS.n156 11.5948
R817 VSS.n196 VSS.n94 11.5948
R818 VSS.n197 VSS.n95 11.5948
R819 VSS.n151 VSS.n96 11.5948
R820 VSS.n198 VSS.n96 11.5948
R821 VSS.n146 VSS.n97 11.5948
R822 VSS.n199 VSS.n147 11.5948
R823 VSS.n143 VSS.n98 11.5948
R824 VSS.n200 VSS.n144 11.5948
R825 VSS.n203 VSS.n141 11.5948
R826 VSS.n139 VSS.n138 11.5948
R827 VSS.n205 VSS.n139 11.5948
R828 VSS.n136 VSS.n135 11.5948
R829 VSS.n207 VSS.n102 11.5948
R830 VSS.n133 VSS.n132 11.5948
R831 VSS.n209 VSS.n103 11.5948
R832 VSS.n211 VSS.n105 11.5948
R833 VSS.n129 VSS.n128 11.5948
R834 VSS.n213 VSS.n106 11.5948
R835 VSS.n124 VSS.n123 11.5948
R836 VSS.n215 VSS.n124 11.5948
R837 VSS.n120 VSS.n108 11.5948
R838 VSS.n217 VSS.n121 11.5948
R839 VSS.n220 VSS.n118 11.5948
R840 VSS.n115 VSS.n110 11.5948
R841 VSS.n222 VSS.n116 10.9423
R842 VSS.n1561 VSS.n222 10.9423
R843 VSS.n735 VSS.n733 10.5226
R844 VSS.n513 VSS.n512 10.5226
R845 VSS.n713 VSS.n712 10.5226
R846 VSS.n589 VSS.n588 10.5226
R847 VSS.n658 VSS.n489 10.5226
R848 VSS.n511 VSS.n509 10.5226
R849 VSS.n734 VSS.n539 10.5226
R850 VSS.n715 VSS.n714 10.5226
R851 VSS.n694 VSS.n693 10.5226
R852 VSS.n561 VSS.n559 10.5226
R853 VSS.n587 VSS.n585 10.5226
R854 VSS.n690 VSS.n615 10.5226
R855 VSS.n691 VSS.n689 10.5226
R856 VSS.n672 VSS.n671 10.5226
R857 VSS.n628 VSS.n626 10.5226
R858 VSS.n669 VSS.n652 10.5226
R859 VSS.n670 VSS.n668 10.5226
R860 VSS.n1282 VSS.n489 10.1725
R861 VSS.n1648 VSS.n10 9.81703
R862 VSS.n1976 VSS.n10 9.54113
R863 VSS.n2003 VSS.n10 9.38994
R864 VSS.n295 VSS.n294 9.11631
R865 VSS.n252 VSS.n249 9.11631
R866 VSS.n1653 VSS.n1649 9.11631
R867 VSS.n1292 VSS.n1287 9.11631
R868 VSS.n1978 VSS.n1977 9.11631
R869 VSS.n811 VSS.n494 9.11631
R870 VSS.n1653 VSS.n1652 9.11343
R871 VSS.n364 VSS.t72 9.08698
R872 VSS.n1172 VSS.n1141 9.07383
R873 VSS.n1553 VSS.n1552 9.07383
R874 VSS.n385 VSS.n384 9.07383
R875 VSS.t72 VSS.n363 9.0445
R876 VSS.n1823 VSS.n11 9.0005
R877 VSS.n1824 VSS.n1763 9.0005
R878 VSS.n1826 VSS.n1825 9.0005
R879 VSS.n1827 VSS.n1762 9.0005
R880 VSS.n1829 VSS.n1828 9.0005
R881 VSS.n1830 VSS.n1759 9.0005
R882 VSS.n1832 VSS.n1831 9.0005
R883 VSS.n1842 VSS.n1750 9.0005
R884 VSS.n1844 VSS.n1843 9.0005
R885 VSS.n1744 VSS.n173 9.0005
R886 VSS.n1743 VSS.n1742 9.0005
R887 VSS.n1728 VSS.n181 9.0005
R888 VSS.n1727 VSS.n1726 9.0005
R889 VSS.n288 VSS.n237 9.0005
R890 VSS.n290 VSS.n289 9.0005
R891 VSS.n291 VSS.n232 9.0005
R892 VSS.n293 VSS.n292 9.0005
R893 VSS.n1724 VSS.n183 9.0005
R894 VSS.n281 VSS.n185 9.0005
R895 VSS.n282 VSS.n280 9.0005
R896 VSS.n284 VSS.n283 9.0005
R897 VSS.n285 VSS.n238 9.0005
R898 VSS.n287 VSS.n286 9.0005
R899 VSS.n1740 VSS.n175 9.0005
R900 VSS.n1738 VSS.n1737 9.0005
R901 VSS.n1736 VSS.n177 9.0005
R902 VSS.n1735 VSS.n1734 9.0005
R903 VSS.n1732 VSS.n179 9.0005
R904 VSS.n1730 VSS.n1729 9.0005
R905 VSS.n1845 VSS.n1749 9.0005
R906 VSS.n1847 VSS.n1846 9.0005
R907 VSS.n1848 VSS.n1745 9.0005
R908 VSS.n1850 VSS.n1849 9.0005
R909 VSS.n1851 VSS.n174 9.0005
R910 VSS.n1853 VSS.n1852 9.0005
R911 VSS.n1833 VSS.n1758 9.0005
R912 VSS.n1835 VSS.n1834 9.0005
R913 VSS.n1836 VSS.n1755 9.0005
R914 VSS.n1838 VSS.n1837 9.0005
R915 VSS.n1839 VSS.n1754 9.0005
R916 VSS.n1841 VSS.n1840 9.0005
R917 VSS.n1823 VSS.n1766 9.0005
R918 VSS.n1824 VSS.n1765 9.0005
R919 VSS.n1825 VSS.n1764 9.0005
R920 VSS.n1782 VSS.n1762 9.0005
R921 VSS.n1829 VSS.t7 9.0005
R922 VSS.n1830 VSS.n1761 9.0005
R923 VSS.n1831 VSS.n1760 9.0005
R924 VSS.n1842 VSS.t11 9.0005
R925 VSS.n1843 VSS.n1751 9.0005
R926 VSS.n173 VSS.n171 9.0005
R927 VSS.n1742 VSS.n1741 9.0005
R928 VSS.n181 VSS.n180 9.0005
R929 VSS.n1726 VSS.n1725 9.0005
R930 VSS.n237 VSS.n236 9.0005
R931 VSS.n290 VSS.n235 9.0005
R932 VSS.n231 VSS.n230 9.0005
R933 VSS.n292 VSS.n233 9.0005
R934 VSS.n291 VSS.n234 9.0005
R935 VSS.n286 VSS.n239 9.0005
R936 VSS.n285 VSS.n277 9.0005
R937 VSS.n284 VSS.n278 9.0005
R938 VSS.n280 VSS.n279 9.0005
R939 VSS.n185 VSS.n184 9.0005
R940 VSS.n1724 VSS.n1723 9.0005
R941 VSS.n1730 VSS.n182 9.0005
R942 VSS.n1732 VSS.n1731 9.0005
R943 VSS.n1734 VSS.n1733 9.0005
R944 VSS.n177 VSS.n176 9.0005
R945 VSS.n1738 VSS.n178 9.0005
R946 VSS.n1740 VSS.n1739 9.0005
R947 VSS.n1854 VSS.n1853 9.0005
R948 VSS.n1815 VSS.n174 9.0005
R949 VSS.n1849 VSS.n1746 9.0005
R950 VSS.n1848 VSS.n1747 9.0005
R951 VSS.n1847 VSS.n1748 9.0005
R952 VSS.n1809 VSS.n1749 9.0005
R953 VSS.n1841 VSS.n1753 9.0005
R954 VSS.n1800 VSS.n1754 9.0005
R955 VSS.n1837 VSS.n1756 9.0005
R956 VSS.n1836 VSS.t10 9.0005
R957 VSS.n1835 VSS.n1757 9.0005
R958 VSS.n1788 VSS.n1758 9.0005
R959 VSS.n1999 VSS.n1998 9.0005
R960 VSS.n33 VSS.n32 9.0005
R961 VSS.n1940 VSS.n37 9.0005
R962 VSS.n1944 VSS.n63 9.0005
R963 VSS.n1950 VSS.n57 9.0005
R964 VSS.n1954 VSS.n54 9.0005
R965 VSS.n1958 VSS.n50 9.0005
R966 VSS.n1920 VSS.n1919 9.0005
R967 VSS.n1914 VSS.n1913 9.0005
R968 VSS.n1907 VSS.n1906 9.0005
R969 VSS.n1895 VSS.n1894 9.0005
R970 VSS.n1890 VSS.n1889 9.0005
R971 VSS.n1883 VSS.n1882 9.0005
R972 VSS.n1871 VSS.n1870 9.0005
R973 VSS.n1866 VSS.n1865 9.0005
R974 VSS.n1861 VSS.n85 9.0005
R975 VSS.n1863 VSS.n83 9.0005
R976 VSS.n1875 VSS.n79 9.0005
R977 VSS.n1885 VSS.n77 9.0005
R978 VSS.n1887 VSS.n75 9.0005
R979 VSS.n1899 VSS.n71 9.0005
R980 VSS.n1909 VSS.n69 9.0005
R981 VSS.n1911 VSS.n67 9.0005
R982 VSS.n1927 VSS.n49 9.0005
R983 VSS.n1956 VSS.n52 9.0005
R984 VSS.n1952 VSS.n55 9.0005
R985 VSS.n1942 VSS.n1938 9.0005
R986 VSS.n1967 VSS.n1966 9.0005
R987 VSS.n1980 VSS.n1979 9.0005
R988 VSS.n1982 VSS.n1981 9.0005
R989 VSS.n1984 VSS.n1983 9.0005
R990 VSS.n1986 VSS.n1985 9.0005
R991 VSS.n1988 VSS.n1987 9.0005
R992 VSS.n1990 VSS.n1989 9.0005
R993 VSS.n1992 VSS.n1991 9.0005
R994 VSS.n1994 VSS.n1993 9.0005
R995 VSS.n35 VSS.n34 9.0005
R996 VSS.n1946 VSS.n61 9.0005
R997 VSS.n1948 VSS.n59 9.0005
R998 VSS.n1926 VSS.n1925 9.0005
R999 VSS.n1922 VSS.n65 9.0005
R1000 VSS.n1902 VSS.n1901 9.0005
R1001 VSS.n1897 VSS.n73 9.0005
R1002 VSS.n1878 VSS.n1877 9.0005
R1003 VSS.n1873 VSS.n81 9.0005
R1004 VSS.n1519 VSS.n1518 9.0005
R1005 VSS.n1510 VSS.n397 9.0005
R1006 VSS.n1513 VSS.n1512 9.0005
R1007 VSS.n1508 VSS.n399 9.0005
R1008 VSS.n1506 VSS.n1505 9.0005
R1009 VSS.n1498 VSS.n401 9.0005
R1010 VSS.n1501 VSS.n1500 9.0005
R1011 VSS.n1496 VSS.n403 9.0005
R1012 VSS.n1494 VSS.n1493 9.0005
R1013 VSS.n1488 VSS.n405 9.0005
R1014 VSS.n1489 VSS.n1487 9.0005
R1015 VSS.n1485 VSS.n407 9.0005
R1016 VSS.n1483 VSS.n1482 9.0005
R1017 VSS.n1475 VSS.n409 9.0005
R1018 VSS.n1478 VSS.n1477 9.0005
R1019 VSS.n1473 VSS.n411 9.0005
R1020 VSS.n1471 VSS.n1470 9.0005
R1021 VSS.n1463 VSS.n413 9.0005
R1022 VSS.n1466 VSS.n1465 9.0005
R1023 VSS.n1461 VSS.n415 9.0005
R1024 VSS.t48 VSS.n1459 9.0005
R1025 VSS.n1452 VSS.n417 9.0005
R1026 VSS.n1455 VSS.n1454 9.0005
R1027 VSS.n1450 VSS.n419 9.0005
R1028 VSS.n1448 VSS.n1447 9.0005
R1029 VSS.n1440 VSS.n421 9.0005
R1030 VSS.n1443 VSS.n1442 9.0005
R1031 VSS.n1438 VSS.n423 9.0005
R1032 VSS.n1436 VSS.n1435 9.0005
R1033 VSS.n1430 VSS.n425 9.0005
R1034 VSS.n1431 VSS.t50 9.0005
R1035 VSS.n1427 VSS.n427 9.0005
R1036 VSS.n1425 VSS.n1424 9.0005
R1037 VSS.n1417 VSS.n429 9.0005
R1038 VSS.n1420 VSS.n1419 9.0005
R1039 VSS.n1415 VSS.n431 9.0005
R1040 VSS.n1413 VSS.n1412 9.0005
R1041 VSS.n1405 VSS.n433 9.0005
R1042 VSS.n1408 VSS.n1407 9.0005
R1043 VSS.n1403 VSS.n435 9.0005
R1044 VSS.n1402 VSS.n1401 9.0005
R1045 VSS.n1394 VSS.n437 9.0005
R1046 VSS.n1397 VSS.n1396 9.0005
R1047 VSS.n1392 VSS.n439 9.0005
R1048 VSS.n1390 VSS.n1389 9.0005
R1049 VSS.n1382 VSS.n441 9.0005
R1050 VSS.n1385 VSS.n1384 9.0005
R1051 VSS.n1380 VSS.n443 9.0005
R1052 VSS.n1378 VSS.n1377 9.0005
R1053 VSS.t54 VSS.n445 9.0005
R1054 VSS.n1373 VSS.n1372 9.0005
R1055 VSS.n1369 VSS.n447 9.0005
R1056 VSS.n1367 VSS.n1366 9.0005
R1057 VSS.n1359 VSS.n449 9.0005
R1058 VSS.n1362 VSS.n1361 9.0005
R1059 VSS.n1357 VSS.n451 9.0005
R1060 VSS.n1355 VSS.n1354 9.0005
R1061 VSS.n1347 VSS.n453 9.0005
R1062 VSS.n1350 VSS.n1349 9.0005
R1063 VSS.t56 VSS.n455 9.0005
R1064 VSS.n1344 VSS.n1343 9.0005
R1065 VSS.n1336 VSS.n457 9.0005
R1066 VSS.n1339 VSS.n1338 9.0005
R1067 VSS.n1334 VSS.n459 9.0005
R1068 VSS.n1332 VSS.n1331 9.0005
R1069 VSS.n1324 VSS.n461 9.0005
R1070 VSS.n1327 VSS.n1326 9.0005
R1071 VSS.n1322 VSS.n463 9.0005
R1072 VSS.n1320 VSS.n1319 9.0005
R1073 VSS.n1312 VSS.n464 9.0005
R1074 VSS.n1315 VSS.n1314 9.0005
R1075 VSS.n1310 VSS.n466 9.0005
R1076 VSS.n1308 VSS.n1307 9.0005
R1077 VSS.n1300 VSS.n468 9.0005
R1078 VSS.n1303 VSS.n1302 9.0005
R1079 VSS.n1298 VSS.n470 9.0005
R1080 VSS.n1296 VSS.n1295 9.0005
R1081 VSS.n1290 VSS.n472 9.0005
R1082 VSS.n1291 VSS.n1289 9.0005
R1083 VSS.n1539 VSS.n330 9.0005
R1084 VSS.n1538 VSS.n1537 9.0005
R1085 VSS.n1538 VSS.n331 9.0005
R1086 VSS.n1539 VSS.n298 9.0005
R1087 VSS.n369 VSS.t101 9.0005
R1088 VSS.n382 VSS.n381 9.0005
R1089 VSS.n379 VSS.n378 9.0005
R1090 VSS.n377 VSS.n376 9.0005
R1091 VSS.n375 VSS.n374 9.0005
R1092 VSS.n373 VSS.n372 9.0005
R1093 VSS.n326 VSS.n325 9.0005
R1094 VSS.n1544 VSS.n304 9.0005
R1095 VSS.n1545 VSS.t93 9.0005
R1096 VSS.n1546 VSS.t89 9.0005
R1097 VSS.n1550 VSS.n1549 9.0005
R1098 VSS.n1548 VSS.n323 9.0005
R1099 VSS.n1174 VSS.n1173 9.0005
R1100 VSS.n1175 VSS.n1136 9.0005
R1101 VSS.n1177 VSS.n1176 9.0005
R1102 VSS.n1179 VSS.n1135 9.0005
R1103 VSS.n1180 VSS.n1134 9.0005
R1104 VSS.n1181 VSS.t19 9.0005
R1105 VSS.n1128 VSS.n1182 9.0005
R1106 VSS.t121 VSS.n1127 9.0005
R1107 VSS.n1126 VSS.n1125 9.0005
R1108 VSS.n1185 VSS.n1184 9.0005
R1109 VSS.n1187 VSS.n1186 9.0005
R1110 VSS.n1188 VSS.n1119 9.0005
R1111 VSS.n1190 VSS.n1118 9.0005
R1112 VSS.n1192 VSS.n1191 9.0005
R1113 VSS.n1194 VSS.n1193 9.0005
R1114 VSS.n1195 VSS.n1112 9.0005
R1115 VSS.n1197 VSS.n1111 9.0005
R1116 VSS.n1199 VSS.n1198 9.0005
R1117 VSS.n1201 VSS.n1200 9.0005
R1118 VSS.n1202 VSS.n1105 9.0005
R1119 VSS.n1204 VSS.n1103 9.0005
R1120 VSS.n1206 VSS.n1205 9.0005
R1121 VSS.n1098 VSS.n1207 9.0005
R1122 VSS.t62 VSS.n1096 9.0005
R1123 VSS.n1209 VSS.n1208 9.0005
R1124 VSS.n1210 VSS.n1090 9.0005
R1125 VSS.n1212 VSS.n1211 9.0005
R1126 VSS.t21 VSS.n1089 9.0005
R1127 VSS.n1088 VSS.n1087 9.0005
R1128 VSS.n1215 VSS.n1214 9.0005
R1129 VSS.t123 VSS.n1216 9.0005
R1130 VSS.n1081 VSS.n1080 9.0005
R1131 VSS.n1217 VSS.n1079 9.0005
R1132 VSS.n1218 VSS.t66 9.0005
R1133 VSS.n1073 VSS.n1219 9.0005
R1134 VSS.n1220 VSS.n1072 9.0005
R1135 VSS.n1071 VSS.n1070 9.0005
R1136 VSS.n1222 VSS.t74 9.0005
R1137 VSS.n1224 VSS.n1223 9.0005
R1138 VSS.n1225 VSS.n1063 9.0005
R1139 VSS.n1226 VSS.t86 9.0005
R1140 VSS.n1227 VSS.n1024 9.0005
R1141 VSS.t91 VSS.n1228 9.0005
R1142 VSS.n1025 VSS.n1022 9.0005
R1143 VSS.n1057 VSS.n1056 9.0005
R1144 VSS.n1053 VSS.n1052 9.0005
R1145 VSS.n1051 VSS.n1050 9.0005
R1146 VSS.n1049 VSS.n1048 9.0005
R1147 VSS.n1047 VSS.n1027 9.0005
R1148 VSS.n1043 VSS.n1042 9.0005
R1149 VSS.n1041 VSS.n1040 9.0005
R1150 VSS.n1039 VSS.n1038 9.0005
R1151 VSS.n1037 VSS.n1029 9.0005
R1152 VSS.n1035 VSS.n1034 9.0005
R1153 VSS.n1008 VSS.n1007 9.0005
R1154 VSS.n1235 VSS.n748 9.0005
R1155 VSS.t87 VSS.n1236 9.0005
R1156 VSS.n750 VSS.n747 9.0005
R1157 VSS.n1002 VSS.t82 9.0005
R1158 VSS.n1001 VSS.n1000 9.0005
R1159 VSS.n999 VSS.n998 9.0005
R1160 VSS.n997 VSS.n752 9.0005
R1161 VSS.n993 VSS.t84 9.0005
R1162 VSS.n992 VSS.n991 9.0005
R1163 VSS.n990 VSS.n989 9.0005
R1164 VSS.n987 VSS.n754 9.0005
R1165 VSS.n983 VSS.n982 9.0005
R1166 VSS.n979 VSS.n978 9.0005
R1167 VSS.n974 VSS.n973 9.0005
R1168 VSS.n970 VSS.n969 9.0005
R1169 VSS.n965 VSS.n964 9.0005
R1170 VSS.n961 VSS.n960 9.0005
R1171 VSS.n956 VSS.n955 9.0005
R1172 VSS.n952 VSS.n951 9.0005
R1173 VSS.n947 VSS.n946 9.0005
R1174 VSS.n943 VSS.n942 9.0005
R1175 VSS.n938 VSS.n937 9.0005
R1176 VSS.n934 VSS.n933 9.0005
R1177 VSS.n929 VSS.n928 9.0005
R1178 VSS.n925 VSS.n924 9.0005
R1179 VSS.n920 VSS.n919 9.0005
R1180 VSS.n917 VSS.n916 9.0005
R1181 VSS.n912 VSS.n911 9.0005
R1182 VSS.n908 VSS.n907 9.0005
R1183 VSS.n903 VSS.n902 9.0005
R1184 VSS.n899 VSS.n898 9.0005
R1185 VSS.n894 VSS.n893 9.0005
R1186 VSS.n890 VSS.n889 9.0005
R1187 VSS.n885 VSS.n884 9.0005
R1188 VSS.n881 VSS.n880 9.0005
R1189 VSS.n876 VSS.t38 9.0005
R1190 VSS.n873 VSS.n872 9.0005
R1191 VSS.n868 VSS.n867 9.0005
R1192 VSS.n864 VSS.n863 9.0005
R1193 VSS.n859 VSS.n858 9.0005
R1194 VSS.n855 VSS.t40 9.0005
R1195 VSS.n851 VSS.n850 9.0005
R1196 VSS.n847 VSS.n846 9.0005
R1197 VSS.n842 VSS.n841 9.0005
R1198 VSS.n838 VSS.n837 9.0005
R1199 VSS.n833 VSS.n832 9.0005
R1200 VSS.n829 VSS.n828 9.0005
R1201 VSS.n824 VSS.n823 9.0005
R1202 VSS.n820 VSS.n819 9.0005
R1203 VSS.n815 VSS.n814 9.0005
R1204 VSS.n813 VSS.n812 9.0005
R1205 VSS.n810 VSS.n809 9.0005
R1206 VSS.n822 VSS.n821 9.0005
R1207 VSS.n807 VSS.n806 9.0005
R1208 VSS.n831 VSS.n830 9.0005
R1209 VSS.n804 VSS.n803 9.0005
R1210 VSS.n840 VSS.n839 9.0005
R1211 VSS.n801 VSS.n800 9.0005
R1212 VSS.n849 VSS.n848 9.0005
R1213 VSS.n798 VSS.n797 9.0005
R1214 VSS.n857 VSS.n856 9.0005
R1215 VSS.n795 VSS.n794 9.0005
R1216 VSS.n866 VSS.n865 9.0005
R1217 VSS.n792 VSS.n791 9.0005
R1218 VSS.n875 VSS.n874 9.0005
R1219 VSS.n789 VSS.n788 9.0005
R1220 VSS.n883 VSS.n882 9.0005
R1221 VSS.n786 VSS.n785 9.0005
R1222 VSS.n892 VSS.n891 9.0005
R1223 VSS.n783 VSS.n782 9.0005
R1224 VSS.n901 VSS.n900 9.0005
R1225 VSS.n780 VSS.n779 9.0005
R1226 VSS.n910 VSS.n909 9.0005
R1227 VSS.n777 VSS.n776 9.0005
R1228 VSS.n918 VSS.t34 9.0005
R1229 VSS.n774 VSS.n773 9.0005
R1230 VSS.n927 VSS.n926 9.0005
R1231 VSS.n771 VSS.n770 9.0005
R1232 VSS.n936 VSS.n935 9.0005
R1233 VSS.n768 VSS.t32 9.0005
R1234 VSS.n945 VSS.n944 9.0005
R1235 VSS.n766 VSS.n765 9.0005
R1236 VSS.n954 VSS.n953 9.0005
R1237 VSS.n763 VSS.n762 9.0005
R1238 VSS.n963 VSS.n962 9.0005
R1239 VSS.n760 VSS.n759 9.0005
R1240 VSS.n972 VSS.n971 9.0005
R1241 VSS.n757 VSS.n756 9.0005
R1242 VSS.n981 VSS.n980 9.0005
R1243 VSS.n1655 VSS.n1654 9.0005
R1244 VSS.n1618 VSS.n1616 9.0005
R1245 VSS.n1633 VSS.n1632 9.0005
R1246 VSS.n1631 VSS.t5 9.0005
R1247 VSS.n1630 VSS.n1620 9.0005
R1248 VSS.n1627 VSS.n1626 9.0005
R1249 VSS.n1688 VSS.n1602 9.0005
R1250 VSS.n1691 VSS.n1690 9.0005
R1251 VSS.n1693 VSS.n1692 9.0005
R1252 VSS.n1592 VSS.n1590 9.0005
R1253 VSS.n1597 VSS.n1596 9.0005
R1254 VSS.n1595 VSS.n1584 9.0005
R1255 VSS.n1706 VSS.n1705 9.0005
R1256 VSS.n1708 VSS.n1578 9.0005
R1257 VSS.n1711 VSS.n1710 9.0005
R1258 VSS.n1713 VSS.n1712 9.0005
R1259 VSS.n1720 VSS.n1719 9.0005
R1260 VSS.n201 VSS.n188 9.0005
R1261 VSS.n270 VSS.n269 9.0005
R1262 VSS.n272 VSS.n271 9.0005
R1263 VSS.n274 VSS.n273 9.0005
R1264 VSS.n243 VSS.n242 9.0005
R1265 VSS.n258 VSS.n257 9.0005
R1266 VSS.n248 VSS.n247 9.0005
R1267 VSS.n251 VSS.n250 9.0005
R1268 VSS.n1647 VSS.n1646 9.0005
R1269 VSS.n1639 VSS.n1638 9.0005
R1270 VSS.n1668 VSS.n1667 9.0005
R1271 VSS.n1670 VSS.n1669 9.0005
R1272 VSS.n1625 VSS.t6 9.0005
R1273 VSS.n1624 VSS.n1606 9.0005
R1274 VSS.n1701 VSS.n1583 9.0005
R1275 VSS.n1704 VSS.n1703 9.0005
R1276 VSS.n1715 VSS.n191 9.0005
R1277 VSS.n1718 VSS.n1717 9.0005
R1278 VSS.n262 VSS.n261 9.0005
R1279 VSS.n260 VSS.n259 9.0005
R1280 VSS.n1580 VSS.n1578 9.0005
R1281 VSS.n1711 VSS.n1577 9.0005
R1282 VSS.n1712 VSS.n1576 9.0005
R1283 VSS.n1575 VSS.n191 9.0005
R1284 VSS.n1718 VSS.n190 9.0005
R1285 VSS.n263 VSS.n262 9.0005
R1286 VSS.n260 VSS.n244 9.0005
R1287 VSS.n258 VSS.n254 9.0005
R1288 VSS.n253 VSS.n248 9.0005
R1289 VSS.n1719 VSS.n189 9.0005
R1290 VSS.n267 VSS.n188 9.0005
R1291 VSS.n270 VSS.n268 9.0005
R1292 VSS.n272 VSS.n266 9.0005
R1293 VSS.n273 VSS.n265 9.0005
R1294 VSS.n264 VSS.n243 9.0005
R1295 VSS.n1668 VSS.n1637 9.0005
R1296 VSS.n1669 VSS.n1636 9.0005
R1297 VSS.n1635 VSS.n1618 9.0005
R1298 VSS.n1634 VSS.n1633 9.0005
R1299 VSS.n1631 VSS.n1619 9.0005
R1300 VSS.n1630 VSS.n1629 9.0005
R1301 VSS.n1628 VSS.n1627 9.0005
R1302 VSS.n1625 VSS.n1621 9.0005
R1303 VSS.n1624 VSS.n1623 9.0005
R1304 VSS.n1593 VSS.n1583 9.0005
R1305 VSS.n1704 VSS.n1582 9.0005
R1306 VSS.n1705 VSS.n1581 9.0005
R1307 VSS.n1622 VSS.n1602 9.0005
R1308 VSS.n1691 VSS.n1601 9.0005
R1309 VSS.n1692 VSS.n1600 9.0005
R1310 VSS.n1599 VSS.n1592 9.0005
R1311 VSS.n1598 VSS.n1597 9.0005
R1312 VSS.n1595 VSS.n1594 9.0005
R1313 VSS.n1518 VSS.n1517 9.0005
R1314 VSS.n1515 VSS.n397 9.0005
R1315 VSS.n1514 VSS.n1513 9.0005
R1316 VSS.n399 VSS.n398 9.0005
R1317 VSS.n1505 VSS.n1504 9.0005
R1318 VSS.n1503 VSS.n401 9.0005
R1319 VSS.n1502 VSS.n1501 9.0005
R1320 VSS.n403 VSS.n402 9.0005
R1321 VSS.n1493 VSS.n1492 9.0005
R1322 VSS.n1491 VSS.n405 9.0005
R1323 VSS.n1490 VSS.n1489 9.0005
R1324 VSS.n407 VSS.n406 9.0005
R1325 VSS.n1482 VSS.n1481 9.0005
R1326 VSS.n1480 VSS.n409 9.0005
R1327 VSS.n1479 VSS.n1478 9.0005
R1328 VSS.n411 VSS.n410 9.0005
R1329 VSS.n1470 VSS.n1469 9.0005
R1330 VSS.n1468 VSS.n413 9.0005
R1331 VSS.n1467 VSS.n1466 9.0005
R1332 VSS.n415 VSS.n414 9.0005
R1333 VSS.n1459 VSS.n1458 9.0005
R1334 VSS.n1457 VSS.n417 9.0005
R1335 VSS.n1456 VSS.n1455 9.0005
R1336 VSS.n419 VSS.n418 9.0005
R1337 VSS.n1447 VSS.n1446 9.0005
R1338 VSS.n1445 VSS.n421 9.0005
R1339 VSS.n1444 VSS.n1443 9.0005
R1340 VSS.n423 VSS.n422 9.0005
R1341 VSS.n1435 VSS.n1434 9.0005
R1342 VSS.n1433 VSS.n425 9.0005
R1343 VSS.n1432 VSS.n1431 9.0005
R1344 VSS.n427 VSS.n426 9.0005
R1345 VSS.n1424 VSS.n1423 9.0005
R1346 VSS.n1422 VSS.n429 9.0005
R1347 VSS.n1421 VSS.n1420 9.0005
R1348 VSS.n431 VSS.n430 9.0005
R1349 VSS.n1412 VSS.n1411 9.0005
R1350 VSS.n1410 VSS.n433 9.0005
R1351 VSS.n1409 VSS.n1408 9.0005
R1352 VSS.n435 VSS.n434 9.0005
R1353 VSS.n1401 VSS.n1400 9.0005
R1354 VSS.n1399 VSS.n437 9.0005
R1355 VSS.n1398 VSS.n1397 9.0005
R1356 VSS.n439 VSS.n438 9.0005
R1357 VSS.n1389 VSS.n1388 9.0005
R1358 VSS.n1387 VSS.n441 9.0005
R1359 VSS.n1386 VSS.n1385 9.0005
R1360 VSS.n443 VSS.n442 9.0005
R1361 VSS.n1377 VSS.n1376 9.0005
R1362 VSS.n1375 VSS.n445 9.0005
R1363 VSS.n1374 VSS.n1373 9.0005
R1364 VSS.n447 VSS.n446 9.0005
R1365 VSS.n1366 VSS.n1365 9.0005
R1366 VSS.n1364 VSS.n449 9.0005
R1367 VSS.n1363 VSS.n1362 9.0005
R1368 VSS.n451 VSS.n450 9.0005
R1369 VSS.n1354 VSS.n1353 9.0005
R1370 VSS.n1352 VSS.n453 9.0005
R1371 VSS.n1351 VSS.n1350 9.0005
R1372 VSS.n455 VSS.n454 9.0005
R1373 VSS.n1343 VSS.n1342 9.0005
R1374 VSS.n1341 VSS.n457 9.0005
R1375 VSS.n1340 VSS.n1339 9.0005
R1376 VSS.n459 VSS.n458 9.0005
R1377 VSS.n1331 VSS.n1330 9.0005
R1378 VSS.n1329 VSS.n461 9.0005
R1379 VSS.n1328 VSS.n1327 9.0005
R1380 VSS.n463 VSS.n462 9.0005
R1381 VSS.n1319 VSS.n1318 9.0005
R1382 VSS.n1317 VSS.n464 9.0005
R1383 VSS.n1316 VSS.n1315 9.0005
R1384 VSS.n466 VSS.n465 9.0005
R1385 VSS.n1307 VSS.n1306 9.0005
R1386 VSS.n1305 VSS.n468 9.0005
R1387 VSS.n1304 VSS.n1303 9.0005
R1388 VSS.n470 VSS.n469 9.0005
R1389 VSS.n1295 VSS.n1294 9.0005
R1390 VSS.n1293 VSS.n472 9.0005
R1391 VSS.n1969 VSS.n33 9.0005
R1392 VSS.n1968 VSS.n1967 9.0005
R1393 VSS.n37 VSS.n36 9.0005
R1394 VSS.n1938 VSS.n1937 9.0005
R1395 VSS.n1936 VSS.n63 9.0005
R1396 VSS.n1935 VSS.n61 9.0005
R1397 VSS.n1934 VSS.n59 9.0005
R1398 VSS.n1926 VSS.n64 9.0005
R1399 VSS.n1917 VSS.n65 9.0005
R1400 VSS.n1903 VSS.n1902 9.0005
R1401 VSS.n73 VSS.n72 9.0005
R1402 VSS.n1879 VSS.n1878 9.0005
R1403 VSS.n81 VSS.n80 9.0005
R1404 VSS.n1870 VSS.n1869 9.0005
R1405 VSS.n1868 VSS.n83 9.0005
R1406 VSS.n1867 VSS.n1866 9.0005
R1407 VSS.n85 VSS.n84 9.0005
R1408 VSS.n1894 VSS.n1893 9.0005
R1409 VSS.n1892 VSS.n75 9.0005
R1410 VSS.n1891 VSS.n1890 9.0005
R1411 VSS.n77 VSS.n76 9.0005
R1412 VSS.n1882 VSS.n1881 9.0005
R1413 VSS.n1880 VSS.n79 9.0005
R1414 VSS.n1919 VSS.n1918 9.0005
R1415 VSS.n1916 VSS.n67 9.0005
R1416 VSS.n1915 VSS.n1914 9.0005
R1417 VSS.n69 VSS.n68 9.0005
R1418 VSS.n1906 VSS.n1905 9.0005
R1419 VSS.n1904 VSS.n71 9.0005
R1420 VSS.n1933 VSS.n57 9.0005
R1421 VSS.n1932 VSS.n55 9.0005
R1422 VSS.n1931 VSS.n54 9.0005
R1423 VSS.n1930 VSS.n52 9.0005
R1424 VSS.n1929 VSS.n50 9.0005
R1425 VSS.n1928 VSS.n1927 9.0005
R1426 VSS.n1982 VSS.n1975 9.0005
R1427 VSS.n1984 VSS.n1974 9.0005
R1428 VSS.n1986 VSS.n1973 9.0005
R1429 VSS.n1988 VSS.n1972 9.0005
R1430 VSS.n1990 VSS.n1971 9.0005
R1431 VSS.n1992 VSS.n1970 9.0005
R1432 VSS.n1995 VSS.n1994 9.0005
R1433 VSS.n1996 VSS.n35 9.0005
R1434 VSS.n1998 VSS.n1997 9.0005
R1435 VSS.n1054 VSS.n1053 9.0005
R1436 VSS.n1050 VSS.n1026 9.0005
R1437 VSS.n1049 VSS.n1046 9.0005
R1438 VSS.n1045 VSS.n1027 9.0005
R1439 VSS.n1044 VSS.n1043 9.0005
R1440 VSS.n1040 VSS.n1028 9.0005
R1441 VSS.n1039 VSS.n1030 9.0005
R1442 VSS.n1032 VSS.n1029 9.0005
R1443 VSS.n1034 VSS.n1033 9.0005
R1444 VSS.n1031 VSS.n1007 9.0005
R1445 VSS.n1235 VSS.n1006 9.0005
R1446 VSS.n1236 VSS.n1005 9.0005
R1447 VSS.n1004 VSS.n750 9.0005
R1448 VSS.n1003 VSS.n1002 9.0005
R1449 VSS.n1000 VSS.n751 9.0005
R1450 VSS.n999 VSS.n996 9.0005
R1451 VSS.n995 VSS.n752 9.0005
R1452 VSS.n994 VSS.n993 9.0005
R1453 VSS.n991 VSS.n753 9.0005
R1454 VSS.n990 VSS.n986 9.0005
R1455 VSS.n985 VSS.n754 9.0005
R1456 VSS.n984 VSS.n983 9.0005
R1457 VSS.n981 VSS.n755 9.0005
R1458 VSS.n979 VSS.n977 9.0005
R1459 VSS.n976 VSS.n757 9.0005
R1460 VSS.n975 VSS.n974 9.0005
R1461 VSS.n972 VSS.n758 9.0005
R1462 VSS.n970 VSS.n968 9.0005
R1463 VSS.n967 VSS.n760 9.0005
R1464 VSS.n966 VSS.n965 9.0005
R1465 VSS.n963 VSS.n761 9.0005
R1466 VSS.n961 VSS.n959 9.0005
R1467 VSS.n958 VSS.n763 9.0005
R1468 VSS.n957 VSS.n956 9.0005
R1469 VSS.n954 VSS.n764 9.0005
R1470 VSS.n952 VSS.n950 9.0005
R1471 VSS.n949 VSS.n766 9.0005
R1472 VSS.n948 VSS.n947 9.0005
R1473 VSS.n945 VSS.n767 9.0005
R1474 VSS.n943 VSS.n941 9.0005
R1475 VSS.n940 VSS.n768 9.0005
R1476 VSS.n939 VSS.n938 9.0005
R1477 VSS.n936 VSS.n769 9.0005
R1478 VSS.n934 VSS.n932 9.0005
R1479 VSS.n931 VSS.n771 9.0005
R1480 VSS.n930 VSS.n929 9.0005
R1481 VSS.n927 VSS.n772 9.0005
R1482 VSS.n925 VSS.n923 9.0005
R1483 VSS.n922 VSS.n774 9.0005
R1484 VSS.n921 VSS.n920 9.0005
R1485 VSS.n918 VSS.n775 9.0005
R1486 VSS.n917 VSS.n915 9.0005
R1487 VSS.n914 VSS.n777 9.0005
R1488 VSS.n913 VSS.n912 9.0005
R1489 VSS.n910 VSS.n778 9.0005
R1490 VSS.n908 VSS.n906 9.0005
R1491 VSS.n905 VSS.n780 9.0005
R1492 VSS.n904 VSS.n903 9.0005
R1493 VSS.n901 VSS.n781 9.0005
R1494 VSS.n899 VSS.n897 9.0005
R1495 VSS.n896 VSS.n783 9.0005
R1496 VSS.n895 VSS.n894 9.0005
R1497 VSS.n892 VSS.n784 9.0005
R1498 VSS.n890 VSS.n888 9.0005
R1499 VSS.n887 VSS.n786 9.0005
R1500 VSS.n886 VSS.n885 9.0005
R1501 VSS.n883 VSS.n787 9.0005
R1502 VSS.n881 VSS.n879 9.0005
R1503 VSS.n878 VSS.n789 9.0005
R1504 VSS.n877 VSS.n876 9.0005
R1505 VSS.n875 VSS.n790 9.0005
R1506 VSS.n873 VSS.n871 9.0005
R1507 VSS.n870 VSS.n792 9.0005
R1508 VSS.n869 VSS.n868 9.0005
R1509 VSS.n866 VSS.n793 9.0005
R1510 VSS.n864 VSS.n862 9.0005
R1511 VSS.n861 VSS.n795 9.0005
R1512 VSS.n860 VSS.n859 9.0005
R1513 VSS.n857 VSS.n796 9.0005
R1514 VSS.n855 VSS.n854 9.0005
R1515 VSS.n853 VSS.n798 9.0005
R1516 VSS.n852 VSS.n851 9.0005
R1517 VSS.n849 VSS.n799 9.0005
R1518 VSS.n847 VSS.n845 9.0005
R1519 VSS.n844 VSS.n801 9.0005
R1520 VSS.n843 VSS.n842 9.0005
R1521 VSS.n840 VSS.n802 9.0005
R1522 VSS.n838 VSS.n836 9.0005
R1523 VSS.n835 VSS.n804 9.0005
R1524 VSS.n834 VSS.n833 9.0005
R1525 VSS.n831 VSS.n805 9.0005
R1526 VSS.n829 VSS.n827 9.0005
R1527 VSS.n826 VSS.n807 9.0005
R1528 VSS.n825 VSS.n824 9.0005
R1529 VSS.n822 VSS.n808 9.0005
R1530 VSS.n820 VSS.n818 9.0005
R1531 VSS.n817 VSS.n810 9.0005
R1532 VSS.n816 VSS.n815 9.0005
R1533 VSS.n1175 VSS.n1140 9.0005
R1534 VSS.n1176 VSS.n1139 9.0005
R1535 VSS.n1138 VSS.n1135 9.0005
R1536 VSS.n1137 VSS.n1134 9.0005
R1537 VSS.n1181 VSS.n1133 9.0005
R1538 VSS.n1182 VSS.n1132 9.0005
R1539 VSS.n1131 VSS.n1127 9.0005
R1540 VSS.n1130 VSS.n1125 9.0005
R1541 VSS.n1185 VSS.n1124 9.0005
R1542 VSS.n1186 VSS.n1123 9.0005
R1543 VSS.n1122 VSS.n1119 9.0005
R1544 VSS.n1121 VSS.n1118 9.0005
R1545 VSS.n1192 VSS.n1117 9.0005
R1546 VSS.n1193 VSS.n1116 9.0005
R1547 VSS.n1115 VSS.n1112 9.0005
R1548 VSS.n1114 VSS.n1111 9.0005
R1549 VSS.n1199 VSS.n1110 9.0005
R1550 VSS.n1200 VSS.n1109 9.0005
R1551 VSS.n1108 VSS.n1105 9.0005
R1552 VSS.n1107 VSS.n1103 9.0005
R1553 VSS.n1206 VSS.n1102 9.0005
R1554 VSS.n1207 VSS.n1101 9.0005
R1555 VSS.n1100 VSS.n1096 9.0005
R1556 VSS.n1209 VSS.n1095 9.0005
R1557 VSS.n1210 VSS.n1094 9.0005
R1558 VSS.n1211 VSS.n1093 9.0005
R1559 VSS.n1092 VSS.n1089 9.0005
R1560 VSS.n1091 VSS.n1087 9.0005
R1561 VSS.n1215 VSS.n1086 9.0005
R1562 VSS.n1216 VSS.n1085 9.0005
R1563 VSS.n1084 VSS.n1080 9.0005
R1564 VSS.n1083 VSS.n1079 9.0005
R1565 VSS.n1218 VSS.n1078 9.0005
R1566 VSS.n1219 VSS.n1077 9.0005
R1567 VSS.n1076 VSS.n1072 9.0005
R1568 VSS.n1075 VSS.n1070 9.0005
R1569 VSS.n1222 VSS.n1069 9.0005
R1570 VSS.n1223 VSS.n1068 9.0005
R1571 VSS.n1067 VSS.n1063 9.0005
R1572 VSS.n1226 VSS.n1062 9.0005
R1573 VSS.n1227 VSS.n1061 9.0005
R1574 VSS.n1228 VSS.n1060 9.0005
R1575 VSS.n1059 VSS.n1025 9.0005
R1576 VSS.n1058 VSS.n1057 9.0005
R1577 VSS.n1551 VSS.n1550 9.0005
R1578 VSS.n1542 VSS.n326 9.0005
R1579 VSS.n1544 VSS.n1543 9.0005
R1580 VSS.n1545 VSS.n324 9.0005
R1581 VSS.n1547 VSS.n1546 9.0005
R1582 VSS.n383 VSS.n382 9.0005
R1583 VSS.n380 VSS.n379 9.0005
R1584 VSS.n372 VSS.n327 9.0005
R1585 VSS.n375 VSS.n371 9.0005
R1586 VSS.n376 VSS.n370 9.0005
R1587 VSS.n1820 VSS.n16 8.501
R1588 VSS.n1821 VSS.n1820 8.501
R1589 VSS.n1820 VSS.n1775 8.501
R1590 VSS.n1820 VSS.n1778 8.501
R1591 VSS.n1820 VSS.n1784 8.501
R1592 VSS.n1820 VSS.n1772 8.501
R1593 VSS.n1820 VSS.n1791 8.501
R1594 VSS.n1820 VSS.n1795 8.501
R1595 VSS.n1820 VSS.n1770 8.501
R1596 VSS.n1820 VSS.n1796 8.501
R1597 VSS.n1820 VSS.n1769 8.501
R1598 VSS.n1820 VSS.n1805 8.501
R1599 VSS.n1820 VSS.n1768 8.501
R1600 VSS.n1820 VSS.n1814 8.501
R1601 VSS.n1820 VSS.n1819 8.501
R1602 VSS.n1963 VSS.n1962 8.501
R1603 VSS.n1962 VSS.n43 8.501
R1604 VSS.n1962 VSS.n44 8.501
R1605 VSS.n1962 VSS.n45 8.501
R1606 VSS.n1962 VSS.n47 8.501
R1607 VSS.n1561 VSS.n1558 8.501
R1608 VSS.n1246 VSS.n1241 8.501
R1609 VSS.n1246 VSS.n1242 8.501
R1610 VSS.n1246 VSS.n1243 8.501
R1611 VSS.n8 VSS.n0 5.33454
R1612 VSS.n1246 VSS.n738 8.501
R1613 VSS.n1246 VSS.n737 8.501
R1614 VSS.n1246 VSS.n1245 8.501
R1615 VSS.n1246 VSS.n736 8.501
R1616 VSS.n1148 VSS.n1145 8.501
R1617 VSS.n1148 VSS.n1144 8.501
R1618 VSS.n1232 VSS.n1010 8.501
R1619 VSS.n1233 VSS.n1232 8.501
R1620 VSS.n1283 VSS.n1282 8.501
R1621 VSS.n1282 VSS.n474 8.501
R1622 VSS.n1282 VSS.n488 8.501
R1623 VSS.n1282 VSS.n486 8.501
R1624 VSS.n1282 VSS.n491 8.501
R1625 VSS.n1282 VSS.n492 8.501
R1626 VSS.n1282 VSS.n483 8.501
R1627 VSS.n1282 VSS.n482 8.501
R1628 VSS.n1282 VSS.n481 8.501
R1629 VSS.n1282 VSS.n480 8.501
R1630 VSS.n1282 VSS.n479 8.501
R1631 VSS.n1282 VSS.n478 8.501
R1632 VSS.n1282 VSS.n477 8.501
R1633 VSS.n1282 VSS.n476 8.501
R1634 VSS.n1282 VSS.n475 8.501
R1635 VSS.n1586 VSS.n18 8.501
R1636 VSS.n1658 VSS.n1586 8.501
R1637 VSS.n1662 VSS.n1586 8.501
R1638 VSS.n1615 VSS.n1586 8.501
R1639 VSS.n1673 VSS.n1586 8.501
R1640 VSS.n1675 VSS.n1586 8.501
R1641 VSS.n1677 VSS.n1586 8.501
R1642 VSS.n1679 VSS.n1586 8.501
R1643 VSS.n1681 VSS.n1586 8.501
R1644 VSS.n1683 VSS.n1586 8.501
R1645 VSS.n1604 VSS.n1586 8.501
R1646 VSS.n1589 VSS.n1586 8.501
R1647 VSS.n1696 VSS.n1586 8.501
R1648 VSS.n1561 VSS.n111 8.501
R1649 VSS.n1562 VSS.n1561 8.501
R1650 VSS.n1561 VSS.n1559 8.501
R1651 VSS.n1561 VSS.n1557 8.501
R1652 VSS.n1561 VSS.n1556 8.501
R1653 VSS.n9 VSS.n345 8.5005
R1654 VSS.n9 VSS.n355 8.5005
R1655 VSS.n1573 VSS.n1572 8.50038
R1656 VSS.n333 VSS.n9 8.48883
R1657 VSS.n1564 VSS.n1563 8.48291
R1658 VSS.n1285 VSS.n1284 8.47784
R1659 VSS.n487 VSS.n473 8.47784
R1660 VSS.n1274 VSS.n1273 8.47784
R1661 VSS.n1276 VSS.n1271 8.47784
R1662 VSS.n1277 VSS.n1270 8.47784
R1663 VSS.n1267 VSS.n1266 8.47784
R1664 VSS.n1265 VSS.n1264 8.47784
R1665 VSS.n1263 VSS.n1262 8.47784
R1666 VSS.n1261 VSS.n1260 8.47784
R1667 VSS.n1259 VSS.n1258 8.47784
R1668 VSS.n1257 VSS.n1256 8.47784
R1669 VSS.n1255 VSS.n1254 8.47784
R1670 VSS.n1253 VSS.n1252 8.47784
R1671 VSS.n1251 VSS.n1250 8.47784
R1672 VSS.n2001 VSS.n15 8.47732
R1673 VSS.t146 VSS.n1822 8.47732
R1674 VSS.n1767 VSS.t4 8.47732
R1675 VSS.n1777 VSS.n1776 8.47732
R1676 VSS.n1781 VSS.n1779 8.47732
R1677 VSS.n1773 VSS.t8 8.47732
R1678 VSS.n1786 VSS.n1785 8.47732
R1679 VSS.n1790 VSS.n1789 8.47732
R1680 VSS.n1792 VSS.t9 8.47732
R1681 VSS.n1794 VSS.n1793 8.47732
R1682 VSS.n1799 VSS.n1798 8.47732
R1683 VSS.n1797 VSS.n1752 8.47732
R1684 VSS.n1804 VSS.t12 8.47732
R1685 VSS.n1808 VSS.n1807 8.47732
R1686 VSS.n1811 VSS.n1810 8.47732
R1687 VSS.n1813 VSS.t13 8.47732
R1688 VSS.n1817 VSS.n1816 8.47732
R1689 VSS.n1856 VSS.n1855 8.47732
R1690 VSS.n1856 VSS.n169 8.47732
R1691 VSS.n1856 VSS.n166 8.47732
R1692 VSS.n1856 VSS.n164 8.47732
R1693 VSS.n1856 VSS.n161 8.47732
R1694 VSS.n1856 VSS.n158 8.47732
R1695 VSS.n1856 VSS.n155 8.47732
R1696 VSS.n1856 VSS.n153 8.47732
R1697 VSS.n1856 VSS.n150 8.47732
R1698 VSS.n1856 VSS.n148 8.47732
R1699 VSS.n1856 VSS.n145 8.47732
R1700 VSS.n1856 VSS.n142 8.47732
R1701 VSS.n1856 VSS.n140 8.47732
R1702 VSS.n1856 VSS.n137 8.47732
R1703 VSS.n1856 VSS.n134 8.47732
R1704 VSS.n1856 VSS.n127 8.47732
R1705 VSS.n1856 VSS.n125 8.47732
R1706 VSS.n1856 VSS.n122 8.47732
R1707 VSS.n2001 VSS.n12 8.47732
R1708 VSS.n1856 VSS.n119 8.47732
R1709 VSS.n1856 VSS.n117 8.47732
R1710 VSS.n2001 VSS.n2000 8.47732
R1711 VSS.n1965 VSS.n1964 8.47732
R1712 VSS.n39 VSS.n38 8.47732
R1713 VSS.n1945 VSS.n62 8.47732
R1714 VSS.n1947 VSS.n60 8.47732
R1715 VSS.n1949 VSS.n58 8.47732
R1716 VSS.n1955 VSS.n53 8.47732
R1717 VSS.n1957 VSS.n51 8.47732
R1718 VSS.n1923 VSS.n48 8.47732
R1719 VSS.n1921 VSS.n48 8.47732
R1720 VSS.n66 VSS.n48 8.47732
R1721 VSS.n1912 VSS.n48 8.47732
R1722 VSS.n1910 VSS.n48 8.47732
R1723 VSS.n1908 VSS.n48 8.47732
R1724 VSS.n70 VSS.n48 8.47732
R1725 VSS.n1900 VSS.n48 8.47732
R1726 VSS.n1898 VSS.n48 8.47732
R1727 VSS.n1896 VSS.n48 8.47732
R1728 VSS.n74 VSS.n48 8.47732
R1729 VSS.n1888 VSS.n48 8.47732
R1730 VSS.n1886 VSS.n48 8.47732
R1731 VSS.n1884 VSS.n48 8.47732
R1732 VSS.n78 VSS.n48 8.47732
R1733 VSS.n1876 VSS.n48 8.47732
R1734 VSS.n1874 VSS.n48 8.47732
R1735 VSS.n1872 VSS.n48 8.47732
R1736 VSS.n82 VSS.n48 8.47732
R1737 VSS.n1864 VSS.n48 8.47732
R1738 VSS.n1862 VSS.n48 8.47732
R1739 VSS.n1860 VSS.n48 8.47732
R1740 VSS.n2001 VSS.n23 8.47732
R1741 VSS.n2001 VSS.n25 8.47732
R1742 VSS.n2001 VSS.n26 8.47732
R1743 VSS.n2001 VSS.n28 8.47732
R1744 VSS.n2001 VSS.n30 8.47732
R1745 VSS.n2001 VSS.n31 8.47732
R1746 VSS.n471 VSS.n396 8.47732
R1747 VSS.n1297 VSS.n396 8.47732
R1748 VSS.n1299 VSS.n396 8.47732
R1749 VSS.n1301 VSS.n396 8.47732
R1750 VSS.n467 VSS.n396 8.47732
R1751 VSS.n1309 VSS.n396 8.47732
R1752 VSS.n1311 VSS.n396 8.47732
R1753 VSS.n1313 VSS.n396 8.47732
R1754 VSS.t58 VSS.n396 8.47732
R1755 VSS.n1321 VSS.n396 8.47732
R1756 VSS.n1323 VSS.n396 8.47732
R1757 VSS.n1325 VSS.n396 8.47732
R1758 VSS.n460 VSS.n396 8.47732
R1759 VSS.n1333 VSS.n396 8.47732
R1760 VSS.n1335 VSS.n396 8.47732
R1761 VSS.n1337 VSS.n396 8.47732
R1762 VSS.n456 VSS.n396 8.47732
R1763 VSS.n1345 VSS.n396 8.47732
R1764 VSS.n1346 VSS.n396 8.47732
R1765 VSS.n1348 VSS.n396 8.47732
R1766 VSS.n452 VSS.n396 8.47732
R1767 VSS.n1356 VSS.n396 8.47732
R1768 VSS.n1358 VSS.n396 8.47732
R1769 VSS.n1360 VSS.n396 8.47732
R1770 VSS.n448 VSS.n396 8.47732
R1771 VSS.n1368 VSS.n396 8.47732
R1772 VSS.n1370 VSS.n396 8.47732
R1773 VSS.n1379 VSS.n396 8.47732
R1774 VSS.n1381 VSS.n396 8.47732
R1775 VSS.n1383 VSS.n396 8.47732
R1776 VSS.n440 VSS.n396 8.47732
R1777 VSS.n1391 VSS.n396 8.47732
R1778 VSS.n1393 VSS.n396 8.47732
R1779 VSS.n1395 VSS.n396 8.47732
R1780 VSS.n436 VSS.n396 8.47732
R1781 VSS.n1406 VSS.n396 8.47732
R1782 VSS.n432 VSS.n396 8.47732
R1783 VSS.n1414 VSS.n396 8.47732
R1784 VSS.n1416 VSS.n396 8.47732
R1785 VSS.n1418 VSS.n396 8.47732
R1786 VSS.n428 VSS.n396 8.47732
R1787 VSS.n1426 VSS.n396 8.47732
R1788 VSS.n1428 VSS.n396 8.47732
R1789 VSS.n1429 VSS.n396 8.47732
R1790 VSS.n424 VSS.n396 8.47732
R1791 VSS.n1437 VSS.n396 8.47732
R1792 VSS.n1439 VSS.n396 8.47732
R1793 VSS.n1441 VSS.n396 8.47732
R1794 VSS.n420 VSS.n396 8.47732
R1795 VSS.n1449 VSS.n396 8.47732
R1796 VSS.n1451 VSS.n396 8.47732
R1797 VSS.n1453 VSS.n396 8.47732
R1798 VSS.n1462 VSS.n396 8.47732
R1799 VSS.n1464 VSS.n396 8.47732
R1800 VSS.n412 VSS.n396 8.47732
R1801 VSS.n1472 VSS.n396 8.47732
R1802 VSS.n1474 VSS.n396 8.47732
R1803 VSS.n1476 VSS.n396 8.47732
R1804 VSS.n408 VSS.n396 8.47732
R1805 VSS.n1484 VSS.n396 8.47732
R1806 VSS.n404 VSS.n396 8.47732
R1807 VSS.n1495 VSS.n396 8.47732
R1808 VSS.n1497 VSS.n396 8.47732
R1809 VSS.n1499 VSS.n396 8.47732
R1810 VSS.n400 VSS.n396 8.47732
R1811 VSS.n1507 VSS.n396 8.47732
R1812 VSS.n1509 VSS.n396 8.47732
R1813 VSS.n1511 VSS.n396 8.47732
R1814 VSS.t45 VSS.n396 8.47732
R1815 VSS.n9 VSS.n346 8.47732
R1816 VSS.n9 VSS.n353 8.47732
R1817 VSS.n9 VSS.n356 8.47732
R1818 VSS.n9 VSS.n366 8.47732
R1819 VSS.n9 VSS.n342 8.47732
R1820 VSS.n9 VSS.n338 8.47732
R1821 VSS.n1248 VSS.t30 8.47732
R1822 VSS.n1248 VSS.n498 8.47732
R1823 VSS.n1248 VSS.n501 8.47732
R1824 VSS.n1248 VSS.n504 8.47732
R1825 VSS.n1248 VSS.n507 8.47732
R1826 VSS.n1248 VSS.n510 8.47732
R1827 VSS.n1248 VSS.n514 8.47732
R1828 VSS.n1248 VSS.n517 8.47732
R1829 VSS.n1248 VSS.n520 8.47732
R1830 VSS.n1248 VSS.n528 8.47732
R1831 VSS.n1248 VSS.n531 8.47732
R1832 VSS.n1248 VSS.n534 8.47732
R1833 VSS.n1248 VSS.n537 8.47732
R1834 VSS.n1248 VSS.n540 8.47732
R1835 VSS.n1248 VSS.n541 8.47732
R1836 VSS.n1248 VSS.n542 8.47732
R1837 VSS.n1248 VSS.n543 8.47732
R1838 VSS.n1248 VSS.n545 8.47732
R1839 VSS.n1248 VSS.n546 8.47732
R1840 VSS.n1248 VSS.n547 8.47732
R1841 VSS.n1248 VSS.n548 8.47732
R1842 VSS.n1248 VSS.n549 8.47732
R1843 VSS.n1248 VSS.n550 8.47732
R1844 VSS.n1248 VSS.n551 8.47732
R1845 VSS.n1248 VSS.n552 8.47732
R1846 VSS.n1248 VSS.n553 8.47732
R1847 VSS.n1248 VSS.n554 8.47732
R1848 VSS.n1248 VSS.n555 8.47732
R1849 VSS.n1248 VSS.n556 8.47732
R1850 VSS.n1248 VSS.n557 8.47732
R1851 VSS.n1248 VSS.n558 8.47732
R1852 VSS.n1248 VSS.n560 8.47732
R1853 VSS.n1248 VSS.n563 8.47732
R1854 VSS.n1248 VSS.n566 8.47732
R1855 VSS.n1248 VSS.n574 8.47732
R1856 VSS.n1248 VSS.n577 8.47732
R1857 VSS.n1248 VSS.n580 8.47732
R1858 VSS.n1248 VSS.n583 8.47732
R1859 VSS.n1248 VSS.n586 8.47732
R1860 VSS.n1248 VSS.n590 8.47732
R1861 VSS.n1248 VSS.n593 8.47732
R1862 VSS.n1248 VSS.n596 8.47732
R1863 VSS.n1248 VSS.n604 8.47732
R1864 VSS.n1248 VSS.n607 8.47732
R1865 VSS.n1248 VSS.n610 8.47732
R1866 VSS.n1248 VSS.n613 8.47732
R1867 VSS.n1248 VSS.n616 8.47732
R1868 VSS.n1248 VSS.n617 8.47732
R1869 VSS.n1248 VSS.n618 8.47732
R1870 VSS.n1248 VSS.n619 8.47732
R1871 VSS.n1248 VSS.n620 8.47732
R1872 VSS.n1248 VSS.n621 8.47732
R1873 VSS.n1248 VSS.n622 8.47732
R1874 VSS.n1248 VSS.n623 8.47732
R1875 VSS.n1248 VSS.n624 8.47732
R1876 VSS.n1248 VSS.n625 8.47732
R1877 VSS.n1248 VSS.n627 8.47732
R1878 VSS.n1248 VSS.n630 8.47732
R1879 VSS.n1248 VSS.n633 8.47732
R1880 VSS.n1248 VSS.n636 8.47732
R1881 VSS.n1248 VSS.t42 8.47732
R1882 VSS.n1248 VSS.n641 8.47732
R1883 VSS.n1248 VSS.n644 8.47732
R1884 VSS.n1248 VSS.n647 8.47732
R1885 VSS.n1248 VSS.n650 8.47732
R1886 VSS.n1248 VSS.n653 8.47732
R1887 VSS.n1248 VSS.n654 8.47732
R1888 VSS.n1248 VSS.n655 8.47732
R1889 VSS.n1248 VSS.n656 8.47732
R1890 VSS.n2001 VSS.n20 8.47732
R1891 VSS.n2001 VSS.n19 8.47732
R1892 VSS.n1657 VSS.t140 8.47732
R1893 VSS.n1661 VSS.n1644 8.47732
R1894 VSS.n1663 VSS.n1643 8.47732
R1895 VSS.n1640 VSS.n1617 8.47732
R1896 VSS.n1672 VSS.n1671 8.47732
R1897 VSS.n1674 VSS.n1614 8.47732
R1898 VSS.n1676 VSS.n1613 8.47732
R1899 VSS.n1678 VSS.n1612 8.47732
R1900 VSS.n1680 VSS.n1611 8.47732
R1901 VSS.n1682 VSS.n1610 8.47732
R1902 VSS.n1684 VSS.n1608 8.47732
R1903 VSS.n1689 VSS.n1605 8.47732
R1904 VSS.n1603 VSS.n1591 8.47732
R1905 VSS.n1695 VSS.n1694 8.47732
R1906 VSS.n1697 VSS.n1588 8.47732
R1907 VSS.n1700 VSS.n1699 8.47732
R1908 VSS.n1702 VSS.n1573 8.47732
R1909 VSS.n1579 VSS.n1573 8.47732
R1910 VSS.n1709 VSS.n1573 8.47732
R1911 VSS.n1574 VSS.n1573 8.47732
R1912 VSS.n1714 VSS.n1573 8.47732
R1913 VSS.n1716 VSS.n1573 8.47732
R1914 VSS.n1573 VSS.n202 8.47732
R1915 VSS.n1573 VSS.n204 8.47732
R1916 VSS.n1573 VSS.n210 8.47732
R1917 VSS.n1573 VSS.n212 8.47732
R1918 VSS.n1573 VSS.n216 8.47732
R1919 VSS.n1856 VSS.n112 8.47732
R1920 VSS.n1566 VSS.n297 8.47732
R1921 VSS.n1569 VSS.n227 8.47732
R1922 VSS.n1570 VSS.n226 8.47732
R1923 VSS.n1571 VSS.n225 8.47732
R1924 VSS.n1521 VSS.n396 8.47677
R1925 VSS.n1522 VSS.n395 8.47677
R1926 VSS.n1523 VSS.n394 8.47677
R1927 VSS.n1524 VSS.n393 8.47677
R1928 VSS.n1528 VSS.n391 8.47677
R1929 VSS.n1529 VSS.n390 8.47677
R1930 VSS.n1530 VSS.n389 8.47677
R1931 VSS.n1531 VSS.n388 8.47677
R1932 VSS.n1286 VSS.n396 8.4742
R1933 VSS.n1249 VSS.n1248 8.4742
R1934 VSS.n1535 VSS.n1534 8.47111
R1935 VSS.t76 VSS.n321 8.47111
R1936 VSS.t76 VSS.n302 8.47111
R1937 VSS.t76 VSS.n318 8.47111
R1938 VSS.t76 VSS.n315 8.47111
R1939 VSS.n1535 VSS.t95 8.47111
R1940 VSS.n1178 VSS.t24 8.47111
R1941 VSS.n1129 VSS.t24 8.47111
R1942 VSS.n1183 VSS.t70 8.47111
R1943 VSS.n1120 VSS.t70 8.47111
R1944 VSS.n1189 VSS.t70 8.47111
R1945 VSS.n1113 VSS.t70 8.47111
R1946 VSS.n1196 VSS.t70 8.47111
R1947 VSS.t70 VSS.n1106 8.47111
R1948 VSS.n1203 VSS.n1104 8.47111
R1949 VSS.n1146 VSS.n1099 8.47111
R1950 VSS.n1097 VSS.n1065 8.47111
R1951 VSS.n1213 VSS.n1065 8.47111
R1952 VSS.n1082 VSS.n1065 8.47111
R1953 VSS.n1074 VSS.n1065 8.47111
R1954 VSS.n1221 VSS.n1065 8.47111
R1955 VSS.n1066 VSS.n1065 8.47111
R1956 VSS.n1064 VSS.n1065 8.47111
R1957 VSS.t79 VSS.n1229 8.47111
R1958 VSS.t79 VSS.n1012 8.47111
R1959 VSS.t79 VSS.n1015 8.47111
R1960 VSS.t79 VSS.n1016 8.47111
R1961 VSS.t79 VSS.n1017 8.47111
R1962 VSS.t79 VSS.n1018 8.47111
R1963 VSS.n1036 VSS.n1009 8.47111
R1964 VSS.n749 VSS.n1234 8.47111
R1965 VSS.n1237 VSS.n740 8.47111
R1966 VSS.n1237 VSS.n742 8.47111
R1967 VSS.n1237 VSS.n743 8.47111
R1968 VSS.n1237 VSS.n744 8.47111
R1969 VSS.n1573 VSS.n221 8.46924
R1970 VSS.n2006 VSS.n2005 7.85649
R1971 VSS.n670 VSS.t43 5.81305
R1972 VSS.n1171 VSS.n1170 5.66923
R1973 VSS.n1820 VSS.n1774 5.66778
R1974 VSS.n1820 VSS.n1771 5.66778
R1975 VSS.n1820 VSS.n1803 5.66778
R1976 VSS.n1820 VSS.n1812 5.66778
R1977 VSS.n1962 VSS.n42 5.66778
R1978 VSS.n1962 VSS.n41 5.66778
R1979 VSS.n1962 VSS.n40 5.66778
R1980 VSS.n1962 VSS.n46 5.66778
R1981 VSS.t134 VSS.n87 5.66778
R1982 VSS.n1246 VSS.n1240 5.66778
R1983 VSS.n1247 VSS.n1246 5.66778
R1984 VSS.n1246 VSS.n1244 5.66778
R1985 VSS.n1282 VSS.n490 5.66778
R1986 VSS.n1282 VSS.n485 5.66778
R1987 VSS.n1282 VSS.n1281 5.66778
R1988 VSS.n1282 VSS.n484 5.66778
R1989 VSS.n1660 VSS.n1586 5.66778
R1990 VSS.n1664 VSS.n1586 5.66778
R1991 VSS.n1641 VSS.n1586 5.66778
R1992 VSS.n1685 VSS.n1586 5.66778
R1993 VSS.n1607 VSS.n1586 5.66778
R1994 VSS.n1698 VSS.n1586 5.66778
R1995 VSS.n1586 VSS.n1585 5.66778
R1996 VSS.n1561 VSS.n1560 5.66778
R1997 VSS.n1148 VSS.n1147 5.66767
R1998 VSS.n1232 VSS.n739 5.66767
R1999 VSS.n1561 VSS.n223 5.66767
R2000 VSS.n1142 VSS.t24 5.66031
R2001 VSS.t76 VSS.n1554 5.65099
R2002 VSS.n1525 VSS.n392 5.63736
R2003 VSS.n1275 VSS.n1272 5.62674
R2004 VSS.n1278 VSS.n1269 5.62674
R2005 VSS.n1280 VSS.n1279 5.62674
R2006 VSS.n1268 VSS.n493 5.62674
R2007 VSS.n1783 VSS.n1780 5.62581
R2008 VSS.n1802 VSS.n1801 5.62581
R2009 VSS.n1818 VSS.n172 5.62581
R2010 VSS.n1856 VSS.n104 5.62581
R2011 VSS.n1941 VSS.n1939 5.62581
R2012 VSS.n1951 VSS.n56 5.62581
R2013 VSS.n1960 VSS.n1959 5.62581
R2014 VSS.n2001 VSS.n22 5.62581
R2015 VSS.n2001 VSS.n27 5.62581
R2016 VSS.n1288 VSS.n396 5.62581
R2017 VSS.n444 VSS.n396 5.62581
R2018 VSS.n1404 VSS.n396 5.62581
R2019 VSS.n1460 VSS.n396 5.62581
R2020 VSS.n1486 VSS.n396 5.62581
R2021 VSS.n9 VSS.n365 5.62581
R2022 VSS.n1248 VSS.n523 5.62581
R2023 VSS.n1248 VSS.n544 5.62581
R2024 VSS.n1248 VSS.n569 5.62581
R2025 VSS.n1248 VSS.n599 5.62581
R2026 VSS.n1248 VSS.n657 5.62581
R2027 VSS.n1659 VSS.n1656 5.62581
R2028 VSS.n1666 VSS.n1665 5.62581
R2029 VSS.n1687 VSS.n1686 5.62581
R2030 VSS.n1573 VSS.n187 5.62581
R2031 VSS.n1573 VSS.n206 5.62581
R2032 VSS.n1573 VSS.n214 5.62581
R2033 VSS.n1573 VSS.n219 5.62581
R2034 VSS.n1567 VSS.n296 5.62581
R2035 VSS.n1532 VSS.n387 5.62484
R2036 VSS.t76 VSS.n320 5.61485
R2037 VSS.n165 VSS.t14 4.79743
R2038 VSS.n294 VSS.n293 4.73162
R2039 VSS.n1645 VSS.n1637 4.73162
R2040 VSS.n253 VSS.n252 4.73162
R2041 VSS.n1978 VSS.n1975 4.73162
R2042 VSS.n1293 VSS.n1292 4.73162
R2043 VSS.n816 VSS.n811 4.73162
R2044 VSS.n1141 VSS.n1140 4.64666
R2045 VSS.n1552 VSS.n1551 4.64666
R2046 VSS.n384 VSS.n383 4.64666
R2047 VSS.n1231 VSS.t80 4.49152
R2048 VSS.n1158 VSS.t2 4.49152
R2049 VSS.n332 VSS.n86 4.4712
R2050 VSS.n1014 VSS.n328 4.4712
R2051 VSS.n1540 VSS.n329 4.4712
R2052 VSS.n1055 VSS.n328 4.46488
R2053 VSS.n1516 VSS.n332 4.46488
R2054 VSS.n1541 VSS.n1540 4.46488
R2055 VSS.n336 VSS.t132 4.28775
R2056 VSS.n1561 VSS.n113 4.25113
R2057 VSS.n9 VSS.n361 4.19225
R2058 VSS.n1172 VSS.n1171 3.52606
R2059 VSS.n1820 VSS.n170 3.40112
R2060 VSS.n1962 VSS.n1961 3.40112
R2061 VSS.n1517 VSS.n1516 3.37628
R2062 VSS.n2001 VSS.n13 3.3265
R2063 VSS.n9 VSS.n351 3.32615
R2064 VSS.n658 VSS.n396 3.24021
R2065 VSS.n660 VSS.n396 3.24021
R2066 VSS.n662 VSS.n396 3.24021
R2067 VSS.n664 VSS.n396 3.24021
R2068 VSS.n666 VSS.n396 3.24021
R2069 VSS.n668 VSS.n396 3.24021
R2070 VSS.n651 VSS.n396 3.24021
R2071 VSS.n648 VSS.n396 3.24021
R2072 VSS.n645 VSS.n396 3.24021
R2073 VSS.n642 VSS.n396 3.24021
R2074 VSS.n639 VSS.n396 3.24021
R2075 VSS.n637 VSS.n396 3.24021
R2076 VSS.n634 VSS.n396 3.24021
R2077 VSS.n631 VSS.n396 3.24021
R2078 VSS.n628 VSS.n396 3.24021
R2079 VSS.n673 VSS.n396 3.24021
R2080 VSS.n675 VSS.n396 3.24021
R2081 VSS.n677 VSS.n396 3.24021
R2082 VSS.n679 VSS.n396 3.24021
R2083 VSS.n681 VSS.n396 3.24021
R2084 VSS.n683 VSS.n396 3.24021
R2085 VSS.n685 VSS.n396 3.24021
R2086 VSS.n687 VSS.n396 3.24021
R2087 VSS.n689 VSS.n396 3.24021
R2088 VSS.n614 VSS.n396 3.24021
R2089 VSS.n611 VSS.n396 3.24021
R2090 VSS.n608 VSS.n396 3.24021
R2091 VSS.n605 VSS.n396 3.24021
R2092 VSS.n602 VSS.n396 3.24021
R2093 VSS.n600 VSS.n396 3.24021
R2094 VSS.n597 VSS.n396 3.24021
R2095 VSS.n594 VSS.n396 3.24021
R2096 VSS.n591 VSS.n396 3.24021
R2097 VSS.n584 VSS.n396 3.24021
R2098 VSS.n581 VSS.n396 3.24021
R2099 VSS.n578 VSS.n396 3.24021
R2100 VSS.n575 VSS.n396 3.24021
R2101 VSS.n572 VSS.n396 3.24021
R2102 VSS.n570 VSS.n396 3.24021
R2103 VSS.n567 VSS.n396 3.24021
R2104 VSS.n564 VSS.n396 3.24021
R2105 VSS.n561 VSS.n396 3.24021
R2106 VSS.n695 VSS.n396 3.24021
R2107 VSS.n697 VSS.n396 3.24021
R2108 VSS.n699 VSS.n396 3.24021
R2109 VSS.n701 VSS.n396 3.24021
R2110 VSS.n703 VSS.n396 3.24021
R2111 VSS.n705 VSS.n396 3.24021
R2112 VSS.n707 VSS.n396 3.24021
R2113 VSS.n709 VSS.n396 3.24021
R2114 VSS.n711 VSS.n396 3.24021
R2115 VSS.n716 VSS.n396 3.24021
R2116 VSS.n718 VSS.n396 3.24021
R2117 VSS.n720 VSS.n396 3.24021
R2118 VSS.n723 VSS.n396 3.24021
R2119 VSS.n725 VSS.n396 3.24021
R2120 VSS.n727 VSS.n396 3.24021
R2121 VSS.n729 VSS.n396 3.24021
R2122 VSS.n731 VSS.n396 3.24021
R2123 VSS.n733 VSS.n396 3.24021
R2124 VSS.n538 VSS.n396 3.24021
R2125 VSS.n535 VSS.n396 3.24021
R2126 VSS.n532 VSS.n396 3.24021
R2127 VSS.n529 VSS.n396 3.24021
R2128 VSS.n526 VSS.n396 3.24021
R2129 VSS.n524 VSS.n396 3.24021
R2130 VSS.n521 VSS.n396 3.24021
R2131 VSS.n518 VSS.n396 3.24021
R2132 VSS.n515 VSS.n396 3.24021
R2133 VSS.n508 VSS.n396 3.24021
R2134 VSS.n505 VSS.n396 3.24021
R2135 VSS.n502 VSS.n396 3.24021
R2136 VSS.n499 VSS.n396 3.24021
R2137 VSS.n496 VSS.n396 3.24021
R2138 VSS.n1248 VSS.n497 3.24021
R2139 VSS.n1248 VSS.n500 3.24021
R2140 VSS.n1248 VSS.n503 3.24021
R2141 VSS.n1248 VSS.n506 3.24021
R2142 VSS.n1248 VSS.n509 3.24021
R2143 VSS.n1248 VSS.n513 3.24021
R2144 VSS.n1248 VSS.n516 3.24021
R2145 VSS.n1248 VSS.n519 3.24021
R2146 VSS.n1248 VSS.n522 3.24021
R2147 VSS.n1248 VSS.n525 3.24021
R2148 VSS.n1248 VSS.n527 3.24021
R2149 VSS.n1248 VSS.n530 3.24021
R2150 VSS.n1248 VSS.n533 3.24021
R2151 VSS.n1248 VSS.n536 3.24021
R2152 VSS.n1248 VSS.n539 3.24021
R2153 VSS.n1248 VSS.n732 3.24021
R2154 VSS.n1248 VSS.n730 3.24021
R2155 VSS.n1248 VSS.n728 3.24021
R2156 VSS.n1248 VSS.n726 3.24021
R2157 VSS.n1248 VSS.n724 3.24021
R2158 VSS.n1248 VSS.n721 3.24021
R2159 VSS.n1248 VSS.n719 3.24021
R2160 VSS.n1248 VSS.n717 3.24021
R2161 VSS.n1248 VSS.n715 3.24021
R2162 VSS.n1248 VSS.n712 3.24021
R2163 VSS.n1248 VSS.n710 3.24021
R2164 VSS.n1248 VSS.n708 3.24021
R2165 VSS.n1248 VSS.n706 3.24021
R2166 VSS.n1248 VSS.n704 3.24021
R2167 VSS.n1248 VSS.n702 3.24021
R2168 VSS.n1248 VSS.n700 3.24021
R2169 VSS.n1248 VSS.n698 3.24021
R2170 VSS.n1248 VSS.n696 3.24021
R2171 VSS.n1248 VSS.n694 3.24021
R2172 VSS.n1248 VSS.n562 3.24021
R2173 VSS.n1248 VSS.n565 3.24021
R2174 VSS.n1248 VSS.n568 3.24021
R2175 VSS.n1248 VSS.n571 3.24021
R2176 VSS.n1248 VSS.n573 3.24021
R2177 VSS.n1248 VSS.n576 3.24021
R2178 VSS.n1248 VSS.n579 3.24021
R2179 VSS.n1248 VSS.n582 3.24021
R2180 VSS.n1248 VSS.n585 3.24021
R2181 VSS.n1248 VSS.n589 3.24021
R2182 VSS.n1248 VSS.n592 3.24021
R2183 VSS.n1248 VSS.n595 3.24021
R2184 VSS.n1248 VSS.n598 3.24021
R2185 VSS.n1248 VSS.n601 3.24021
R2186 VSS.n1248 VSS.n603 3.24021
R2187 VSS.n1248 VSS.n606 3.24021
R2188 VSS.n1248 VSS.n609 3.24021
R2189 VSS.n1248 VSS.n612 3.24021
R2190 VSS.n1248 VSS.n615 3.24021
R2191 VSS.n1248 VSS.n688 3.24021
R2192 VSS.n1248 VSS.n686 3.24021
R2193 VSS.n1248 VSS.n684 3.24021
R2194 VSS.n1248 VSS.n682 3.24021
R2195 VSS.n1248 VSS.n680 3.24021
R2196 VSS.n1248 VSS.n678 3.24021
R2197 VSS.n1248 VSS.n676 3.24021
R2198 VSS.n1248 VSS.n674 3.24021
R2199 VSS.n1248 VSS.n672 3.24021
R2200 VSS.n1248 VSS.n629 3.24021
R2201 VSS.n1248 VSS.n632 3.24021
R2202 VSS.n1248 VSS.n635 3.24021
R2203 VSS.n1248 VSS.n638 3.24021
R2204 VSS.n1248 VSS.n640 3.24021
R2205 VSS.n1248 VSS.n643 3.24021
R2206 VSS.n1248 VSS.n646 3.24021
R2207 VSS.n1248 VSS.n649 3.24021
R2208 VSS.n1248 VSS.n652 3.24021
R2209 VSS.n1248 VSS.n667 3.24021
R2210 VSS.n1248 VSS.n665 3.24021
R2211 VSS.n1248 VSS.n663 3.24021
R2212 VSS.n1248 VSS.n661 3.24021
R2213 VSS.n1248 VSS.n659 3.24021
R2214 VSS.n1573 VSS.n222 3.03033
R2215 VSS.n2006 VSS.n10 2.93359
R2216 VSS.n512 VSS.t28 2.90677
R2217 VSS.t39 VSS.n690 2.90677
R2218 VSS.n1520 VSS.n86 2.7456
R2219 VSS.n9 VSS.n339 2.74414
R2220 VSS.n9 VSS.n337 2.74403
R2221 VSS.n1707 VSS.n1573 2.74397
R2222 VSS.t76 VSS.n316 2.72142
R2223 VSS.n167 VSS.n48 2.70412
R2224 VSS.n162 VSS.n48 2.70412
R2225 VSS.n159 VSS.n48 2.70412
R2226 VSS.n156 VSS.n48 2.70412
R2227 VSS.n151 VSS.n48 2.70412
R2228 VSS.n146 VSS.n48 2.70412
R2229 VSS.n143 VSS.n48 2.70412
R2230 VSS.n138 VSS.n48 2.70412
R2231 VSS.n135 VSS.n48 2.70412
R2232 VSS.n132 VSS.n48 2.70412
R2233 VSS.n128 VSS.n48 2.70412
R2234 VSS.n123 VSS.n48 2.70412
R2235 VSS.n120 VSS.n48 2.70412
R2236 VSS.n115 VSS.n48 2.70412
R2237 VSS.n1573 VSS.n192 2.70412
R2238 VSS.n1573 VSS.n193 2.70412
R2239 VSS.n1573 VSS.n194 2.70412
R2240 VSS.n1573 VSS.n195 2.70412
R2241 VSS.n1573 VSS.n196 2.70412
R2242 VSS.n1573 VSS.n197 2.70412
R2243 VSS.n1573 VSS.n198 2.70412
R2244 VSS.n1573 VSS.n199 2.70412
R2245 VSS.n1573 VSS.n200 2.70412
R2246 VSS.n1573 VSS.n203 2.70412
R2247 VSS.n1573 VSS.n205 2.70412
R2248 VSS.n1573 VSS.n207 2.70412
R2249 VSS.n1573 VSS.n209 2.70412
R2250 VSS.n1573 VSS.n211 2.70412
R2251 VSS.n1573 VSS.n213 2.70412
R2252 VSS.n1573 VSS.n215 2.70412
R2253 VSS.n1573 VSS.n217 2.70412
R2254 VSS.n1573 VSS.n220 2.70412
R2255 VSS.n1516 VSS.n84 2.43862
R2256 VSS.t76 VSS.n303 2.11212
R2257 VSS.n1535 VSS.n368 2.11212
R2258 VSS.t76 VSS.n311 1.97632
R2259 VSS.n1859 VSS.n86 1.83435
R2260 VSS.n2002 VSS.n2001 1.75596
R2261 VSS.n2001 VSS.n17 1.7558
R2262 VSS.n9 VSS.n343 1.75483
R2263 VSS.n1565 VSS.n298 1.66925
R2264 VSS.n245 VSS.t141 1.43372
R2265 VSS.n228 VSS.t143 1.43372
R2266 VSS.t143 VSS.n229 1.42949
R2267 VSS.t141 VSS.n246 1.42949
R2268 VSS.t113 VSS.t117 1.41892
R2269 VSS.t111 VSS.t116 1.41892
R2270 VSS.t115 VSS.t109 1.41892
R2271 VSS.t114 VSS.t107 1.41892
R2272 VSS.n1650 VSS.t138 1.37661
R2273 VSS.t138 VSS.n1651 1.37661
R2274 VSS.n383 VSS.n380 1.3114
R2275 VSS.n1962 VSS.n21 0.85096
R2276 VSS.n988 VSS.n386 0.832974
R2277 VSS.t155 VSS.t157 0.806856
R2278 VSS.t149 VSS.t151 0.806856
R2279 VSS.t27 VSS.n352 0.802775
R2280 VSS.n1541 VSS.n327 0.801519
R2281 VSS.t117 VSS.n255 0.722582
R2282 VSS.t116 VSS.n240 0.722582
R2283 VSS.n276 VSS.t115 0.722582
R2284 VSS.n1722 VSS.t114 0.722582
R2285 VSS.n256 VSS.t113 0.72222
R2286 VSS.n241 VSS.t111 0.72222
R2287 VSS.t109 VSS.n275 0.72222
R2288 VSS.t107 VSS.n1721 0.72222
R2289 VSS.n1533 VSS.n386 0.710232
R2290 VSS.n1527 VSS.n1526 0.6955
R2291 VSS.n2005 VSS.n11 0.692362
R2292 VSS.n1581 VSS.n1580 0.692362
R2293 VSS.n1540 VSS.n328 0.66578
R2294 VSS.n1248 VSS.n386 0.599811
R2295 VSS.n357 VSS.t160 0.595317
R2296 VSS.t158 VSS.n359 0.595317
R2297 VSS.n347 VSS.t154 0.595317
R2298 VSS.t152 VSS.n349 0.595317
R2299 VSS.t95 VSS.n311 0.586866
R2300 VSS.n1163 VSS.t70 0.572871
R2301 VSS.t79 VSS.n1021 0.572871
R2302 VSS.t76 VSS.n305 0.557126
R2303 VSS.n1554 VSS.n224 0.548518
R2304 VSS.n367 VSS.n343 0.522138
R2305 VSS.t141 VSS.t143 0.492336
R2306 VSS.n1157 VSS.n1065 0.490843
R2307 VSS.n1153 VSS.n1065 0.490843
R2308 VSS.n1151 VSS.n1065 0.490843
R2309 VSS.n1238 VSS.n1237 0.490843
R2310 VSS.n1160 VSS.t70 0.489061
R2311 VSS.t79 VSS.n1019 0.489061
R2312 VSS.t76 VSS.n308 0.477286
R2313 VSS.n1246 VSS.n495 0.477022
R2314 VSS.t76 VSS.n307 0.472981
R2315 VSS.n1629 VSS.n1628 0.461741
R2316 VSS.n1654 VSS.n1647 0.461741
R2317 VSS.n9 VSS.n7 0.453073
R2318 VSS.n358 VSS.n343 0.447055
R2319 VSS.n1551 VSS.n1547 0.437466
R2320 VSS.n2003 VSS.n2002 0.417043
R2321 VSS.n17 VSS.n14 0.416917
R2322 VSS.n1648 VSS.n17 0.416191
R2323 VSS.n2002 VSS.n14 0.416074
R2324 VSS.n1540 VSS.n1539 0.41058
R2325 VSS.n311 VSS.n378 0.407016
R2326 VSS.n1169 VSS.t24 0.400619
R2327 VSS.n1248 VSS.n495 0.398785
R2328 VSS.n990 VSS.n754 0.390431
R2329 VSS.n986 VSS.n985 0.390431
R2330 VSS.n329 VSS.n316 0.354963
R2331 VSS.n1534 VSS.n1533 0.345789
R2332 VSS.n337 VSS.n331 0.338123
R2333 VSS.n1708 VSS.n1707 0.330718
R2334 VSS.n348 VSS.n339 0.31249
R2335 VSS.n373 VSS.n316 0.296592
R2336 VSS.n989 VSS.n988 0.2855
R2337 VSS.n1279 VSS.n1278 0.280152
R2338 VSS.n1279 VSS.n1268 0.280152
R2339 VSS.t27 VSS.n351 0.2761
R2340 VSS.t76 VSS.n322 0.267335
R2341 VSS.n351 VSS.n347 0.266107
R2342 VSS.n2003 VSS.n13 0.265497
R2343 VSS.n1976 VSS.n13 0.264227
R2344 VSS.n1532 VSS.n1531 0.24416
R2345 VSS.t89 VSS.n320 0.240825
R2346 VSS.n1567 VSS.n1566 0.238668
R2347 VSS.t140 VSS.n1656 0.238668
R2348 VSS.n337 VSS.n298 0.238347
R2349 VSS.n352 VSS.n339 0.238044
R2350 VSS.n1707 VSS.n1706 0.236071
R2351 VSS.n1276 VSS.n1275 0.233757
R2352 VSS.n1268 VSS.n1267 0.233757
R2353 VSS.n1275 VSS.n1274 0.233419
R2354 VSS.n1278 VSS.n1277 0.233419
R2355 VSS.n1763 VSS.n11 0.231121
R2356 VSS.n1826 VSS.n1763 0.231121
R2357 VSS.n1827 VSS.n1826 0.231121
R2358 VSS.n1828 VSS.n1827 0.231121
R2359 VSS.n1828 VSS.n1759 0.231121
R2360 VSS.n1832 VSS.n1759 0.231121
R2361 VSS.n1833 VSS.n1832 0.231121
R2362 VSS.n1834 VSS.n1833 0.231121
R2363 VSS.n1834 VSS.n1755 0.231121
R2364 VSS.n1838 VSS.n1755 0.231121
R2365 VSS.n1839 VSS.n1838 0.231121
R2366 VSS.n1840 VSS.n1839 0.231121
R2367 VSS.n1840 VSS.n1750 0.231121
R2368 VSS.n1844 VSS.n1750 0.231121
R2369 VSS.n1845 VSS.n1844 0.231121
R2370 VSS.n1846 VSS.n1845 0.231121
R2371 VSS.n1846 VSS.n1745 0.231121
R2372 VSS.n1850 VSS.n1745 0.231121
R2373 VSS.n1851 VSS.n1850 0.231121
R2374 VSS.n1852 VSS.n1851 0.231121
R2375 VSS.n1852 VSS.n1744 0.231121
R2376 VSS.n1744 VSS.n1743 0.231121
R2377 VSS.n1743 VSS.n175 0.231121
R2378 VSS.n1737 VSS.n175 0.231121
R2379 VSS.n1737 VSS.n1736 0.231121
R2380 VSS.n1736 VSS.n1735 0.231121
R2381 VSS.n1735 VSS.n179 0.231121
R2382 VSS.n1729 VSS.n179 0.231121
R2383 VSS.n1729 VSS.n1728 0.231121
R2384 VSS.n1728 VSS.n1727 0.231121
R2385 VSS.n1727 VSS.n183 0.231121
R2386 VSS.n281 VSS.n183 0.231121
R2387 VSS.n282 VSS.n281 0.231121
R2388 VSS.n283 VSS.n282 0.231121
R2389 VSS.n283 VSS.n238 0.231121
R2390 VSS.n287 VSS.n238 0.231121
R2391 VSS.n288 VSS.n287 0.231121
R2392 VSS.n289 VSS.n288 0.231121
R2393 VSS.n289 VSS.n232 0.231121
R2394 VSS.n293 VSS.n232 0.231121
R2395 VSS.n1824 VSS.n1823 0.231121
R2396 VSS.n1825 VSS.n1824 0.231121
R2397 VSS.n1825 VSS.n1762 0.231121
R2398 VSS.n1829 VSS.n1762 0.231121
R2399 VSS.n1830 VSS.n1829 0.231121
R2400 VSS.n1831 VSS.n1830 0.231121
R2401 VSS.n1831 VSS.n1758 0.231121
R2402 VSS.n1835 VSS.n1758 0.231121
R2403 VSS.n1836 VSS.n1835 0.231121
R2404 VSS.n1837 VSS.n1836 0.231121
R2405 VSS.n1837 VSS.n1754 0.231121
R2406 VSS.n1841 VSS.n1754 0.231121
R2407 VSS.n1842 VSS.n1841 0.231121
R2408 VSS.n1843 VSS.n1842 0.231121
R2409 VSS.n1843 VSS.n1749 0.231121
R2410 VSS.n1847 VSS.n1749 0.231121
R2411 VSS.n1848 VSS.n1847 0.231121
R2412 VSS.n1849 VSS.n1848 0.231121
R2413 VSS.n1849 VSS.n174 0.231121
R2414 VSS.n1853 VSS.n174 0.231121
R2415 VSS.n1853 VSS.n173 0.231121
R2416 VSS.n1742 VSS.n173 0.231121
R2417 VSS.n1742 VSS.n1740 0.231121
R2418 VSS.n1740 VSS.n1738 0.231121
R2419 VSS.n1738 VSS.n177 0.231121
R2420 VSS.n1734 VSS.n177 0.231121
R2421 VSS.n1734 VSS.n1732 0.231121
R2422 VSS.n1732 VSS.n1730 0.231121
R2423 VSS.n1730 VSS.n181 0.231121
R2424 VSS.n1726 VSS.n181 0.231121
R2425 VSS.n1726 VSS.n1724 0.231121
R2426 VSS.n1724 VSS.n185 0.231121
R2427 VSS.n280 VSS.n185 0.231121
R2428 VSS.n284 VSS.n280 0.231121
R2429 VSS.n285 VSS.n284 0.231121
R2430 VSS.n286 VSS.n285 0.231121
R2431 VSS.n286 VSS.n237 0.231121
R2432 VSS.n290 VSS.n237 0.231121
R2433 VSS.n291 VSS.n290 0.231121
R2434 VSS.n292 VSS.n291 0.231121
R2435 VSS.n292 VSS.n231 0.231121
R2436 VSS.n1711 VSS.n1578 0.231121
R2437 VSS.n1712 VSS.n1711 0.231121
R2438 VSS.n1712 VSS.n191 0.231121
R2439 VSS.n1718 VSS.n191 0.231121
R2440 VSS.n1719 VSS.n1718 0.231121
R2441 VSS.n1719 VSS.n188 0.231121
R2442 VSS.n270 VSS.n188 0.231121
R2443 VSS.n272 VSS.n270 0.231121
R2444 VSS.n273 VSS.n272 0.231121
R2445 VSS.n273 VSS.n243 0.231121
R2446 VSS.n262 VSS.n243 0.231121
R2447 VSS.n262 VSS.n260 0.231121
R2448 VSS.n260 VSS.n258 0.231121
R2449 VSS.n258 VSS.n248 0.231121
R2450 VSS.n251 VSS.n248 0.231121
R2451 VSS.n1637 VSS.n1636 0.231121
R2452 VSS.n1636 VSS.n1635 0.231121
R2453 VSS.n1635 VSS.n1634 0.231121
R2454 VSS.n1634 VSS.n1619 0.231121
R2455 VSS.n1629 VSS.n1619 0.231121
R2456 VSS.n1628 VSS.n1621 0.231121
R2457 VSS.n1623 VSS.n1621 0.231121
R2458 VSS.n1623 VSS.n1622 0.231121
R2459 VSS.n1622 VSS.n1601 0.231121
R2460 VSS.n1601 VSS.n1600 0.231121
R2461 VSS.n1600 VSS.n1599 0.231121
R2462 VSS.n1599 VSS.n1598 0.231121
R2463 VSS.n1598 VSS.n1594 0.231121
R2464 VSS.n1594 VSS.n1593 0.231121
R2465 VSS.n1593 VSS.n1582 0.231121
R2466 VSS.n1582 VSS.n1581 0.231121
R2467 VSS.n1580 VSS.n1577 0.231121
R2468 VSS.n1577 VSS.n1576 0.231121
R2469 VSS.n1576 VSS.n1575 0.231121
R2470 VSS.n1575 VSS.n190 0.231121
R2471 VSS.n190 VSS.n189 0.231121
R2472 VSS.n267 VSS.n189 0.231121
R2473 VSS.n268 VSS.n267 0.231121
R2474 VSS.n268 VSS.n266 0.231121
R2475 VSS.n266 VSS.n265 0.231121
R2476 VSS.n265 VSS.n264 0.231121
R2477 VSS.n264 VSS.n263 0.231121
R2478 VSS.n263 VSS.n244 0.231121
R2479 VSS.n254 VSS.n244 0.231121
R2480 VSS.n254 VSS.n253 0.231121
R2481 VSS.n1627 VSS.n1625 0.231121
R2482 VSS.n1625 VSS.n1624 0.231121
R2483 VSS.n1624 VSS.n1602 0.231121
R2484 VSS.n1691 VSS.n1602 0.231121
R2485 VSS.n1692 VSS.n1691 0.231121
R2486 VSS.n1692 VSS.n1592 0.231121
R2487 VSS.n1597 VSS.n1592 0.231121
R2488 VSS.n1597 VSS.n1595 0.231121
R2489 VSS.n1595 VSS.n1583 0.231121
R2490 VSS.n1704 VSS.n1583 0.231121
R2491 VSS.n1705 VSS.n1704 0.231121
R2492 VSS.n1668 VSS.n1638 0.231121
R2493 VSS.n1669 VSS.n1668 0.231121
R2494 VSS.n1669 VSS.n1618 0.231121
R2495 VSS.n1633 VSS.n1618 0.231121
R2496 VSS.n1633 VSS.n1631 0.231121
R2497 VSS.n1631 VSS.n1630 0.231121
R2498 VSS.n1518 VSS.n397 0.231121
R2499 VSS.n1513 VSS.n397 0.231121
R2500 VSS.n1513 VSS.n399 0.231121
R2501 VSS.n1505 VSS.n399 0.231121
R2502 VSS.n1505 VSS.n401 0.231121
R2503 VSS.n1501 VSS.n401 0.231121
R2504 VSS.n1501 VSS.n403 0.231121
R2505 VSS.n1493 VSS.n403 0.231121
R2506 VSS.n1493 VSS.n405 0.231121
R2507 VSS.n1489 VSS.n405 0.231121
R2508 VSS.n1489 VSS.n407 0.231121
R2509 VSS.n1482 VSS.n407 0.231121
R2510 VSS.n1482 VSS.n409 0.231121
R2511 VSS.n1478 VSS.n409 0.231121
R2512 VSS.n1478 VSS.n411 0.231121
R2513 VSS.n1470 VSS.n411 0.231121
R2514 VSS.n1470 VSS.n413 0.231121
R2515 VSS.n1466 VSS.n413 0.231121
R2516 VSS.n1466 VSS.n415 0.231121
R2517 VSS.n1459 VSS.n415 0.231121
R2518 VSS.n1459 VSS.n417 0.231121
R2519 VSS.n1455 VSS.n417 0.231121
R2520 VSS.n1455 VSS.n419 0.231121
R2521 VSS.n1447 VSS.n419 0.231121
R2522 VSS.n1447 VSS.n421 0.231121
R2523 VSS.n1443 VSS.n421 0.231121
R2524 VSS.n1443 VSS.n423 0.231121
R2525 VSS.n1435 VSS.n423 0.231121
R2526 VSS.n1435 VSS.n425 0.231121
R2527 VSS.n1431 VSS.n425 0.231121
R2528 VSS.n1431 VSS.n427 0.231121
R2529 VSS.n1424 VSS.n427 0.231121
R2530 VSS.n1424 VSS.n429 0.231121
R2531 VSS.n1420 VSS.n429 0.231121
R2532 VSS.n1420 VSS.n431 0.231121
R2533 VSS.n1412 VSS.n431 0.231121
R2534 VSS.n1412 VSS.n433 0.231121
R2535 VSS.n1408 VSS.n433 0.231121
R2536 VSS.n1408 VSS.n435 0.231121
R2537 VSS.n1401 VSS.n435 0.231121
R2538 VSS.n1401 VSS.n437 0.231121
R2539 VSS.n1397 VSS.n437 0.231121
R2540 VSS.n1397 VSS.n439 0.231121
R2541 VSS.n1389 VSS.n439 0.231121
R2542 VSS.n1389 VSS.n441 0.231121
R2543 VSS.n1385 VSS.n441 0.231121
R2544 VSS.n1385 VSS.n443 0.231121
R2545 VSS.n1377 VSS.n443 0.231121
R2546 VSS.n1377 VSS.n445 0.231121
R2547 VSS.n1373 VSS.n445 0.231121
R2548 VSS.n1373 VSS.n447 0.231121
R2549 VSS.n1366 VSS.n447 0.231121
R2550 VSS.n1366 VSS.n449 0.231121
R2551 VSS.n1362 VSS.n449 0.231121
R2552 VSS.n1362 VSS.n451 0.231121
R2553 VSS.n1354 VSS.n451 0.231121
R2554 VSS.n1354 VSS.n453 0.231121
R2555 VSS.n1350 VSS.n453 0.231121
R2556 VSS.n1350 VSS.n455 0.231121
R2557 VSS.n1343 VSS.n455 0.231121
R2558 VSS.n1343 VSS.n457 0.231121
R2559 VSS.n1339 VSS.n457 0.231121
R2560 VSS.n1339 VSS.n459 0.231121
R2561 VSS.n1331 VSS.n459 0.231121
R2562 VSS.n1331 VSS.n461 0.231121
R2563 VSS.n1327 VSS.n461 0.231121
R2564 VSS.n1327 VSS.n463 0.231121
R2565 VSS.n1319 VSS.n463 0.231121
R2566 VSS.n1319 VSS.n464 0.231121
R2567 VSS.n1315 VSS.n464 0.231121
R2568 VSS.n1315 VSS.n466 0.231121
R2569 VSS.n1307 VSS.n466 0.231121
R2570 VSS.n1307 VSS.n468 0.231121
R2571 VSS.n1303 VSS.n468 0.231121
R2572 VSS.n1303 VSS.n470 0.231121
R2573 VSS.n1295 VSS.n470 0.231121
R2574 VSS.n1295 VSS.n472 0.231121
R2575 VSS.n1291 VSS.n472 0.231121
R2576 VSS.n1975 VSS.n1974 0.231121
R2577 VSS.n1974 VSS.n1973 0.231121
R2578 VSS.n1973 VSS.n1972 0.231121
R2579 VSS.n1972 VSS.n1971 0.231121
R2580 VSS.n1971 VSS.n1970 0.231121
R2581 VSS.n1995 VSS.n1970 0.231121
R2582 VSS.n1996 VSS.n1995 0.231121
R2583 VSS.n1997 VSS.n1996 0.231121
R2584 VSS.n1997 VSS.n1969 0.231121
R2585 VSS.n1969 VSS.n1968 0.231121
R2586 VSS.n1968 VSS.n36 0.231121
R2587 VSS.n1937 VSS.n36 0.231121
R2588 VSS.n1937 VSS.n1936 0.231121
R2589 VSS.n1936 VSS.n1935 0.231121
R2590 VSS.n1935 VSS.n1934 0.231121
R2591 VSS.n1934 VSS.n1933 0.231121
R2592 VSS.n1933 VSS.n1932 0.231121
R2593 VSS.n1932 VSS.n1931 0.231121
R2594 VSS.n1931 VSS.n1930 0.231121
R2595 VSS.n1930 VSS.n1929 0.231121
R2596 VSS.n1929 VSS.n1928 0.231121
R2597 VSS.n1928 VSS.n64 0.231121
R2598 VSS.n1917 VSS.n64 0.231121
R2599 VSS.n1918 VSS.n1917 0.231121
R2600 VSS.n1918 VSS.n1916 0.231121
R2601 VSS.n1916 VSS.n1915 0.231121
R2602 VSS.n1915 VSS.n68 0.231121
R2603 VSS.n1905 VSS.n68 0.231121
R2604 VSS.n1905 VSS.n1904 0.231121
R2605 VSS.n1904 VSS.n1903 0.231121
R2606 VSS.n1903 VSS.n72 0.231121
R2607 VSS.n1893 VSS.n72 0.231121
R2608 VSS.n1893 VSS.n1892 0.231121
R2609 VSS.n1892 VSS.n1891 0.231121
R2610 VSS.n1891 VSS.n76 0.231121
R2611 VSS.n1881 VSS.n76 0.231121
R2612 VSS.n1881 VSS.n1880 0.231121
R2613 VSS.n1880 VSS.n1879 0.231121
R2614 VSS.n1879 VSS.n80 0.231121
R2615 VSS.n1869 VSS.n80 0.231121
R2616 VSS.n1869 VSS.n1868 0.231121
R2617 VSS.n1868 VSS.n1867 0.231121
R2618 VSS.n1867 VSS.n84 0.231121
R2619 VSS.n1517 VSS.n1515 0.231121
R2620 VSS.n1515 VSS.n1514 0.231121
R2621 VSS.n1514 VSS.n398 0.231121
R2622 VSS.n1504 VSS.n398 0.231121
R2623 VSS.n1504 VSS.n1503 0.231121
R2624 VSS.n1503 VSS.n1502 0.231121
R2625 VSS.n1502 VSS.n402 0.231121
R2626 VSS.n1492 VSS.n402 0.231121
R2627 VSS.n1492 VSS.n1491 0.231121
R2628 VSS.n1491 VSS.n1490 0.231121
R2629 VSS.n1490 VSS.n406 0.231121
R2630 VSS.n1481 VSS.n406 0.231121
R2631 VSS.n1481 VSS.n1480 0.231121
R2632 VSS.n1480 VSS.n1479 0.231121
R2633 VSS.n1479 VSS.n410 0.231121
R2634 VSS.n1469 VSS.n410 0.231121
R2635 VSS.n1469 VSS.n1468 0.231121
R2636 VSS.n1468 VSS.n1467 0.231121
R2637 VSS.n1467 VSS.n414 0.231121
R2638 VSS.n1458 VSS.n414 0.231121
R2639 VSS.n1458 VSS.n1457 0.231121
R2640 VSS.n1457 VSS.n1456 0.231121
R2641 VSS.n1456 VSS.n418 0.231121
R2642 VSS.n1446 VSS.n418 0.231121
R2643 VSS.n1446 VSS.n1445 0.231121
R2644 VSS.n1445 VSS.n1444 0.231121
R2645 VSS.n1444 VSS.n422 0.231121
R2646 VSS.n1434 VSS.n422 0.231121
R2647 VSS.n1434 VSS.n1433 0.231121
R2648 VSS.n1433 VSS.n1432 0.231121
R2649 VSS.n1432 VSS.n426 0.231121
R2650 VSS.n1423 VSS.n426 0.231121
R2651 VSS.n1423 VSS.n1422 0.231121
R2652 VSS.n1422 VSS.n1421 0.231121
R2653 VSS.n1421 VSS.n430 0.231121
R2654 VSS.n1411 VSS.n430 0.231121
R2655 VSS.n1411 VSS.n1410 0.231121
R2656 VSS.n1410 VSS.n1409 0.231121
R2657 VSS.n1409 VSS.n434 0.231121
R2658 VSS.n1400 VSS.n434 0.231121
R2659 VSS.n1400 VSS.n1399 0.231121
R2660 VSS.n1399 VSS.n1398 0.231121
R2661 VSS.n1398 VSS.n438 0.231121
R2662 VSS.n1388 VSS.n438 0.231121
R2663 VSS.n1388 VSS.n1387 0.231121
R2664 VSS.n1387 VSS.n1386 0.231121
R2665 VSS.n1386 VSS.n442 0.231121
R2666 VSS.n1376 VSS.n442 0.231121
R2667 VSS.n1376 VSS.n1375 0.231121
R2668 VSS.n1375 VSS.n1374 0.231121
R2669 VSS.n1374 VSS.n446 0.231121
R2670 VSS.n1365 VSS.n446 0.231121
R2671 VSS.n1365 VSS.n1364 0.231121
R2672 VSS.n1364 VSS.n1363 0.231121
R2673 VSS.n1363 VSS.n450 0.231121
R2674 VSS.n1353 VSS.n450 0.231121
R2675 VSS.n1353 VSS.n1352 0.231121
R2676 VSS.n1352 VSS.n1351 0.231121
R2677 VSS.n1351 VSS.n454 0.231121
R2678 VSS.n1342 VSS.n454 0.231121
R2679 VSS.n1342 VSS.n1341 0.231121
R2680 VSS.n1341 VSS.n1340 0.231121
R2681 VSS.n1340 VSS.n458 0.231121
R2682 VSS.n1330 VSS.n458 0.231121
R2683 VSS.n1330 VSS.n1329 0.231121
R2684 VSS.n1329 VSS.n1328 0.231121
R2685 VSS.n1328 VSS.n462 0.231121
R2686 VSS.n1318 VSS.n462 0.231121
R2687 VSS.n1318 VSS.n1317 0.231121
R2688 VSS.n1317 VSS.n1316 0.231121
R2689 VSS.n1316 VSS.n465 0.231121
R2690 VSS.n1306 VSS.n465 0.231121
R2691 VSS.n1306 VSS.n1305 0.231121
R2692 VSS.n1305 VSS.n1304 0.231121
R2693 VSS.n1304 VSS.n469 0.231121
R2694 VSS.n1294 VSS.n469 0.231121
R2695 VSS.n1294 VSS.n1293 0.231121
R2696 VSS.n1982 VSS.n1980 0.231121
R2697 VSS.n1984 VSS.n1982 0.231121
R2698 VSS.n1986 VSS.n1984 0.231121
R2699 VSS.n1988 VSS.n1986 0.231121
R2700 VSS.n1990 VSS.n1988 0.231121
R2701 VSS.n1992 VSS.n1990 0.231121
R2702 VSS.n1994 VSS.n1992 0.231121
R2703 VSS.n1994 VSS.n35 0.231121
R2704 VSS.n1998 VSS.n35 0.231121
R2705 VSS.n1998 VSS.n33 0.231121
R2706 VSS.n1967 VSS.n33 0.231121
R2707 VSS.n1967 VSS.n37 0.231121
R2708 VSS.n1938 VSS.n37 0.231121
R2709 VSS.n1938 VSS.n63 0.231121
R2710 VSS.n63 VSS.n61 0.231121
R2711 VSS.n61 VSS.n59 0.231121
R2712 VSS.n59 VSS.n57 0.231121
R2713 VSS.n57 VSS.n55 0.231121
R2714 VSS.n55 VSS.n54 0.231121
R2715 VSS.n54 VSS.n52 0.231121
R2716 VSS.n52 VSS.n50 0.231121
R2717 VSS.n1927 VSS.n50 0.231121
R2718 VSS.n1927 VSS.n1926 0.231121
R2719 VSS.n1926 VSS.n65 0.231121
R2720 VSS.n1919 VSS.n65 0.231121
R2721 VSS.n1919 VSS.n67 0.231121
R2722 VSS.n1914 VSS.n67 0.231121
R2723 VSS.n1914 VSS.n69 0.231121
R2724 VSS.n1906 VSS.n69 0.231121
R2725 VSS.n1906 VSS.n71 0.231121
R2726 VSS.n1902 VSS.n71 0.231121
R2727 VSS.n1902 VSS.n73 0.231121
R2728 VSS.n1894 VSS.n73 0.231121
R2729 VSS.n1894 VSS.n75 0.231121
R2730 VSS.n1890 VSS.n75 0.231121
R2731 VSS.n1890 VSS.n77 0.231121
R2732 VSS.n1882 VSS.n77 0.231121
R2733 VSS.n1882 VSS.n79 0.231121
R2734 VSS.n1878 VSS.n79 0.231121
R2735 VSS.n1878 VSS.n81 0.231121
R2736 VSS.n1870 VSS.n81 0.231121
R2737 VSS.n1870 VSS.n83 0.231121
R2738 VSS.n1866 VSS.n83 0.231121
R2739 VSS.n1866 VSS.n85 0.231121
R2740 VSS.n983 VSS.n754 0.231121
R2741 VSS.n983 VSS.n981 0.231121
R2742 VSS.n981 VSS.n979 0.231121
R2743 VSS.n979 VSS.n757 0.231121
R2744 VSS.n974 VSS.n757 0.231121
R2745 VSS.n974 VSS.n972 0.231121
R2746 VSS.n972 VSS.n970 0.231121
R2747 VSS.n970 VSS.n760 0.231121
R2748 VSS.n965 VSS.n760 0.231121
R2749 VSS.n965 VSS.n963 0.231121
R2750 VSS.n963 VSS.n961 0.231121
R2751 VSS.n961 VSS.n763 0.231121
R2752 VSS.n956 VSS.n763 0.231121
R2753 VSS.n956 VSS.n954 0.231121
R2754 VSS.n954 VSS.n952 0.231121
R2755 VSS.n952 VSS.n766 0.231121
R2756 VSS.n947 VSS.n766 0.231121
R2757 VSS.n947 VSS.n945 0.231121
R2758 VSS.n945 VSS.n943 0.231121
R2759 VSS.n943 VSS.n768 0.231121
R2760 VSS.n938 VSS.n768 0.231121
R2761 VSS.n938 VSS.n936 0.231121
R2762 VSS.n936 VSS.n934 0.231121
R2763 VSS.n934 VSS.n771 0.231121
R2764 VSS.n929 VSS.n771 0.231121
R2765 VSS.n929 VSS.n927 0.231121
R2766 VSS.n927 VSS.n925 0.231121
R2767 VSS.n925 VSS.n774 0.231121
R2768 VSS.n920 VSS.n774 0.231121
R2769 VSS.n920 VSS.n918 0.231121
R2770 VSS.n918 VSS.n917 0.231121
R2771 VSS.n917 VSS.n777 0.231121
R2772 VSS.n912 VSS.n777 0.231121
R2773 VSS.n912 VSS.n910 0.231121
R2774 VSS.n910 VSS.n908 0.231121
R2775 VSS.n908 VSS.n780 0.231121
R2776 VSS.n903 VSS.n780 0.231121
R2777 VSS.n903 VSS.n901 0.231121
R2778 VSS.n901 VSS.n899 0.231121
R2779 VSS.n899 VSS.n783 0.231121
R2780 VSS.n894 VSS.n783 0.231121
R2781 VSS.n894 VSS.n892 0.231121
R2782 VSS.n892 VSS.n890 0.231121
R2783 VSS.n890 VSS.n786 0.231121
R2784 VSS.n885 VSS.n786 0.231121
R2785 VSS.n885 VSS.n883 0.231121
R2786 VSS.n883 VSS.n881 0.231121
R2787 VSS.n881 VSS.n789 0.231121
R2788 VSS.n876 VSS.n789 0.231121
R2789 VSS.n876 VSS.n875 0.231121
R2790 VSS.n875 VSS.n873 0.231121
R2791 VSS.n873 VSS.n792 0.231121
R2792 VSS.n868 VSS.n792 0.231121
R2793 VSS.n868 VSS.n866 0.231121
R2794 VSS.n866 VSS.n864 0.231121
R2795 VSS.n864 VSS.n795 0.231121
R2796 VSS.n859 VSS.n795 0.231121
R2797 VSS.n859 VSS.n857 0.231121
R2798 VSS.n857 VSS.n855 0.231121
R2799 VSS.n855 VSS.n798 0.231121
R2800 VSS.n851 VSS.n798 0.231121
R2801 VSS.n851 VSS.n849 0.231121
R2802 VSS.n849 VSS.n847 0.231121
R2803 VSS.n847 VSS.n801 0.231121
R2804 VSS.n842 VSS.n801 0.231121
R2805 VSS.n842 VSS.n840 0.231121
R2806 VSS.n840 VSS.n838 0.231121
R2807 VSS.n838 VSS.n804 0.231121
R2808 VSS.n833 VSS.n804 0.231121
R2809 VSS.n833 VSS.n831 0.231121
R2810 VSS.n831 VSS.n829 0.231121
R2811 VSS.n829 VSS.n807 0.231121
R2812 VSS.n824 VSS.n807 0.231121
R2813 VSS.n824 VSS.n822 0.231121
R2814 VSS.n822 VSS.n820 0.231121
R2815 VSS.n820 VSS.n810 0.231121
R2816 VSS.n815 VSS.n810 0.231121
R2817 VSS.n815 VSS.n813 0.231121
R2818 VSS.n985 VSS.n984 0.231121
R2819 VSS.n984 VSS.n755 0.231121
R2820 VSS.n977 VSS.n755 0.231121
R2821 VSS.n977 VSS.n976 0.231121
R2822 VSS.n976 VSS.n975 0.231121
R2823 VSS.n975 VSS.n758 0.231121
R2824 VSS.n968 VSS.n758 0.231121
R2825 VSS.n968 VSS.n967 0.231121
R2826 VSS.n967 VSS.n966 0.231121
R2827 VSS.n966 VSS.n761 0.231121
R2828 VSS.n959 VSS.n761 0.231121
R2829 VSS.n959 VSS.n958 0.231121
R2830 VSS.n958 VSS.n957 0.231121
R2831 VSS.n957 VSS.n764 0.231121
R2832 VSS.n950 VSS.n764 0.231121
R2833 VSS.n950 VSS.n949 0.231121
R2834 VSS.n949 VSS.n948 0.231121
R2835 VSS.n948 VSS.n767 0.231121
R2836 VSS.n941 VSS.n767 0.231121
R2837 VSS.n941 VSS.n940 0.231121
R2838 VSS.n940 VSS.n939 0.231121
R2839 VSS.n939 VSS.n769 0.231121
R2840 VSS.n932 VSS.n769 0.231121
R2841 VSS.n932 VSS.n931 0.231121
R2842 VSS.n931 VSS.n930 0.231121
R2843 VSS.n930 VSS.n772 0.231121
R2844 VSS.n923 VSS.n772 0.231121
R2845 VSS.n923 VSS.n922 0.231121
R2846 VSS.n922 VSS.n921 0.231121
R2847 VSS.n921 VSS.n775 0.231121
R2848 VSS.n915 VSS.n775 0.231121
R2849 VSS.n915 VSS.n914 0.231121
R2850 VSS.n914 VSS.n913 0.231121
R2851 VSS.n913 VSS.n778 0.231121
R2852 VSS.n906 VSS.n778 0.231121
R2853 VSS.n906 VSS.n905 0.231121
R2854 VSS.n905 VSS.n904 0.231121
R2855 VSS.n904 VSS.n781 0.231121
R2856 VSS.n897 VSS.n781 0.231121
R2857 VSS.n897 VSS.n896 0.231121
R2858 VSS.n896 VSS.n895 0.231121
R2859 VSS.n895 VSS.n784 0.231121
R2860 VSS.n888 VSS.n784 0.231121
R2861 VSS.n888 VSS.n887 0.231121
R2862 VSS.n887 VSS.n886 0.231121
R2863 VSS.n886 VSS.n787 0.231121
R2864 VSS.n879 VSS.n787 0.231121
R2865 VSS.n879 VSS.n878 0.231121
R2866 VSS.n878 VSS.n877 0.231121
R2867 VSS.n877 VSS.n790 0.231121
R2868 VSS.n871 VSS.n790 0.231121
R2869 VSS.n871 VSS.n870 0.231121
R2870 VSS.n870 VSS.n869 0.231121
R2871 VSS.n869 VSS.n793 0.231121
R2872 VSS.n862 VSS.n793 0.231121
R2873 VSS.n862 VSS.n861 0.231121
R2874 VSS.n861 VSS.n860 0.231121
R2875 VSS.n860 VSS.n796 0.231121
R2876 VSS.n854 VSS.n796 0.231121
R2877 VSS.n854 VSS.n853 0.231121
R2878 VSS.n853 VSS.n852 0.231121
R2879 VSS.n852 VSS.n799 0.231121
R2880 VSS.n845 VSS.n799 0.231121
R2881 VSS.n845 VSS.n844 0.231121
R2882 VSS.n844 VSS.n843 0.231121
R2883 VSS.n843 VSS.n802 0.231121
R2884 VSS.n836 VSS.n802 0.231121
R2885 VSS.n836 VSS.n835 0.231121
R2886 VSS.n835 VSS.n834 0.231121
R2887 VSS.n834 VSS.n805 0.231121
R2888 VSS.n827 VSS.n805 0.231121
R2889 VSS.n827 VSS.n826 0.231121
R2890 VSS.n826 VSS.n825 0.231121
R2891 VSS.n825 VSS.n808 0.231121
R2892 VSS.n818 VSS.n808 0.231121
R2893 VSS.n818 VSS.n817 0.231121
R2894 VSS.n817 VSS.n816 0.231121
R2895 VSS VSS.n2006 0.226636
R2896 VSS.n363 VSS.n361 0.225674
R2897 VSS.n1525 VSS.n1524 0.225607
R2898 VSS.n361 VSS.n357 0.219424
R2899 VSS.n1058 VSS.n1055 0.218898
R2900 VSS.n1055 VSS.n1054 0.218898
R2901 VSS.n1542 VSS.n1541 0.218898
R2902 VSS.n1539 VSS.n1538 0.20686
R2903 VSS.n1522 VSS.n1521 0.195641
R2904 VSS.n1523 VSS.n1522 0.195641
R2905 VSS.n1524 VSS.n1523 0.195641
R2906 VSS.n1529 VSS.n1528 0.195641
R2907 VSS.n1530 VSS.n1529 0.195641
R2908 VSS.n1531 VSS.n1530 0.195641
R2909 VSS.n1286 VSS.n1285 0.194315
R2910 VSS.n1251 VSS.n1249 0.194315
R2911 VSS.t146 VSS.n15 0.191235
R2912 VSS.n367 VSS.n366 0.191235
R2913 VSS.t140 VSS.n19 0.191235
R2914 VSS.n1644 VSS.n1643 0.191235
R2915 VSS.n1611 VSS.n1610 0.191235
R2916 VSS.n1570 VSS.n1569 0.191235
R2917 VSS.n1571 VSS.n1570 0.191235
R2918 VSS.t160 VSS.t158 0.1875
R2919 VSS.t154 VSS.t152 0.1875
R2920 VSS.n1285 VSS.n473 0.187025
R2921 VSS.n1274 VSS.n473 0.187025
R2922 VSS.n1277 VSS.n1276 0.187025
R2923 VSS.n1267 VSS.n1265 0.187025
R2924 VSS.n1265 VSS.n1263 0.187025
R2925 VSS.n1263 VSS.n1261 0.187025
R2926 VSS.n1261 VSS.n1259 0.187025
R2927 VSS.n1259 VSS.n1257 0.187025
R2928 VSS.n1257 VSS.n1255 0.187025
R2929 VSS.n1255 VSS.n1253 0.187025
R2930 VSS.n1253 VSS.n1251 0.187025
R2931 VSS.n1564 VSS.n112 0.180041
R2932 VSS.t138 VSS.n14 0.167615
R2933 VSS.n1538 VSS.n332 0.16726
R2934 VSS.n1533 VSS.n1532 0.164835
R2935 VSS.n1526 VSS.n365 0.156138
R2936 VSS.n1554 VSS.n1553 0.147398
R2937 VSS.n1053 VSS.n1050 0.146155
R2938 VSS.n1050 VSS.n1049 0.146155
R2939 VSS.n1049 VSS.n1027 0.146155
R2940 VSS.n1043 VSS.n1027 0.146155
R2941 VSS.n1043 VSS.n1040 0.146155
R2942 VSS.n1040 VSS.n1039 0.146155
R2943 VSS.n1039 VSS.n1029 0.146155
R2944 VSS.n1034 VSS.n1029 0.146155
R2945 VSS.n1034 VSS.n1007 0.146155
R2946 VSS.n1235 VSS.n1007 0.146155
R2947 VSS.n1236 VSS.n1235 0.146155
R2948 VSS.n1236 VSS.n750 0.146155
R2949 VSS.n1002 VSS.n750 0.146155
R2950 VSS.n1002 VSS.n1000 0.146155
R2951 VSS.n1000 VSS.n999 0.146155
R2952 VSS.n999 VSS.n752 0.146155
R2953 VSS.n993 VSS.n752 0.146155
R2954 VSS.n993 VSS.n991 0.146155
R2955 VSS.n991 VSS.n990 0.146155
R2956 VSS.n1140 VSS.n1139 0.146155
R2957 VSS.n1139 VSS.n1138 0.146155
R2958 VSS.n1138 VSS.n1137 0.146155
R2959 VSS.n1137 VSS.n1133 0.146155
R2960 VSS.n1133 VSS.n1132 0.146155
R2961 VSS.n1132 VSS.n1131 0.146155
R2962 VSS.n1131 VSS.n1130 0.146155
R2963 VSS.n1130 VSS.n1124 0.146155
R2964 VSS.n1124 VSS.n1123 0.146155
R2965 VSS.n1123 VSS.n1122 0.146155
R2966 VSS.n1122 VSS.n1121 0.146155
R2967 VSS.n1121 VSS.n1117 0.146155
R2968 VSS.n1117 VSS.n1116 0.146155
R2969 VSS.n1116 VSS.n1115 0.146155
R2970 VSS.n1115 VSS.n1114 0.146155
R2971 VSS.n1114 VSS.n1110 0.146155
R2972 VSS.n1110 VSS.n1109 0.146155
R2973 VSS.n1109 VSS.n1108 0.146155
R2974 VSS.n1108 VSS.n1107 0.146155
R2975 VSS.n1107 VSS.n1102 0.146155
R2976 VSS.n1102 VSS.n1101 0.146155
R2977 VSS.n1101 VSS.n1100 0.146155
R2978 VSS.n1100 VSS.n1095 0.146155
R2979 VSS.n1095 VSS.n1094 0.146155
R2980 VSS.n1094 VSS.n1093 0.146155
R2981 VSS.n1093 VSS.n1092 0.146155
R2982 VSS.n1092 VSS.n1091 0.146155
R2983 VSS.n1091 VSS.n1086 0.146155
R2984 VSS.n1086 VSS.n1085 0.146155
R2985 VSS.n1085 VSS.n1084 0.146155
R2986 VSS.n1084 VSS.n1083 0.146155
R2987 VSS.n1083 VSS.n1078 0.146155
R2988 VSS.n1078 VSS.n1077 0.146155
R2989 VSS.n1077 VSS.n1076 0.146155
R2990 VSS.n1076 VSS.n1075 0.146155
R2991 VSS.n1075 VSS.n1069 0.146155
R2992 VSS.n1069 VSS.n1068 0.146155
R2993 VSS.n1068 VSS.n1067 0.146155
R2994 VSS.n1067 VSS.n1062 0.146155
R2995 VSS.n1062 VSS.n1061 0.146155
R2996 VSS.n1061 VSS.n1060 0.146155
R2997 VSS.n1060 VSS.n1059 0.146155
R2998 VSS.n1059 VSS.n1058 0.146155
R2999 VSS.n1054 VSS.n1026 0.146155
R3000 VSS.n1046 VSS.n1026 0.146155
R3001 VSS.n1046 VSS.n1045 0.146155
R3002 VSS.n1045 VSS.n1044 0.146155
R3003 VSS.n1044 VSS.n1028 0.146155
R3004 VSS.n1030 VSS.n1028 0.146155
R3005 VSS.n1032 VSS.n1030 0.146155
R3006 VSS.n1033 VSS.n1032 0.146155
R3007 VSS.n1033 VSS.n1031 0.146155
R3008 VSS.n1031 VSS.n1006 0.146155
R3009 VSS.n1006 VSS.n1005 0.146155
R3010 VSS.n1005 VSS.n1004 0.146155
R3011 VSS.n1004 VSS.n1003 0.146155
R3012 VSS.n1003 VSS.n751 0.146155
R3013 VSS.n996 VSS.n751 0.146155
R3014 VSS.n996 VSS.n995 0.146155
R3015 VSS.n995 VSS.n994 0.146155
R3016 VSS.n994 VSS.n753 0.146155
R3017 VSS.n986 VSS.n753 0.146155
R3018 VSS.n1175 VSS.n1174 0.146155
R3019 VSS.n1176 VSS.n1175 0.146155
R3020 VSS.n1176 VSS.n1135 0.146155
R3021 VSS.n1135 VSS.n1134 0.146155
R3022 VSS.n1181 VSS.n1134 0.146155
R3023 VSS.n1182 VSS.n1181 0.146155
R3024 VSS.n1182 VSS.n1127 0.146155
R3025 VSS.n1127 VSS.n1125 0.146155
R3026 VSS.n1185 VSS.n1125 0.146155
R3027 VSS.n1186 VSS.n1185 0.146155
R3028 VSS.n1186 VSS.n1119 0.146155
R3029 VSS.n1119 VSS.n1118 0.146155
R3030 VSS.n1192 VSS.n1118 0.146155
R3031 VSS.n1193 VSS.n1192 0.146155
R3032 VSS.n1193 VSS.n1112 0.146155
R3033 VSS.n1112 VSS.n1111 0.146155
R3034 VSS.n1199 VSS.n1111 0.146155
R3035 VSS.n1200 VSS.n1199 0.146155
R3036 VSS.n1200 VSS.n1105 0.146155
R3037 VSS.n1105 VSS.n1103 0.146155
R3038 VSS.n1206 VSS.n1103 0.146155
R3039 VSS.n1207 VSS.n1206 0.146155
R3040 VSS.n1207 VSS.n1096 0.146155
R3041 VSS.n1209 VSS.n1096 0.146155
R3042 VSS.n1210 VSS.n1209 0.146155
R3043 VSS.n1211 VSS.n1210 0.146155
R3044 VSS.n1211 VSS.n1089 0.146155
R3045 VSS.n1089 VSS.n1087 0.146155
R3046 VSS.n1215 VSS.n1087 0.146155
R3047 VSS.n1216 VSS.n1215 0.146155
R3048 VSS.n1216 VSS.n1080 0.146155
R3049 VSS.n1080 VSS.n1079 0.146155
R3050 VSS.n1218 VSS.n1079 0.146155
R3051 VSS.n1219 VSS.n1218 0.146155
R3052 VSS.n1219 VSS.n1072 0.146155
R3053 VSS.n1072 VSS.n1070 0.146155
R3054 VSS.n1222 VSS.n1070 0.146155
R3055 VSS.n1223 VSS.n1222 0.146155
R3056 VSS.n1223 VSS.n1063 0.146155
R3057 VSS.n1226 VSS.n1063 0.146155
R3058 VSS.n1227 VSS.n1226 0.146155
R3059 VSS.n1228 VSS.n1227 0.146155
R3060 VSS.n1228 VSS.n1025 0.146155
R3061 VSS.n1057 VSS.n1025 0.146155
R3062 VSS.n1550 VSS.n323 0.146155
R3063 VSS.n1547 VSS.n324 0.146155
R3064 VSS.n1543 VSS.n324 0.146155
R3065 VSS.n1543 VSS.n1542 0.146155
R3066 VSS.n371 VSS.n327 0.146155
R3067 VSS.n371 VSS.n370 0.146155
R3068 VSS.n380 VSS.n370 0.146155
R3069 VSS.n375 VSS.n372 0.146155
R3070 VSS.n376 VSS.n375 0.146155
R3071 VSS.n379 VSS.n376 0.146155
R3072 VSS.n382 VSS.n369 0.146155
R3073 VSS.n1546 VSS.n1545 0.146155
R3074 VSS.n1545 VSS.n1544 0.146155
R3075 VSS.n1544 VSS.n326 0.146155
R3076 VSS.n1572 VSS.n1571 0.145118
R3077 VSS.n1776 VSS.n1764 0.143368
R3078 VSS.n1782 VSS.n1781 0.143368
R3079 VSS.n1785 VSS.n1761 0.143368
R3080 VSS.n1789 VSS.n1757 0.143368
R3081 VSS.n1793 VSS.n1756 0.143368
R3082 VSS.n1800 VSS.n1799 0.143368
R3083 VSS.n1808 VSS.n1751 0.143368
R3084 VSS.n1810 VSS.n1809 0.143368
R3085 VSS.n1816 VSS.n1815 0.143368
R3086 VSS.n1855 VSS.n1854 0.143368
R3087 VSS.n171 VSS.n169 0.143368
R3088 VSS.n1741 VSS.n166 0.143368
R3089 VSS.n1739 VSS.n164 0.143368
R3090 VSS.n178 VSS.n161 0.143368
R3091 VSS.n176 VSS.n158 0.143368
R3092 VSS.n1733 VSS.n155 0.143368
R3093 VSS.n1731 VSS.n153 0.143368
R3094 VSS.n182 VSS.n150 0.143368
R3095 VSS.n180 VSS.n148 0.143368
R3096 VSS.n1725 VSS.n145 0.143368
R3097 VSS.n184 VSS.n140 0.143368
R3098 VSS.n279 VSS.n137 0.143368
R3099 VSS.n278 VSS.n134 0.143368
R3100 VSS.n236 VSS.n127 0.143368
R3101 VSS.n235 VSS.n125 0.143368
R3102 VSS.n1979 VSS.n23 0.143368
R3103 VSS.n1985 VSS.n25 0.143368
R3104 VSS.n1987 VSS.n26 0.143368
R3105 VSS.n1989 VSS.n28 0.143368
R3106 VSS.n34 VSS.n30 0.143368
R3107 VSS.n1999 VSS.n31 0.143368
R3108 VSS.n2000 VSS.n32 0.143368
R3109 VSS.n1966 VSS.n1965 0.143368
R3110 VSS.n1940 VSS.n38 0.143368
R3111 VSS.n1946 VSS.n1945 0.143368
R3112 VSS.n1948 VSS.n1947 0.143368
R3113 VSS.n1950 VSS.n1949 0.143368
R3114 VSS.n1956 VSS.n1955 0.143368
R3115 VSS.n1958 VSS.n1957 0.143368
R3116 VSS.n1923 VSS.n1922 0.143368
R3117 VSS.n1921 VSS.n1920 0.143368
R3118 VSS.n1911 VSS.n66 0.143368
R3119 VSS.n1913 VSS.n1912 0.143368
R3120 VSS.n1910 VSS.n1909 0.143368
R3121 VSS.n1908 VSS.n1907 0.143368
R3122 VSS.n1899 VSS.n70 0.143368
R3123 VSS.n1901 VSS.n1900 0.143368
R3124 VSS.n1898 VSS.n1897 0.143368
R3125 VSS.n1896 VSS.n1895 0.143368
R3126 VSS.n1887 VSS.n74 0.143368
R3127 VSS.n1889 VSS.n1888 0.143368
R3128 VSS.n1886 VSS.n1885 0.143368
R3129 VSS.n1884 VSS.n1883 0.143368
R3130 VSS.n1875 VSS.n78 0.143368
R3131 VSS.n1877 VSS.n1876 0.143368
R3132 VSS.n1874 VSS.n1873 0.143368
R3133 VSS.n1872 VSS.n1871 0.143368
R3134 VSS.n1863 VSS.n82 0.143368
R3135 VSS.n1865 VSS.n1864 0.143368
R3136 VSS.n1862 VSS.n1861 0.143368
R3137 VSS.n1512 VSS.n1511 0.143368
R3138 VSS.n1509 VSS.n1508 0.143368
R3139 VSS.n1507 VSS.n1506 0.143368
R3140 VSS.n1498 VSS.n400 0.143368
R3141 VSS.n1500 VSS.n1499 0.143368
R3142 VSS.n1497 VSS.n1496 0.143368
R3143 VSS.n1495 VSS.n1494 0.143368
R3144 VSS.n1488 VSS.n404 0.143368
R3145 VSS.n1484 VSS.n1483 0.143368
R3146 VSS.n1475 VSS.n408 0.143368
R3147 VSS.n1477 VSS.n1476 0.143368
R3148 VSS.n1474 VSS.n1473 0.143368
R3149 VSS.n1472 VSS.n1471 0.143368
R3150 VSS.n1463 VSS.n412 0.143368
R3151 VSS.n1465 VSS.n1464 0.143368
R3152 VSS.n1462 VSS.n1461 0.143368
R3153 VSS.n1454 VSS.n1453 0.143368
R3154 VSS.n1451 VSS.n1450 0.143368
R3155 VSS.n1449 VSS.n1448 0.143368
R3156 VSS.n1440 VSS.n420 0.143368
R3157 VSS.n1442 VSS.n1441 0.143368
R3158 VSS.n1439 VSS.n1438 0.143368
R3159 VSS.n1437 VSS.n1436 0.143368
R3160 VSS.n1430 VSS.n424 0.143368
R3161 VSS.n1428 VSS.n1427 0.143368
R3162 VSS.n1426 VSS.n1425 0.143368
R3163 VSS.n1417 VSS.n428 0.143368
R3164 VSS.n1419 VSS.n1418 0.143368
R3165 VSS.n1416 VSS.n1415 0.143368
R3166 VSS.n1414 VSS.n1413 0.143368
R3167 VSS.n1405 VSS.n432 0.143368
R3168 VSS.n1407 VSS.n1406 0.143368
R3169 VSS.n1394 VSS.n436 0.143368
R3170 VSS.n1396 VSS.n1395 0.143368
R3171 VSS.n1393 VSS.n1392 0.143368
R3172 VSS.n1391 VSS.n1390 0.143368
R3173 VSS.n1382 VSS.n440 0.143368
R3174 VSS.n1384 VSS.n1383 0.143368
R3175 VSS.n1381 VSS.n1380 0.143368
R3176 VSS.n1379 VSS.n1378 0.143368
R3177 VSS.n1370 VSS.n1369 0.143368
R3178 VSS.n1368 VSS.n1367 0.143368
R3179 VSS.n1359 VSS.n448 0.143368
R3180 VSS.n1361 VSS.n1360 0.143368
R3181 VSS.n1358 VSS.n1357 0.143368
R3182 VSS.n1356 VSS.n1355 0.143368
R3183 VSS.n1347 VSS.n452 0.143368
R3184 VSS.n1349 VSS.n1348 0.143368
R3185 VSS.n1345 VSS.n1344 0.143368
R3186 VSS.n1336 VSS.n456 0.143368
R3187 VSS.n1338 VSS.n1337 0.143368
R3188 VSS.n1335 VSS.n1334 0.143368
R3189 VSS.n1333 VSS.n1332 0.143368
R3190 VSS.n1324 VSS.n460 0.143368
R3191 VSS.n1326 VSS.n1325 0.143368
R3192 VSS.n1323 VSS.n1322 0.143368
R3193 VSS.n1321 VSS.n1320 0.143368
R3194 VSS.n1314 VSS.n1313 0.143368
R3195 VSS.n1311 VSS.n1310 0.143368
R3196 VSS.n1309 VSS.n1308 0.143368
R3197 VSS.n1300 VSS.n467 0.143368
R3198 VSS.n1302 VSS.n1301 0.143368
R3199 VSS.n1299 VSS.n1298 0.143368
R3200 VSS.n1297 VSS.n1296 0.143368
R3201 VSS.n1290 VSS.n471 0.143368
R3202 VSS.n980 VSS.n498 0.143368
R3203 VSS.n978 VSS.n501 0.143368
R3204 VSS.n756 VSS.n504 0.143368
R3205 VSS.n973 VSS.n507 0.143368
R3206 VSS.n971 VSS.n510 0.143368
R3207 VSS.n969 VSS.n514 0.143368
R3208 VSS.n759 VSS.n517 0.143368
R3209 VSS.n964 VSS.n520 0.143368
R3210 VSS.n762 VSS.n528 0.143368
R3211 VSS.n955 VSS.n531 0.143368
R3212 VSS.n953 VSS.n534 0.143368
R3213 VSS.n951 VSS.n537 0.143368
R3214 VSS.n765 VSS.n540 0.143368
R3215 VSS.n946 VSS.n541 0.143368
R3216 VSS.n944 VSS.n542 0.143368
R3217 VSS.n942 VSS.n543 0.143368
R3218 VSS.n935 VSS.n545 0.143368
R3219 VSS.n933 VSS.n546 0.143368
R3220 VSS.n770 VSS.n547 0.143368
R3221 VSS.n928 VSS.n548 0.143368
R3222 VSS.n926 VSS.n549 0.143368
R3223 VSS.n924 VSS.n550 0.143368
R3224 VSS.n773 VSS.n551 0.143368
R3225 VSS.n919 VSS.n552 0.143368
R3226 VSS.n916 VSS.n554 0.143368
R3227 VSS.n776 VSS.n555 0.143368
R3228 VSS.n911 VSS.n556 0.143368
R3229 VSS.n909 VSS.n557 0.143368
R3230 VSS.n907 VSS.n558 0.143368
R3231 VSS.n779 VSS.n560 0.143368
R3232 VSS.n902 VSS.n563 0.143368
R3233 VSS.n900 VSS.n566 0.143368
R3234 VSS.n893 VSS.n574 0.143368
R3235 VSS.n891 VSS.n577 0.143368
R3236 VSS.n889 VSS.n580 0.143368
R3237 VSS.n785 VSS.n583 0.143368
R3238 VSS.n884 VSS.n586 0.143368
R3239 VSS.n882 VSS.n590 0.143368
R3240 VSS.n880 VSS.n593 0.143368
R3241 VSS.n788 VSS.n596 0.143368
R3242 VSS.n872 VSS.n604 0.143368
R3243 VSS.n791 VSS.n607 0.143368
R3244 VSS.n867 VSS.n610 0.143368
R3245 VSS.n865 VSS.n613 0.143368
R3246 VSS.n863 VSS.n616 0.143368
R3247 VSS.n794 VSS.n617 0.143368
R3248 VSS.n858 VSS.n618 0.143368
R3249 VSS.n856 VSS.n619 0.143368
R3250 VSS.n797 VSS.n621 0.143368
R3251 VSS.n850 VSS.n622 0.143368
R3252 VSS.n848 VSS.n623 0.143368
R3253 VSS.n846 VSS.n624 0.143368
R3254 VSS.n800 VSS.n625 0.143368
R3255 VSS.n841 VSS.n627 0.143368
R3256 VSS.n839 VSS.n630 0.143368
R3257 VSS.n837 VSS.n633 0.143368
R3258 VSS.n803 VSS.n636 0.143368
R3259 VSS.n830 VSS.n641 0.143368
R3260 VSS.n828 VSS.n644 0.143368
R3261 VSS.n806 VSS.n647 0.143368
R3262 VSS.n823 VSS.n650 0.143368
R3263 VSS.n821 VSS.n653 0.143368
R3264 VSS.n819 VSS.n654 0.143368
R3265 VSS.n809 VSS.n655 0.143368
R3266 VSS.n814 VSS.n656 0.143368
R3267 VSS.n1655 VSS.n1644 0.143368
R3268 VSS.n1667 VSS.n1617 0.143368
R3269 VSS.n1671 VSS.n1670 0.143368
R3270 VSS.n1616 VSS.n1614 0.143368
R3271 VSS.n1632 VSS.n1613 0.143368
R3272 VSS.n1620 VSS.n1611 0.143368
R3273 VSS.n1608 VSS.n1606 0.143368
R3274 VSS.n1689 VSS.n1688 0.143368
R3275 VSS.n1690 VSS.n1591 0.143368
R3276 VSS.n1694 VSS.n1693 0.143368
R3277 VSS.n1590 VSS.n1588 0.143368
R3278 VSS.n1701 VSS.n1700 0.143368
R3279 VSS.n1703 VSS.n1702 0.143368
R3280 VSS.n1706 VSS.n1579 0.143368
R3281 VSS.n1710 VSS.n1709 0.143368
R3282 VSS.n1713 VSS.n1574 0.143368
R3283 VSS.n1715 VSS.n1714 0.143368
R3284 VSS.n1717 VSS.n1716 0.143368
R3285 VSS.n269 VSS.n202 0.143368
R3286 VSS.n271 VSS.n204 0.143368
R3287 VSS.n261 VSS.n210 0.143368
R3288 VSS.n259 VSS.n212 0.143368
R3289 VSS.n230 VSS.n117 0.143368
R3290 VSS.t13 VSS.n1746 0.143368
R3291 VSS.t11 VSS.t12 0.143368
R3292 VSS.n1753 VSS.n1752 0.143368
R3293 VSS.t9 VSS.t10 0.143368
R3294 VSS.t7 VSS.t8 0.143368
R3295 VSS.n1766 VSS.t146 0.143368
R3296 VSS.t4 VSS.n1765 0.143368
R3297 VSS.t5 VSS.n1612 0.143368
R3298 VSS.n1510 VSS.t45 0.143368
R3299 VSS.t50 VSS.n1429 0.143368
R3300 VSS.n1346 VSS.t56 0.143368
R3301 VSS.n1312 VSS.t58 0.143368
R3302 VSS.n982 VSS.t30 0.143368
R3303 VSS.t34 VSS.n553 0.143368
R3304 VSS.t40 VSS.n620 0.143368
R3305 VSS.n832 VSS.t42 0.143368
R3306 VSS.n1568 VSS.n1567 0.142388
R3307 VSS.n224 VSS.n221 0.142012
R3308 VSS.n228 VSS.n221 0.138262
R3309 VSS.n1860 VSS.n1859 0.128368
R3310 VSS.n329 VSS.n318 0.120892
R3311 VSS.n1014 VSS.n1012 0.120892
R3312 VSS.n1015 VSS.n1014 0.120892
R3313 VSS.n1549 VSS.n1548 0.1205
R3314 VSS.n325 VSS.n304 0.1205
R3315 VSS.n374 VSS.n373 0.1205
R3316 VSS.n378 VSS.n377 0.1205
R3317 VSS.n381 VSS.t101 0.1205
R3318 VSS.n1173 VSS.n1172 0.1205
R3319 VSS.n1177 VSS.n1136 0.1205
R3320 VSS.n1180 VSS.n1179 0.1205
R3321 VSS.n1184 VSS.n1126 0.1205
R3322 VSS.n1188 VSS.n1187 0.1205
R3323 VSS.n1191 VSS.n1190 0.1205
R3324 VSS.n1195 VSS.n1194 0.1205
R3325 VSS.n1198 VSS.n1197 0.1205
R3326 VSS.n1202 VSS.n1201 0.1205
R3327 VSS.n1205 VSS.n1204 0.1205
R3328 VSS.n1208 VSS.t62 0.1205
R3329 VSS.n1212 VSS.n1090 0.1205
R3330 VSS.n1214 VSS.n1088 0.1205
R3331 VSS.n1217 VSS.n1081 0.1205
R3332 VSS.n1220 VSS.n1073 0.1205
R3333 VSS.n1225 VSS.n1224 0.1205
R3334 VSS.n1056 VSS.n1022 0.1205
R3335 VSS.n1052 VSS.n1051 0.1205
R3336 VSS.n1048 VSS.n1047 0.1205
R3337 VSS.n1042 VSS.n1041 0.1205
R3338 VSS.n1038 VSS.n1037 0.1205
R3339 VSS.n1035 VSS.n1008 0.1205
R3340 VSS.t87 VSS.n747 0.1205
R3341 VSS.n998 VSS.n997 0.1205
R3342 VSS.t93 VSS.n304 0.1205
R3343 VSS.t74 VSS.n1071 0.1205
R3344 VSS.n1081 VSS.t123 0.1205
R3345 VSS.n1088 VSS.t21 0.1205
R3346 VSS.t62 VSS.n1098 0.1205
R3347 VSS.n1126 VSS.t121 0.1205
R3348 VSS.n1128 VSS.t19 0.1205
R3349 VSS.n1073 VSS.t66 0.1205
R3350 VSS.t86 VSS.n1024 0.1205
R3351 VSS.t91 VSS.n1022 0.1205
R3352 VSS.t82 VSS.n1001 0.1205
R3353 VSS.t84 VSS.n992 0.1205
R3354 VSS.t87 VSS.n748 0.1205
R3355 VSS.n385 VSS.t101 0.1205
R3356 VSS.n1549 VSS.n320 0.120486
R3357 VSS.n1568 VSS.t143 0.1171
R3358 VSS.n1647 VSS.n1645 0.11631
R3359 VSS.n294 VSS.n231 0.113429
R3360 VSS.n252 VSS.n251 0.113429
R3361 VSS.n1645 VSS.n1638 0.113429
R3362 VSS.n1292 VSS.n1291 0.113429
R3363 VSS.n1980 VSS.n1978 0.113429
R3364 VSS.n813 VSS.n811 0.113429
R3365 VSS.n1651 VSS.n15 0.112118
R3366 VSS.n1521 VSS.n1520 0.105745
R3367 VSS.t155 VSS.n353 0.0971176
R3368 VSS.n1526 VSS.n366 0.0971176
R3369 VSS.n1569 VSS.n1568 0.0971176
R3370 VSS.n1801 VSS.n1753 0.0961384
R3371 VSS.n1854 VSS.n172 0.0961384
R3372 VSS.n236 VSS.n104 0.0961384
R3373 VSS.n1942 VSS.n1941 0.0961384
R3374 VSS.n1952 VSS.n1951 0.0961384
R3375 VSS.n1959 VSS.n49 0.0961384
R3376 VSS.n1288 VSS.n1290 0.0961384
R3377 VSS.n1378 VSS.n444 0.0961384
R3378 VSS.n1407 VSS.n1404 0.0961384
R3379 VSS.n1461 VSS.n1460 0.0961384
R3380 VSS.n1486 VSS.n1488 0.0961384
R3381 VSS.n1979 VSS.n22 0.0961384
R3382 VSS.n1989 VSS.n27 0.0961384
R3383 VSS.n962 VSS.n523 0.0961384
R3384 VSS.t32 VSS.n544 0.0961384
R3385 VSS.n898 VSS.n569 0.0961384
R3386 VSS.t38 VSS.n599 0.0961384
R3387 VSS.n812 VSS.n657 0.0961384
R3388 VSS.n1656 VSS.n1655 0.0961384
R3389 VSS.n1667 VSS.n1666 0.0961384
R3390 VSS.n1688 VSS.n1687 0.0961384
R3391 VSS.n274 VSS.n206 0.0961384
R3392 VSS.n249 VSS.n219 0.0961384
R3393 VSS.n1717 VSS.n187 0.0961384
R3394 VSS.n259 VSS.n214 0.0961384
R3395 VSS.n1782 VSS.n1780 0.0961384
R3396 VSS.n112 VSS.n88 0.0958676
R3397 VSS.n1780 VSS.t7 0.0958002
R3398 VSS.n1801 VSS.n1800 0.0958002
R3399 VSS.n1815 VSS.n172 0.0958002
R3400 VSS.n239 VSS.n104 0.0958002
R3401 VSS.n1977 VSS.n22 0.0958002
R3402 VSS.n1987 VSS.n27 0.0958002
R3403 VSS.n1289 VSS.n1288 0.0958002
R3404 VSS.t54 VSS.n444 0.0958002
R3405 VSS.n1404 VSS.n1403 0.0958002
R3406 VSS.n1941 VSS.n1940 0.0958002
R3407 VSS.n1951 VSS.n1950 0.0958002
R3408 VSS.n1959 VSS.n1958 0.0958002
R3409 VSS.n1487 VSS.n1486 0.0958002
R3410 VSS.n1460 VSS.t48 0.0958002
R3411 VSS.n365 VSS.n364 0.0958002
R3412 VSS.n964 VSS.n523 0.0958002
R3413 VSS.n942 VSS.n544 0.0958002
R3414 VSS.n900 VSS.n569 0.0958002
R3415 VSS.n788 VSS.n599 0.0958002
R3416 VSS.n814 VSS.n657 0.0958002
R3417 VSS.n1666 VSS.n1639 0.0958002
R3418 VSS.n1687 VSS.n1606 0.0958002
R3419 VSS.n1720 VSS.n187 0.0958002
R3420 VSS.n257 VSS.n214 0.0958002
R3421 VSS.n271 VSS.n206 0.0958002
R3422 VSS.n250 VSS.n219 0.0958002
R3423 VSS.n1787 VSS.n1760 0.0955
R3424 VSS.n1788 VSS.n1787 0.0955
R3425 VSS.n1806 VSS.n1748 0.0955
R3426 VSS.n1806 VSS.n1747 0.0955
R3427 VSS.n1981 VSS.n24 0.0955
R3428 VSS.n1983 VSS.n24 0.0955
R3429 VSS.n1991 VSS.n29 0.0955
R3430 VSS.n1993 VSS.n29 0.0955
R3431 VSS.n1943 VSS.n1942 0.0955
R3432 VSS.n1944 VSS.n1943 0.0955
R3433 VSS.n1953 VSS.n1952 0.0955
R3434 VSS.n1954 VSS.n1953 0.0955
R3435 VSS.n1924 VSS.n49 0.0955
R3436 VSS.n1925 VSS.n1924 0.0955
R3437 VSS.t46 VSS.n1485 0.0955
R3438 VSS.n1452 VSS.n416 0.0955
R3439 VSS.t52 VSS.n1402 0.0955
R3440 VSS.n1372 VSS.n1371 0.0955
R3441 VSS.n364 VSS.n362 0.0955
R3442 VSS.n960 VSS.t29 0.0955
R3443 VSS.n937 VSS.n722 0.0955
R3444 VSS.n782 VSS.t36 0.0955
R3445 VSS.n874 VSS.n692 0.0955
R3446 VSS.n1646 VSS.n1642 0.0955
R3447 VSS.n1642 VSS.n1639 0.0955
R3448 VSS.n1626 VSS.n1609 0.0955
R3449 VSS.n1596 VSS.n1587 0.0955
R3450 VSS.n1587 VSS.n1584 0.0955
R3451 VSS.n201 VSS.n186 0.0955
R3452 VSS.n250 VSS.n218 0.0955
R3453 VSS.t6 VSS.n1609 0.0955
R3454 VSS.n1487 VSS.t46 0.0955
R3455 VSS.n1403 VSS.t52 0.0955
R3456 VSS.n1371 VSS.t54 0.0955
R3457 VSS.n1289 VSS.t60 0.0955
R3458 VSS.n962 VSS.t29 0.0955
R3459 VSS.n898 VSS.t36 0.0955
R3460 VSS.t38 VSS.n692 0.0955
R3461 VSS.n812 VSS.t44 0.0955
R3462 VSS.t32 VSS.n722 0.0955
R3463 VSS.n416 VSS.t48 0.0955
R3464 VSS.n255 VSS.n234 0.09425
R3465 VSS.n257 VSS.n256 0.09425
R3466 VSS.n352 VSS.n340 0.093
R3467 VSS.n1528 VSS.n1527 0.0903963
R3468 VSS.n246 VSS.n119 0.0871176
R3469 VSS.t152 VSS.n350 0.0851154
R3470 VSS.t154 VSS.n348 0.0851154
R3471 VSS.t158 VSS.n360 0.0851154
R3472 VSS.t160 VSS.n358 0.0851154
R3473 VSS.n276 VSS.n131 0.08425
R3474 VSS.n275 VSS.n208 0.08425
R3475 VSS.n1723 VSS.n1722 0.08175
R3476 VSS.n349 VSS.n344 0.08175
R3477 VSS.n359 VSS.n354 0.08175
R3478 VSS.n350 VSS.n3 0.08175
R3479 VSS.n360 VSS.n341 0.08175
R3480 VSS.n1721 VSS.n1720 0.08175
R3481 VSS.n114 VSS.n88 0.0805
R3482 VSS.n1651 VSS.n12 0.0796176
R3483 VSS.n1650 VSS.n20 0.0796176
R3484 VSS.n1857 VSS.n88 0.07675
R3485 VSS.n1859 VSS.n1858 0.07425
R3486 VSS.n229 VSS.n114 0.07425
R3487 VSS.t151 VSS.n333 0.0740901
R3488 VSS.n1174 VSS.n1141 0.0726677
R3489 VSS.n1552 VSS.n323 0.0726677
R3490 VSS.n384 VSS.n369 0.0726677
R3491 VSS.n1858 VSS.t134 0.07175
R3492 VSS.n240 VSS.n131 0.06925
R3493 VSS.t134 VSS.n1857 0.06925
R3494 VSS.n241 VSS.n208 0.06925
R3495 VSS.n9 VSS.n8 0.0258209
R3496 VSS.n1053 VSS.n328 0.0672586
R3497 VSS.n1057 VSS.n328 0.0672586
R3498 VSS.n1540 VSS.n326 0.0672586
R3499 VSS.n1142 VSS.n1136 0.0672168
R3500 VSS.n347 VSS.n346 0.0671176
R3501 VSS.n357 VSS.n356 0.0671176
R3502 VSS.n348 VSS.n338 0.0671176
R3503 VSS.n358 VSS.n342 0.0671176
R3504 VSS.n1652 VSS.n1650 0.06425
R3505 VSS.n1722 VSS.n142 0.0621177
R3506 VSS.n349 VSS.n346 0.0621177
R3507 VSS.n359 VSS.n356 0.0621177
R3508 VSS.n350 VSS.n338 0.0621177
R3509 VSS.n360 VSS.n342 0.0621177
R3510 VSS.n1527 VSS.n1525 0.0611136
R3511 VSS.n1548 VSS.n321 0.060789
R3512 VSS.t93 VSS.n302 0.060789
R3513 VSS.n377 VSS.n315 0.060789
R3514 VSS.n381 VSS.t95 0.060789
R3515 VSS.n1534 VSS.n385 0.060789
R3516 VSS.n1553 VSS.n321 0.060789
R3517 VSS.t89 VSS.n302 0.060789
R3518 VSS.n325 VSS.n318 0.060789
R3519 VSS.n374 VSS.n315 0.060789
R3520 VSS.n1179 VSS.n1178 0.060789
R3521 VSS.t19 VSS.n1129 0.060789
R3522 VSS.t121 VSS.n1183 0.060789
R3523 VSS.n1187 VSS.n1120 0.060789
R3524 VSS.n1190 VSS.n1189 0.060789
R3525 VSS.n1194 VSS.n1113 0.060789
R3526 VSS.n1197 VSS.n1196 0.060789
R3527 VSS.n1201 VSS.n1106 0.060789
R3528 VSS.n1204 VSS.n1203 0.060789
R3529 VSS.n1098 VSS.n1099 0.060789
R3530 VSS.n1097 VSS.n1090 0.060789
R3531 VSS.t21 VSS.n1213 0.060789
R3532 VSS.t123 VSS.n1082 0.060789
R3533 VSS.t66 VSS.n1074 0.060789
R3534 VSS.n1071 VSS.n1221 0.060789
R3535 VSS.n1224 VSS.n1066 0.060789
R3536 VSS.t86 VSS.n1064 0.060789
R3537 VSS.n1229 VSS.t91 0.060789
R3538 VSS.n1052 VSS.n1015 0.060789
R3539 VSS.n1048 VSS.n1016 0.060789
R3540 VSS.n1042 VSS.n1017 0.060789
R3541 VSS.n1038 VSS.n1018 0.060789
R3542 VSS.n1037 VSS.n1036 0.060789
R3543 VSS.n749 VSS.n1008 0.060789
R3544 VSS.t82 VSS.n740 0.060789
R3545 VSS.n998 VSS.n742 0.060789
R3546 VSS.t84 VSS.n743 0.060789
R3547 VSS.n989 VSS.n744 0.060789
R3548 VSS.n1178 VSS.n1177 0.060789
R3549 VSS.n1129 VSS.n1180 0.060789
R3550 VSS.n1183 VSS.n1128 0.060789
R3551 VSS.n1184 VSS.n1120 0.060789
R3552 VSS.n1189 VSS.n1188 0.060789
R3553 VSS.n1191 VSS.n1113 0.060789
R3554 VSS.n1196 VSS.n1195 0.060789
R3555 VSS.n1198 VSS.n1106 0.060789
R3556 VSS.n1203 VSS.n1202 0.060789
R3557 VSS.n1205 VSS.n1099 0.060789
R3558 VSS.n1208 VSS.n1097 0.060789
R3559 VSS.n1213 VSS.n1212 0.060789
R3560 VSS.n1214 VSS.n1082 0.060789
R3561 VSS.n1074 VSS.n1217 0.060789
R3562 VSS.n1221 VSS.n1220 0.060789
R3563 VSS.t74 VSS.n1066 0.060789
R3564 VSS.n1064 VSS.n1225 0.060789
R3565 VSS.n1229 VSS.n1024 0.060789
R3566 VSS.n1056 VSS.n1012 0.060789
R3567 VSS.n1051 VSS.n1016 0.060789
R3568 VSS.n1047 VSS.n1017 0.060789
R3569 VSS.n1041 VSS.n1018 0.060789
R3570 VSS.n1036 VSS.n1035 0.060789
R3571 VSS.n748 VSS.n749 0.060789
R3572 VSS.n747 VSS.n740 0.060789
R3573 VSS.n1001 VSS.n742 0.060789
R3574 VSS.n997 VSS.n743 0.060789
R3575 VSS.n992 VSS.n744 0.060789
R3576 VSS.t60 VSS.n1287 0.058
R3577 VSS.t44 VSS.n494 0.058
R3578 VSS.n353 VSS.t27 0.0571176
R3579 VSS.n246 VSS.n233 0.05675
R3580 VSS.n247 VSS.n245 0.05675
R3581 VSS.n1566 VSS.n1565 0.0558676
R3582 VSS.n1173 VSS.n1142 0.0553461
R3583 VSS.n1249 VSS.n494 0.0546082
R3584 VSS.n1287 VSS.n1286 0.0546082
R3585 VSS.n255 VSS.n122 0.0496177
R3586 VSS.n256 VSS.n216 0.0496177
R3587 VSS.n334 VSS.n298 0.04925
R3588 VSS.n334 VSS.t149 0.04925
R3589 VSS.t157 VSS.n340 0.04925
R3590 VSS.n1766 VSS.t4 0.0483676
R3591 VSS.n1776 VSS.n1765 0.0483676
R3592 VSS.n1781 VSS.n1764 0.0483676
R3593 VSS.t8 VSS.n1761 0.0483676
R3594 VSS.n1785 VSS.n1760 0.0483676
R3595 VSS.n1789 VSS.n1788 0.0483676
R3596 VSS.t9 VSS.n1757 0.0483676
R3597 VSS.n1793 VSS.t10 0.0483676
R3598 VSS.n1799 VSS.n1756 0.0483676
R3599 VSS.n1752 VSS.t11 0.0483676
R3600 VSS.t12 VSS.n1751 0.0483676
R3601 VSS.n1809 VSS.n1808 0.0483676
R3602 VSS.n1810 VSS.n1748 0.0483676
R3603 VSS.t13 VSS.n1747 0.0483676
R3604 VSS.n1816 VSS.n1746 0.0483676
R3605 VSS.n1855 VSS.n171 0.0483676
R3606 VSS.n1741 VSS.n169 0.0483676
R3607 VSS.n1739 VSS.n166 0.0483676
R3608 VSS.n178 VSS.n164 0.0483676
R3609 VSS.n176 VSS.n161 0.0483676
R3610 VSS.n1733 VSS.n158 0.0483676
R3611 VSS.n1731 VSS.n155 0.0483676
R3612 VSS.n182 VSS.n153 0.0483676
R3613 VSS.n180 VSS.n150 0.0483676
R3614 VSS.n1725 VSS.n148 0.0483676
R3615 VSS.n1723 VSS.n145 0.0483676
R3616 VSS.n184 VSS.n142 0.0483676
R3617 VSS.n279 VSS.n140 0.0483676
R3618 VSS.n278 VSS.n137 0.0483676
R3619 VSS.n277 VSS.n134 0.0483676
R3620 VSS.n235 VSS.n127 0.0483676
R3621 VSS.n234 VSS.n125 0.0483676
R3622 VSS.n233 VSS.n122 0.0483676
R3623 VSS.n2004 VSS.n12 0.0483676
R3624 VSS.n230 VSS.n119 0.0483676
R3625 VSS.n295 VSS.n117 0.0483676
R3626 VSS.n1981 VSS.n23 0.0483676
R3627 VSS.n1991 VSS.n28 0.0483676
R3628 VSS.n1993 VSS.n30 0.0483676
R3629 VSS.n34 VSS.n31 0.0483676
R3630 VSS.n1296 VSS.n471 0.0483676
R3631 VSS.n1298 VSS.n1297 0.0483676
R3632 VSS.n1302 VSS.n1299 0.0483676
R3633 VSS.n1301 VSS.n1300 0.0483676
R3634 VSS.n1308 VSS.n467 0.0483676
R3635 VSS.n1310 VSS.n1309 0.0483676
R3636 VSS.n1314 VSS.n1311 0.0483676
R3637 VSS.n1313 VSS.n1312 0.0483676
R3638 VSS.n1320 VSS.t58 0.0483676
R3639 VSS.n1322 VSS.n1321 0.0483676
R3640 VSS.n1326 VSS.n1323 0.0483676
R3641 VSS.n1325 VSS.n1324 0.0483676
R3642 VSS.n1332 VSS.n460 0.0483676
R3643 VSS.n1334 VSS.n1333 0.0483676
R3644 VSS.n1338 VSS.n1335 0.0483676
R3645 VSS.n1337 VSS.n1336 0.0483676
R3646 VSS.n1344 VSS.n456 0.0483676
R3647 VSS.t56 VSS.n1345 0.0483676
R3648 VSS.n1349 VSS.n1346 0.0483676
R3649 VSS.n1348 VSS.n1347 0.0483676
R3650 VSS.n1355 VSS.n452 0.0483676
R3651 VSS.n1357 VSS.n1356 0.0483676
R3652 VSS.n1361 VSS.n1358 0.0483676
R3653 VSS.n1360 VSS.n1359 0.0483676
R3654 VSS.n1367 VSS.n448 0.0483676
R3655 VSS.n1369 VSS.n1368 0.0483676
R3656 VSS.n1372 VSS.n1370 0.0483676
R3657 VSS.n1380 VSS.n1379 0.0483676
R3658 VSS.n1384 VSS.n1381 0.0483676
R3659 VSS.n1383 VSS.n1382 0.0483676
R3660 VSS.n1390 VSS.n440 0.0483676
R3661 VSS.n1392 VSS.n1391 0.0483676
R3662 VSS.n1396 VSS.n1393 0.0483676
R3663 VSS.n1395 VSS.n1394 0.0483676
R3664 VSS.n1402 VSS.n436 0.0483676
R3665 VSS.n1406 VSS.n1405 0.0483676
R3666 VSS.n1413 VSS.n432 0.0483676
R3667 VSS.n1415 VSS.n1414 0.0483676
R3668 VSS.n1419 VSS.n1416 0.0483676
R3669 VSS.n1418 VSS.n1417 0.0483676
R3670 VSS.n1425 VSS.n428 0.0483676
R3671 VSS.n1427 VSS.n1426 0.0483676
R3672 VSS.t50 VSS.n1428 0.0483676
R3673 VSS.n1429 VSS.n1430 0.0483676
R3674 VSS.n1436 VSS.n424 0.0483676
R3675 VSS.n1438 VSS.n1437 0.0483676
R3676 VSS.n1442 VSS.n1439 0.0483676
R3677 VSS.n1441 VSS.n1440 0.0483676
R3678 VSS.n1448 VSS.n420 0.0483676
R3679 VSS.n1450 VSS.n1449 0.0483676
R3680 VSS.n1454 VSS.n1451 0.0483676
R3681 VSS.n1453 VSS.n1452 0.0483676
R3682 VSS.n1465 VSS.n1462 0.0483676
R3683 VSS.n1464 VSS.n1463 0.0483676
R3684 VSS.n1471 VSS.n412 0.0483676
R3685 VSS.n1473 VSS.n1472 0.0483676
R3686 VSS.n1477 VSS.n1474 0.0483676
R3687 VSS.n1476 VSS.n1475 0.0483676
R3688 VSS.n1483 VSS.n408 0.0483676
R3689 VSS.n1485 VSS.n1484 0.0483676
R3690 VSS.n1494 VSS.n404 0.0483676
R3691 VSS.n1496 VSS.n1495 0.0483676
R3692 VSS.n1500 VSS.n1497 0.0483676
R3693 VSS.n1499 VSS.n1498 0.0483676
R3694 VSS.n1506 VSS.n400 0.0483676
R3695 VSS.n1508 VSS.n1507 0.0483676
R3696 VSS.n1512 VSS.n1509 0.0483676
R3697 VSS.n1511 VSS.n1510 0.0483676
R3698 VSS.n1519 VSS.t45 0.0483676
R3699 VSS.n1983 VSS.n25 0.0483676
R3700 VSS.n1985 VSS.n26 0.0483676
R3701 VSS.n2000 VSS.n1999 0.0483676
R3702 VSS.n1965 VSS.n32 0.0483676
R3703 VSS.n1966 VSS.n38 0.0483676
R3704 VSS.n1945 VSS.n1944 0.0483676
R3705 VSS.n1947 VSS.n1946 0.0483676
R3706 VSS.n1949 VSS.n1948 0.0483676
R3707 VSS.n1955 VSS.n1954 0.0483676
R3708 VSS.n1957 VSS.n1956 0.0483676
R3709 VSS.n1925 VSS.n1923 0.0483676
R3710 VSS.n1922 VSS.n1921 0.0483676
R3711 VSS.n1920 VSS.n66 0.0483676
R3712 VSS.n1912 VSS.n1911 0.0483676
R3713 VSS.n1913 VSS.n1910 0.0483676
R3714 VSS.n1909 VSS.n1908 0.0483676
R3715 VSS.n1907 VSS.n70 0.0483676
R3716 VSS.n1900 VSS.n1899 0.0483676
R3717 VSS.n1901 VSS.n1898 0.0483676
R3718 VSS.n1897 VSS.n1896 0.0483676
R3719 VSS.n1895 VSS.n74 0.0483676
R3720 VSS.n1888 VSS.n1887 0.0483676
R3721 VSS.n1889 VSS.n1886 0.0483676
R3722 VSS.n1885 VSS.n1884 0.0483676
R3723 VSS.n1883 VSS.n78 0.0483676
R3724 VSS.n1876 VSS.n1875 0.0483676
R3725 VSS.n1877 VSS.n1874 0.0483676
R3726 VSS.n1873 VSS.n1872 0.0483676
R3727 VSS.n1871 VSS.n82 0.0483676
R3728 VSS.n1864 VSS.n1863 0.0483676
R3729 VSS.n1865 VSS.n1862 0.0483676
R3730 VSS.n1861 VSS.n1860 0.0483676
R3731 VSS.n987 VSS.t30 0.0483676
R3732 VSS.n982 VSS.n498 0.0483676
R3733 VSS.n980 VSS.n501 0.0483676
R3734 VSS.n978 VSS.n504 0.0483676
R3735 VSS.n756 VSS.n507 0.0483676
R3736 VSS.n973 VSS.n510 0.0483676
R3737 VSS.n971 VSS.n514 0.0483676
R3738 VSS.n969 VSS.n517 0.0483676
R3739 VSS.n759 VSS.n520 0.0483676
R3740 VSS.n960 VSS.n528 0.0483676
R3741 VSS.n762 VSS.n531 0.0483676
R3742 VSS.n955 VSS.n534 0.0483676
R3743 VSS.n953 VSS.n537 0.0483676
R3744 VSS.n951 VSS.n540 0.0483676
R3745 VSS.n765 VSS.n541 0.0483676
R3746 VSS.n946 VSS.n542 0.0483676
R3747 VSS.n944 VSS.n543 0.0483676
R3748 VSS.n937 VSS.n545 0.0483676
R3749 VSS.n935 VSS.n546 0.0483676
R3750 VSS.n933 VSS.n547 0.0483676
R3751 VSS.n770 VSS.n548 0.0483676
R3752 VSS.n928 VSS.n549 0.0483676
R3753 VSS.n926 VSS.n550 0.0483676
R3754 VSS.n924 VSS.n551 0.0483676
R3755 VSS.n773 VSS.n552 0.0483676
R3756 VSS.n919 VSS.n553 0.0483676
R3757 VSS.t34 VSS.n554 0.0483676
R3758 VSS.n916 VSS.n555 0.0483676
R3759 VSS.n776 VSS.n556 0.0483676
R3760 VSS.n911 VSS.n557 0.0483676
R3761 VSS.n909 VSS.n558 0.0483676
R3762 VSS.n907 VSS.n560 0.0483676
R3763 VSS.n779 VSS.n563 0.0483676
R3764 VSS.n902 VSS.n566 0.0483676
R3765 VSS.n782 VSS.n574 0.0483676
R3766 VSS.n893 VSS.n577 0.0483676
R3767 VSS.n891 VSS.n580 0.0483676
R3768 VSS.n889 VSS.n583 0.0483676
R3769 VSS.n785 VSS.n586 0.0483676
R3770 VSS.n884 VSS.n590 0.0483676
R3771 VSS.n882 VSS.n593 0.0483676
R3772 VSS.n880 VSS.n596 0.0483676
R3773 VSS.n874 VSS.n604 0.0483676
R3774 VSS.n872 VSS.n607 0.0483676
R3775 VSS.n791 VSS.n610 0.0483676
R3776 VSS.n867 VSS.n613 0.0483676
R3777 VSS.n865 VSS.n616 0.0483676
R3778 VSS.n863 VSS.n617 0.0483676
R3779 VSS.n794 VSS.n618 0.0483676
R3780 VSS.n858 VSS.n619 0.0483676
R3781 VSS.n856 VSS.n620 0.0483676
R3782 VSS.t40 VSS.n621 0.0483676
R3783 VSS.n797 VSS.n622 0.0483676
R3784 VSS.n850 VSS.n623 0.0483676
R3785 VSS.n848 VSS.n624 0.0483676
R3786 VSS.n846 VSS.n625 0.0483676
R3787 VSS.n800 VSS.n627 0.0483676
R3788 VSS.n841 VSS.n630 0.0483676
R3789 VSS.n839 VSS.n633 0.0483676
R3790 VSS.n837 VSS.n636 0.0483676
R3791 VSS.n803 VSS.t42 0.0483676
R3792 VSS.n832 VSS.n641 0.0483676
R3793 VSS.n830 VSS.n644 0.0483676
R3794 VSS.n828 VSS.n647 0.0483676
R3795 VSS.n806 VSS.n650 0.0483676
R3796 VSS.n823 VSS.n653 0.0483676
R3797 VSS.n821 VSS.n654 0.0483676
R3798 VSS.n819 VSS.n655 0.0483676
R3799 VSS.n809 VSS.n656 0.0483676
R3800 VSS.n1646 VSS.n1643 0.0483676
R3801 VSS.n1670 VSS.n1617 0.0483676
R3802 VSS.n1671 VSS.n1616 0.0483676
R3803 VSS.n1632 VSS.n1614 0.0483676
R3804 VSS.t5 VSS.n1613 0.0483676
R3805 VSS.n1620 VSS.n1612 0.0483676
R3806 VSS.n1626 VSS.n1610 0.0483676
R3807 VSS.n1690 VSS.n1689 0.0483676
R3808 VSS.n1693 VSS.n1591 0.0483676
R3809 VSS.n1694 VSS.n1590 0.0483676
R3810 VSS.n1596 VSS.n1588 0.0483676
R3811 VSS.n1700 VSS.n1584 0.0483676
R3812 VSS.n247 VSS.n216 0.0483676
R3813 VSS.n1649 VSS.n20 0.0483676
R3814 VSS.n1652 VSS.n19 0.0483676
R3815 VSS.t6 VSS.n1608 0.0483676
R3816 VSS.n1702 VSS.n1701 0.0483676
R3817 VSS.n1703 VSS.n1579 0.0483676
R3818 VSS.n1709 VSS.n1708 0.0483676
R3819 VSS.n1710 VSS.n1574 0.0483676
R3820 VSS.n1714 VSS.n1713 0.0483676
R3821 VSS.n1716 VSS.n1715 0.0483676
R3822 VSS.n202 VSS.n201 0.0483676
R3823 VSS.n269 VSS.n204 0.0483676
R3824 VSS.n242 VSS.n210 0.0483676
R3825 VSS.n261 VSS.n212 0.0483676
R3826 VSS.n354 VSS.t155 0.04675
R3827 VSS.t157 VSS.n341 0.04675
R3828 VSS.n245 VSS.n218 0.03925
R3829 VSS.n1565 VSS.n1564 0.0371729
R3830 VSS.n1520 VSS.n1519 0.03675
R3831 VSS.n988 VSS.n987 0.03675
R3832 VSS.n344 VSS.n330 0.0305
R3833 VSS.n1537 VSS.n3 0.0305
R3834 VSS.n2004 VSS.n2003 0.028
R3835 VSS.n1977 VSS.n1976 0.028
R3836 VSS.n1649 VSS.n1648 0.028
R3837 VSS.n240 VSS.n239 0.02675
R3838 VSS.n242 VSS.n241 0.02675
R3839 VSS.n333 VSS.n331 0.0253401
R3840 VSS.n249 VSS.n228 0.02175
R3841 VSS.n229 VSS.n295 0.02175
R3842 VSS.n1161 VSS.t70 0.0184075
R3843 VSS.t79 VSS.n1020 0.0184075
R3844 VSS.t76 VSS.n306 0.0174009
R3845 VSS.t149 VSS.n330 0.01675
R3846 VSS.n1537 VSS.t151 0.01675
R3847 VSS.n1167 VSS.t24 0.0151406
R3848 VSS.n1155 VSS.n1065 0.0151406
R3849 VSS.n1154 VSS.n1065 0.0151406
R3850 VSS.n1237 VSS.n741 0.0151406
R3851 VSS.t76 VSS.n309 0.0150892
R3852 VSS.n1721 VSS.n186 0.01425
R3853 VSS.n363 VSS.n362 0.013
R3854 VSS.n277 VSS.n276 0.01175
R3855 VSS.n275 VSS.n274 0.01175
R3856 VSS.n9 VSS.n2 0.00445107
R3857 VSS.n113 VSS.n87 0.00295832
R3858 VSS.n9 VSS.n6 0.00255517
R3859 VSS.n1572 VSS.n224 0.00224991
R3860 VSS.n1558 VSS.n87 0.00216667
R3861 VSS.t76 VSS.n312 0.002125
R3862 VSS.n1856 VSS.n170 0.00199999
R3863 VSS.n1961 VSS.n48 0.00199999
R3864 VSS.n1818 VSS.n170 0.00199992
R3865 VSS.n1961 VSS.n1960 0.00199992
R3866 VSS.n1171 VSS.t24 0.00198843
R3867 VSS.n1964 VSS.n21 0.00194998
R3868 VSS.n1535 VSS.n312 0.00187493
R3869 VSS.n1856 VSS.n113 0.00187493
R3870 VSS.n1774 VSS.n1773 0.00166667
R3871 VSS.n1790 VSS.n1771 0.00166667
R3872 VSS.n1803 VSS.n1797 0.00166667
R3873 VSS.n1813 VSS.n1812 0.00166667
R3874 VSS.n62 VSS.n42 0.00166667
R3875 VSS.n60 VSS.n41 0.00166667
R3876 VSS.n53 VSS.n40 0.00166667
R3877 VSS.n51 VSS.n46 0.00166667
R3878 VSS.n1271 VSS.n490 0.00166667
R3879 VSS.n1280 VSS.n485 0.00166667
R3880 VSS.n1281 VSS.n493 0.00166667
R3881 VSS.n1266 VSS.n484 0.00166667
R3882 VSS.n1560 VSS.n227 0.00166667
R3883 VSS.n1661 VSS.n1660 0.00166667
R3884 VSS.n1665 VSS.n1664 0.00166667
R3885 VSS.n1641 VSS.n1640 0.00166667
R3886 VSS.n1686 VSS.n1685 0.00166667
R3887 VSS.n1607 VSS.n1605 0.00166667
R3888 VSS.n1699 VSS.n1698 0.00166667
R3889 VSS.n1699 VSS.n1585 0.00166667
R3890 VSS.n1240 VSS.n395 0.00166667
R3891 VSS.n1244 VSS.n391 0.00166667
R3892 VSS.n1248 VSS.n1247 0.00166667
R3893 VSS.n1 VSS.n0 8.50175
R3894 VSS.n1783 VSS.n1774 0.00133332
R3895 VSS.n1786 VSS.n1771 0.00133332
R3896 VSS.n1803 VSS.n1802 0.00133332
R3897 VSS.n1812 VSS.n1811 0.00133332
R3898 VSS.n1939 VSS.n42 0.00133332
R3899 VSS.n62 VSS.n41 0.00133332
R3900 VSS.n56 VSS.n40 0.00133332
R3901 VSS.n53 VSS.n46 0.00133332
R3902 VSS.n1240 VSS.n396 0.00133332
R3903 VSS.n1244 VSS.n392 0.00133332
R3904 VSS.n1247 VSS.n387 0.00133332
R3905 VSS.n1272 VSS.n490 0.00133332
R3906 VSS.n1269 VSS.n485 0.00133332
R3907 VSS.n1281 VSS.n1280 0.00133332
R3908 VSS.n493 VSS.n484 0.00133332
R3909 VSS.n1660 VSS.n1659 0.00133332
R3910 VSS.n1664 VSS.n1663 0.00133332
R3911 VSS.n1665 VSS.n1641 0.00133332
R3912 VSS.n1685 VSS.n1684 0.00133332
R3913 VSS.n1686 VSS.n1607 0.00133332
R3914 VSS.n1698 VSS.n1697 0.00133332
R3915 VSS.n1585 VSS.n1573 0.00133332
R3916 VSS.n1560 VSS.n296 0.00133332
R3917 VSS.n9 VSS.n5 0.00108295
R3918 VSS.n9 VSS.n4 0.00107073
R3919 VSS.n2001 VSS.n21 0.00104999
R3920 VSS.n1822 VSS.n16 0.001
R3921 VSS.n1821 VSS.n1767 0.001
R3922 VSS.n1777 VSS.n1775 0.001
R3923 VSS.n1779 VSS.n1778 0.001
R3924 VSS.n1784 VSS.n1783 0.001
R3925 VSS.n1786 VSS.n1772 0.001
R3926 VSS.n1792 VSS.n1791 0.001
R3927 VSS.n1795 VSS.n1794 0.001
R3928 VSS.n1794 VSS.n1770 0.001
R3929 VSS.n1802 VSS.n1796 0.001
R3930 VSS.n1804 VSS.n1769 0.001
R3931 VSS.n1805 VSS.n1804 0.001
R3932 VSS.n1811 VSS.n1768 0.001
R3933 VSS.n1817 VSS.n1814 0.001
R3934 VSS.n1819 VSS.n1818 0.001
R3935 VSS.n2001 VSS.n16 0.001
R3936 VSS.n1822 VSS.n1821 0.001
R3937 VSS.n1775 VSS.n1767 0.001
R3938 VSS.n1778 VSS.n1777 0.001
R3939 VSS.n1784 VSS.n1779 0.001
R3940 VSS.n1773 VSS.n1772 0.001
R3941 VSS.n1791 VSS.n1790 0.001
R3942 VSS.n1795 VSS.n1792 0.001
R3943 VSS.n1798 VSS.n1770 0.001
R3944 VSS.n1798 VSS.n1796 0.001
R3945 VSS.n1797 VSS.n1769 0.001
R3946 VSS.n1807 VSS.n1805 0.001
R3947 VSS.n1807 VSS.n1768 0.001
R3948 VSS.n1814 VSS.n1813 0.001
R3949 VSS.n1819 VSS.n1817 0.001
R3950 VSS.n1963 VSS.n39 0.001
R3951 VSS.n1939 VSS.n43 0.001
R3952 VSS.n58 VSS.n44 0.001
R3953 VSS.n56 VSS.n45 0.001
R3954 VSS.n1960 VSS.n47 0.001
R3955 VSS.n1964 VSS.n1963 0.001
R3956 VSS.n43 VSS.n39 0.001
R3957 VSS.n60 VSS.n44 0.001
R3958 VSS.n58 VSS.n45 0.001
R3959 VSS.n51 VSS.n47 0.001
R3960 VSS.n1558 VSS.n48 0.001
R3961 VSS.n1241 VSS.n394 0.001
R3962 VSS.n1242 VSS.n393 0.001
R3963 VSS.n1243 VSS.n392 0.001
R3964 VSS.n9 VSS.n1 0.00125
R3965 VSS.n738 VSS.n390 0.001
R3966 VSS.n737 VSS.n389 0.001
R3967 VSS.n1245 VSS.n389 0.001
R3968 VSS.n736 VSS.n387 0.001
R3969 VSS.n1143 VSS.t70 0.001
R3970 VSS.n1145 VSS.t70 0.001
R3971 VSS.n1144 VSS.n1104 0.001
R3972 VSS.n1147 VSS.n1065 0.001
R3973 VSS.t79 VSS.n1011 0.001
R3974 VSS.t79 VSS.n1010 0.001
R3975 VSS.n1233 VSS.n1009 0.001
R3976 VSS.n1237 VSS.n739 0.001
R3977 VSS.n1143 VSS.t24 0.001
R3978 VSS.n1145 VSS.n1104 0.001
R3979 VSS.n1146 VSS.n1144 0.001
R3980 VSS.n1147 VSS.n1146 0.001
R3981 VSS.n1065 VSS.n1011 0.001
R3982 VSS.n1010 VSS.n1009 0.001
R3983 VSS.n1234 VSS.n1233 0.001
R3984 VSS.n1234 VSS.n739 0.001
R3985 VSS.n1284 VSS.n1283 0.001
R3986 VSS.n487 VSS.n474 0.001
R3987 VSS.n1273 VSS.n488 0.001
R3988 VSS.n1272 VSS.n486 0.001
R3989 VSS.n1270 VSS.n491 0.001
R3990 VSS.n1269 VSS.n492 0.001
R3991 VSS.n1264 VSS.n483 0.001
R3992 VSS.n1262 VSS.n482 0.001
R3993 VSS.n1260 VSS.n481 0.001
R3994 VSS.n1258 VSS.n480 0.001
R3995 VSS.n1256 VSS.n479 0.001
R3996 VSS.n1254 VSS.n478 0.001
R3997 VSS.n1252 VSS.n477 0.001
R3998 VSS.n1250 VSS.n476 0.001
R3999 VSS.n1248 VSS.n475 0.001
R4000 VSS.n1283 VSS.n396 0.001
R4001 VSS.n1284 VSS.n474 0.001
R4002 VSS.n488 VSS.n487 0.001
R4003 VSS.n1273 VSS.n486 0.001
R4004 VSS.n1271 VSS.n491 0.001
R4005 VSS.n1270 VSS.n492 0.001
R4006 VSS.n1266 VSS.n483 0.001
R4007 VSS.n1264 VSS.n482 0.001
R4008 VSS.n1262 VSS.n481 0.001
R4009 VSS.n1260 VSS.n480 0.001
R4010 VSS.n1258 VSS.n479 0.001
R4011 VSS.n1256 VSS.n478 0.001
R4012 VSS.n1254 VSS.n477 0.001
R4013 VSS.n1252 VSS.n476 0.001
R4014 VSS.n1250 VSS.n475 0.001
R4015 VSS.n2001 VSS.n18 0.001
R4016 VSS.n1659 VSS.n1658 0.001
R4017 VSS.n1663 VSS.n1662 0.001
R4018 VSS.n1640 VSS.n1615 0.001
R4019 VSS.n1674 VSS.n1673 0.001
R4020 VSS.n1676 VSS.n1675 0.001
R4021 VSS.n1678 VSS.n1677 0.001
R4022 VSS.n1680 VSS.n1679 0.001
R4023 VSS.n1682 VSS.n1681 0.001
R4024 VSS.n1684 VSS.n1683 0.001
R4025 VSS.n1604 VSS.n1603 0.001
R4026 VSS.n1603 VSS.n1589 0.001
R4027 VSS.n1697 VSS.n1696 0.001
R4028 VSS.n1563 VSS.n111 0.001
R4029 VSS.n1562 VSS.n297 0.001
R4030 VSS.n1559 VSS.n296 0.001
R4031 VSS.n1557 VSS.n226 0.001
R4032 VSS.n1556 VSS.n225 0.001
R4033 VSS.n1573 VSS.n223 0.001
R4034 VSS.n1856 VSS.n111 0.001
R4035 VSS.n1563 VSS.n1562 0.001
R4036 VSS.n1559 VSS.n297 0.001
R4037 VSS.n1557 VSS.n227 0.001
R4038 VSS.n1556 VSS.n226 0.001
R4039 VSS.n225 VSS.n223 0.001
R4040 VSS.n1657 VSS.n18 0.001
R4041 VSS.n1658 VSS.n1657 0.001
R4042 VSS.n1662 VSS.n1661 0.001
R4043 VSS.n1672 VSS.n1615 0.001
R4044 VSS.n1673 VSS.n1672 0.001
R4045 VSS.n1675 VSS.n1674 0.001
R4046 VSS.n1677 VSS.n1676 0.001
R4047 VSS.n1679 VSS.n1678 0.001
R4048 VSS.n1681 VSS.n1680 0.001
R4049 VSS.n1683 VSS.n1682 0.001
R4050 VSS.n1605 VSS.n1604 0.001
R4051 VSS.n1695 VSS.n1589 0.001
R4052 VSS.n1696 VSS.n1695 0.001
R4053 VSS.n1241 VSS.n395 0.001
R4054 VSS.n1242 VSS.n394 0.001
R4055 VSS.n1243 VSS.n393 0.001
R4056 VSS.n738 VSS.n391 0.001
R4057 VSS.n737 VSS.n390 0.001
R4058 VSS.n1245 VSS.n388 0.001
R4059 VSS.n736 VSS.n388 0.001
R4060 VSS.n367 VSS.n1 8.47794
C300 DELAY_VBIASP VSS 10.3722f
C301 DELAY_OUT_LAST VSS 2.48085f
C302 DELAY_VBIASN VSS 0.10357p
C303 DELAY_IN VSS 6.20723f
C304 DLL_RESETN VSS 10.3876f
C305 VDD VSS 19.08415f
C306 a_9712_1370# VSS 1.59526f ; **FLOATING
C307 a_9444_1370# VSS 2.31588f ; **FLOATING
C308 a_5778_825# VSS 5.9766f ; **FLOATING
C309 a_15464_1142# VSS 0.91181f ; **FLOATING
C310 a_14757_2640# VSS 0.1031f ; **FLOATING
C311 a_13880_2576# VSS 0.0742f ; **FLOATING
C312 a_15688_2861# VSS 0.27866f ; **FLOATING
C313 a_15108_2783# VSS 0.24688f ; **FLOATING
C314 a_14851_2640# VSS 0.39269f ; **FLOATING
C315 a_9444_2048# VSS 6.48112f ; **FLOATING
C316 a_14111_2685# VSS 0.20221f ; **FLOATING
C317 a_14009_2542# VSS 0.4602f ; **FLOATING
C318 a_13592_2881# VSS 1.62662f ; **FLOATING
C319 a_13306_2563# VSS 0.31101f ; **FLOATING
C320 a_13566_2786# VSS 0.1634f ; **FLOATING
C321 a_13132_2878# VSS 0.14211f ; **FLOATING
C322 a_12907_2878# VSS 0.1476f ; **FLOATING
C323 a_12907_2644# VSS 0.14887f ; **FLOATING
C324 a_13106_2815# VSS 0.07369f ; **FLOATING
C325 a_15304_2063# VSS 0.46629f ; **FLOATING
C326 a_14757_3686# VSS 0.10568f ; **FLOATING
C327 a_15688_3325# VSS 0.2737f ; **FLOATING
C328 a_14851_3686# VSS 0.40535f ; **FLOATING
C329 a_15108_3567# VSS 0.25077f ; **FLOATING
C330 a_14111_3336# VSS 0.23266f ; **FLOATING
C331 a_13880_3750# VSS 0.0799f ; **FLOATING
C332 a_14009_3336# VSS 0.494f ; **FLOATING
C333 a_13592_3329# VSS 1.63328f ; **FLOATING
C334 a_13566_3293# VSS 0.1587f ; **FLOATING
C335 a_13045_3673# VSS 0.01186f ; **FLOATING
C336 a_13306_3763# VSS 0.32799f ; **FLOATING
C337 a_12849_3325# VSS 1.40481f ; **FLOATING
C338 a_13121_3289# VSS 0.83335f ; **FLOATING
C339 a_13019_3289# VSS 3.91004f ; **FLOATING
C340 a_12656_3322# VSS 0.29728f ; **FLOATING
C341 a_12355_3325# VSS 0.76652f ; **FLOATING
C342 a_11397_3686# VSS 0.10938f ; **FLOATING
C343 a_12158_3325# VSS 0.27426f ; **FLOATING
C344 a_11491_3686# VSS 0.32236f ; **FLOATING
C345 a_11748_3567# VSS 0.18335f ; **FLOATING
C346 a_10751_3336# VSS 0.21951f ; **FLOATING
C347 a_10520_3750# VSS 0.05232f ; **FLOATING
C348 a_10649_3336# VSS 0.49351f ; **FLOATING
C349 a_10232_3329# VSS 1.59913f ; **FLOATING
C350 a_10206_3293# VSS 0.09627f ; **FLOATING
C351 a_9946_3763# VSS 0.20725f ; **FLOATING
C352 a_9772_3301# VSS 0.13878f ; **FLOATING
C353 a_9746_3263# VSS 0.07638f ; **FLOATING
C354 a_9547_3630# VSS 0.16803f ; **FLOATING
C355 a_9547_3400# VSS 0.12932f ; **FLOATING
C356 a_6854_2912# VSS 3.65501f ; **FLOATING
C357 a_6126_1274# VSS 17.0938f ; **FLOATING
C358 a_6854_3444# VSS 2.92522f ; **FLOATING
C359 a_5974_3181# VSS 2.52813f ; **FLOATING
C360 a_6326_2048# VSS 1.17208f ; **FLOATING
C361 VSS.t134 VSS 3.78188f ; **FLOATING
C362 VDD.t31 VSS 4.16989f ; **FLOATING
C363 VDD.n0 VSS 0.05103f ; **FLOATING
C364 VDD.n1 VSS 0.55416f ; **FLOATING
C365 VDD.n2 VSS 0.08917f ; **FLOATING
C366 VDD.n3 VSS 0.03638f ; **FLOATING
C367 VDD.n4 VSS 0.03638f ; **FLOATING
C368 VDD.n5 VSS 0.01958f ; **FLOATING
C369 VDD.n6 VSS 0.38623f ; **FLOATING
C370 VDD.n8 VSS 0.01958f ; **FLOATING
C371 VDD.t18 VSS 7.48457f ; **FLOATING
C372 VDD.n10 VSS 0.01821f ; **FLOATING
C373 VDD.t83 VSS 0.0286f ; **FLOATING
C374 VDD.n11 VSS 0.15646f ; **FLOATING
C375 VDD.n12 VSS 0.01444f ; **FLOATING
C376 VDD.n13 VSS 0.01958f ; **FLOATING
C377 VDD.n14 VSS 0.27463f ; **FLOATING
C378 VDD.n15 VSS 0.15355f ; **FLOATING
C379 VDD.n17 VSS 0.15621f ; **FLOATING
C380 VDD.n18 VSS 0.25629f ; **FLOATING
C381 VDD.n19 VSS 0.01958f ; **FLOATING
C382 VDD.n20 VSS 0.20963f ; **FLOATING
C383 VDD.n21 VSS 0.03639f ; **FLOATING
C384 VDD.n22 VSS 0.01374f ; **FLOATING
C385 VDD.n25 VSS 0.01925f ; **FLOATING
C386 VDD.n27 VSS 0.02967f ; **FLOATING
C387 VDD.n28 VSS 0.08091f ; **FLOATING
C388 VDD.n29 VSS 0.07094f ; **FLOATING
C389 VDD.n30 VSS 0.01231f ; **FLOATING
C390 VDD.n31 VSS 0.55814f ; **FLOATING
C391 VDD.n32 VSS 0.0733f ; **FLOATING
C392 VDD.n36 VSS 0.07472f ; **FLOATING
C393 VDD.n37 VSS 0.10992f ; **FLOATING
C394 VDD.t75 VSS 0.01654f ; **FLOATING
C395 VDD.n38 VSS 0.0342f ; **FLOATING
C396 VDD.n40 VSS 0.01007f ; **FLOATING
C397 VDD.n51 VSS 0.01027f ; **FLOATING
C398 VDD.n52 VSS 0.01027f ; **FLOATING
C399 VDD.n53 VSS 0.01027f ; **FLOATING
C400 VDD.n54 VSS 0.01027f ; **FLOATING
C401 VDD.n55 VSS 0.01027f ; **FLOATING
C402 VDD.n56 VSS 0.01027f ; **FLOATING
C403 VDD.n57 VSS 0.01027f ; **FLOATING
C404 VDD.n58 VSS 0.01027f ; **FLOATING
C405 VDD.n60 VSS 0.01189f ; **FLOATING
C406 VDD.n62 VSS 0.02166f ; **FLOATING
C407 VDD.n63 VSS 0.02166f ; **FLOATING
C408 VDD.n64 VSS 0.1024f ; **FLOATING
C409 VDD.n65 VSS 0.02251f ; **FLOATING
C410 VDD.n66 VSS 0.01027f ; **FLOATING
C411 VDD.n69 VSS 0.01027f ; **FLOATING
C412 VDD.t35 VSS 0.03942f ; **FLOATING
C413 VDD.t45 VSS 0.03942f ; **FLOATING
C414 VDD.n70 VSS 0.10394f ; **FLOATING
C415 VDD.t38 VSS 0.02318f ; **FLOATING
C416 VDD.t42 VSS 0.02318f ; **FLOATING
C417 VDD.n71 VSS 0.09504f ; **FLOATING
C418 VDD.t26 VSS 0.03151f ; **FLOATING
C419 VDD.n72 VSS 0.04719f ; **FLOATING
C420 VDD.n73 VSS 0.01027f ; **FLOATING
C421 VDD.n74 VSS 0.01027f ; **FLOATING
C422 VDD.n75 VSS 0.01027f ; **FLOATING
C423 VDD.n76 VSS 0.01027f ; **FLOATING
C424 VDD.n77 VSS 0.01027f ; **FLOATING
C425 VDD.n78 VSS 0.01027f ; **FLOATING
C426 VDD.n79 VSS 0.01027f ; **FLOATING
C427 VDD.n80 VSS 0.01027f ; **FLOATING
C428 VDD.n81 VSS 0.01027f ; **FLOATING
C429 VDD.n82 VSS 0.01027f ; **FLOATING
C430 VDD.n83 VSS 0.01027f ; **FLOATING
C431 VDD.t27 VSS 0.01075f ; **FLOATING
C432 VDD.t37 VSS 0.05348f ; **FLOATING
C433 VDD.t84 VSS 0.01075f ; **FLOATING
C434 VDD.t41 VSS 0.05348f ; **FLOATING
C435 VDD.t34 VSS 0.0326f ; **FLOATING
C436 VDD.t47 VSS 0.0326f ; **FLOATING
C437 VDD.n84 VSS 0.13139f ; **FLOATING
C438 VDD.n85 VSS 0.01027f ; **FLOATING
C439 VDD.n86 VSS 0.02374f ; **FLOATING
C440 VDD.t73 VSS 0.02844f ; **FLOATING
C441 VDD.t72 VSS 0.02029f ; **FLOATING
C442 VDD.t74 VSS 0.03141f ; **FLOATING
C443 VDD.t76 VSS 0.02858f ; **FLOATING
C444 VDD.t78 VSS 0.02849f ; **FLOATING
C445 VDD.t77 VSS 0.02029f ; **FLOATING
C446 VDD.t79 VSS 0.03141f ; **FLOATING
C447 VDD.t80 VSS 0.01654f ; **FLOATING
C448 VDD.t81 VSS 0.02837f ; **FLOATING
C449 VDD.t49 VSS 0.03244f ; **FLOATING
C450 VDD.t52 VSS 0.02098f ; **FLOATING
C451 VDD.n87 VSS 0.06732f ; **FLOATING
C452 VDD.n88 VSS 0.01102f ; **FLOATING
C453 VDD.n89 VSS 0.01027f ; **FLOATING
C454 VDD.n90 VSS 0.02062f ; **FLOATING
C455 VDD.n91 VSS 0.02064f ; **FLOATING
C456 VDD.n92 VSS 0.01027f ; **FLOATING
C457 VDD.n93 VSS 0.01027f ; **FLOATING
C458 VDD.t54 VSS 0.02909f ; **FLOATING
C459 VDD.n94 VSS 0.01027f ; **FLOATING
C460 VDD.n95 VSS 0.01027f ; **FLOATING
C461 VDD.n96 VSS 0.01027f ; **FLOATING
C462 VDD.n97 VSS 0.01027f ; **FLOATING
C463 VDD.n98 VSS 0.01027f ; **FLOATING
C464 VDD.t21 VSS 0.03259f ; **FLOATING
C465 VDD.n99 VSS 0.01027f ; **FLOATING
C466 VDD.n100 VSS 0.01027f ; **FLOATING
C467 VDD.n101 VSS 0.01027f ; **FLOATING
C468 VDD.n102 VSS 0.01027f ; **FLOATING
C469 VDD.n103 VSS 0.01027f ; **FLOATING
C470 VDD.n104 VSS 0.01027f ; **FLOATING
C471 VDD.n105 VSS 0.01027f ; **FLOATING
C472 VDD.n106 VSS 0.01027f ; **FLOATING
C473 VDD.n107 VSS 0.01027f ; **FLOATING
C474 VDD.n108 VSS 0.01027f ; **FLOATING
C475 VDD.n109 VSS 0.01027f ; **FLOATING
C476 VDD.n110 VSS 0.01027f ; **FLOATING
C477 VDD.n111 VSS 0.01027f ; **FLOATING
C478 VDD.n112 VSS 0.01027f ; **FLOATING
C479 VDD.n113 VSS 0.01027f ; **FLOATING
C480 VDD.n114 VSS 0.01027f ; **FLOATING
C481 VDD.n115 VSS 0.01027f ; **FLOATING
C482 VDD.n116 VSS 0.01027f ; **FLOATING
C483 VDD.n117 VSS 0.01027f ; **FLOATING
C484 VDD.n118 VSS 0.01027f ; **FLOATING
C485 VDD.n119 VSS 0.01027f ; **FLOATING
C486 VDD.n120 VSS 0.01027f ; **FLOATING
C487 VDD.n121 VSS 0.01027f ; **FLOATING
C488 VDD.n122 VSS 0.01027f ; **FLOATING
C489 VDD.n123 VSS 0.01027f ; **FLOATING
C490 VDD.t24 VSS 0.02318f ; **FLOATING
C491 VDD.n124 VSS 0.01027f ; **FLOATING
C492 VDD.n125 VSS 0.01027f ; **FLOATING
C493 VDD.n126 VSS 0.01027f ; **FLOATING
C494 VDD.n127 VSS 0.01027f ; **FLOATING
C495 VDD.n128 VSS 0.01027f ; **FLOATING
C496 VDD.n129 VSS 0.01027f ; **FLOATING
C497 VDD.t22 VSS 0.01075f ; **FLOATING
C498 VDD.t19 VSS 0.05348f ; **FLOATING
C499 VDD.n130 VSS 0.01027f ; **FLOATING
C500 VDD.t0 VSS 11.1189f ; **FLOATING
C501 VDD.t9 VSS 0.05609f ; **FLOATING
C502 VDD.t5 VSS 0.05609f ; **FLOATING
C503 VDD.n131 VSS 0.07963f ; **FLOATING
C504 VDD.n132 VSS 0.01626f ; **FLOATING
C505 VDD.n133 VSS 0.01626f ; **FLOATING
C506 VDD.n134 VSS 0.08816f ; **FLOATING
C507 VDD.n135 VSS 0.01626f ; **FLOATING
C508 VDD.n136 VSS 0.01626f ; **FLOATING
C509 VDD.n137 VSS 0.01626f ; **FLOATING
C510 VDD.n138 VSS 0.01626f ; **FLOATING
C511 VDD.n139 VSS 0.01626f ; **FLOATING
C512 VDD.n140 VSS 0.01626f ; **FLOATING
C513 VDD.n141 VSS 0.01626f ; **FLOATING
C514 VDD.n142 VSS 0.01626f ; **FLOATING
C515 VDD.n143 VSS 0.01626f ; **FLOATING
C516 VDD.t2 VSS 0.05609f ; **FLOATING
C517 VDD.t11 VSS 0.05609f ; **FLOATING
C518 VDD.n144 VSS 0.01626f ; **FLOATING
C519 VDD.n145 VSS 0.01626f ; **FLOATING
C520 VDD.n146 VSS 0.01626f ; **FLOATING
C521 VDD.n147 VSS 0.10102f ; **FLOATING
C522 VDD.t10 VSS 0.05609f ; **FLOATING
C523 VDD.t1 VSS 0.05609f ; **FLOATING
C524 VDD.t61 VSS 0.31733f ; **FLOATING
C525 VDD.n148 VSS 0.01626f ; **FLOATING
C526 VDD.n149 VSS 0.08882f ; **FLOATING
C527 VDD.n150 VSS 0.01626f ; **FLOATING
C528 VDD.n151 VSS 0.70924f ; **FLOATING
C529 VDD.n152 VSS 2.49492f ; **FLOATING
C530 VDD.t17 VSS 0.01919f ; **FLOATING
C531 VDD.t63 VSS 0.05018f ; **FLOATING
C532 VDD.n153 VSS 0.01958f ; **FLOATING
C533 VDD.t69 VSS 0.05018f ; **FLOATING
C534 VDD.n154 VSS 0.01958f ; **FLOATING
C535 VDD.n155 VSS 0.03961f ; **FLOATING
C536 VDD.n156 VSS 0.01281f ; **FLOATING
C537 VDD.n157 VSS 0.03961f ; **FLOATING
C538 VDD.n158 VSS 0.03639f ; **FLOATING
C539 VDD.n159 VSS 0.01626f ; **FLOATING
C540 VDD.n160 VSS 0.01626f ; **FLOATING
C541 VDD.n161 VSS 0.01626f ; **FLOATING
C542 VDD.n162 VSS 0.01626f ; **FLOATING
C543 VDD.t4 VSS 0.05609f ; **FLOATING
C544 VDD.t12 VSS 0.05609f ; **FLOATING
C545 VDD.n163 VSS 0.03639f ; **FLOATING
C546 VDD.n164 VSS 0.01626f ; **FLOATING
C547 VDD.n165 VSS 0.01626f ; **FLOATING
C548 VDD.n166 VSS 0.01626f ; **FLOATING
C549 VDD.n167 VSS 0.01626f ; **FLOATING
C550 VDD.n168 VSS 0.01626f ; **FLOATING
C551 VDD.t7 VSS 0.05609f ; **FLOATING
C552 VDD.n169 VSS 0.03638f ; **FLOATING
C553 VDD.t15 VSS 0.05609f ; **FLOATING
C554 VDD.n170 VSS 0.01626f ; **FLOATING
C555 VDD.n171 VSS 0.01626f ; **FLOATING
C556 VDD.t71 VSS 0.05135f ; **FLOATING
C557 VDD.t66 VSS 0.05162f ; **FLOATING
C558 VDD.t64 VSS 0.31733f ; **FLOATING
.ends
