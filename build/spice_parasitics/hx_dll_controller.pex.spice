* NGSPICE file created from hx_dll_controller.ext - technology: ihp-sg13g2

.subckt hx_dll_controller VDD VSS DLL_RESETN DELAY_OUT_LAST DELAY_IN DELAY_VBIASN
+ DELAY_VBIASP
X0 VSS.t84 a_12849_3240# a_13400_3678# VSS.t83 sg13_lv_nmos ad=0.1626p pd=1.415u as=60.89999f ps=0.71u w=0.42u l=0.13u
X1 VSS.t150 VSS.t150 VSS.t152 VSS.t151 sg13_lv_nmos ad=0.1406p pd=1.12u as=0 ps=0 w=0.74u l=0.13u
X2 VSS.t91 a_14851_2555# a_15688_2776# VSS.t96 sg13_lv_nmos ad=0.1406p pd=1.12u as=0.2516p ps=2.16u w=0.74u l=0.13u
X3 a_6854_2827# a_6326_1963# VDD.t10 VDD.t0 sg13_lv_pmos ad=0.38p pd=2.38u as=0.38p ps=2.38u w=2u l=1u
X4 VSS.t110 a_9444_1963# a_9444_1285# VSS.t103 sg13_lv_nmos ad=0.68p pd=4.68u as=0.38p ps=2.38u w=2u l=1u
X5 VDD.t12 a_6326_1963# a_6126_1189# VDD.t0 sg13_lv_pmos ad=0.38p pd=2.38u as=0.38p ps=2.38u w=2u l=1u
X6 a_9946_3678# a_9772_3216# VDD.t22 VDD.t0 sg13_lv_pmos ad=79.8f pd=0.8u as=0.1428p ps=1.52u w=0.42u l=0.13u
X7 a_9712_1285# a_6854_2827# a_9444_1285# VSS.t14 sg13_lv_nmos ad=0.38p pd=2.38u as=0.68p ps=4.68u w=2u l=1u
X8 a_6854_3359# a_15304_1978# DELAY_VBIASN VDD.t31 sg13_lv_pmos ad=0.136p pd=1.14u as=0.158p ps=1.245u w=0.4u l=0.2u
X9 a_9444_1285# a_9444_1963# VSS.t109 VSS.t101 sg13_lv_nmos ad=0.38p pd=2.38u as=0.68p ps=4.68u w=2u l=1u
X10 a_6326_1963# a_6126_1189# a_5778_740# VSS.t3 sg13_lv_nmos ad=0.38p pd=2.38u as=0.68p ps=4.68u w=2u l=1u
X11 a_6854_2827# a_6326_1963# VDD.t7 VDD.t0 sg13_lv_pmos ad=0.38p pd=2.38u as=0.38p ps=2.38u w=2u l=1u
X12 VSS.t91 a_15108_2698# a_14757_2555# VSS.t124 sg13_lv_nmos ad=79.8f pd=0.8u as=0.1428p ps=1.52u w=0.42u l=0.13u
X13 a_14009_3251# DELAY_IN VSS.t77 VSS.t118 sg13_lv_nmos ad=0.2516p pd=2.16u as=1.9998p ps=12.915u w=0.74u l=0.13u
X14 VSS.t58 DELAY_VBIASN VSS.t56 VSS.t41 sg13_lv_nmos ad=1.33p pd=7.38u as=0 ps=0 w=7u l=7u
X15 a_9746_3178# a_9547_3315# VSS.t24 VSS.t25 sg13_lv_nmos ad=0.27427p pd=2.28u as=2.39977p ps=15.495u w=0.795u l=0.13u
X16 VSS.t19 DLL_RESETN a_10040_3678# VSS.t18 sg13_lv_nmos ad=0.1626p pd=1.415u as=60.89999f ps=0.71u w=0.42u l=0.13u
X17 a_13949_2869# a_13592_2796# VDD.t42 VDD.t0 sg13_lv_pmos ad=63f pd=0.72u as=0.1563p ps=1.22u w=0.42u l=0.13u
X18 VSS.t136 VSS.t134 VSS.t134 VSS.t135 sg13_lv_nmos ad=0.68p pd=4.68u as=0 ps=0 w=2u l=1u
X19 a_9772_3216# a_9746_3178# VDD.t18 VDD.t0 sg13_lv_pmos ad=0.3927p pd=2.99u as=1.10612p ps=6.66u w=1.155u l=0.13u
X20 a_13121_3204# a_15688_3240# VDD.t34 VDD.t0 sg13_lv_pmos ad=0.3808p pd=2.92u as=0.2128p ps=1.5u w=1.12u l=0.13u
X21 a_15108_3482# a_14851_3601# a_15270_3678# VSS.t78 sg13_lv_nmos ad=0.1428p pd=1.52u as=37.8f ps=0.6u w=0.42u l=0.13u
X22 VSS.t74 a_12907_2559# a_12907_2559# VSS.t119 sg13_lv_nmos ad=1.45407p pd=9.445u as=0.111p ps=1.34u w=0.3u l=0.13u
X23 VDD.t79 VDD.t77 VDD.t78 VDD.t31 sg13_lv_pmos ad=0.3808p pd=2.92u as=0 ps=0 w=1.12u l=0.13u
X24 VSS.t139 VSS.t131 VSS.t131 VSS.t132 sg13_lv_nmos ad=0.68p pd=4.68u as=0 ps=0 w=2u l=1u
X25 a_15108_2698# a_12849_3240# VDD.t18 VDD.t0 sg13_lv_pmos ad=79.8f pd=0.8u as=1.03698p ps=6.245u w=0.42u l=0.13u
X26 a_13121_3204# a_15688_3240# VSS.t82 VSS.t93 sg13_lv_nmos ad=0.2516p pd=2.16u as=0.1406p ps=1.12u w=0.74u l=0.13u
X27 VDD.t74 VDD.t75 VDD.t76 VDD.t31 sg13_lv_pmos ad=0.2128p pd=1.5u as=0 ps=0 w=1.12u l=0.13u
X28 a_5974_3096# a_6126_1189# VSS.t12 VSS.t0 sg13_lv_nmos ad=0.38p pd=2.38u as=0.68p ps=4.68u w=2u l=1u
X29 VDD.t17 a_5974_3096# a_5974_3096# VDD.t0 sg13_lv_pmos ad=0.2448p pd=2.08u as=0.2826p ps=2.29u w=0.36u l=2u
X30 VSS.t21 a_11748_3482# a_11397_3601# VSS.t2 sg13_lv_nmos ad=79.8f pd=0.8u as=0.1428p ps=1.52u w=0.42u l=0.13u
X31 VSS.t60 DELAY_VBIASN VSS.t58 VSS.t43 sg13_lv_nmos ad=1.33p pd=7.38u as=0 ps=0 w=7u l=7u
X32 a_6326_1963# a_6126_1189# a_5778_740# VSS.t3 sg13_lv_nmos ad=0.38p pd=2.38u as=0.68p ps=4.68u w=2u l=1u
X33 VDD.t69 VDD.t61 VDD.t10 VDD.t0 sg13_lv_pmos ad=0.68p pd=4.68u as=0 ps=0 w=2u l=1u
X34 VSS.t36 DELAY_VBIASN VSS.t38 VSS.t37 sg13_lv_nmos ad=1.33p pd=7.38u as=0 ps=0 w=7u l=7u
X35 a_13306_2478# a_13132_2793# VDD.t84 VDD.t0 sg13_lv_pmos ad=79.8f pd=0.8u as=0.1428p ps=1.52u w=0.42u l=0.13u
X36 a_6126_1189# a_6126_1189# VSS.t5 VSS.t3 sg13_lv_nmos ad=0.38p pd=2.38u as=0.68p ps=4.68u w=2u l=1u
X37 a_6326_1963# a_6326_1963# VDD.t2 VDD.t0 sg13_lv_pmos ad=0.38p pd=2.38u as=0.38p ps=2.38u w=2u l=1u
X38 a_13592_3244# a_13566_3208# VSS.t84 VSS.t83 sg13_lv_nmos ad=0.2516p pd=2.16u as=0.1626p ps=1.415u w=0.74u l=0.13u
X39 VSS.t54 DELAY_VBIASN VSS.t52 VSS.t37 sg13_lv_nmos ad=1.33p pd=7.38u as=0 ps=0 w=7u l=7u
X40 VDD.t7 a_6326_1963# a_6126_1189# VDD.t0 sg13_lv_pmos ad=0.38p pd=2.38u as=0.38p ps=2.38u w=2u l=1u
X41 VDD.t18 a_11491_3601# a_11748_3482# VDD.t0 sg13_lv_pmos ad=1.10612p pd=6.66u as=79.8f ps=0.8u w=0.42u l=0.13u
X42 VSS.t50 DELAY_VBIASN VSS.t48 VSS.t33 sg13_lv_nmos ad=1.33p pd=7.38u as=0 ps=0 w=7u l=7u
X43 VDD.t83 DELAY_VBIASP DELAY_VBIASP VDD.t31 sg13_lv_pmos ad=0.3808p pd=2.92u as=1.0304p ps=4.08u w=1.12u l=0.6u
X44 VSS.t42 DELAY_VBIASN VSS.t44 VSS.t43 sg13_lv_nmos ad=1.33p pd=7.38u as=0 ps=0 w=7u l=7u
X45 VDD.t2 a_6326_1963# a_6854_3359# VDD.t0 sg13_lv_pmos ad=0.38p pd=2.38u as=0.38p ps=2.38u w=2u l=1u
X46 a_13132_2793# a_13106_2730# VDD.t18 VDD.t0 sg13_lv_pmos ad=0.3927p pd=2.99u as=1.10612p ps=6.66u w=1.155u l=0.13u
X47 a_14009_3251# DELAY_IN VDD.t18 VDD.t0 sg13_lv_pmos ad=0.4088p pd=2.97u as=1.03698p ps=6.245u w=1.12u l=0.13u
X48 a_15108_3482# a_12849_3240# VDD.t18 VDD.t0 sg13_lv_pmos ad=79.8f pd=0.8u as=1.03698p ps=6.245u w=0.42u l=0.13u
X49 VSS.t56 DELAY_VBIASN VSS.t54 VSS.t39 sg13_lv_nmos ad=1.33p pd=7.38u as=0 ps=0 w=7u l=7u
X50 VDD.t21 a_11491_3601# a_12158_3240# VDD.t0 sg13_lv_pmos ad=0.2128p pd=1.5u as=0.3864p ps=2.93u w=1.12u l=0.13u
X51 a_5778_740# VSS.t127 VSS.t126 rppd l=32u w=1u
X52 VSS.t108 a_9444_1963# a_9444_1285# VSS.t107 sg13_lv_nmos ad=0.68p pd=4.68u as=0.38p ps=2.38u w=2u l=1u
X53 a_13880_2491# a_14111_2600# a_13566_2701# VSS.t129 sg13_lv_nmos ad=0.2373p pd=1.97u as=79.8f ps=0.8u w=0.42u l=0.13u
X54 VSS.t21 a_11491_3601# a_12158_3240# VSS.t20 sg13_lv_nmos ad=0.1406p pd=1.12u as=0.2516p ps=2.16u w=0.74u l=0.13u
X55 a_11693_3363# a_10751_3251# a_11491_3601# VDD.t0 sg13_lv_pmos ad=93.45f pd=0.865u as=0.2048p ps=1.63u w=0.42u l=0.13u
X56 a_13306_3678# a_12355_3240# VDD.t27 VDD.t0 sg13_lv_pmos ad=79.8f pd=0.8u as=0.1428p ps=1.52u w=0.42u l=0.13u
X57 VDD.t18 a_12907_2559# a_12907_2793# VDD.t0 sg13_lv_pmos ad=1.10612p pd=6.66u as=0.2442p ps=2.06u w=0.66u l=0.13u
X58 a_13566_2701# a_14009_2457# a_13949_2869# VDD.t0 sg13_lv_pmos ad=79.8f pd=0.8u as=63f ps=0.72u w=0.42u l=0.13u
X59 a_13306_3678# a_14111_3251# a_13566_3208# VDD.t0 sg13_lv_pmos ad=0.1428p pd=1.52u as=79.8f ps=0.8u w=0.42u l=0.13u
X60 a_13106_2730# a_12907_2793# VSS.t74 VSS.t98 sg13_lv_nmos ad=0.27427p pd=2.28u as=1.45407p ps=9.445u w=0.795u l=0.13u
X61 VSS.t46 DELAY_VBIASN VSS.t45 VSS.t28 sg13_lv_nmos ad=2.38p pd=14.68u as=0 ps=0 w=7u l=7u
X62 a_13566_3208# a_14009_3251# a_13306_3678# VSS.t75 sg13_lv_nmos ad=79.8f pd=0.8u as=0.1296p ps=1.52u w=0.42u l=0.13u
X63 a_13019_3204# a_15688_2776# VSS.t91 VSS.t99 sg13_lv_nmos ad=0.2516p pd=2.16u as=0.1406p ps=1.12u w=0.74u l=0.13u
X64 VDD.t19 DLL_RESETN a_9946_3678# VDD.t0 sg13_lv_pmos ad=0.36237p pd=2.605u as=79.8f ps=0.8u w=0.42u l=0.13u
X65 a_6326_1963# a_5974_3096# a_6126_1189# VSS.t0 sg13_lv_nmos ad=0.38p pd=2.38u as=0.68p ps=4.68u w=2u l=1u
X66 a_5778_740# a_6126_1189# a_6326_1963# VSS.t3 sg13_lv_nmos ad=0.68p pd=4.68u as=0.38p ps=2.38u w=2u l=1u
X67 a_9444_1285# a_6854_2827# a_9712_1285# VSS.t17 sg13_lv_nmos ad=0.68p pd=4.68u as=0.38p ps=2.38u w=2u l=1u
X68 a_6854_3359# a_6326_1963# VDD.t1 VDD.t0 sg13_lv_pmos ad=0.38p pd=2.38u as=0.38p ps=2.38u w=2u l=1u
X69 a_9712_1285# a_13019_3204# DELAY_VBIASN VSS.t64 sg13_lv_nmos ad=0.136p pd=1.14u as=0.232p ps=2.08u w=0.4u l=0.2u
X70 a_13818_2491# a_12849_3240# VSS.t87 VSS.t89 sg13_lv_nmos ad=37.8f pd=0.6u as=0.1701p ps=1.65u w=0.42u l=0.13u
X71 VDD.t4 a_6326_1963# a_6326_1963# VDD.t0 sg13_lv_pmos ad=0.38p pd=2.38u as=0.38p ps=2.38u w=2u l=1u
X72 VDD.t42 a_12849_3240# a_13566_2701# VDD.t0 sg13_lv_pmos ad=0.1563p pd=1.22u as=0.147p ps=1.54u w=0.42u l=0.13u
X73 VSS.t32 DELAY_VBIASN VSS.t34 VSS.t33 sg13_lv_nmos ad=1.33p pd=7.38u as=0 ps=0 w=7u l=7u
X74 a_15270_2478# a_12849_3240# VSS.t91 VSS.t90 sg13_lv_nmos ad=37.8f pd=0.6u as=79.8f ps=0.8u w=0.42u l=0.13u
X75 a_15304_1978# a_14851_3601# VDD.t35 VDD.t0 sg13_lv_pmos ad=0.4312p pd=3.01u as=0.2639p ps=1.81u w=1.12u l=0.13u
X76 a_15304_1978# a_14851_3601# VSS.t80 VSS.t79 sg13_lv_nmos ad=0.2849p pd=2.25u as=0.2516p ps=2.16u w=0.74u l=0.13u
X77 a_9444_1285# a_9444_1963# VSS.t106 VSS.t105 sg13_lv_nmos ad=0.38p pd=2.38u as=0.68p ps=4.68u w=2u l=1u
X78 VDD.t45 a_14851_2555# a_15108_2698# VDD.t0 sg13_lv_pmos ad=0.2639p pd=1.81u as=79.8f ps=0.8u w=0.42u l=0.13u
X79 a_13400_2478# a_13132_2793# a_13306_2478# VSS.t128 sg13_lv_nmos ad=60.89999f pd=0.71u as=0.1428p ps=1.52u w=0.42u l=0.13u
X80 a_11910_3678# DLL_RESETN VSS.t21 VSS.t2 sg13_lv_nmos ad=37.8f pd=0.6u as=79.8f ps=0.8u w=0.42u l=0.13u
X81 a_12849_3240# a_12656_3237# VSS.t21 VSS.t65 sg13_lv_nmos ad=0.1406p pd=1.12u as=0.2516p ps=2.16u w=0.74u l=0.13u
X82 a_5974_3096# a_6126_1189# VSS.t7 VSS.t0 sg13_lv_nmos ad=0.38p pd=2.38u as=0.68p ps=4.68u w=2u l=1u
X83 a_13880_3665# a_13592_3244# a_13818_3665# VSS.t153 sg13_lv_nmos ad=0.1428p pd=1.52u as=37.8f ps=0.6u w=0.42u l=0.13u
X84 VSS.t48 DELAY_VBIASN VSS.t46 VSS.t31 sg13_lv_nmos ad=1.33p pd=7.38u as=0 ps=0 w=7u l=7u
X85 a_5974_3096# a_6126_1189# VSS.t9 VSS.t0 sg13_lv_nmos ad=0.38p pd=2.38u as=0.68p ps=4.68u w=2u l=1u
X86 a_13592_2796# a_13566_2701# VSS.t87 VSS.t120 sg13_lv_nmos ad=0.2516p pd=2.16u as=0.1626p ps=1.415u w=0.74u l=0.13u
X87 a_12656_3237# DLL_RESETN VSS.t21 VSS.t116 sg13_lv_nmos ad=0.2516p pd=2.16u as=0.2516p ps=2.16u w=0.74u l=0.13u
X88 a_14851_3601# a_14009_3251# a_14757_3601# VSS.t78 sg13_lv_nmos ad=0.12665p pd=1.145u as=0.1428p ps=1.52u w=0.42u l=0.13u
X89 a_9712_1285# a_6854_2827# a_9444_1285# VSS.t16 sg13_lv_nmos ad=0.38p pd=2.38u as=0.68p ps=4.68u w=2u l=1u
X90 VDD.t63 VDD.t61 VDD.t1 VDD.t0 sg13_lv_pmos ad=0.68p pd=4.68u as=0 ps=0 w=2u l=1u
X91 VDD.t26 a_13019_3204# a_12943_3240# VDD.t0 sg13_lv_pmos ad=0.2128p pd=1.5u as=0.2128p ps=1.5u w=1.12u l=0.13u
X92 VSS.t80 a_15108_3482# a_14757_3601# VSS.t78 sg13_lv_nmos ad=79.8f pd=0.8u as=0.1428p ps=1.52u w=0.42u l=0.13u
X93 VDD.t41 a_12849_3240# a_13306_2478# VDD.t0 sg13_lv_pmos ad=0.36237p pd=2.605u as=79.8f ps=0.8u w=0.42u l=0.13u
X94 a_10520_3665# a_10232_3244# a_10458_3665# VSS.t61 sg13_lv_nmos ad=0.1428p pd=1.52u as=37.8f ps=0.6u w=0.42u l=0.13u
X95 a_15053_2793# a_14111_2600# a_14851_2555# VDD.t0 sg13_lv_pmos ad=93.45f pd=0.865u as=0.2048p ps=1.63u w=0.42u l=0.13u
X96 a_12656_3237# DLL_RESETN VDD.t54 VDD.t0 sg13_lv_pmos ad=0.3808p pd=2.92u as=0.3808p ps=2.92u w=1.12u l=0.13u
X97 a_11491_3601# a_10649_3251# a_11397_3601# VSS.t2 sg13_lv_nmos ad=0.12665p pd=1.145u as=0.1428p ps=1.52u w=0.42u l=0.13u
X98 VSS.t21 a_13121_3204# a_13045_3588# VSS.t72 sg13_lv_nmos ad=0.2516p pd=2.16u as=0.1406p ps=1.12u w=0.74u l=0.13u
X99 VDD.t47 a_14851_2555# a_15688_2776# VDD.t0 sg13_lv_pmos ad=0.2128p pd=1.5u as=0.3864p ps=2.93u w=1.12u l=0.13u
X100 a_14009_2457# DELAY_OUT_LAST VSS.t74 VSS.t73 sg13_lv_nmos ad=0.2516p pd=2.16u as=1.45407p ps=9.445u w=0.74u l=0.13u
X101 VDD.t35 a_14851_3601# a_15108_3482# VDD.t0 sg13_lv_pmos ad=0.2639p pd=1.81u as=79.8f ps=0.8u w=0.42u l=0.13u
X102 a_13592_2796# a_13566_2701# VDD.t41 VDD.t0 sg13_lv_pmos ad=0.34p pd=2.68u as=0.36237p ps=2.605u w=1u l=0.13u
X103 VSS.t112 a_9444_1963# a_9444_1963# VSS.t107 sg13_lv_nmos ad=0.68p pd=4.68u as=0.38p ps=2.38u w=2u l=1u
X104 a_12355_3240# a_12158_3240# VDD.t21 VDD.t0 sg13_lv_pmos ad=0.3808p pd=2.92u as=0.2128p ps=1.5u w=1.12u l=0.13u
X105 VSS.t38 DELAY_VBIASN VSS.t40 VSS.t39 sg13_lv_nmos ad=1.33p pd=7.38u as=0 ps=0 w=7u l=7u
X106 a_14009_2457# DELAY_OUT_LAST VDD.t18 VDD.t0 sg13_lv_pmos ad=0.4088p pd=2.97u as=1.10612p ps=6.66u w=1.12u l=0.13u
X107 a_10206_3208# a_10649_3251# a_10589_3287# VDD.t0 sg13_lv_pmos ad=79.8f pd=0.8u as=63f ps=0.72u w=0.42u l=0.13u
X108 a_12355_3240# a_12158_3240# VSS.t21 VSS.t70 sg13_lv_nmos ad=0.2516p pd=2.16u as=0.1406p ps=1.12u w=0.74u l=0.13u
X109 VDD.t37 a_12849_3240# a_13306_3678# VDD.t0 sg13_lv_pmos ad=0.36237p pd=2.605u as=79.8f ps=0.8u w=0.42u l=0.13u
X110 a_10040_3678# a_9772_3216# a_9946_3678# VSS.t22 sg13_lv_nmos ad=60.89999f pd=0.71u as=0.1428p ps=1.52u w=0.42u l=0.13u
X111 a_10520_3665# a_10751_3251# a_10206_3208# VSS.t1 sg13_lv_nmos ad=0.2373p pd=1.97u as=79.8f ps=0.8u w=0.42u l=0.13u
X112 VSS.t34 DELAY_VBIASN VSS.t36 VSS.t35 sg13_lv_nmos ad=1.33p pd=7.38u as=0 ps=0 w=7u l=7u
X113 a_15464_1057# a_14851_2555# VSS.t91 VSS.t97 sg13_lv_nmos ad=0.2849p pd=2.25u as=0.2516p ps=2.16u w=0.74u l=0.13u
X114 a_6126_1189# a_5974_3096# a_6326_1963# VSS.t0 sg13_lv_nmos ad=0.68p pd=4.68u as=0.38p ps=2.38u w=2u l=1u
X115 VSS.t77 a_14009_3251# a_14111_3251# VSS.t76 sg13_lv_nmos ad=2.39977p pd=15.495u as=0.2516p ps=2.16u w=0.74u l=0.13u
X116 a_9444_1963# a_6854_2827# a_6854_2827# VSS.t17 sg13_lv_nmos ad=0.68p pd=4.68u as=0.38p ps=2.38u w=2u l=1u
X117 a_13592_2796# a_14111_2600# a_14851_2555# VSS.t130 sg13_lv_nmos ad=0.3473p pd=2.71u as=0.12665p ps=1.145u w=0.74u l=0.13u
X118 VSS.t150 VSS.t147 VSS.t149 VSS.t148 sg13_lv_nmos ad=0.2516p pd=2.16u as=0 ps=0 w=0.74u l=0.13u
X119 VSS.t144 VSS.t144 VSS.t146 VSS.t145 sg13_lv_nmos ad=0.1406p pd=1.12u as=0 ps=0 w=0.74u l=0.13u
X120 a_15053_3363# a_14111_3251# a_14851_3601# VDD.t0 sg13_lv_pmos ad=93.45f pd=0.865u as=0.2048p ps=1.63u w=0.42u l=0.13u
X121 VDD.t18 a_9547_3545# a_9547_3315# VDD.t0 sg13_lv_pmos ad=1.10612p pd=6.66u as=0.2442p ps=2.06u w=0.66u l=0.13u
X122 VSS.t69 a_10649_3251# a_10751_3251# VSS.t68 sg13_lv_nmos ad=2.39977p pd=15.495u as=0.2516p ps=2.16u w=0.74u l=0.13u
X123 VSS.t52 DELAY_VBIASN VSS.t50 VSS.t35 sg13_lv_nmos ad=1.33p pd=7.38u as=0 ps=0 w=7u l=7u
X124 a_9444_1963# a_9444_1963# VSS.t111 VSS.t105 sg13_lv_nmos ad=0.38p pd=2.38u as=0.68p ps=4.68u w=2u l=1u
X125 a_14851_2555# a_14009_2457# a_14757_2555# VSS.t123 sg13_lv_nmos ad=0.12665p pd=1.145u as=0.1428p ps=1.52u w=0.42u l=0.13u
X126 VDD.t5 VDD.t64 VDD.t71 VDD.t0 sg13_lv_pmos ad=0.38p pd=2.38u as=0 ps=0 w=2u l=1u
X127 a_14851_2555# a_14009_2457# a_13592_2796# VDD.t0 sg13_lv_pmos ad=0.2048p pd=1.63u as=0.34p ps=2.68u w=1u l=0.13u
X128 VSS.t30 DELAY_VBIASN VSS.t29 VSS.t28 sg13_lv_nmos ad=2.38p pd=14.68u as=0 ps=0 w=7u l=7u
X129 VSS.t27 DELAY_VBIASN DELAY_VBIASP VSS.t26 sg13_lv_nmos ad=0.2516p pd=2.16u as=0.6808p ps=3.32u w=0.74u l=0.6u
X130 DELAY_VBIASN DLL_RESETN VDD.t52 VDD.t31 sg13_lv_pmos ad=0.158p pd=1.245u as=0.272p ps=2.28u w=0.8u l=0.2u
X131 VDD.t74 VDD.t72 VDD.t73 VDD.t31 sg13_lv_pmos ad=0.3808p pd=2.92u as=0 ps=0 w=1.12u l=0.13u
X132 a_13949_3287# a_13592_3244# VDD.t38 VDD.t0 sg13_lv_pmos ad=63f pd=0.72u as=0.1563p ps=1.22u w=0.42u l=0.13u
X133 VDD.t79 VDD.t80 VDD.t81 VDD.t31 sg13_lv_pmos ad=0.2128p pd=1.5u as=0 ps=0 w=1.12u l=0.13u
X134 a_10232_3244# a_10206_3208# VDD.t19 VDD.t0 sg13_lv_pmos ad=0.34p pd=2.68u as=0.36237p ps=2.605u w=1u l=0.13u
X135 VSS.t71 a_13121_3204# a_6854_3359# VDD.t31 sg13_lv_pmos ad=0.232p pd=2.08u as=0.136p ps=1.14u w=0.4u l=0.2u
X136 a_5778_740# a_6126_1189# a_6326_1963# VSS.t3 sg13_lv_nmos ad=0.68p pd=4.68u as=0.38p ps=2.38u w=2u l=1u
X137 VDD.t24 DLL_RESETN a_10206_3208# VDD.t0 sg13_lv_pmos ad=0.1563p pd=1.22u as=0.147p ps=1.54u w=0.42u l=0.13u
X138 a_13592_3244# a_14111_3251# a_14851_3601# VSS.t78 sg13_lv_nmos ad=0.3473p pd=2.71u as=0.12665p ps=1.145u w=0.74u l=0.13u
X139 a_6854_2827# a_6854_2827# a_9444_1963# VSS.t16 sg13_lv_nmos ad=0.38p pd=2.38u as=0.68p ps=4.68u w=2u l=1u
X140 a_5778_740# a_6126_1189# a_6326_1963# VSS.t3 sg13_lv_nmos ad=0.68p pd=4.68u as=0.38p ps=2.38u w=2u l=1u
X141 VSS.t29 DELAY_VBIASN VSS.t32 VSS.t31 sg13_lv_nmos ad=1.33p pd=7.38u as=0 ps=0 w=7u l=7u
X142 a_10589_3287# a_10232_3244# VDD.t24 VDD.t0 sg13_lv_pmos ad=63f pd=0.72u as=0.1563p ps=1.22u w=0.42u l=0.13u
X143 a_15270_3678# a_12849_3240# VSS.t80 VSS.t78 sg13_lv_nmos ad=37.8f pd=0.6u as=79.8f ps=0.8u w=0.42u l=0.13u
X144 VDD.t18 a_14009_3251# a_14111_3251# VDD.t0 sg13_lv_pmos ad=1.10612p pd=6.66u as=0.3864p ps=2.93u w=1.12u l=0.13u
X145 a_6326_1963# a_6126_1189# a_5778_740# VSS.t3 sg13_lv_nmos ad=0.42p pd=2.42u as=0.68p ps=4.68u w=2u l=1u
X146 a_6326_1963# a_6326_1963# VDD.t12 VDD.t0 sg13_lv_pmos ad=0.38p pd=2.38u as=0.38p ps=2.38u w=2u l=1u
X147 a_10232_3244# a_10751_3251# a_11491_3601# VSS.t2 sg13_lv_nmos ad=0.3473p pd=2.71u as=0.12665p ps=1.145u w=0.74u l=0.13u
X148 VDD.t5 a_6326_1963# a_6854_3359# VDD.t0 sg13_lv_pmos ad=0.38p pd=2.38u as=0.38p ps=2.38u w=2u l=1u
X149 VDD.t18 a_11748_3482# a_11693_3363# VDD.t0 sg13_lv_pmos ad=1.10612p pd=6.66u as=93.45f ps=0.865u w=0.42u l=0.13u
X150 VSS.t87 a_12849_3240# a_13400_2478# VSS.t86 sg13_lv_nmos ad=0.1626p pd=1.415u as=60.89999f ps=0.71u w=0.42u l=0.13u
X151 a_13400_3678# a_12355_3240# a_13306_3678# VSS.t66 sg13_lv_nmos ad=60.89999f pd=0.71u as=0.1428p ps=1.52u w=0.42u l=0.13u
X152 a_13019_3204# a_15688_2776# VDD.t47 VDD.t0 sg13_lv_pmos ad=0.3808p pd=2.92u as=0.2128p ps=1.5u w=1.12u l=0.13u
X153 VDD.t18 a_10649_3251# a_10751_3251# VDD.t0 sg13_lv_pmos ad=1.10612p pd=6.66u as=0.3864p ps=2.93u w=1.12u l=0.13u
X154 a_9444_1963# a_6854_2827# a_6854_2827# VSS.t15 sg13_lv_nmos ad=0.68p pd=4.68u as=0.38p ps=2.38u w=2u l=1u
X155 a_10458_3665# DLL_RESETN VSS.t19 VSS.t115 sg13_lv_nmos ad=37.8f pd=0.6u as=0.1701p ps=1.65u w=0.42u l=0.13u
X156 a_13566_2701# a_14009_2457# a_13306_2478# VSS.t121 sg13_lv_nmos ad=79.8f pd=0.8u as=0.1296p ps=1.52u w=0.42u l=0.13u
X157 a_13306_2478# a_14111_2600# a_13566_2701# VDD.t0 sg13_lv_pmos ad=0.1428p pd=1.52u as=79.8f ps=0.8u w=0.42u l=0.13u
X158 a_6326_1963# a_6126_1189# a_5778_740# VSS.t3 sg13_lv_nmos ad=0.38p pd=2.38u as=0.68p ps=4.68u w=2u l=1u
X159 a_13880_2491# a_13592_2796# a_13818_2491# VSS.t125 sg13_lv_nmos ad=0.1428p pd=1.52u as=37.8f ps=0.6u w=0.42u l=0.13u
X160 a_15108_2698# a_14851_2555# a_15270_2478# VSS.t95 sg13_lv_nmos ad=0.1428p pd=1.52u as=37.8f ps=0.6u w=0.42u l=0.13u
X161 a_13566_3208# a_14009_3251# a_13949_3287# VDD.t0 sg13_lv_pmos ad=79.8f pd=0.8u as=63f ps=0.72u w=0.42u l=0.13u
X162 a_11491_3601# a_10649_3251# a_10232_3244# VDD.t0 sg13_lv_pmos ad=0.2048p pd=1.63u as=0.34p ps=2.68u w=1u l=0.13u
X163 a_5778_740# a_6126_1189# a_6326_1963# VSS.t3 sg13_lv_nmos ad=0.68p pd=4.68u as=0.42p ps=2.42u w=2u l=1u
X164 a_13880_3665# a_14111_3251# a_13566_3208# VSS.t94 sg13_lv_nmos ad=0.2373p pd=1.97u as=79.8f ps=0.8u w=0.42u l=0.13u
X165 VSS.t6 a_6126_1189# a_6126_1189# VSS.t3 sg13_lv_nmos ad=0.68p pd=4.68u as=0.38p ps=2.38u w=2u l=1u
X166 a_6854_3359# a_6326_1963# VDD.t15 VDD.t0 sg13_lv_pmos ad=0.38p pd=2.38u as=0.38p ps=2.38u w=2u l=1u
X167 a_11748_3482# a_11491_3601# a_11910_3678# VSS.t2 sg13_lv_nmos ad=0.1428p pd=1.52u as=37.8f ps=0.6u w=0.42u l=0.13u
X168 VSS.t104 a_9444_1963# a_9444_1963# VSS.t103 sg13_lv_nmos ad=0.68p pd=4.68u as=0.38p ps=2.38u w=2u l=1u
X169 a_12943_3240# a_12656_3237# a_12849_3240# VDD.t0 sg13_lv_pmos ad=0.2128p pd=1.5u as=0.3808p ps=2.92u w=1.12u l=0.13u
X170 a_13592_3244# a_13566_3208# VDD.t37 VDD.t0 sg13_lv_pmos ad=0.34p pd=2.68u as=0.36237p ps=2.605u w=1u l=0.13u
X171 a_6854_2827# a_6854_2827# a_9444_1963# VSS.t14 sg13_lv_nmos ad=0.38p pd=2.38u as=0.68p ps=4.68u w=2u l=1u
X172 VDD.t38 a_12849_3240# a_13566_3208# VDD.t0 sg13_lv_pmos ad=0.1563p pd=1.22u as=0.147p ps=1.54u w=0.42u l=0.13u
X173 a_9444_1963# a_9444_1963# VSS.t102 VSS.t101 sg13_lv_nmos ad=0.38p pd=2.38u as=0.68p ps=4.68u w=2u l=1u
X174 VDD.t34 a_14851_3601# a_15688_3240# VDD.t0 sg13_lv_pmos ad=0.2128p pd=1.5u as=0.3864p ps=2.93u w=1.12u l=0.13u
X175 VSS.t9 a_6126_1189# a_5974_3096# VSS.t0 sg13_lv_nmos ad=0.68p pd=4.68u as=0.38p ps=2.38u w=2u l=1u
X176 VDD.t66 VDD.t64 VDD.t9 VDD.t0 sg13_lv_pmos ad=0.38p pd=2.38u as=0 ps=0 w=2u l=1u
X177 VSS.t82 a_14851_3601# a_15688_3240# VSS.t81 sg13_lv_nmos ad=0.1406p pd=1.12u as=0.2516p ps=2.16u w=0.74u l=0.13u
X178 VDD.t49 a_15464_1057# a_9712_1285# VSS.t100 sg13_lv_nmos ad=0.232p pd=2.08u as=0.136p ps=1.14u w=0.4u l=0.2u
X179 VSS.t136 VSS.t134 VSS.t134 VSS.t135 sg13_lv_nmos ad=0.68p pd=4.68u as=0 ps=0 w=2u l=1u
X180 VDD.t18 a_15108_2698# a_15053_2793# VDD.t0 sg13_lv_pmos ad=1.10612p pd=6.66u as=93.45f ps=0.865u w=0.42u l=0.13u
X181 VSS.t40 DELAY_VBIASN VSS.t42 VSS.t41 sg13_lv_nmos ad=1.33p pd=7.38u as=0 ps=0 w=7u l=7u
X182 a_10649_3251# DELAY_IN VSS.t69 VSS.t117 sg13_lv_nmos ad=0.2516p pd=2.16u as=1.9998p ps=12.915u w=0.74u l=0.13u
X183 VSS.t7 a_6126_1189# a_5974_3096# VSS.t0 sg13_lv_nmos ad=0.68p pd=4.68u as=0.38p ps=2.38u w=2u l=1u
X184 VSS.t131 VSS.t131 VSS.t133 VSS.t132 sg13_lv_nmos ad=0.68p pd=4.68u as=0 ps=0 w=2u l=1u
X185 VSS.t74 a_14009_2457# a_14111_2600# VSS.t122 sg13_lv_nmos ad=1.45407p pd=9.445u as=0.2516p ps=2.16u w=0.74u l=0.13u
X186 a_6126_1189# a_6326_1963# VDD.t11 VDD.t0 sg13_lv_pmos ad=0.38p pd=2.38u as=0.38p ps=2.38u w=2u l=1u
X187 VDD.t15 a_6326_1963# a_6326_1963# VDD.t0 sg13_lv_pmos ad=0.38p pd=2.38u as=0.38p ps=2.38u w=2u l=1u
X188 a_12943_3240# a_13121_3204# VDD.t26 VDD.t0 sg13_lv_pmos ad=0.3808p pd=2.92u as=0.2128p ps=1.5u w=1.12u l=0.13u
X189 VDD.t18 a_14009_2457# a_14111_2600# VDD.t0 sg13_lv_pmos ad=1.10612p pd=6.66u as=0.3864p ps=2.93u w=1.12u l=0.13u
X190 VDD.t11 a_6326_1963# a_6854_2827# VDD.t0 sg13_lv_pmos ad=0.38p pd=2.38u as=0.38p ps=2.38u w=2u l=1u
X191 a_11748_3482# DLL_RESETN VDD.t18 VDD.t0 sg13_lv_pmos ad=79.8f pd=0.8u as=1.10612p ps=6.66u w=0.42u l=0.13u
X192 a_13818_3665# a_12849_3240# VSS.t84 VSS.t88 sg13_lv_nmos ad=37.8f pd=0.6u as=0.1701p ps=1.65u w=0.42u l=0.13u
X193 a_15464_1057# a_14851_2555# VDD.t45 VDD.t0 sg13_lv_pmos ad=0.4312p pd=3.01u as=0.2639p ps=1.81u w=1.12u l=0.13u
X194 a_9444_1285# a_6854_2827# a_9712_1285# VSS.t15 sg13_lv_nmos ad=0.68p pd=4.68u as=0.38p ps=2.38u w=2u l=1u
X195 a_6126_1189# a_6326_1963# VDD.t4 VDD.t0 sg13_lv_pmos ad=0.38p pd=2.38u as=0.38p ps=2.38u w=2u l=1u
X196 VSS.t24 a_9547_3545# a_9547_3545# VSS.t23 sg13_lv_nmos ad=2.39977p pd=15.495u as=0.111p ps=1.34u w=0.3u l=0.13u
X197 VDD.t9 a_6326_1963# a_6854_2827# VDD.t0 sg13_lv_pmos ad=0.38p pd=2.38u as=0.38p ps=2.38u w=2u l=1u
X198 a_13045_3588# a_13019_3204# a_12849_3240# VSS.t63 sg13_lv_nmos ad=0.1406p pd=1.12u as=0.1406p ps=1.12u w=0.74u l=0.13u
X199 a_10232_3244# a_10206_3208# VSS.t19 VSS.t18 sg13_lv_nmos ad=0.2516p pd=2.16u as=0.1626p ps=1.415u w=0.74u l=0.13u
X200 VDD.t18 a_15108_3482# a_15053_3363# VDD.t0 sg13_lv_pmos ad=1.10612p pd=6.66u as=93.45f ps=0.865u w=0.42u l=0.13u
X201 a_5974_3096# a_6126_1189# VSS.t4 VSS.t0 sg13_lv_nmos ad=0.38p pd=2.38u as=0.68p ps=4.68u w=2u l=1u
X202 a_9946_3678# a_10751_3251# a_10206_3208# VDD.t0 sg13_lv_pmos ad=0.1428p pd=1.52u as=79.8f ps=0.8u w=0.42u l=0.13u
X203 a_14851_3601# a_14009_3251# a_13592_3244# VDD.t0 sg13_lv_pmos ad=0.2048p pd=1.63u as=0.34p ps=2.68u w=1u l=0.13u
X204 a_10206_3208# a_10649_3251# a_9946_3678# VSS.t67 sg13_lv_nmos ad=79.8f pd=0.8u as=0.1296p ps=1.52u w=0.42u l=0.13u
X205 VSS.t13 a_6126_1189# a_5974_3096# VSS.t0 sg13_lv_nmos ad=0.68p pd=4.68u as=0.38p ps=2.38u w=2u l=1u
X206 a_10649_3251# DELAY_IN VDD.t18 VDD.t0 sg13_lv_pmos ad=0.4088p pd=2.97u as=1.03698p ps=6.245u w=1.12u l=0.13u
X207 VSS.t144 VSS.t142 VSS.t142 VSS.t143 sg13_lv_nmos ad=0.2516p pd=2.16u as=0 ps=0 w=0.74u l=0.13u
X208 VSS.t11 a_6126_1189# a_5974_3096# VSS.t0 sg13_lv_nmos ad=0.76p pd=4.76u as=0.38p ps=2.38u w=2u l=1u
C0 DELAY_OUT_LAST a_13121_3204# 0.13178f
C1 a_14757_2555# a_14851_2555# 0.28931f
C2 DLL_RESETN a_6126_1189# 0.06398f
C3 a_15464_1057# a_15688_2776# 0.1999f
C4 a_6126_1189# a_5778_740# 1.6143f
C5 VDD a_12907_2793# 0.07751f
C6 VDD a_13566_3208# 0.09466f
C7 VDD a_9772_3216# 0.24701f
C8 a_13132_2793# a_12849_3240# 0.06758f
C9 VDD a_15464_1057# 0.52426f
C10 a_12158_3240# a_11748_3482# 0.10373f
C11 VDD a_6854_2827# 1.03678f
C12 a_10751_3251# a_10232_3244# 0.34102f
C13 a_12656_3237# a_12849_3240# 0.33075f
C14 a_14111_3251# a_15304_1978# 0.01811f
C15 VDD a_14111_3251# 0.21331f
C16 a_13592_3244# a_13121_3204# 0.01445f
C17 a_10751_3251# a_11748_3482# 0.03061f
C18 DELAY_IN a_13019_3204# 0.35409f
C19 DLL_RESETN a_10232_3244# 0.39088f
C20 VDD a_5974_3096# 0.91576f
C21 DELAY_IN a_9712_1285# 0.06562f
C22 a_15108_3482# a_15304_1978# 0.17528f
C23 VDD a_15108_3482# 0.1349f
C24 a_13121_3204# a_14851_3601# 0.03404f
C25 DELAY_IN a_13132_2793# 0.02025f
C26 DLL_RESETN a_11748_3482# 0.11133f
C27 a_6126_1189# a_6326_1963# 2.84014f
C28 a_10520_3665# a_10232_3244# 0.43707f
C29 a_13106_2730# a_12907_2559# 0.02437f
C30 a_10751_3251# a_10649_3251# 0.47795f
C31 VDD a_13306_2478# 0.79678f
C32 a_5974_3096# a_6854_2827# 0.01757f
C33 a_12656_3237# DELAY_IN 0.01215f
C34 VDD a_9547_3545# 0.08695f
C35 a_14111_3251# a_15108_3482# 0.03093f
C36 DLL_RESETN a_10649_3251# 0.05713f
C37 DLL_RESETN DELAY_VBIASP 0.05659f
C38 a_15108_2698# a_15304_1978# 0.01986f
C39 VDD a_15108_2698# 0.13728f
C40 a_6126_1189# a_9444_1963# 0.03029f
C41 a_6126_1189# a_5864_740# 0.23738f
C42 a_12849_3240# a_15304_1978# 0.0606f
C43 VDD a_12849_3240# 2.56972f
C44 DELAY_IN a_11491_3601# 0.01827f
C45 DLL_RESETN a_6854_3359# 0.50331f
C46 a_10649_3251# a_10520_3665# 0.01562f
C47 VDD a_14111_2600# 0.33926f
C48 a_14111_2600# a_15304_1978# 0.01761f
C49 a_15464_1057# a_15108_2698# 0.12158f
C50 a_13566_3208# a_12849_3240# 0.27346f
C51 a_11397_3601# a_11491_3601# 0.28931f
C52 a_13121_3204# a_13019_3204# 0.56469f
C53 a_14111_3251# a_12849_3240# 0.42174f
C54 DELAY_OUT_LAST a_14851_2555# 0.02109f
C55 DLL_RESETN a_9444_1285# 0.03031f
C56 a_12158_3240# a_12355_3240# 0.12454f
C57 VDD a_13306_3678# 0.77573f
C58 DELAY_IN a_15304_1978# 0.01066f
C59 DELAY_IN VDD 0.28486f
C60 a_10206_3208# a_10232_3244# 0.36952f
C61 a_12849_3240# a_15108_3482# 0.10225f
C62 a_13566_3208# a_13306_3678# 0.75507f
C63 DELAY_IN a_13566_3208# 0.01538f
C64 a_6326_1963# a_6854_3359# 1.31745f
C65 DELAY_OUT_LAST DELAY_VBIASP 0.82908f
C66 VDD a_9547_3315# 0.1511f
C67 a_12849_3240# a_13306_2478# 0.10976f
C68 a_13132_2793# a_13106_2730# 0.1657f
C69 a_13121_3204# a_15688_3240# 0.17255f
C70 DELAY_OUT_LAST a_6854_3359# 0.08491f
C71 DLL_RESETN a_12355_3240# 0.04879f
C72 a_14111_3251# a_13306_3678# 0.097f
C73 DELAY_IN a_14111_3251# 0.02263f
C74 a_13306_2478# a_14111_2600# 0.097f
C75 a_9547_3315# a_9772_3216# 0.02416f
C76 DLL_RESETN a_12158_3240# 0.02442f
C77 a_12849_3240# a_15108_2698# 0.10521f
C78 a_10649_3251# a_10206_3208# 0.02242f
C79 a_9444_1963# a_6854_3359# 0.02502f
C80 a_14009_3251# a_13880_3665# 0.01562f
C81 a_15108_2698# a_14111_2600# 0.03012f
C82 DLL_RESETN a_10751_3251# 0.45018f
C83 a_9946_3678# a_10232_3244# 0.41329f
C84 a_12849_3240# a_14111_2600# 0.42064f
C85 VDD a_13592_2796# 0.11685f
C86 a_13592_2796# a_15304_1978# 0.01817f
C87 VDD a_14009_2457# 0.31815f
C88 a_13121_3204# a_15688_2776# 0.01441f
C89 DELAY_IN a_13306_2478# 0.06166f
C90 a_9444_1285# a_9444_1963# 2.20289f
C91 a_5864_740# a_9444_1285# 0.02483f
C92 a_10751_3251# a_10520_3665# 0.12701f
C93 a_13121_3204# a_15304_1978# 0.40921f
C94 VDD a_13121_3204# 0.99724f
C95 DLL_RESETN a_5778_740# 0.01215f
C96 a_13121_3204# a_13566_3208# 0.01158f
C97 a_13121_3204# a_15464_1057# 0.33256f
C98 a_12849_3240# a_13306_3678# 0.12097f
C99 DELAY_IN a_12849_3240# 0.26382f
C100 a_9946_3678# a_10649_3251# 0.02432f
C101 a_9547_3315# a_9547_3545# 0.1117f
C102 DLL_RESETN a_12943_3240# 0.03616f
C103 a_13121_3204# a_14111_3251# 0.0235f
C104 VDD a_13106_2730# 0.09228f
C105 a_13106_2730# a_12907_2793# 0.14994f
C106 DELAY_VBIASN DELAY_VBIASP 5.10609f
C107 a_13121_3204# a_15108_3482# 0.03701f
C108 DELAY_VBIASN a_6854_3359# 0.15808f
C109 DELAY_VBIASP a_13019_3204# 0.02377f
C110 a_13592_2796# a_13306_2478# 0.41329f
C111 a_13306_2478# a_14009_2457# 0.02454f
C112 DELAY_VBIASP a_9712_1285# 0.11086f
C113 a_6326_1963# a_5778_740# 0.8779f
C114 DELAY_IN a_13306_3678# 0.05059f
C115 VDD a_6126_1189# 0.81494f
C116 a_11491_3601# a_10232_3244# 0.01529f
C117 a_9712_1285# a_6854_3359# 0.83268f
C118 a_13592_2796# a_12849_3240# 0.38497f
C119 a_11491_3601# a_11748_3482# 0.34468f
C120 a_12849_3240# a_14009_2457# 0.03463f
C121 a_13132_2793# a_6854_3359# 0.01367f
C122 a_13121_3204# a_15108_2698# 0.05903f
C123 DLL_RESETN a_9444_1963# 0.10275f
C124 a_13592_2796# a_14111_2600# 0.34114f
C125 DLL_RESETN a_5864_740# 0.1727f
C126 a_13592_3244# a_14009_3251# 0.37583f
C127 a_14009_2457# a_14111_2600# 0.47622f
C128 a_13592_3244# a_13880_3665# 0.43707f
C129 a_5778_740# a_9444_1963# 0.19787f
C130 a_13121_3204# a_12849_3240# 0.55272f
C131 a_6126_1189# a_6854_2827# 0.22705f
C132 a_5864_740# a_5778_740# 0.07306f
C133 a_9712_1285# a_9444_1285# 0.72189f
C134 DLL_RESETN a_10206_3208# 0.27343f
C135 DLL_RESETN a_12907_2559# 0.02177f
C136 a_14851_2555# a_15688_2776# 0.08776f
C137 VDD a_10232_3244# 0.07206f
C138 a_6126_1189# a_5974_3096# 1.74589f
C139 a_14851_2555# a_15304_1978# 0.05156f
C140 VDD a_14851_2555# 0.26676f
C141 VDD a_11748_3482# 0.16819f
C142 DELAY_IN a_13592_2796# 0.03445f
C143 a_12355_3240# a_13019_3204# 0.3846f
C144 a_10751_3251# a_9946_3678# 0.097f
C145 a_14851_2555# a_15464_1057# 0.04797f
C146 a_13019_3204# a_13045_3588# 0.01249f
C147 a_13121_3204# a_13306_3678# 0.01008f
C148 DELAY_IN a_13121_3204# 1.40135f
C149 a_6326_1963# a_9444_1963# 0.01269f
C150 a_6326_1963# a_5864_740# 0.01889f
C151 VDD a_10649_3251# 0.23431f
C152 DLL_RESETN a_9946_3678# 0.09997f
C153 VDD DELAY_VBIASP 1.07078f
C154 VDD a_13880_2491# 0.02994f
C155 a_15304_1978# a_6854_3359# 0.08165f
C156 VDD a_6854_3359# 1.20794f
C157 a_12656_3237# a_12355_3240# 0.03277f
C158 DELAY_VBIASN DLL_RESETN 0.12904f
C159 a_9946_3678# a_10520_3665# 0.31978f
C160 a_5864_740# a_9444_1963# 0.06832f
C161 DLL_RESETN a_13019_3204# 0.01429f
C162 a_6854_2827# a_6854_3359# 0.30378f
C163 DLL_RESETN a_9712_1285# 0.4243f
C164 a_13592_2796# a_14009_2457# 0.3749f
C165 a_11491_3601# a_12158_3240# 0.0894f
C166 DLL_RESETN a_13132_2793# 0.01689f
C167 a_12943_3240# a_13019_3204# 0.03346f
C168 a_14851_2555# a_15108_2698# 0.29858f
C169 a_5974_3096# a_6854_3359# 0.029f
C170 a_14851_2555# a_12849_3240# 0.13376f
C171 a_9444_1285# a_6854_2827# 0.8486f
C172 a_12656_3237# DLL_RESETN 0.11782f
C173 a_10751_3251# a_11491_3601# 0.26905f
C174 a_14851_2555# a_14111_2600# 0.26905f
C175 a_13592_3244# a_14851_3601# 0.01529f
C176 a_14757_2555# a_15304_1978# 0.02225f
C177 a_13880_2491# a_13306_2478# 0.31978f
C178 VDD a_12355_3240# 0.37639f
C179 DELAY_VBIASN DELAY_OUT_LAST 3.14505f
C180 DLL_RESETN a_11491_3601# 0.14622f
C181 a_14009_3251# a_14757_3601# 0.01058f
C182 VDD a_12158_3240# 0.37862f
C183 a_6326_1963# a_9712_1285# 0.04741f
C184 DELAY_OUT_LAST a_13019_3204# 0.08017f
C185 a_9946_3678# a_10206_3208# 0.75507f
C186 VDD a_9746_3178# 0.0918f
C187 DELAY_IN a_10232_3244# 0.08086f
C188 a_12849_3240# a_6854_3359# 0.06216f
C189 VDD a_10751_3251# 0.20377f
C190 a_11397_3601# a_10232_3244# 0.43239f
C191 VDD a_14009_3251# 0.23872f
C192 DELAY_IN a_11748_3482# 0.0148f
C193 a_13880_2491# a_14111_2600# 0.12701f
C194 a_9772_3216# a_9746_3178# 0.1657f
C195 a_9712_1285# a_9444_1963# 0.39071f
C196 a_14009_3251# a_13566_3208# 0.02242f
C197 DLL_RESETN a_15304_1978# 0.03137f
C198 DLL_RESETN VDD 2.28901f
C199 a_13592_3244# a_13019_3204# 0.04178f
C200 DLL_RESETN a_12907_2793# 0.04234f
C201 DELAY_IN a_10649_3251# 0.25484f
C202 VDD a_13566_2701# 0.0947f
C203 a_14111_3251# a_14009_3251# 0.47795f
C204 DLL_RESETN a_9772_3216# 0.06592f
C205 a_14111_3251# a_13880_3665# 0.12701f
C206 a_14851_3601# a_13019_3204# 0.01651f
C207 a_11397_3601# a_10649_3251# 0.01058f
C208 VDD a_12943_3240# 0.29479f
C209 DELAY_IN a_6854_3359# 0.05061f
C210 DLL_RESETN a_6854_2827# 0.03626f
C211 a_5778_740# a_6854_2827# 0.02695f
C212 a_14851_2555# a_13592_2796# 0.01529f
C213 a_12849_3240# a_12355_3240# 0.07687f
C214 a_9746_3178# a_9547_3545# 0.02437f
C215 DLL_RESETN a_5974_3096# 0.02002f
C216 a_13121_3204# a_14851_2555# 0.03337f
C217 a_5974_3096# a_5778_740# 2.88221f
C218 VDD a_6326_1963# 7.53039f
C219 DELAY_OUT_LAST a_15688_2776# 0.01699f
C220 DELAY_VBIASN a_13019_3204# 1.23663f
C221 DELAY_OUT_LAST a_15304_1978# 0.05582f
C222 DELAY_OUT_LAST VDD 0.17745f
C223 a_15688_3240# a_14851_3601# 0.08776f
C224 DELAY_VBIASN a_9712_1285# 0.22281f
C225 a_13592_3244# a_14757_3601# 0.43239f
C226 a_14009_3251# a_12849_3240# 0.03525f
C227 a_13566_2701# a_13306_2478# 0.75507f
C228 a_6326_1963# a_6854_2827# 1.25249f
C229 a_13592_2796# a_13880_2491# 0.43707f
C230 a_13592_2796# a_6854_3359# 0.01958f
C231 DELAY_OUT_LAST a_15464_1057# 0.02565f
C232 a_13880_2491# a_14009_2457# 0.01562f
C233 VDD a_9444_1963# 0.01443f
C234 a_9712_1285# a_13019_3204# 0.03275f
C235 a_12355_3240# a_13306_3678# 0.26489f
C236 a_14851_3601# a_14757_3601# 0.28931f
C237 DELAY_IN a_12355_3240# 1.0042f
C238 DLL_RESETN a_12849_3240# 0.3501f
C239 VDD a_10206_3208# 0.09392f
C240 a_13121_3204# a_6854_3359# 0.10056f
C241 VDD a_12907_2559# 0.06323f
C242 a_13592_3244# VDD 0.07242f
C243 a_6326_1963# a_5974_3096# 0.33136f
C244 DELAY_IN a_12158_3240# 0.01309f
C245 a_12849_3240# a_13566_2701# 0.26617f
C246 a_6854_2827# a_9444_1963# 1.25013f
C247 a_12656_3237# a_13019_3204# 0.04193f
C248 a_12907_2559# a_12907_2793# 0.1117f
C249 a_5864_740# a_6854_2827# 0.03661f
C250 a_13592_3244# a_13566_3208# 0.36952f
C251 VDD a_14851_3601# 0.25326f
C252 a_12849_3240# a_12943_3240# 0.16706f
C253 a_14851_3601# a_15304_1978# 0.12139f
C254 DELAY_IN a_10751_3251# 0.01931f
C255 a_14009_3251# a_13306_3678# 0.02432f
C256 a_13880_3665# a_13306_3678# 0.31978f
C257 DELAY_IN a_14009_3251# 0.25847f
C258 a_15688_3240# a_13019_3204# 0.0195f
C259 a_13592_3244# a_14111_3251# 0.34102f
C260 a_9547_3315# a_9746_3178# 0.14994f
C261 a_5974_3096# a_5864_740# 0.01697f
C262 DLL_RESETN DELAY_IN 10.4683f
C263 a_14111_3251# a_14851_3601# 0.26905f
C264 VDD a_9946_3678# 0.77198f
C265 a_14757_2555# a_13592_2796# 0.43239f
C266 a_14757_2555# a_14009_2457# 0.01058f
C267 DELAY_IN a_13566_2701# 0.01093f
C268 DELAY_OUT_LAST a_15108_2698# 0.01399f
C269 DELAY_OUT_LAST a_12849_3240# 0.01791f
C270 a_13121_3204# a_12355_3240# 0.05795f
C271 a_6126_1189# a_6854_3359# 0.18536f
C272 DELAY_VBIASN a_15304_1978# 0.07802f
C273 a_9772_3216# a_9946_3678# 0.27179f
C274 DELAY_VBIASN VDD 0.23309f
C275 a_13019_3204# a_15688_2776# 0.1287f
C276 a_14851_3601# a_15108_3482# 0.29858f
C277 DELAY_OUT_LAST a_14111_2600# 0.02024f
C278 a_13019_3204# a_15304_1978# 0.07025f
C279 VDD a_13019_3204# 0.4182f
C280 VDD a_9712_1285# 0.22552f
C281 a_6126_1189# a_9444_1285# 0.25721f
C282 a_15464_1057# a_13019_3204# 0.59875f
C283 a_10649_3251# a_10232_3244# 0.37583f
C284 a_13592_3244# a_12849_3240# 0.38817f
C285 a_13121_3204# a_14009_3251# 0.01604f
C286 VDD a_13132_2793# 0.23863f
C287 a_9712_1285# a_15464_1057# 0.01237f
C288 a_13132_2793# a_12907_2793# 0.02416f
C289 a_12656_3237# VDD 0.26066f
C290 a_9712_1285# a_6854_2827# 0.6789f
C291 DLL_RESETN a_13121_3204# 0.04337f
C292 a_13592_2796# a_13566_2701# 0.36952f
C293 a_14851_3601# a_12849_3240# 0.13392f
C294 a_13566_2701# a_14009_2457# 0.02242f
C295 a_15688_3240# a_15304_1978# 0.19136f
C296 VDD a_15688_3240# 0.30345f
C297 a_5974_3096# a_9712_1285# 0.01152f
C298 VDD a_11491_3601# 0.16753f
C299 a_13121_3204# a_12943_3240# 0.09118f
C300 DLL_RESETN a_13106_2730# 0.01263f
C301 a_13592_3244# a_13306_3678# 0.41329f
C302 a_13592_3244# DELAY_IN 0.11539f
C303 DELAY_VBIASP a_6854_3359# 0.01478f
C304 a_13132_2793# a_13306_2478# 0.27179f
C305 DELAY_OUT_LAST a_13592_2796# 0.08062f
C306 VDD a_15688_2776# 0.30345f
C307 DELAY_OUT_LAST a_14009_2457# 0.25594f
C308 a_12849_3240# a_13019_3204# 0.12838f
C309 VDD a_15304_1978# 0.72158f
R0 VDD.n23 VDD.t24 17.3693
R1 VDD.n11 VDD.t42 17.3693
R2 VDD.n11 VDD.t38 17.3693
R3 VDD.n22 VDD.t22 17.3517
R4 VDD.n14 VDD.t84 17.3517
R5 VDD.n13 VDD.t27 17.3517
R6 VDD.n17 VDD.t26 17.2247
R7 VDD.n22 VDD.t19 17.0005
R8 VDD.n14 VDD.t41 17.0005
R9 VDD.n13 VDD.t37 17.0005
R10 VDD.t31 VDD.t72 15.0005
R11 VDD.t31 VDD.t77 15.0005
R12 VDD.t31 VDD.t80 15.0005
R13 VDD.t31 VDD.t49 17.9449
R14 VDD.n32 VDD.t17 9.02285
R15 VDD.t31 VDD.t52 8.95516
R16 VDD.n7 VDD.t45 8.76054
R17 VDD.n7 VDD.t35 8.76054
R18 VDD.n0 VDD.t0 1.78925
R19 VDD.n21 VDD.t21 5.9886
R20 VDD.n5 VDD.t47 5.97675
R21 VDD.n5 VDD.t34 5.97675
R22 VDD.n19 VDD.t54 5.96478
R23 VDD.t0 VDD.n33 5.62581
R24 VDD.t18 VDD.n16 5.61485
R25 VDD.t18 VDD.n20 5.61485
R26 VDD.t31 VDD.t73 5.71133
R27 VDD.t31 VDD.t79 5.59179
R28 VDD.n2 VDD.t64 4.9462
R29 VDD.n42 VDD.t61 4.9462
R30 VDD.n9 VDD.t31 7.13279
R31 VDD.t0 VDD.n62 4.19238
R32 VDD.t0 VDD.n25 4.19238
R33 VDD.t0 VDD.n34 4.19225
R34 VDD.t0 VDD.n30 4.19225
R35 VDD.t18 VDD.n18 3.31226
R36 VDD.t18 VDD.n10 3.30706
R37 VDD.t18 VDD.n12 3.30706
R38 VDD.t18 VDD.n24 3.30688
R39 VDD.t18 VDD.n6 2.7751
R40 VDD.t18 VDD 1.47683
R41 VDD.n69 VDD.t66 2.69937
R42 VDD.n40 VDD.t69 2.69937
R43 VDD.n38 VDD.t63 2.69937
R44 VDD.n1 VDD.t71 2.69937
R45 VDD.n67 VDD.t5 2.6992
R46 VDD.n65 VDD.t9 2.6992
R47 VDD.n36 VDD.t10 2.6992
R48 VDD.n44 VDD.t1 2.6992
R49 VDD.n49 VDD.t2 2.6992
R50 VDD.n48 VDD.t11 2.6992
R51 VDD.n54 VDD.t4 2.6992
R52 VDD.n53 VDD.t12 2.6992
R53 VDD.n59 VDD.t7 2.6992
R54 VDD.n58 VDD.t15 2.6992
R55 VDD.t0 VDD.n61 2.32439
R56 VDD.t0 VDD.n28 2.32439
R57 VDD.t0 VDD.n46 2.32425
R58 VDD.t0 VDD.n56 2.32425
R59 VDD.t0 VDD.n29 2.32417
R60 VDD.t0 VDD.n26 2.32417
R61 VDD.t0 VDD.n27 2.0061
R62 VDD.t0 VDD.n51 2.00592
R63 VDD.t0 VDD.n71 1.75938
R64 VDD.t18 VDD.n8 1.20461
R65 VDD.n49 VDD.n48 1.11007
R66 VDD.n54 VDD.n53 1.11007
R67 VDD.n59 VDD.n58 1.11007
R68 VDD.n23 VDD.n4 0.975304
R69 VDD.n39 VDD.n31 0.895821
R70 VDD.n32 VDD.n31 0.880553
R71 VDD.n4 VDD.n21 0.817678
R72 VDD.n9 VDD.n8 0.671512
R73 VDD.n8 VDD.n7 0.6645
R74 VDD.n70 VDD.n69 0.570444
R75 VDD.n38 VDD.n37 0.570444
R76 VDD.n65 VDD.n64 0.570274
R77 VDD.n45 VDD.n44 0.570274
R78 VDD.n50 VDD.n49 0.570274
R79 VDD.n55 VDD.n54 0.570274
R80 VDD.n60 VDD.n59 0.570274
R81 VDD.n67 VDD.n66 0.569912
R82 VDD.n36 VDD.n35 0.569912
R83 VDD.n48 VDD.n47 0.569912
R84 VDD.n53 VDD.n52 0.569912
R85 VDD.n58 VDD.n57 0.569912
R86 VDD.n40 VDD.n39 0.569733
R87 VDD.n1 VDD.n63 0.569733
R88 VDD.t18 VDD.n4 0.49685
R89 VDD.n41 VDD.n40 0.492175
R90 VDD VDD.n1 0.492175
R91 VDD.n68 VDD.n67 0.492005
R92 VDD.n43 VDD.n36 0.492005
R93 VDD.n68 VDD.n65 0.491643
R94 VDD.n44 VDD.n43 0.491643
R95 VDD.n69 VDD 0.491464
R96 VDD.n41 VDD.n38 0.491464
R97 VDD.t0 VDD.n31 0.487114
R98 VDD.t31 VDD.t83 6.09264
R99 VDD.n71 VDD.n70 0.43335
R100 VDD.n71 VDD 0.403558
R101 VDD.t0 VDD.t18 0.383639
R102 VDD.n52 VDD.n28 0.372952
R103 VDD.n56 VDD.n55 0.372812
R104 VDD.n47 VDD.n26 0.354692
R105 VDD.n50 VDD.n46 0.354557
R106 VDD.n61 VDD.n60 0.347952
R107 VDD.n57 VDD.n29 0.347655
R108 VDD.n47 VDD.n27 0.347254
R109 VDD.n51 VDD.n50 0.346901
R110 VDD.n24 VDD.n23 0.335799
R111 VDD.n12 VDD.n11 0.335496
R112 VDD.n66 VDD.n29 0.334692
R113 VDD.n64 VDD.n61 0.334405
R114 VDD.n15 VDD.n12 0.332368
R115 VDD.n24 VDD.n3 0.332058
R116 VDD.n63 VDD.n0 0.383516
R117 VDD.n55 VDD.n51 0.329276
R118 VDD.n52 VDD.n27 0.328947
R119 VDD.n46 VDD.n45 0.327812
R120 VDD.n35 VDD.n26 0.327655
R121 VDD.n19 VDD.n18 0.32704
R122 VDD.n60 VDD.n56 0.309557
R123 VDD.n57 VDD.n28 0.309405
R124 VDD.n7 VDD.n6 0.306614
R125 VDD.n10 VDD.n9 0.298721
R126 VDD VDD.n3 0.423614
R127 VDD.n18 VDD.n17 0.282613
R128 VDD.n11 VDD.n10 0.260496
R129 VDD.n2 VDD.n68 0.253639
R130 VDD.n42 VDD.n41 0.253639
R131 VDD.n43 VDD.n42 0.253298
R132 VDD.n21 VDD.n20 0.202075
R133 VDD.n45 VDD.n34 0.191924
R134 VDD.n35 VDD.n25 0.191793
R135 VDD.n64 VDD.n62 0.184552
R136 VDD.n66 VDD.n30 0.184424
R137 VDD.n37 VDD.n33 0.179888
R138 VDD.n20 VDD.n19 0.175486
R139 VDD.n17 VDD.n16 0.171736
R140 VDD.n63 VDD.n30 0.161924
R141 VDD.n70 VDD.n62 0.161793
R142 VDD.n39 VDD.n25 0.154552
R143 VDD.n37 VDD.n34 0.154424
R144 VDD.n3 VDD.n22 0.152808
R145 VDD.n15 VDD.n14 0.152808
R146 VDD.n15 VDD.n13 0.152808
R147 VDD.n16 VDD.n15 0.147075
R148 VDD.n6 VDD.n5 0.127628
R149 VDD.n33 VDD.n32 0.11705
R150 VDD.t31 VDD.t75 15.0334
R151 VDD.t31 VDD.t74 5.81814
R152 VDD.t78 VDD.t31 5.76644
R153 VDD VDD.n2 0.612395
R154 VDD VDD.n0 0.543771
R155 VDD.t81 VDD.t31 5.75163
R156 VDD.t76 VDD.t31 5.77389
R157 VSS.n251 VSS.t132 119321
R158 VSS.n172 VSS.n171 22369.4
R159 VSS.n230 VSS.n204 1028.14
R160 VSS.n246 VSS.n225 1028.14
R161 VSS.t97 VSS.n151 849.322
R162 VSS.n482 VSS.n195 572.005
R163 VSS.t3 VSS.t0 571.348
R164 VSS.n236 VSS.t116 566.691
R165 VSS.n235 VSS.t65 560.899
R166 VSS.n210 VSS.t79 550.193
R167 VSS.n155 VSS.t130 539.653
R168 VSS.t63 VSS.n233 532.819
R169 VSS.n503 VSS.t122 522.508
R170 VSS.n249 VSS.t25 521.236
R171 VSS.t72 VSS.n232 514.091
R172 VSS.n242 VSS.t68 504.839
R173 VSS.n216 VSS.t76 504.839
R174 VSS.n501 VSS.t123 491.87
R175 VSS.n237 VSS.t70 474.904
R176 VSS.t124 VSS.n153 470.019
R177 VSS.n238 VSS.t20 456.175
R178 VSS.n248 VSS.t22 427.695
R179 VSS.n232 VSS.t66 427.219
R180 VSS.n211 VSS.n206 412.791
R181 VSS.n240 VSS.n239 412.791
R182 VSS.n213 VSS.n211 404.192
R183 VSS.n239 VSS.n229 404.192
R184 VSS.t73 VSS.n501 401.591
R185 VSS.t97 VSS.n152 388.781
R186 VSS.n250 VSS.t23 375.276
R187 VSS.t118 VSS.n206 372.094
R188 VSS.t117 VSS.n240 372.094
R189 VSS.n70 VSS.n571 370.009
R190 VSS.t83 VSS.n218 363.339
R191 VSS.t18 VSS.n245 363.339
R192 VSS.t90 VSS.t95 359.769
R193 VSS.n208 VSS.t93 347.49
R194 VSS.n209 VSS.t81 329.238
R195 VSS.n546 VSS.t3 327.81
R196 VSS.n504 VSS.t121 313.659
R197 VSS.t88 VSS.t153 304.42
R198 VSS.t75 VSS.n205 304.42
R199 VSS.t115 VSS.t61 304.42
R200 VSS.t67 VSS.n243 304.42
R201 VSS.t129 VSS.n503 299.735
R202 VSS.n216 VSS.t94 291.37
R203 VSS.t1 VSS.n242 291.37
R204 VSS.n231 VSS.n230 249.036
R205 VSS.n247 VSS.n246 249.036
R206 VSS.t81 VSS.n208 243.244
R207 VSS.t93 VSS.n195 224.516
R208 VSS.n46 VSS.t126 216.093
R209 VSS.n13 VSS.t126 215.731
R210 VSS.n502 VSS.t73 208.828
R211 VSS.n504 VSS.t129 202.362
R212 VSS.n215 VSS.t118 202.071
R213 VSS.n241 VSS.t117 202.071
R214 VSS.t23 VSS.n249 196.911
R215 VSS.t94 VSS.n205 196.399
R216 VSS.n243 VSS.t1 196.399
R217 VSS.t121 VSS.n149 187.895
R218 VSS.n13 VSS.t132 185.393
R219 VSS.t2 VSS.n238 183.975
R220 VSS.n217 VSS.t75 182.797
R221 VSS.n244 VSS.t67 182.797
R222 VSS.t78 VSS.n210 167.954
R223 VSS.n7 VSS.n172 157.912
R224 VSS.t97 VSS.n1 154.968
R225 VSS.t66 VSS.n231 144.788
R226 VSS.t22 VSS.n247 144.788
R227 VSS.t100 VSS.n0 143.149
R228 VSS.t0 VSS.t132 142.417
R229 VSS.t153 VSS.n217 138.607
R230 VSS.t61 VSS.n244 138.607
R231 VSS.n175 VSS.t143 123.18
R232 VSS.n185 VSS.t148 123.18
R233 VSS.n172 VSS.n149 122.129
R234 VSS.n153 VSS.t90 121.858
R235 VSS.n483 VSS.n482 118.993
R236 VSS.t64 VSS.n4 118.9
R237 VSS.t20 VSS.n237 115.831
R238 VSS.n230 VSS.t83 112.361
R239 VSS.n246 VSS.t18 112.361
R240 VSS.n154 VSS.t124 103.538
R241 VSS.t26 VSS.n6 101.448
R242 VSS.t98 VSS.n143 99.4847
R243 VSS.n482 VSS.n481 98.6652
R244 VSS.t70 VSS.n236 97.5777
R245 VSS.n506 VSS.t128 93.1365
R246 VSS.t122 VSS.n502 88.3462
R247 VSS.n505 VSS.t120 87.3255
R248 VSS.t76 VSS.n215 85.7923
R249 VSS.t68 VSS.n241 85.7923
R250 VSS.t123 VSS.n155 81.2384
R251 VSS.t145 VSS.n6 79.5957
R252 VSS.t151 VSS.n5 79.5956
R253 VSS.n175 VSS.t145 79.4707
R254 VSS.n185 VSS.t151 79.4707
R255 VSS.t95 VSS.n152 75.4357
R256 VSS.t14 VSS.n116 70.0202
R257 VSS.n571 VSS.t119 68.534
R258 VSS.t125 VSS.t89 68.534
R259 VSS.n484 VSS.t99 66.3233
R260 VSS.n9 VSS.t26 65.6868
R261 VSS.t86 VSS.n144 65.2179
R262 VSS.n171 VSS.n145 65.2179
R263 VSS.n131 VSS.t107 62.1307
R264 VSS.t16 VSS.n119 60.1583
R265 VSS.n233 VSS.t72 57.9156
R266 VSS.n198 VSS.n197 56.3803
R267 VSS.n171 VSS.n148 53.7749
R268 VSS.t28 VSS.n265 53.413
R269 VSS.n369 VSS.t39 53.413
R270 VSS.t99 VSS.n483 52.6695
R271 VSS.n512 VSS.t103 52.2687
R272 VSS.t25 VSS.n248 51.2456
R273 VSS.t43 VSS.n408 50.4456
R274 VSS.t101 VSS.n122 50.2964
R275 VSS.n529 VSS.t132 48.324
R276 VSS.n5 VSS.t64 47.8054
R277 VSS.n484 VSS.t96 46.4264
R278 VSS.t33 VSS.n306 44.5109
R279 VSS.n328 VSS.t35 44.5109
R280 VSS.t135 VSS.n134 44.3792
R281 VSS.n218 VSS.t88 44.1903
R282 VSS.n245 VSS.t115 44.1903
R283 VSS.t15 VSS.n118 42.4068
R284 VSS.n525 VSS.t17 42.4068
R285 VSS.n505 VSS.t86 40.8995
R286 VSS.t105 VSS.n127 40.4344
R287 VSS.n234 VSS.t63 39.1873
R288 VSS.n143 VSS.t119 37.5834
R289 VSS.t148 VSS.n9 35.8845
R290 VSS.t143 VSS.n7 35.882
R291 VSS.n287 VSS.t31 35.6088
R292 VSS.t37 VSS.n347 35.6088
R293 VSS.n128 VSS.t105 34.5173
R294 VSS.n46 VSS.t132 34.1226
R295 VSS.t130 VSS.n154 33.9067
R296 VSS.n507 VSS.t15 32.5449
R297 VSS.t17 VSS.n121 32.5449
R298 VSS.n520 VSS.t135 30.5725
R299 VSS.n389 VSS.t41 29.6741
R300 VSS.t128 VSS.n144 27.635
R301 VSS.t65 VSS.n234 27.6043
R302 VSS.t41 VSS.n388 26.7067
R303 VSS.n123 VSS.t101 24.6553
R304 VSS.n4 VSS.t100 23.5351
R305 VSS.t89 VSS.n148 22.8243
R306 VSS.t103 VSS.n124 22.6829
R307 VSS.t79 VSS.n209 22.2881
R308 VSS.t116 VSS.n235 22.2881
R309 VSS.n506 VSS.t98 21.2859
R310 VSS.n420 VSS.n419 21.211
R311 VSS.n417 VSS.n416 21.211
R312 VSS.n413 VSS.n412 21.211
R313 VSS.n411 VSS.n410 21.211
R314 VSS.n400 VSS.n399 21.211
R315 VSS.n394 VSS.n393 21.211
R316 VSS.n387 VSS.n386 21.211
R317 VSS.n385 VSS.n384 21.211
R318 VSS.n379 VSS.n378 21.211
R319 VSS.n377 VSS.n376 21.211
R320 VSS.n375 VSS.n374 21.211
R321 VSS.n373 VSS.n372 21.211
R322 VSS.n366 VSS.n365 21.211
R323 VSS.n364 VSS.n363 21.211
R324 VSS.n362 VSS.n361 21.211
R325 VSS.n360 VSS.n359 21.211
R326 VSS.n358 VSS.n357 21.211
R327 VSS.n356 VSS.n355 21.211
R328 VSS.n354 VSS.n353 21.211
R329 VSS.n339 VSS.n338 21.211
R330 VSS.n335 VSS.n334 21.211
R331 VSS.n333 VSS.n332 21.211
R332 VSS.n331 VSS.n330 21.211
R333 VSS.n322 VSS.n321 21.211
R334 VSS.n320 VSS.n319 21.211
R335 VSS.n316 VSS.n315 21.211
R336 VSS.n310 VSS.n309 21.211
R337 VSS.n305 VSS.n304 21.211
R338 VSS.n301 VSS.n300 21.211
R339 VSS.n297 VSS.n296 21.211
R340 VSS.n295 VSS.n294 21.211
R341 VSS.n293 VSS.n292 21.211
R342 VSS.n289 VSS.n288 21.211
R343 VSS.n278 VSS.n277 21.211
R344 VSS.n276 VSS.n275 21.211
R345 VSS.n274 VSS.n273 21.211
R346 VSS.n261 VSS.n260 21.211
R347 VSS.n259 VSS.n258 21.211
R348 VSS.n257 VSS.n199 21.211
R349 VSS.n258 VSS.n257 21.211
R350 VSS.n260 VSS.n259 21.211
R351 VSS.n262 VSS.n261 21.211
R352 VSS.n263 VSS.n262 21.211
R353 VSS.n264 VSS.n263 21.211
R354 VSS.n268 VSS.n267 21.211
R355 VSS.n269 VSS.n268 21.211
R356 VSS.n270 VSS.n269 21.211
R357 VSS.n271 VSS.n270 21.211
R358 VSS.n272 VSS.n271 21.211
R359 VSS.n273 VSS.n272 21.211
R360 VSS.n275 VSS.n274 21.211
R361 VSS.n277 VSS.n276 21.211
R362 VSS.n279 VSS.n278 21.211
R363 VSS.n280 VSS.n279 21.211
R364 VSS.n281 VSS.n280 21.211
R365 VSS.n282 VSS.n281 21.211
R366 VSS.n283 VSS.n282 21.211
R367 VSS.n284 VSS.n283 21.211
R368 VSS.n285 VSS.n284 21.211
R369 VSS.n290 VSS.n289 21.211
R370 VSS.n291 VSS.n290 21.211
R371 VSS.n292 VSS.n291 21.211
R372 VSS.n294 VSS.n293 21.211
R373 VSS.n296 VSS.n295 21.211
R374 VSS.n298 VSS.n297 21.211
R375 VSS.n299 VSS.n298 21.211
R376 VSS.n300 VSS.n299 21.211
R377 VSS.n302 VSS.n301 21.211
R378 VSS.n303 VSS.n302 21.211
R379 VSS.n304 VSS.n303 21.211
R380 VSS.n309 VSS.n308 21.211
R381 VSS.n311 VSS.n310 21.211
R382 VSS.n312 VSS.n311 21.211
R383 VSS.n313 VSS.n312 21.211
R384 VSS.n314 VSS.n313 21.211
R385 VSS.n315 VSS.n314 21.211
R386 VSS.n317 VSS.n316 21.211
R387 VSS.n318 VSS.n317 21.211
R388 VSS.n319 VSS.n318 21.211
R389 VSS.n321 VSS.n320 21.211
R390 VSS.n323 VSS.n322 21.211
R391 VSS.n324 VSS.n323 21.211
R392 VSS.n325 VSS.n324 21.211
R393 VSS.n326 VSS.n325 21.211
R394 VSS.n330 VSS.n329 21.211
R395 VSS.n332 VSS.n331 21.211
R396 VSS.n334 VSS.n333 21.211
R397 VSS.n336 VSS.n335 21.211
R398 VSS.n337 VSS.n336 21.211
R399 VSS.n338 VSS.n337 21.211
R400 VSS.n340 VSS.n339 21.211
R401 VSS.n341 VSS.n340 21.211
R402 VSS.n342 VSS.n341 21.211
R403 VSS.n343 VSS.n342 21.211
R404 VSS.n344 VSS.n343 21.211
R405 VSS.n345 VSS.n344 21.211
R406 VSS.n346 VSS.n345 21.211
R407 VSS.n350 VSS.n349 21.211
R408 VSS.n351 VSS.n350 21.211
R409 VSS.n352 VSS.n351 21.211
R410 VSS.n353 VSS.n352 21.211
R411 VSS.n355 VSS.n354 21.211
R412 VSS.n357 VSS.n356 21.211
R413 VSS.n359 VSS.n358 21.211
R414 VSS.n361 VSS.n360 21.211
R415 VSS.n363 VSS.n362 21.211
R416 VSS.n365 VSS.n364 21.211
R417 VSS.n367 VSS.n366 21.211
R418 VSS.n371 VSS.n370 21.211
R419 VSS.n372 VSS.n371 21.211
R420 VSS.n374 VSS.n373 21.211
R421 VSS.n376 VSS.n375 21.211
R422 VSS.n378 VSS.n377 21.211
R423 VSS.n380 VSS.n379 21.211
R424 VSS.n381 VSS.n380 21.211
R425 VSS.n382 VSS.n381 21.211
R426 VSS.n383 VSS.n382 21.211
R427 VSS.n384 VSS.n383 21.211
R428 VSS.n386 VSS.n385 21.211
R429 VSS.n391 VSS.n390 21.211
R430 VSS.n392 VSS.n391 21.211
R431 VSS.n393 VSS.n392 21.211
R432 VSS.n395 VSS.n394 21.211
R433 VSS.n396 VSS.n395 21.211
R434 VSS.n397 VSS.n396 21.211
R435 VSS.n398 VSS.n397 21.211
R436 VSS.n399 VSS.n398 21.211
R437 VSS.n401 VSS.n400 21.211
R438 VSS.n402 VSS.n401 21.211
R439 VSS.n403 VSS.n402 21.211
R440 VSS.n404 VSS.n403 21.211
R441 VSS.n405 VSS.n404 21.211
R442 VSS.n406 VSS.n405 21.211
R443 VSS.n407 VSS.n406 21.211
R444 VSS.n412 VSS.n411 21.211
R445 VSS.n414 VSS.n413 21.211
R446 VSS.n415 VSS.n414 21.211
R447 VSS.n416 VSS.n415 21.211
R448 VSS.n418 VSS.n417 21.211
R449 VSS.n419 VSS.n418 21.211
R450 VSS.t31 VSS.n286 20.772
R451 VSS.n348 VSS.t37 20.772
R452 VSS.t120 VSS.n145 18.792
R453 VSS.n518 VSS.n30 18.6251
R454 VSS.n528 VSS.n34 18.6249
R455 VSS.n526 VSS.n35 18.6249
R456 VSS.n508 VSS.n37 18.6249
R457 VSS.n510 VSS.n38 18.6249
R458 VSS.n524 VSS.n40 18.6249
R459 VSS.n521 VSS.n41 18.6249
R460 VSS.n513 VSS.n42 18.6249
R461 VSS.n514 VSS.n43 18.6249
R462 VSS.n516 VSS.n44 18.6249
R463 VSS.n517 VSS.n45 18.6249
R464 VSS.n527 VSS.n35 18.6249
R465 VSS.n508 VSS.n36 18.6249
R466 VSS.n509 VSS.n37 18.6249
R467 VSS.n511 VSS.n38 18.6249
R468 VSS.n524 VSS.n39 18.6249
R469 VSS.n523 VSS.n40 18.6249
R470 VSS.n522 VSS.n41 18.6249
R471 VSS.n513 VSS.n43 18.6249
R472 VSS.n515 VSS.n44 18.6249
R473 VSS.n518 VSS.n45 18.6249
R474 VSS.n519 VSS.n135 18.0386
R475 VSS.t96 VSS.t97 17.6866
R476 VSS.n409 VSS.n73 17.0005
R477 VSS.n408 VSS.n73 17.0005
R478 VSS.n369 VSS.n73 17.0005
R479 VSS.n368 VSS.n73 17.0005
R480 VSS.n348 VSS.n73 17.0005
R481 VSS.n347 VSS.n73 17.0005
R482 VSS.n287 VSS.n73 17.0005
R483 VSS.n286 VSS.n73 17.0005
R484 VSS.n266 VSS.n73 17.0005
R485 VSS.n265 VSS.n73 17.0005
R486 VSS.n198 VSS.n73 17.0005
R487 VSS.n46 VSS.n126 17.0005
R488 VSS.n67 VSS.n529 17.0005
R489 VSS.n67 VSS.n507 17.0005
R490 VSS.n67 VSS.n525 17.0005
R491 VSS.n67 VSS.n512 17.0005
R492 VSS.n566 VSS.n67 17.0005
R493 VSS.n67 VSS.n520 17.0005
R494 VSS.n67 VSS.n142 17.0005
R495 VSS.n571 VSS.t74 17.0005
R496 VSS.t74 VSS.n143 17.0005
R497 VSS.t74 VSS.n144 17.0005
R498 VSS.t74 VSS.n505 17.0005
R499 VSS.t74 VSS.n145 17.0005
R500 VSS.t74 VSS.n504 17.0005
R501 VSS.n485 VSS.n484 17.0005
R502 VSS.t74 VSS.n152 17.0005
R503 VSS.t74 VSS.n153 17.0005
R504 VSS.t74 VSS.n155 17.0005
R505 VSS.n249 VSS.t24 17.0005
R506 VSS.n247 VSS.t24 17.0005
R507 VSS.n245 VSS.t69 17.0005
R508 VSS.n243 VSS.t69 17.0005
R509 VSS.n240 VSS.t69 17.0005
R510 VSS.n237 VSS.n220 17.0005
R511 VSS.n233 VSS.n220 17.0005
R512 VSS.n231 VSS.n220 17.0005
R513 VSS.t77 VSS.n218 17.0005
R514 VSS.t77 VSS.n205 17.0005
R515 VSS.t77 VSS.n206 17.0005
R516 VSS.n210 VSS.n200 17.0005
R517 VSS.n208 VSS.n200 17.0005
R518 VSS.n76 VSS.n389 17.0005
R519 VSS.n76 VSS.n388 17.0005
R520 VSS.n76 VSS.n328 17.0005
R521 VSS.n76 VSS.n327 17.0005
R522 VSS.n76 VSS.n307 17.0005
R523 VSS.n76 VSS.n306 17.0005
R524 VSS.n76 VSS.n197 17.0005
R525 VSS.n46 VSS.n136 17.0005
R526 VSS.n10 VSS.n163 17.0005
R527 VSS.n10 VSS.n164 17.0005
R528 VSS.n10 VSS.n167 17.0005
R529 VSS.n10 VSS.n174 17.0005
R530 VSS.n10 VSS.n184 17.0005
R531 VSS.n10 VSS.n192 17.0005
R532 VSS.n251 VSS.n250 16.2018
R533 VSS.n120 VSS.t16 14.7934
R534 VSS.n445 VSS.n420 14.5841
R535 VSS.t107 VSS.n129 12.821
R536 VSS.n142 VSS.n135 12.6861
R537 VSS.n307 VSS.t33 11.8699
R538 VSS.t35 VSS.n327 11.8699
R539 VSS.n527 VSS.n117 11.6958
R540 VSS.n510 VSS.n120 11.6958
R541 VSS.n522 VSS.n123 11.6958
R542 VSS.n515 VSS.n128 11.6958
R543 VSS.n517 VSS.n131 11.6958
R544 VSS.n519 VSS.n134 11.6958
R545 VSS.n528 VSS.n116 11.6958
R546 VSS.n526 VSS.n118 11.6958
R547 VSS.n509 VSS.n119 11.6958
R548 VSS.n511 VSS.n121 11.6958
R549 VSS.n523 VSS.n122 11.6958
R550 VSS.n521 VSS.n124 11.6958
R551 VSS.n514 VSS.n127 11.6958
R552 VSS.n516 VSS.n129 11.6958
R553 VSS.n70 VSS.n142 13.2721
R554 VSS.n327 VSS.n326 10.6058
R555 VSS.n408 VSS.n407 10.6058
R556 VSS.n368 VSS.n367 10.6058
R557 VSS.n347 VSS.n346 10.6058
R558 VSS.n286 VSS.n285 10.6058
R559 VSS.n265 VSS.n264 10.6058
R560 VSS.n199 VSS.n198 10.6058
R561 VSS.n267 VSS.n266 10.6058
R562 VSS.n288 VSS.n287 10.6058
R563 VSS.n306 VSS.n305 10.6058
R564 VSS.n308 VSS.n307 10.6058
R565 VSS.n329 VSS.n328 10.6058
R566 VSS.n349 VSS.n348 10.6058
R567 VSS.n370 VSS.n369 10.6058
R568 VSS.n388 VSS.n387 10.6058
R569 VSS.n390 VSS.n389 10.6058
R570 VSS.n410 VSS.n409 10.6058
R571 VSS.n88 VSS.n87 9.81769
R572 VSS.n88 VSS.n80 9.53935
R573 VSS.n89 VSS.n88 9.39094
R574 VSS.n495 VSS.t71 9.08698
R575 VSS.t71 VSS.n494 9.0445
R576 VSS.n499 VSS.n157 9.0005
R577 VSS.n168 VSS.n158 9.0005
R578 VSS.n160 VSS.n158 9.0005
R579 VSS.n499 VSS.n498 9.0005
R580 VSS.n197 VSS.n74 9.07876
R581 VSS.n13 VSS.n31 8.501
R582 VSS.n12 VSS.n13 2.83417
R583 VSS.n11 VSS.n12 0.00166658
R584 VSS.n15 VSS.n11 0.00149997
R585 VSS.n16 VSS.n13 2.83428
R586 VSS.n19 VSS.n16 0.00249992
R587 VSS.n20 VSS.n13 2.83439
R588 VSS.n22 VSS.n20 0.00141665
R589 VSS.n23 VSS.n24 0.00216959
R590 VSS.n25 VSS.n23 0.00170812
R591 VSS.n26 VSS.n25 0.00166658
R592 VSS.n28 VSS.n26 0.00149997
R593 VSS.n29 VSS.n13 4.25113
R594 VSS.n546 VSS.n46 8.501
R595 VSS.n546 VSS.n49 3.40102
R596 VSS.n546 VSS.n52 2.4296
R597 VSS.n546 VSS.n53 2.12578
R598 VSS.n53 VSS.n55 0.00166651
R599 VSS.n55 VSS.n57 0.00158329
R600 VSS.n546 VSS.n60 4.25113
R601 VSS.n546 VSS.n63 3.40102
R602 VSS.n546 VSS.n66 4.25113
R603 VSS.n74 VSS.n73 0.496504
R604 VSS.n229 VSS.n227 8.501
R605 VSS.n229 VSS.n226 8.501
R606 VSS.n214 VSS.n213 8.501
R607 VSS.n213 VSS.n207 8.501
R608 VSS.n461 VSS.n460 8.501
R609 VSS.n460 VSS.n441 8.501
R610 VSS.n460 VSS.n444 8.501
R611 VSS.n460 VSS.n446 8.501
R612 VSS.n460 VSS.n447 8.501
R613 VSS.n460 VSS.n448 8.501
R614 VSS.n460 VSS.n449 8.501
R615 VSS.n460 VSS.n450 8.501
R616 VSS.n460 VSS.n451 8.501
R617 VSS.n460 VSS.n443 8.501
R618 VSS.n460 VSS.n452 8.501
R619 VSS.n460 VSS.n453 8.501
R620 VSS.n460 VSS.n454 8.501
R621 VSS.n460 VSS.n455 8.501
R622 VSS.n460 VSS.n442 8.501
R623 VSS.n460 VSS.n456 8.501
R624 VSS.n460 VSS.n457 8.501
R625 VSS.n460 VSS.n459 8.501
R626 VSS.n460 VSS.n421 8.501
R627 VSS.n1 VSS.n0 5.35126
R628 VSS.n46 VSS.n116 8.5005
R629 VSS.n46 VSS.n117 8.5005
R630 VSS.n46 VSS.n118 8.5005
R631 VSS.n46 VSS.n119 8.5005
R632 VSS.n46 VSS.n120 8.5005
R633 VSS.n46 VSS.n121 8.5005
R634 VSS.n46 VSS.n122 8.5005
R635 VSS.n46 VSS.n123 8.5005
R636 VSS.n46 VSS.n124 8.5005
R637 VSS.n46 VSS.n127 8.5005
R638 VSS.n46 VSS.n128 8.5005
R639 VSS.n46 VSS.n129 8.5005
R640 VSS.n46 VSS.n131 8.5005
R641 VSS.n46 VSS.n134 8.5005
R642 VSS.n10 VSS.n175 8.5005
R643 VSS.n10 VSS.n185 8.5005
R644 VSS.n491 VSS.n73 8.49109
R645 VSS.n10 VSS.n170 8.48883
R646 VSS.n10 VSS.n8 8.48883
R647 VSS.t60 VSS.n462 8.47784
R648 VSS.n465 VSS.n440 8.47784
R649 VSS.n466 VSS.n439 8.47784
R650 VSS.n467 VSS.n438 8.47784
R651 VSS.n468 VSS.n437 8.47784
R652 VSS.n469 VSS.n436 8.47784
R653 VSS.n470 VSS.n435 8.47784
R654 VSS.n471 VSS.n434 8.47784
R655 VSS.n472 VSS.n433 8.47784
R656 VSS.n473 VSS.n432 8.47784
R657 VSS.n474 VSS.n431 8.47784
R658 VSS.n475 VSS.n430 8.47784
R659 VSS.n476 VSS.n429 8.47784
R660 VSS.n477 VSS.n428 8.47784
R661 VSS.n478 VSS.n427 8.47784
R662 VSS.n479 VSS.n426 8.47784
R663 VSS.n422 VSS.n424 8.47784
R664 VSS.t44 VSS.n423 8.47784
R665 VSS.n464 VSS.n73 8.47732
R666 VSS.n46 VSS.n82 8.47732
R667 VSS.n46 VSS.n83 8.47732
R668 VSS.t139 VSS.n111 8.47732
R669 VSS.t4 VSS.n11 8.47732
R670 VSS.n110 VSS.n15 8.47732
R671 VSS.n112 VSS.n14 8.47732
R672 VSS.n109 VSS.n17 8.47732
R673 VSS.t7 VSS.n19 8.47732
R674 VSS.n101 VSS.n100 8.47732
R675 VSS.n98 VSS.n21 8.47732
R676 VSS.n22 VSS.n99 8.47732
R677 VSS.n23 VSS.t12 8.47732
R678 VSS.n25 VSS.n97 8.47732
R679 VSS.n26 VSS.n96 8.47732
R680 VSS.t13 VSS.n28 8.47732
R681 VSS.n95 VSS.n27 8.47732
R682 VSS.n29 VSS.n114 8.47732
R683 VSS.n46 VSS.n132 8.47732
R684 VSS.n46 VSS.n85 8.47732
R685 VSS.n46 VSS.n84 8.47732
R686 VSS.n548 VSS.n48 8.47732
R687 VSS.n551 VSS.n51 8.47732
R688 VSS.n552 VSS.n50 8.47732
R689 VSS.n553 VSS.n54 8.47732
R690 VSS.n554 VSS.n55 8.47732
R691 VSS.t5 VSS.n57 8.47732
R692 VSS.n542 VSS.n56 8.47732
R693 VSS.n555 VSS.n58 8.47732
R694 VSS.n541 VSS.n60 8.47732
R695 VSS.n556 VSS.n62 8.47732
R696 VSS.n558 VSS.n64 8.47732
R697 VSS.n559 VSS.n66 8.47732
R698 VSS.n561 VSS.n68 8.47732
R699 VSS.n534 VSS.n67 8.47732
R700 VSS.n76 VSS.n256 8.47732
R701 VSS.n10 VSS.n162 8.47732
R702 VSS.n10 VSS.n166 8.47732
R703 VSS.n10 VSS.n173 8.47732
R704 VSS.n10 VSS.n176 8.47732
R705 VSS.n10 VSS.n183 8.47732
R706 VSS.n10 VSS.n186 8.47732
R707 VSS.n489 VSS.n75 8.47677
R708 VSS.n490 VSS.n71 8.47677
R709 VSS.n253 VSS.n223 8.47111
R710 VSS.t21 VSS.n222 8.47111
R711 VSS.n255 VSS.n203 8.47111
R712 VSS.t80 VSS.n202 8.47111
R713 VSS.n570 VSS.n67 8.46924
R714 VSS.n520 VSS.n30 6.93039
R715 VSS.n507 VSS.n36 6.92951
R716 VSS.n525 VSS.n39 6.92951
R717 VSS.n529 VSS.n34 6.92951
R718 VSS.n512 VSS.n42 6.92951
R719 VSS.n445 VSS.n73 6.5121
R720 VSS.n409 VSS.t43 5.93522
R721 VSS.n252 VSS.n251 5.66985
R722 VSS.n107 VSS.n13 5.66778
R723 VSS.n105 VSS.n13 5.66778
R724 VSS.n102 VSS.n13 5.66778
R725 VSS.n24 VSS.n13 1.54575
R726 VSS.n33 VSS.n13 5.66778
R727 VSS.n547 VSS.n49 0.00229996
R728 VSS.n546 VSS.n544 5.66778
R729 VSS.n52 VSS.n543 0.0024999
R730 VSS.n63 VSS.n59 0.00229996
R731 VSS.n546 VSS.n545 5.66778
R732 VSS.n69 VSS.n65 0.0024166
R733 VSS.n78 VSS.n193 0.00289569
R734 VSS.n481 VSS.n196 5.66778
R735 VSS.n460 VSS.n458 5.66778
R736 VSS.n546 VSS.n69 2.83432
R737 VSS.n229 VSS.n228 5.66767
R738 VSS.n213 VSS.n212 5.66767
R739 VSS.n480 VSS.n425 5.62674
R740 VSS.n108 VSS.n18 5.62581
R741 VSS.n104 VSS.n106 5.62581
R742 VSS.t9 VSS.n103 5.62581
R743 VSS.n113 VSS.t11 5.62581
R744 VSS.n115 VSS.n94 5.62581
R745 VSS.t133 VSS.n547 5.62581
R746 VSS.n549 VSS.n47 5.62581
R747 VSS.n550 VSS.n543 5.62581
R748 VSS.t6 VSS.n59 5.62581
R749 VSS.n557 VSS.n61 5.62581
R750 VSS.n560 VSS.n65 5.62581
R751 VSS.n10 VSS.n496 5.62581
R752 VSS.n487 VSS.n77 5.62484
R753 VSS.n488 VSS.n193 5.62484
R754 VSS.n500 VSS.n156 5.13648
R755 VSS.n117 VSS.t14 4.93147
R756 VSS.n158 VSS.n79 4.63796
R757 VSS.n211 VSS.t78 4.49152
R758 VSS.n239 VSS.t2 4.49152
R759 VSS.t87 VSS.n500 4.4712
R760 VSS.n172 VSS.t125 4.42202
R761 VSS.n46 VSS.n137 4.19639
R762 VSS.n530 VSS.n67 4.19244
R763 VSS.n46 VSS.n133 4.19225
R764 VSS.n10 VSS.n191 4.19225
R765 VSS.t91 VSS.n485 4.177
R766 VSS.n460 VSS.n445 3.9788
R767 VSS.n46 VSS.t127 3.37895
R768 VSS.n497 VSS.n10 3.32697
R769 VSS.n46 VSS.n81 3.32633
R770 VSS.n46 VSS.n140 3.32623
R771 VSS.n10 VSS.n181 3.32615
R772 VSS.t77 VSS.n219 3.30696
R773 VSS.n419 VSS.n73 3.19862
R774 VSS.n417 VSS.n73 3.19862
R775 VSS.n415 VSS.n73 3.19862
R776 VSS.n413 VSS.n73 3.19862
R777 VSS.n411 VSS.n73 3.19862
R778 VSS.n406 VSS.n73 3.19862
R779 VSS.n404 VSS.n73 3.19862
R780 VSS.n402 VSS.n73 3.19862
R781 VSS.n400 VSS.n73 3.19862
R782 VSS.n398 VSS.n73 3.19862
R783 VSS.n396 VSS.n73 3.19862
R784 VSS.n394 VSS.n73 3.19862
R785 VSS.n392 VSS.n73 3.19862
R786 VSS.n390 VSS.n73 3.19862
R787 VSS.n387 VSS.n73 3.19862
R788 VSS.n385 VSS.n73 3.19862
R789 VSS.n383 VSS.n73 3.19862
R790 VSS.n381 VSS.n73 3.19862
R791 VSS.n379 VSS.n73 3.19862
R792 VSS.n377 VSS.n73 3.19862
R793 VSS.n375 VSS.n73 3.19862
R794 VSS.n373 VSS.n73 3.19862
R795 VSS.n371 VSS.n73 3.19862
R796 VSS.n366 VSS.n73 3.19862
R797 VSS.n364 VSS.n73 3.19862
R798 VSS.n362 VSS.n73 3.19862
R799 VSS.n360 VSS.n73 3.19862
R800 VSS.n358 VSS.n73 3.19862
R801 VSS.n356 VSS.n73 3.19862
R802 VSS.n354 VSS.n73 3.19862
R803 VSS.n352 VSS.n73 3.19862
R804 VSS.n350 VSS.n73 3.19862
R805 VSS.n345 VSS.n73 3.19862
R806 VSS.n343 VSS.n73 3.19862
R807 VSS.n341 VSS.n73 3.19862
R808 VSS.n339 VSS.n73 3.19862
R809 VSS.n337 VSS.n73 3.19862
R810 VSS.n335 VSS.n73 3.19862
R811 VSS.n333 VSS.n73 3.19862
R812 VSS.n331 VSS.n73 3.19862
R813 VSS.n329 VSS.n73 3.19862
R814 VSS.n326 VSS.n73 3.19862
R815 VSS.n324 VSS.n73 3.19862
R816 VSS.n322 VSS.n73 3.19862
R817 VSS.n320 VSS.n73 3.19862
R818 VSS.n318 VSS.n73 3.19862
R819 VSS.n316 VSS.n73 3.19862
R820 VSS.n314 VSS.n73 3.19862
R821 VSS.n312 VSS.n73 3.19862
R822 VSS.n310 VSS.n73 3.19862
R823 VSS.n308 VSS.n73 3.19862
R824 VSS.n305 VSS.n73 3.19862
R825 VSS.n303 VSS.n73 3.19862
R826 VSS.n301 VSS.n73 3.19862
R827 VSS.n299 VSS.n73 3.19862
R828 VSS.n297 VSS.n73 3.19862
R829 VSS.n295 VSS.n73 3.19862
R830 VSS.n293 VSS.n73 3.19862
R831 VSS.n291 VSS.n73 3.19862
R832 VSS.n289 VSS.n73 3.19862
R833 VSS.n284 VSS.n73 3.19862
R834 VSS.n282 VSS.n73 3.19862
R835 VSS.n280 VSS.n73 3.19862
R836 VSS.n278 VSS.n73 3.19862
R837 VSS.n276 VSS.n73 3.19862
R838 VSS.n274 VSS.n73 3.19862
R839 VSS.n272 VSS.n73 3.19862
R840 VSS.n270 VSS.n73 3.19862
R841 VSS.n268 VSS.n73 3.19862
R842 VSS.n263 VSS.n73 3.19862
R843 VSS.n261 VSS.n73 3.19862
R844 VSS.n259 VSS.n73 3.19862
R845 VSS.n257 VSS.n73 3.19862
R846 VSS.n76 VSS.n418 3.19862
R847 VSS.n76 VSS.n416 3.19862
R848 VSS.n76 VSS.n414 3.19862
R849 VSS.n76 VSS.n412 3.19862
R850 VSS.n76 VSS.n410 3.19862
R851 VSS.n76 VSS.n407 3.19862
R852 VSS.n76 VSS.n405 3.19862
R853 VSS.n76 VSS.n403 3.19862
R854 VSS.n76 VSS.n401 3.19862
R855 VSS.n76 VSS.n399 3.19862
R856 VSS.n76 VSS.n397 3.19862
R857 VSS.n76 VSS.n395 3.19862
R858 VSS.n76 VSS.n393 3.19862
R859 VSS.n76 VSS.n391 3.19862
R860 VSS.n76 VSS.n386 3.19862
R861 VSS.n76 VSS.n384 3.19862
R862 VSS.n76 VSS.n382 3.19862
R863 VSS.n76 VSS.n380 3.19862
R864 VSS.n76 VSS.n378 3.19862
R865 VSS.n76 VSS.n376 3.19862
R866 VSS.n76 VSS.n374 3.19862
R867 VSS.n76 VSS.n372 3.19862
R868 VSS.n76 VSS.n370 3.19862
R869 VSS.n76 VSS.n367 3.19862
R870 VSS.n76 VSS.n365 3.19862
R871 VSS.n76 VSS.n363 3.19862
R872 VSS.n76 VSS.n361 3.19862
R873 VSS.n76 VSS.n359 3.19862
R874 VSS.n76 VSS.n357 3.19862
R875 VSS.n76 VSS.n355 3.19862
R876 VSS.n76 VSS.n353 3.19862
R877 VSS.n76 VSS.n351 3.19862
R878 VSS.n76 VSS.n349 3.19862
R879 VSS.n76 VSS.n346 3.19862
R880 VSS.n76 VSS.n344 3.19862
R881 VSS.n76 VSS.n342 3.19862
R882 VSS.n76 VSS.n340 3.19862
R883 VSS.n76 VSS.n338 3.19862
R884 VSS.n76 VSS.n336 3.19862
R885 VSS.n76 VSS.n334 3.19862
R886 VSS.n76 VSS.n332 3.19862
R887 VSS.n76 VSS.n330 3.19862
R888 VSS.n76 VSS.n325 3.19862
R889 VSS.n76 VSS.n323 3.19862
R890 VSS.n76 VSS.n321 3.19862
R891 VSS.n76 VSS.n319 3.19862
R892 VSS.n76 VSS.n317 3.19862
R893 VSS.n76 VSS.n315 3.19862
R894 VSS.n76 VSS.n313 3.19862
R895 VSS.n76 VSS.n311 3.19862
R896 VSS.n76 VSS.n309 3.19862
R897 VSS.n76 VSS.n304 3.19862
R898 VSS.n76 VSS.n302 3.19862
R899 VSS.n76 VSS.n300 3.19862
R900 VSS.n76 VSS.n298 3.19862
R901 VSS.n76 VSS.n296 3.19862
R902 VSS.n76 VSS.n294 3.19862
R903 VSS.n76 VSS.n292 3.19862
R904 VSS.n76 VSS.n290 3.19862
R905 VSS.n76 VSS.n288 3.19862
R906 VSS.n76 VSS.n285 3.19862
R907 VSS.n76 VSS.n283 3.19862
R908 VSS.n76 VSS.n281 3.19862
R909 VSS.n76 VSS.n279 3.19862
R910 VSS.n76 VSS.n277 3.19862
R911 VSS.n76 VSS.n275 3.19862
R912 VSS.n76 VSS.n273 3.19862
R913 VSS.n76 VSS.n271 3.19862
R914 VSS.n76 VSS.n269 3.19862
R915 VSS.n76 VSS.n267 3.19862
R916 VSS.n76 VSS.n264 3.19862
R917 VSS.n76 VSS.n262 3.19862
R918 VSS.n76 VSS.n260 3.19862
R919 VSS.n76 VSS.n258 3.19862
R920 VSS.n76 VSS.n199 3.19862
R921 VSS.n76 VSS.n420 3.19862
R922 VSS.n46 VSS.n70 0.156514
R923 VSS.n266 VSS.t28 2.96786
R924 VSS.t39 VSS.n368 2.96786
R925 VSS.n463 VSS.n79 2.7456
R926 VSS.n10 VSS.n165 2.74414
R927 VSS.n67 VSS.n528 2.65358
R928 VSS.n67 VSS.n527 2.65358
R929 VSS.n67 VSS.n526 2.65358
R930 VSS.n67 VSS.n508 2.65358
R931 VSS.n67 VSS.n509 2.65358
R932 VSS.n67 VSS.n510 2.65358
R933 VSS.n67 VSS.n511 2.65358
R934 VSS.n67 VSS.n524 2.65358
R935 VSS.n67 VSS.n523 2.65358
R936 VSS.n67 VSS.n522 2.65358
R937 VSS.n67 VSS.n521 2.65358
R938 VSS.n67 VSS.n513 2.65358
R939 VSS.n67 VSS.n514 2.65358
R940 VSS.n67 VSS.n515 2.65358
R941 VSS.n67 VSS.n516 2.65358
R942 VSS.n67 VSS.n517 2.65358
R943 VSS.n67 VSS.n518 2.65358
R944 VSS.n67 VSS.n519 2.65358
R945 VSS.n568 VSS.n67 2.32483
R946 VSS.n46 VSS.n130 2.32406
R947 VSS.t74 VSS.n148 2.06357
R948 VSS.n485 VSS.n483 2.06357
R949 VSS.n46 VSS.n141 2.01633
R950 VSS.n564 VSS.n67 2.00687
R951 VSS.n46 VSS.n125 2.00599
R952 VSS.n254 VSS.t77 1.97699
R953 VSS.t19 VSS.n252 1.80539
R954 VSS VSS.n79 1.77935
R955 VSS.n46 VSS.n86 1.7562
R956 VSS.n46 VSS.n93 1.75596
R957 VSS.n10 VSS.n161 1.75483
R958 VSS.t82 VSS.n200 1.72287
R959 VSS.n498 VSS.n159 1.66925
R960 VSS.n73 VSS.n72 1.55041
R961 VSS.n46 VSS.n135 1.43974
R962 VSS.n535 VSS.t134 1.43372
R963 VSS.n531 VSS.t136 1.43372
R964 VSS.t136 VSS.n532 1.42949
R965 VSS.t134 VSS.n536 1.42949
R966 VSS.t108 VSS.t112 1.41892
R967 VSS.t106 VSS.t111 1.41892
R968 VSS.t104 VSS.t110 1.41892
R969 VSS.t102 VSS.t109 1.41892
R970 VSS.t131 VSS.n90 1.37661
R971 VSS.t131 VSS.n91 1.37661
R972 VSS.n572 VSS.n80 1.32707
R973 VSS.n139 VSS.n572 1.30246
R974 VSS.t60 VSS.t58 1.25614
R975 VSS.t44 VSS.t42 1.24896
R976 VSS.t50 VSS.t48 1.18726
R977 VSS.t34 VSS.t32 1.18357
R978 VSS.t46 VSS.t45 1.18188
R979 VSS.t36 VSS.t34 1.17915
R980 VSS.t52 VSS.t50 1.17786
R981 VSS.t29 VSS.t30 1.1778
R982 VSS.t38 VSS.t40 1.17383
R983 VSS.t56 VSS.t54 1.17241
R984 VSS.t58 VSS.t56 1.16468
R985 VSS.t42 VSS.t40 1.15329
R986 VSS.n150 VSS.t91 1.12123
R987 VSS.t54 VSS.t52 1.11752
R988 VSS.t38 VSS.t36 1.11317
R989 VSS.t32 VSS.t29 1.10881
R990 VSS.t48 VSS.t46 1.10748
R991 VSS.t74 VSS.n146 1.09664
R992 VSS.n224 VSS.t69 1.08287
R993 VSS.n221 VSS.t84 1.04142
R994 VSS.n221 VSS.t21 1.0392
R995 VSS.n146 VSS.n147 1.02454
R996 VSS.n94 VSS.n32 0.959122
R997 VSS.n562 VSS.n561 0.932604
R998 VSS.n481 VSS.n74 0.606348
R999 VSS.n150 VSS.t87 0.885254
R1000 VSS.n563 VSS.n562 0.881792
R1001 VSS.n540 VSS.n32 0.84534
R1002 VSS.n253 VSS.n224 0.839803
R1003 VSS.n201 VSS.n194 0.832641
R1004 VSS.n481 VSS.n78 0.709635
R1005 VSS.t147 VSS.t149 0.806856
R1006 VSS.n169 VSS.t142 0.806855
R1007 VSS.t27 VSS.n182 0.802775
R1008 VSS.n46 VSS.n30 0.787095
R1009 VSS.n46 VSS.n34 0.786747
R1010 VSS.n46 VSS.n35 0.786747
R1011 VSS.n46 VSS.n36 0.786747
R1012 VSS.n46 VSS.n37 0.786747
R1013 VSS.n46 VSS.n38 0.786747
R1014 VSS.n46 VSS.n39 0.786747
R1015 VSS.n46 VSS.n40 0.786747
R1016 VSS.n46 VSS.n41 0.786747
R1017 VSS.n46 VSS.n42 0.786747
R1018 VSS.n46 VSS.n43 0.786747
R1019 VSS.n46 VSS.n44 0.786747
R1020 VSS.n46 VSS.n45 0.786747
R1021 VSS.n224 VSS.t19 0.756052
R1022 VSS.n201 VSS.t82 0.745491
R1023 VSS.t74 VSS.n150 0.728354
R1024 VSS.n569 VSS.t108 0.722582
R1025 VSS.n567 VSS.t106 0.722582
R1026 VSS.n565 VSS.t104 0.722582
R1027 VSS.n563 VSS.t102 0.722582
R1028 VSS.t112 VSS.n537 0.72222
R1029 VSS.t111 VSS.n538 0.72222
R1030 VSS.t110 VSS.n539 0.72222
R1031 VSS.t109 VSS.n540 0.72222
R1032 VSS.n486 VSS.n194 0.710589
R1033 VSS.t87 VSS.n146 0.699997
R1034 VSS.n493 VSS.n492 0.6955
R1035 VSS.n221 VSS.n220 0.662806
R1036 VSS.t82 VSS.t80 0.640187
R1037 VSS.n46 VSS.n32 0.601638
R1038 VSS.n76 VSS.n194 0.600028
R1039 VSS.n187 VSS.t152 0.595317
R1040 VSS.t150 VSS.n189 0.595317
R1041 VSS.n177 VSS.t146 0.595317
R1042 VSS.t144 VSS.n179 0.595317
R1043 VSS.n255 VSS.n254 0.588545
R1044 VSS.n244 VSS.t69 0.572871
R1045 VSS.t77 VSS.n217 0.572871
R1046 VSS.t74 VSS.n149 0.557126
R1047 VSS.n562 VSS.n67 0.556483
R1048 VSS.n2 VSS.n161 0.522138
R1049 VSS.t134 VSS.t136 0.492336
R1050 VSS.n238 VSS.n220 0.490843
R1051 VSS.n234 VSS.n220 0.490843
R1052 VSS.n232 VSS.n220 0.490843
R1053 VSS.n200 VSS.n195 0.490843
R1054 VSS.n241 VSS.t69 0.489061
R1055 VSS.t77 VSS.n215 0.489061
R1056 VSS.n463 VSS.n72 0.47741
R1057 VSS.t74 VSS.n501 0.477286
R1058 VSS.t74 VSS.n502 0.472981
R1059 VSS.n254 VSS.n156 0.465582
R1060 VSS.n486 VSS.t91 0.464894
R1061 VSS.n492 VSS.n72 0.460744
R1062 VSS.n188 VSS.n161 0.447055
R1063 VSS.n10 VSS.n4 0.431438
R1064 VSS.n92 VSS.n86 0.417336
R1065 VSS.n93 VSS.n89 0.417043
R1066 VSS.n93 VSS.n92 0.416074
R1067 VSS.n87 VSS.n86 0.415796
R1068 VSS.n500 VSS.n499 0.41014
R1069 VSS.n250 VSS.t24 0.400619
R1070 VSS.n569 VSS.n568 0.376066
R1071 VSS.n537 VSS.n130 0.375071
R1072 VSS.n533 VSS.n141 0.36227
R1073 VSS.n540 VSS.n125 0.339682
R1074 VSS.n565 VSS.n564 0.338265
R1075 VSS.n564 VSS.n563 0.338019
R1076 VSS.n539 VSS.n125 0.336516
R1077 VSS.n178 VSS.n165 0.31249
R1078 VSS.n538 VSS.n130 0.307271
R1079 VSS.n568 VSS.n567 0.306341
R1080 VSS.n219 VSS.n156 0.298621
R1081 VSS.n488 VSS.n487 0.293017
R1082 VSS.n497 VSS.n160 0.291601
R1083 VSS.n498 VSS.n497 0.287886
R1084 VSS.n104 VSS.n108 0.286439
R1085 VSS.n550 VSS.n549 0.286439
R1086 VSS.t9 VSS.n104 0.286439
R1087 VSS.t27 VSS.n181 0.2761
R1088 VSS.n181 VSS.n177 0.266107
R1089 VSS.n89 VSS.n81 0.265797
R1090 VSS.n81 VSS.n80 0.263915
R1091 VSS.t74 VSS.n506 0.255045
R1092 VSS.n147 VSS.n141 0.248324
R1093 VSS.n489 VSS.n488 0.244498
R1094 VSS.t21 VSS.n253 0.241078
R1095 VSS.t80 VSS.n255 0.241078
R1096 VSS.n551 VSS.n550 0.239006
R1097 VSS.n556 VSS.t6 0.239006
R1098 VSS.n558 VSS.n557 0.239006
R1099 VSS.n561 VSS.n560 0.239006
R1100 VSS.n548 VSS.t133 0.239006
R1101 VSS.n101 VSS.t9 0.239006
R1102 VSS.t11 VSS.t12 0.239006
R1103 VSS.n114 VSS.n94 0.238668
R1104 VSS.n549 VSS.n548 0.238668
R1105 VSS.n557 VSS.n556 0.238668
R1106 VSS.n560 VSS.n559 0.238668
R1107 VSS.t6 VSS.n541 0.238668
R1108 VSS.t133 VSS.n84 0.238668
R1109 VSS.n108 VSS.t7 0.238668
R1110 VSS.n99 VSS.t11 0.238668
R1111 VSS.n182 VSS.n165 0.238044
R1112 VSS.n533 VSS.n140 0.236315
R1113 VSS.n422 VSS.n480 0.233757
R1114 VSS.n480 VSS.n479 0.233419
R1115 VSS.n494 VSS.n191 0.225674
R1116 VSS.n191 VSS.n187 0.219424
R1117 VSS.n499 VSS.n158 0.20686
R1118 VSS.n159 VSS.n140 0.197153
R1119 VSS.n490 VSS.n489 0.195641
R1120 VSS.t139 VSS.n83 0.191235
R1121 VSS.n112 VSS.n110 0.191235
R1122 VSS.n109 VSS.n112 0.191235
R1123 VSS.n98 VSS.n101 0.191235
R1124 VSS.n99 VSS.n98 0.191235
R1125 VSS.t12 VSS.n97 0.191235
R1126 VSS.n97 VSS.n96 0.191235
R1127 VSS.n96 VSS.t13 0.191235
R1128 VSS.n114 VSS.n95 0.191235
R1129 VSS.n552 VSS.n551 0.191235
R1130 VSS.n553 VSS.n552 0.191235
R1131 VSS.n554 VSS.n553 0.191235
R1132 VSS.t5 VSS.n554 0.191235
R1133 VSS.n555 VSS.n542 0.191235
R1134 VSS.n541 VSS.n555 0.191235
R1135 VSS.n559 VSS.n558 0.191235
R1136 VSS.n2 VSS.n173 0.191235
R1137 VSS.n542 VSS.t5 0.191235
R1138 VSS.t7 VSS.n109 0.191235
R1139 VSS.t4 VSS.t139 0.191235
R1140 VSS.n110 VSS.t4 0.191235
R1141 VSS.n95 VSS.t13 0.191235
R1142 VSS.t152 VSS.t150 0.1875
R1143 VSS.t146 VSS.t144 0.1875
R1144 VSS.n465 VSS.t60 0.187025
R1145 VSS.n466 VSS.n465 0.187025
R1146 VSS.n467 VSS.n466 0.187025
R1147 VSS.n468 VSS.n467 0.187025
R1148 VSS.n469 VSS.n468 0.187025
R1149 VSS.n470 VSS.n469 0.187025
R1150 VSS.n471 VSS.n470 0.187025
R1151 VSS.n472 VSS.n471 0.187025
R1152 VSS.n473 VSS.n472 0.187025
R1153 VSS.n474 VSS.n473 0.187025
R1154 VSS.n475 VSS.n474 0.187025
R1155 VSS.n476 VSS.n475 0.187025
R1156 VSS.n477 VSS.n476 0.187025
R1157 VSS.n478 VSS.n477 0.187025
R1158 VSS.n479 VSS.n478 0.187025
R1159 VSS.t44 VSS.n422 0.187025
R1160 VSS.n138 VSS.n137 0.185168
R1161 VSS.n536 VSS.n133 0.181924
R1162 VSS.n530 VSS.n535 0.181543
R1163 VSS.t84 VSS.n219 0.177814
R1164 VSS.n92 VSS.t131 0.167615
R1165 VSS.n491 VSS.n490 0.167615
R1166 VSS.n531 VSS.n530 0.164808
R1167 VSS.n487 VSS.n486 0.164496
R1168 VSS.n532 VSS.n133 0.164424
R1169 VSS.n496 VSS.n493 0.156138
R1170 VSS.t50 VSS.n73 0.150099
R1171 VSS.n76 VSS.t34 0.14953
R1172 VSS.t127 VSS.n138 0.146818
R1173 VSS.t127 VSS.n139 0.145603
R1174 VSS.n147 VSS.n570 0.142012
R1175 VSS.t54 VSS.n73 0.139355
R1176 VSS.t46 VSS.n73 0.139321
R1177 VSS.n76 VSS.t29 0.138705
R1178 VSS.n76 VSS.t38 0.1387
R1179 VSS.n570 VSS.n531 0.138262
R1180 VSS.n159 VSS.n137 0.126532
R1181 VSS.t136 VSS.n533 0.1171
R1182 VSS.n90 VSS.n83 0.112118
R1183 VSS.n91 VSS.n84 0.112118
R1184 VSS.n76 VSS.t42 0.11129
R1185 VSS.n536 VSS.n132 0.104618
R1186 VSS.n535 VSS.n534 0.104618
R1187 VSS.t58 VSS.n73 0.103851
R1188 VSS.t147 VSS.n183 0.0971176
R1189 VSS.n493 VSS.n173 0.0971176
R1190 VSS.n496 VSS.n495 0.0958002
R1191 VSS.n495 VSS.n192 0.0955
R1192 VSS.n182 VSS.n164 0.093
R1193 VSS.t144 VSS.n180 0.0851154
R1194 VSS.t146 VSS.n178 0.0851154
R1195 VSS.t150 VSS.n190 0.0851154
R1196 VSS.t152 VSS.n188 0.0851154
R1197 VSS.n464 VSS.n463 0.0846176
R1198 VSS.n256 VSS.n201 0.0846176
R1199 VSS.n539 VSS.n126 0.08425
R1200 VSS.n566 VSS.n565 0.08425
R1201 VSS.n179 VSS.n174 0.08175
R1202 VSS.n189 VSS.n184 0.08175
R1203 VSS.n180 VSS.n167 0.08175
R1204 VSS.n190 VSS.n163 0.08175
R1205 VSS.n138 VSS.n136 0.0805
R1206 VSS.n90 VSS.n82 0.0796176
R1207 VSS.n91 VSS.n85 0.0796176
R1208 VSS.n89 VSS.n82 0.0758676
R1209 VSS.n87 VSS.n85 0.0758676
R1210 VSS.n532 VSS.n136 0.07425
R1211 VSS.t142 VSS.n8 0.0740901
R1212 VSS.n170 VSS.n169 0.0740901
R1213 VSS.t45 VSS.n464 0.0708676
R1214 VSS.t30 VSS.n256 0.0708676
R1215 VSS.n538 VSS.n126 0.06925
R1216 VSS.n567 VSS.n566 0.06925
R1217 VSS.n177 VSS.n176 0.0671176
R1218 VSS.n187 VSS.n186 0.0671176
R1219 VSS.n178 VSS.n166 0.0671176
R1220 VSS.n188 VSS.n162 0.0671176
R1221 VSS.n179 VSS.n176 0.0621177
R1222 VSS.n189 VSS.n186 0.0621177
R1223 VSS.n180 VSS.n166 0.0621177
R1224 VSS.n190 VSS.n162 0.0621177
R1225 VSS.n10 VSS.n0 0.0235439
R1226 VSS.n183 VSS.t27 0.0571176
R1227 VSS VSS.n139 0.0555
R1228 VSS.n537 VSS.n132 0.0496177
R1229 VSS.n534 VSS.n569 0.0496177
R1230 VSS.t149 VSS.n164 0.04925
R1231 VSS.n184 VSS.t147 0.04675
R1232 VSS.t149 VSS.n163 0.04675
R1233 VSS.n174 VSS.n157 0.0305
R1234 VSS.n168 VSS.n167 0.0305
R1235 VSS.n170 VSS.n160 0.0253401
R1236 VSS.n498 VSS.n8 0.0253401
R1237 VSS.n492 VSS.n491 0.0214413
R1238 VSS.n242 VSS.t69 0.0184075
R1239 VSS.t77 VSS.n216 0.0184075
R1240 VSS.t74 VSS.n503 0.0173993
R1241 VSS.t142 VSS.n157 0.01675
R1242 VSS.n169 VSS.n168 0.01675
R1243 VSS.n248 VSS.t24 0.0151406
R1244 VSS.n236 VSS.n220 0.0151406
R1245 VSS.n235 VSS.n220 0.0151406
R1246 VSS.n209 VSS.n200 0.0151406
R1247 VSS.t74 VSS.n154 0.0150892
R1248 VSS.n494 VSS.n192 0.013
R1249 VSS.n572 VSS.n46 0.00994139
R1250 VSS.n24 VSS.n113 0.00495229
R1251 VSS.n10 VSS.n7 0.00419011
R1252 VSS.n54 VSS.n53 0.00349933
R1253 VSS.n51 VSS.n50 0.00249999
R1254 VSS.n12 VSS.n111 0.00283308
R1255 VSS.n66 VSS.n65 0.00224999
R1256 VSS.n60 VSS.n59 0.00224999
R1257 VSS.n115 VSS.n29 0.00224999
R1258 VSS.n113 VSS.n22 0.00224999
R1259 VSS.n461 VSS.n73 0.0022
R1260 VSS.n10 VSS.n9 0.00212213
R1261 VSS.n458 VSS.n424 0.00166667
R1262 VSS.n107 VSS.n106 0.00166667
R1263 VSS.n105 VSS.n103 0.00166667
R1264 VSS.n102 VSS.n100 0.00166667
R1265 VSS.n46 VSS.n33 0.00166667
R1266 VSS.n49 VSS.n48 0.00169993
R1267 VSS.n544 VSS.n543 0.00166667
R1268 VSS.n52 VSS.n51 0.00149995
R1269 VSS.n63 VSS.n62 0.00169993
R1270 VSS.n545 VSS.n64 0.00166667
R1271 VSS.n69 VSS.n68 0.00158327
R1272 VSS.n196 VSS.n75 0.00166667
R1273 VSS.n77 VSS.n76 0.0015
R1274 VSS.n71 VSS.n75 0.0015
R1275 VSS.n46 VSS.n31 0.0015
R1276 VSS.n68 VSS.n67 0.0015
R1277 VSS.n252 VSS.t24 0.00136832
R1278 VSS.n18 VSS.n107 0.00133332
R1279 VSS.n106 VSS.n105 0.00133332
R1280 VSS.n103 VSS.n102 0.00133332
R1281 VSS.n33 VSS.n115 0.00133332
R1282 VSS.n544 VSS.n47 0.00133332
R1283 VSS.n545 VSS.n61 0.00133332
R1284 VSS.n78 VSS.n77 0.0011042
R1285 VSS.n196 VSS.n193 0.00133332
R1286 VSS.n458 VSS.n425 0.00133332
R1287 VSS.n10 VSS.n6 0.00132085
R1288 VSS.n10 VSS.n5 0.00132021
R1289 VSS.n111 VSS.n31 0.001
R1290 VSS.n15 VSS.n14 0.001
R1291 VSS.n19 VSS.n18 0.001
R1292 VSS.n21 VSS.n20 0.00183322
R1293 VSS.n28 VSS.n27 0.001
R1294 VSS.n27 VSS.n29 0.00174999
R1295 VSS.n547 VSS.n46 0.001
R1296 VSS.n57 VSS.n56 0.00124999
R1297 VSS.n60 VSS.n58 0.00174999
R1298 VSS.n66 VSS.n64 0.00174999
R1299 VSS.n62 VSS.n61 0.0015
R1300 VSS.n56 VSS.n58 0.0015
R1301 VSS.n50 VSS.n54 0.0015
R1302 VSS.n48 VSS.n47 0.0015
R1303 VSS.n67 VSS.n46 0.0015
R1304 VSS.n100 VSS.n21 0.0015
R1305 VSS.n17 VSS.n16 0.00199984
R1306 VSS.n14 VSS.n17 0.0015
R1307 VSS.n10 VSS.n3 0.00125
R1308 VSS.n485 VSS.n151 0.001
R1309 VSS.t74 VSS.n151 0.001
R1310 VSS.n73 VSS.n71 0.00129999
R1311 VSS.n225 VSS.t69 0.001
R1312 VSS.n227 VSS.t69 0.001
R1313 VSS.n226 VSS.n223 0.001
R1314 VSS.n228 VSS.n220 0.001
R1315 VSS.t77 VSS.n204 0.001
R1316 VSS.t77 VSS.n214 0.001
R1317 VSS.n207 VSS.n203 0.001
R1318 VSS.n212 VSS.n200 0.001
R1319 VSS.n225 VSS.t24 0.001
R1320 VSS.n227 VSS.n223 0.001
R1321 VSS.n226 VSS.n222 0.001
R1322 VSS.n228 VSS.n222 0.001
R1323 VSS.n220 VSS.n204 0.001
R1324 VSS.n214 VSS.n203 0.001
R1325 VSS.n207 VSS.n202 0.001
R1326 VSS.n212 VSS.n202 0.001
R1327 VSS.n462 VSS.n461 0.001
R1328 VSS.n441 VSS.n440 0.001
R1329 VSS.n444 VSS.n440 0.001
R1330 VSS.n446 VSS.n438 0.001
R1331 VSS.n447 VSS.n437 0.001
R1332 VSS.n448 VSS.n436 0.001
R1333 VSS.n449 VSS.n435 0.001
R1334 VSS.n450 VSS.n434 0.001
R1335 VSS.n451 VSS.n433 0.001
R1336 VSS.n443 VSS.n433 0.001
R1337 VSS.n452 VSS.n431 0.001
R1338 VSS.n453 VSS.n430 0.001
R1339 VSS.n454 VSS.n429 0.001
R1340 VSS.n455 VSS.n428 0.001
R1341 VSS.n442 VSS.n428 0.001
R1342 VSS.n456 VSS.n426 0.001
R1343 VSS.n457 VSS.n425 0.001
R1344 VSS.n459 VSS.n424 0.001
R1345 VSS.n423 VSS.n421 0.001
R1346 VSS.n462 VSS.n441 0.001
R1347 VSS.n444 VSS.n439 0.001
R1348 VSS.n446 VSS.n439 0.001
R1349 VSS.n447 VSS.n438 0.001
R1350 VSS.n448 VSS.n437 0.001
R1351 VSS.n449 VSS.n436 0.001
R1352 VSS.n450 VSS.n435 0.001
R1353 VSS.n451 VSS.n434 0.001
R1354 VSS.n443 VSS.n432 0.001
R1355 VSS.n452 VSS.n432 0.001
R1356 VSS.n453 VSS.n431 0.001
R1357 VSS.n454 VSS.n430 0.001
R1358 VSS.n455 VSS.n429 0.001
R1359 VSS.n442 VSS.n427 0.001
R1360 VSS.n456 VSS.n427 0.001
R1361 VSS.n457 VSS.n426 0.001
R1362 VSS.n459 VSS.n423 0.001
R1363 VSS.n76 VSS.n421 0.001
R1364 VSS.n3 VSS.n2 8.47794
R1365 VSS.n3 VSS.n1 8.50175
C310 DELAY_VBIASP VSS 4.41492f
C311 DELAY_OUT_LAST VSS 2.65853f
C312 DELAY_VBIASN VSS 99.4221f
C313 DELAY_IN VSS 3.31101f
C314 DLL_RESETN VSS 4.6876f
C315 VDD VSS 14.20096f
C316 a_9712_1285# VSS 1.59068f ; **FLOATING
C317 a_9444_1285# VSS 2.15703f ; **FLOATING
C318 a_5778_740# VSS 5.33396f ; **FLOATING
C319 a_15464_1057# VSS 0.75544f ; **FLOATING
C320 a_14757_2555# VSS 0.09495f ; **FLOATING
C321 a_13880_2491# VSS 0.06985f ; **FLOATING
C322 a_15688_2776# VSS 0.26291f ; **FLOATING
C323 a_15108_2698# VSS 0.24458f ; **FLOATING
C324 a_14851_2555# VSS 0.38123f ; **FLOATING
C325 a_9444_1963# VSS 6.08462f ; **FLOATING
C326 a_14111_2600# VSS 0.19866f ; **FLOATING
C327 a_14009_2457# VSS 0.44622f ; **FLOATING
C328 a_13592_2796# VSS 1.57456f ; **FLOATING
C329 a_13306_2478# VSS 0.30095f ; **FLOATING
C330 a_13566_2701# VSS 0.15441f ; **FLOATING
C331 a_13132_2793# VSS 0.13036f ; **FLOATING
C332 a_12907_2793# VSS 0.14377f ; **FLOATING
C333 a_12907_2559# VSS 0.14861f ; **FLOATING
C334 a_13106_2730# VSS 0.06343f ; **FLOATING
C335 a_15304_1978# VSS 0.37009f ; **FLOATING
C336 a_14757_3601# VSS 0.09586f ; **FLOATING
C337 a_15688_3240# VSS 0.26405f ; **FLOATING
C338 a_14851_3601# VSS 0.39588f ; **FLOATING
C339 a_15108_3482# VSS 0.24582f ; **FLOATING
C340 a_14111_3251# VSS 0.21915f ; **FLOATING
C341 a_13880_3665# VSS 0.07345f ; **FLOATING
C342 a_14009_3251# VSS 0.48187f ; **FLOATING
C343 a_13592_3244# VSS 1.58208f ; **FLOATING
C344 a_13566_3208# VSS 0.15442f ; **FLOATING
C345 a_13045_3588# VSS 0.01124f ; **FLOATING
C346 a_13306_3678# VSS 0.31701f ; **FLOATING
C347 a_12849_3240# VSS 1.40248f ; **FLOATING
C348 a_13121_3204# VSS 0.80439f ; **FLOATING
C349 a_13019_3204# VSS 2.18888f ; **FLOATING
C350 a_12656_3237# VSS 0.28393f ; **FLOATING
C351 a_12355_3240# VSS 0.62262f ; **FLOATING
C352 a_11397_3601# VSS 0.09495f ; **FLOATING
C353 a_12158_3240# VSS 0.25874f ; **FLOATING
C354 a_11491_3601# VSS 0.30073f ; **FLOATING
C355 a_11748_3482# VSS 0.17021f ; **FLOATING
C356 a_10751_3251# VSS 0.19918f ; **FLOATING
C357 a_10520_3665# VSS 0.03671f ; **FLOATING
C358 a_10649_3251# VSS 0.47308f ; **FLOATING
C359 a_10232_3244# VSS 1.52123f ; **FLOATING
C360 a_10206_3208# VSS 0.08466f ; **FLOATING
C361 a_9946_3678# VSS 0.18126f ; **FLOATING
C362 a_9772_3216# VSS 0.12435f ; **FLOATING
C363 a_9746_3178# VSS 0.06613f ; **FLOATING
C364 a_9547_3545# VSS 0.16037f ; **FLOATING
C365 a_9547_3315# VSS 0.11966f ; **FLOATING
C366 a_6854_2827# VSS 3.66026f ; **FLOATING
C367 a_6126_1189# VSS 13.8075f ; **FLOATING
C368 a_6854_3359# VSS 1.21519f ; **FLOATING
C369 a_5974_3096# VSS 2.40124f ; **FLOATING
C370 a_6326_1963# VSS 1.03474f ; **FLOATING
C371 VSS.t127 VSS 3.31349f ; **FLOATING
C372 VDD.t31 VSS 4.06862f ; **FLOATING
C373 VDD.t83 VSS 0.02694f ; **FLOATING
C374 VDD.n0 VSS 0.02184f ; **FLOATING
C375 VDD.n1 VSS 0.01769f ; **FLOATING
C376 VDD.n2 VSS 0.01158f ; **FLOATING
C377 VDD.n3 VSS 0.05893f ; **FLOATING
C378 VDD.t75 VSS 0.01495f ; **FLOATING
C379 VDD.n4 VSS 0.10534f ; **FLOATING
C380 VDD.t18 VSS 6.61111f ; **FLOATING
C381 VDD.t34 VSS 0.02947f ; **FLOATING
C382 VDD.t47 VSS 0.02947f ; **FLOATING
C383 VDD.n5 VSS 0.10062f ; **FLOATING
C384 VDD.n6 VSS 0.01266f ; **FLOATING
C385 VDD.t35 VSS 0.03564f ; **FLOATING
C386 VDD.t45 VSS 0.03564f ; **FLOATING
C387 VDD.n7 VSS 0.11347f ; **FLOATING
C388 VDD.n8 VSS 0.06006f ; **FLOATING
C389 VDD.t73 VSS 0.02571f ; **FLOATING
C390 VDD.t72 VSS 0.01834f ; **FLOATING
C391 VDD.t74 VSS 0.02839f ; **FLOATING
C392 VDD.t76 VSS 0.02585f ; **FLOATING
C393 VDD.t78 VSS 0.02587f ; **FLOATING
C394 VDD.t77 VSS 0.01834f ; **FLOATING
C395 VDD.t79 VSS 0.02839f ; **FLOATING
C396 VDD.t80 VSS 0.01494f ; **FLOATING
C397 VDD.t81 VSS 0.02579f ; **FLOATING
C398 VDD.t49 VSS 0.02789f ; **FLOATING
C399 VDD.t52 VSS 0.01897f ; **FLOATING
C400 VDD.n9 VSS 0.2546f ; **FLOATING
C401 VDD.n10 VSS 0.02182f ; **FLOATING
C402 VDD.t38 VSS 0.02095f ; **FLOATING
C403 VDD.t42 VSS 0.02095f ; **FLOATING
C404 VDD.n11 VSS 0.06221f ; **FLOATING
C405 VDD.n12 VSS 0.02952f ; **FLOATING
C406 VDD.t37 VSS 0.04835f ; **FLOATING
C407 VDD.n13 VSS 0.01958f ; **FLOATING
C408 VDD.t41 VSS 0.04835f ; **FLOATING
C409 VDD.n14 VSS 0.01958f ; **FLOATING
C410 VDD.n15 VSS 0.04323f ; **FLOATING
C411 VDD.n16 VSS 0.01149f ; **FLOATING
C412 VDD.t26 VSS 0.02848f ; **FLOATING
C413 VDD.n17 VSS 0.05121f ; **FLOATING
C414 VDD.n18 VSS 0.02815f ; **FLOATING
C415 VDD.t54 VSS 0.0263f ; **FLOATING
C416 VDD.n19 VSS 0.06103f ; **FLOATING
C417 VDD.n20 VSS 0.01606f ; **FLOATING
C418 VDD.t21 VSS 0.02947f ; **FLOATING
C419 VDD.n21 VSS 0.13166f ; **FLOATING
C420 VDD.t19 VSS 0.04835f ; **FLOATING
C421 VDD.n22 VSS 0.01958f ; **FLOATING
C422 VDD.t24 VSS 0.02095f ; **FLOATING
C423 VDD.n23 VSS 0.11792f ; **FLOATING
C424 VDD.n24 VSS 0.02954f ; **FLOATING
C425 VDD.n25 VSS 0.01247f ; **FLOATING
C426 VDD.n26 VSS 0.02859f ; **FLOATING
C427 VDD.n27 VSS 0.02492f ; **FLOATING
C428 VDD.n28 VSS 0.02846f ; **FLOATING
C429 VDD.n29 VSS 0.0286f ; **FLOATING
C430 VDD.n30 VSS 0.01258f ; **FLOATING
C431 VDD.n31 VSS 1.40445f ; **FLOATING
C432 VDD.t17 VSS 0.01735f ; **FLOATING
C433 VDD.n32 VSS 1.37842f ; **FLOATING
C434 VDD.n33 VSS 0.01227f ; **FLOATING
C435 VDD.n34 VSS 0.01252f ; **FLOATING
C436 VDD.n35 VSS 0.05421f ; **FLOATING
C437 VDD.t10 VSS 0.0507f ; **FLOATING
C438 VDD.n36 VSS 0.0177f ; **FLOATING
C439 VDD.n37 VSS 0.03966f ; **FLOATING
C440 VDD.t63 VSS 0.04536f ; **FLOATING
C441 VDD.n38 VSS 0.01768f ; **FLOATING
C442 VDD.t69 VSS 0.04536f ; **FLOATING
C443 VDD.n39 VSS 0.91435f ; **FLOATING
C444 VDD.n40 VSS 0.01769f ; **FLOATING
C445 VDD.n41 VSS 0.03582f ; **FLOATING
C446 VDD.t61 VSS 0.28686f ; **FLOATING
C447 VDD.n42 VSS 0.01158f ; **FLOATING
C448 VDD.n43 VSS 0.03581f ; **FLOATING
C449 VDD.t1 VSS 0.0507f ; **FLOATING
C450 VDD.n44 VSS 0.0177f ; **FLOATING
C451 VDD.n45 VSS 0.05416f ; **FLOATING
C452 VDD.n46 VSS 0.02862f ; **FLOATING
C453 VDD.n47 VSS 0.06896f ; **FLOATING
C454 VDD.t11 VSS 0.0507f ; **FLOATING
C455 VDD.n48 VSS 0.03289f ; **FLOATING
C456 VDD.t2 VSS 0.0507f ; **FLOATING
C457 VDD.n49 VSS 0.0329f ; **FLOATING
C458 VDD.n50 VSS 0.06896f ; **FLOATING
C459 VDD.n51 VSS 0.02493f ; **FLOATING
C460 VDD.n52 VSS 0.06913f ; **FLOATING
C461 VDD.t12 VSS 0.0507f ; **FLOATING
C462 VDD.n53 VSS 0.03289f ; **FLOATING
C463 VDD.t4 VSS 0.0507f ; **FLOATING
C464 VDD.n54 VSS 0.0329f ; **FLOATING
C465 VDD.n55 VSS 0.06909f ; **FLOATING
C466 VDD.n56 VSS 0.02852f ; **FLOATING
C467 VDD.n57 VSS 0.06534f ; **FLOATING
C468 VDD.t15 VSS 0.0507f ; **FLOATING
C469 VDD.n58 VSS 0.03289f ; **FLOATING
C470 VDD.t7 VSS 0.0507f ; **FLOATING
C471 VDD.n59 VSS 0.0329f ; **FLOATING
C472 VDD.n60 VSS 0.0653f ; **FLOATING
C473 VDD.n61 VSS 0.02857f ; **FLOATING
C474 VDD.n62 VSS 0.01252f ; **FLOATING
C475 VDD.t66 VSS 0.04536f ; **FLOATING
C476 VDD.t71 VSS 0.04536f ; **FLOATING
C477 VDD.n63 VSS 0.05877f ; **FLOATING
C478 VDD.t9 VSS 0.0507f ; **FLOATING
C479 VDD.n64 VSS 0.05423f ; **FLOATING
C480 VDD.n65 VSS 0.0177f ; **FLOATING
C481 VDD.n66 VSS 0.05419f ; **FLOATING
C482 VDD.t5 VSS 0.0507f ; **FLOATING
C483 VDD.n67 VSS 0.0177f ; **FLOATING
C484 VDD.n68 VSS 0.03581f ; **FLOATING
C485 VDD.t64 VSS 0.28686f ; **FLOATING
C486 VDD.n69 VSS 0.01768f ; **FLOATING
C487 VDD.n70 VSS 0.06459f ; **FLOATING
C488 VDD.n71 VSS 0.0376f ; **FLOATING
C489 VDD.t0 VSS 9.98751f ; **FLOATING
.ends
