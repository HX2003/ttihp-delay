* NGSPICE file created from hx_dll_controller.ext - technology: ihp-sg13g2

.subckt hx_dll_controller VDD VSS DLL_RESETN DELAY_OUT_LAST DELAY_IN DELAY_VBIASN
+ DELAY_VBIASP
X0 VSS.t84 a_12849_3240# a_13400_3678# VSS.t83 sg13_lv_nmos ad=0.1626p pd=1.415u as=60.89999f ps=0.71u w=0.42u l=0.13u
X1 VSS.t150 VSS.t150 VSS.t152 VSS.t151 sg13_lv_nmos ad=0.1406p pd=1.12u as=0 ps=0 w=0.74u l=0.13u
X2 VSS.t91 a_14851_2555# a_15688_2776# VSS.t96 sg13_lv_nmos ad=0.1406p pd=1.12u as=0.2516p ps=2.16u w=0.74u l=0.13u
X3 a_6854_2827# a_6326_1963# VDD.t10 VDD.t0 sg13_lv_pmos ad=0.38p pd=2.38u as=0.38p ps=2.38u w=2u l=1u
X4 VSS.t110 a_9444_1963# a_9444_1285# VSS.t103 sg13_lv_nmos ad=0.68p pd=4.68u as=0.38p ps=2.38u w=2u l=1u
X5 VDD.t12 a_6326_1963# a_6126_1189# VDD.t0 sg13_lv_pmos ad=0.38p pd=2.38u as=0.38p ps=2.38u w=2u l=1u
X6 a_9946_3678# a_9772_3216# VDD.t22 VDD.t0 sg13_lv_pmos ad=79.8f pd=0.8u as=0.1428p ps=1.52u w=0.42u l=0.13u
X7 a_9712_1285# a_6854_2827# a_9444_1285# VSS.t14 sg13_lv_nmos ad=0.38p pd=2.38u as=0.68p ps=4.68u w=2u l=1u
X8 a_6854_3359# a_15304_1978# DELAY_VBIASN VDD.t31 sg13_lv_pmos ad=0.136p pd=1.14u as=0.158p ps=1.245u w=0.4u l=0.2u
X9 a_9444_1285# a_9444_1963# VSS.t109 VSS.t101 sg13_lv_nmos ad=0.38p pd=2.38u as=0.68p ps=4.68u w=2u l=1u
X10 a_6326_1963# a_6126_1189# a_5778_740# VSS.t3 sg13_lv_nmos ad=0.38p pd=2.38u as=0.68p ps=4.68u w=2u l=1u
X11 a_6854_2827# a_6326_1963# VDD.t7 VDD.t0 sg13_lv_pmos ad=0.38p pd=2.38u as=0.38p ps=2.38u w=2u l=1u
X12 VSS.t91 a_15108_2698# a_14757_2555# VSS.t124 sg13_lv_nmos ad=79.8f pd=0.8u as=0.1428p ps=1.52u w=0.42u l=0.13u
X13 a_14009_3251# DELAY_IN VSS.t77 VSS.t118 sg13_lv_nmos ad=0.2516p pd=2.16u as=1.9998p ps=12.915u w=0.74u l=0.13u
X14 VSS.t58 DELAY_VBIASN VSS.t56 VSS.t41 sg13_lv_nmos ad=1.33p pd=7.38u as=0 ps=0 w=7u l=7u
X15 a_9746_3178# a_9547_3315# VSS.t24 VSS.t25 sg13_lv_nmos ad=0.27427p pd=2.28u as=2.39977p ps=15.495u w=0.795u l=0.13u
X16 VSS.t19 DLL_RESETN a_10040_3678# VSS.t18 sg13_lv_nmos ad=0.1626p pd=1.415u as=60.89999f ps=0.71u w=0.42u l=0.13u
X17 a_13949_2869# a_13592_2796# VDD.t42 VDD.t0 sg13_lv_pmos ad=63f pd=0.72u as=0.1563p ps=1.22u w=0.42u l=0.13u
X18 VSS.t136 VSS.t134 VSS.t134 VSS.t135 sg13_lv_nmos ad=0.68p pd=4.68u as=0 ps=0 w=2u l=1u
X19 a_9772_3216# a_9746_3178# VDD.t18 VDD.t0 sg13_lv_pmos ad=0.3927p pd=2.99u as=1.10612p ps=6.66u w=1.155u l=0.13u
X20 a_13121_3204# a_15688_3240# VDD.t34 VDD.t0 sg13_lv_pmos ad=0.3808p pd=2.92u as=0.2128p ps=1.5u w=1.12u l=0.13u
X21 a_15108_3482# a_14851_3601# a_15270_3678# VSS.t78 sg13_lv_nmos ad=0.1428p pd=1.52u as=37.8f ps=0.6u w=0.42u l=0.13u
X22 VSS.t74 a_12907_2559# a_12907_2559# VSS.t119 sg13_lv_nmos ad=1.45407p pd=9.445u as=0.111p ps=1.34u w=0.3u l=0.13u
X23 VDD.t79 VDD.t77 VDD.t78 VDD.t31 sg13_lv_pmos ad=0.3808p pd=2.92u as=0 ps=0 w=1.12u l=0.13u
X24 VSS.t139 VSS.t131 VSS.t131 VSS.t132 sg13_lv_nmos ad=0.68p pd=4.68u as=0 ps=0 w=2u l=1u
X25 a_15108_2698# a_12849_3240# VDD.t18 VDD.t0 sg13_lv_pmos ad=79.8f pd=0.8u as=1.03698p ps=6.245u w=0.42u l=0.13u
X26 a_13121_3204# a_15688_3240# VSS.t82 VSS.t93 sg13_lv_nmos ad=0.2516p pd=2.16u as=0.1406p ps=1.12u w=0.74u l=0.13u
X27 VDD.t74 VDD.t75 VDD.t76 VDD.t31 sg13_lv_pmos ad=0.2128p pd=1.5u as=0 ps=0 w=1.12u l=0.13u
X28 a_5974_3096# a_6126_1189# VSS.t11 VSS.t0 sg13_lv_nmos ad=0.38p pd=2.38u as=0.68p ps=4.68u w=2u l=1u
X29 VDD.t17 a_5974_3096# a_5974_3096# VDD.t0 sg13_lv_pmos ad=0.2448p pd=2.08u as=0.2826p ps=2.29u w=0.36u l=2u
X30 VSS.t21 a_11748_3482# a_11397_3601# VSS.t2 sg13_lv_nmos ad=79.8f pd=0.8u as=0.1428p ps=1.52u w=0.42u l=0.13u
X31 VSS.t60 DELAY_VBIASN VSS.t58 VSS.t43 sg13_lv_nmos ad=1.33p pd=7.38u as=0 ps=0 w=7u l=7u
X32 a_6326_1963# a_6126_1189# a_5778_740# VSS.t3 sg13_lv_nmos ad=0.38p pd=2.38u as=0.68p ps=4.68u w=2u l=1u
X33 VDD.t69 VDD.t61 VDD.t10 VDD.t0 sg13_lv_pmos ad=0.68p pd=4.68u as=0 ps=0 w=2u l=1u
X34 VSS.t36 DELAY_VBIASN VSS.t38 VSS.t37 sg13_lv_nmos ad=1.33p pd=7.38u as=0 ps=0 w=7u l=7u
X35 a_13306_2478# a_13132_2793# VDD.t84 VDD.t0 sg13_lv_pmos ad=79.8f pd=0.8u as=0.1428p ps=1.52u w=0.42u l=0.13u
X36 a_6126_1189# a_6126_1189# VSS.t5 VSS.t3 sg13_lv_nmos ad=0.38p pd=2.38u as=0.68p ps=4.68u w=2u l=1u
X37 a_6326_1963# a_6326_1963# VDD.t2 VDD.t0 sg13_lv_pmos ad=0.38p pd=2.38u as=0.38p ps=2.38u w=2u l=1u
X38 a_13592_3244# a_13566_3208# VSS.t84 VSS.t83 sg13_lv_nmos ad=0.2516p pd=2.16u as=0.1626p ps=1.415u w=0.74u l=0.13u
X39 VSS.t54 DELAY_VBIASN VSS.t52 VSS.t37 sg13_lv_nmos ad=1.33p pd=7.38u as=0 ps=0 w=7u l=7u
X40 VDD.t7 a_6326_1963# a_6126_1189# VDD.t0 sg13_lv_pmos ad=0.38p pd=2.38u as=0.38p ps=2.38u w=2u l=1u
X41 VDD.t18 a_11491_3601# a_11748_3482# VDD.t0 sg13_lv_pmos ad=1.10612p pd=6.66u as=79.8f ps=0.8u w=0.42u l=0.13u
X42 VSS.t50 DELAY_VBIASN VSS.t48 VSS.t33 sg13_lv_nmos ad=1.33p pd=7.38u as=0 ps=0 w=7u l=7u
X43 VDD.t83 DELAY_VBIASP DELAY_VBIASP VDD.t31 sg13_lv_pmos ad=0.3808p pd=2.92u as=1.0304p ps=4.08u w=1.12u l=0.6u
X44 VSS.t42 DELAY_VBIASN VSS.t44 VSS.t43 sg13_lv_nmos ad=1.33p pd=7.38u as=0 ps=0 w=7u l=7u
X45 VDD.t2 a_6326_1963# a_6854_3359# VDD.t0 sg13_lv_pmos ad=0.38p pd=2.38u as=0.38p ps=2.38u w=2u l=1u
X46 a_13132_2793# a_13106_2730# VDD.t18 VDD.t0 sg13_lv_pmos ad=0.3927p pd=2.99u as=1.10612p ps=6.66u w=1.155u l=0.13u
X47 a_14009_3251# DELAY_IN VDD.t18 VDD.t0 sg13_lv_pmos ad=0.4088p pd=2.97u as=1.03698p ps=6.245u w=1.12u l=0.13u
X48 a_15108_3482# a_12849_3240# VDD.t18 VDD.t0 sg13_lv_pmos ad=79.8f pd=0.8u as=1.03698p ps=6.245u w=0.42u l=0.13u
X49 VSS.t56 DELAY_VBIASN VSS.t54 VSS.t39 sg13_lv_nmos ad=1.33p pd=7.38u as=0 ps=0 w=7u l=7u
X50 VDD.t21 a_11491_3601# a_12158_3240# VDD.t0 sg13_lv_pmos ad=0.2128p pd=1.5u as=0.3864p ps=2.93u w=1.12u l=0.13u
X51 a_5778_740# VSS.t127 VSS.t126 rppd l=32u w=1u
X52 VSS.t108 a_9444_1963# a_9444_1285# VSS.t107 sg13_lv_nmos ad=0.68p pd=4.68u as=0.38p ps=2.38u w=2u l=1u
X53 a_13880_2491# a_14111_2600# a_13566_2701# VSS.t129 sg13_lv_nmos ad=0.2373p pd=1.97u as=79.8f ps=0.8u w=0.42u l=0.13u
X54 VSS.t21 a_11491_3601# a_12158_3240# VSS.t20 sg13_lv_nmos ad=0.1406p pd=1.12u as=0.2516p ps=2.16u w=0.74u l=0.13u
X55 a_11693_3363# a_10751_3251# a_11491_3601# VDD.t0 sg13_lv_pmos ad=93.45f pd=0.865u as=0.2048p ps=1.63u w=0.42u l=0.13u
X56 a_13306_3678# a_12355_3240# VDD.t27 VDD.t0 sg13_lv_pmos ad=79.8f pd=0.8u as=0.1428p ps=1.52u w=0.42u l=0.13u
X57 VDD.t18 a_12907_2559# a_12907_2793# VDD.t0 sg13_lv_pmos ad=1.10612p pd=6.66u as=0.2442p ps=2.06u w=0.66u l=0.13u
X58 a_13566_2701# a_14009_2457# a_13949_2869# VDD.t0 sg13_lv_pmos ad=79.8f pd=0.8u as=63f ps=0.72u w=0.42u l=0.13u
X59 a_13306_3678# a_14111_3251# a_13566_3208# VDD.t0 sg13_lv_pmos ad=0.1428p pd=1.52u as=79.8f ps=0.8u w=0.42u l=0.13u
X60 a_13106_2730# a_12907_2793# VSS.t74 VSS.t98 sg13_lv_nmos ad=0.27427p pd=2.28u as=1.45407p ps=9.445u w=0.795u l=0.13u
X61 VSS.t46 DELAY_VBIASN VSS.t45 VSS.t28 sg13_lv_nmos ad=2.38p pd=14.68u as=0 ps=0 w=7u l=7u
X62 a_13566_3208# a_14009_3251# a_13306_3678# VSS.t75 sg13_lv_nmos ad=79.8f pd=0.8u as=0.1296p ps=1.52u w=0.42u l=0.13u
X63 a_13019_3204# a_15688_2776# VSS.t91 VSS.t99 sg13_lv_nmos ad=0.2516p pd=2.16u as=0.1406p ps=1.12u w=0.74u l=0.13u
X64 VDD.t19 DLL_RESETN a_9946_3678# VDD.t0 sg13_lv_pmos ad=0.36237p pd=2.605u as=79.8f ps=0.8u w=0.42u l=0.13u
X65 a_6326_1963# a_5974_3096# a_6126_1189# VSS.t0 sg13_lv_nmos ad=0.38p pd=2.38u as=0.68p ps=4.68u w=2u l=1u
X66 a_5778_740# a_6126_1189# a_6326_1963# VSS.t3 sg13_lv_nmos ad=0.68p pd=4.68u as=0.38p ps=2.38u w=2u l=1u
X67 a_9444_1285# a_6854_2827# a_9712_1285# VSS.t17 sg13_lv_nmos ad=0.68p pd=4.68u as=0.38p ps=2.38u w=2u l=1u
X68 a_6854_3359# a_6326_1963# VDD.t1 VDD.t0 sg13_lv_pmos ad=0.38p pd=2.38u as=0.38p ps=2.38u w=2u l=1u
X69 a_9712_1285# a_13019_3204# DELAY_VBIASN VSS.t64 sg13_lv_nmos ad=0.136p pd=1.14u as=0.232p ps=2.08u w=0.4u l=0.2u
X70 a_13818_2491# a_12849_3240# VSS.t87 VSS.t89 sg13_lv_nmos ad=37.8f pd=0.6u as=0.1701p ps=1.65u w=0.42u l=0.13u
X71 VDD.t4 a_6326_1963# a_6326_1963# VDD.t0 sg13_lv_pmos ad=0.38p pd=2.38u as=0.38p ps=2.38u w=2u l=1u
X72 VDD.t42 a_12849_3240# a_13566_2701# VDD.t0 sg13_lv_pmos ad=0.1563p pd=1.22u as=0.147p ps=1.54u w=0.42u l=0.13u
X73 VSS.t32 DELAY_VBIASN VSS.t34 VSS.t33 sg13_lv_nmos ad=1.33p pd=7.38u as=0 ps=0 w=7u l=7u
X74 a_15270_2478# a_12849_3240# VSS.t91 VSS.t90 sg13_lv_nmos ad=37.8f pd=0.6u as=79.8f ps=0.8u w=0.42u l=0.13u
X75 a_15304_1978# a_14851_3601# VDD.t35 VDD.t0 sg13_lv_pmos ad=0.4312p pd=3.01u as=0.2639p ps=1.81u w=1.12u l=0.13u
X76 a_15304_1978# a_14851_3601# VSS.t80 VSS.t79 sg13_lv_nmos ad=0.2849p pd=2.25u as=0.2516p ps=2.16u w=0.74u l=0.13u
X77 a_9444_1285# a_9444_1963# VSS.t106 VSS.t105 sg13_lv_nmos ad=0.38p pd=2.38u as=0.68p ps=4.68u w=2u l=1u
X78 VDD.t45 a_14851_2555# a_15108_2698# VDD.t0 sg13_lv_pmos ad=0.2639p pd=1.81u as=79.8f ps=0.8u w=0.42u l=0.13u
X79 a_13400_2478# a_13132_2793# a_13306_2478# VSS.t128 sg13_lv_nmos ad=60.89999f pd=0.71u as=0.1428p ps=1.52u w=0.42u l=0.13u
X80 a_11910_3678# DLL_RESETN VSS.t21 VSS.t2 sg13_lv_nmos ad=37.8f pd=0.6u as=79.8f ps=0.8u w=0.42u l=0.13u
X81 a_12849_3240# a_12656_3237# VSS.t21 VSS.t65 sg13_lv_nmos ad=0.1406p pd=1.12u as=0.2516p ps=2.16u w=0.74u l=0.13u
X82 a_5974_3096# a_6126_1189# VSS.t7 VSS.t0 sg13_lv_nmos ad=0.38p pd=2.38u as=0.68p ps=4.68u w=2u l=1u
X83 a_13880_3665# a_13592_3244# a_13818_3665# VSS.t153 sg13_lv_nmos ad=0.1428p pd=1.52u as=37.8f ps=0.6u w=0.42u l=0.13u
X84 VSS.t48 DELAY_VBIASN VSS.t46 VSS.t31 sg13_lv_nmos ad=1.33p pd=7.38u as=0 ps=0 w=7u l=7u
X85 a_5974_3096# a_6126_1189# VSS.t10 VSS.t0 sg13_lv_nmos ad=0.38p pd=2.38u as=0.68p ps=4.68u w=2u l=1u
X86 a_13592_2796# a_13566_2701# VSS.t87 VSS.t120 sg13_lv_nmos ad=0.2516p pd=2.16u as=0.1626p ps=1.415u w=0.74u l=0.13u
X87 a_12656_3237# DLL_RESETN VSS.t21 VSS.t116 sg13_lv_nmos ad=0.2516p pd=2.16u as=0.2516p ps=2.16u w=0.74u l=0.13u
X88 a_14851_3601# a_14009_3251# a_14757_3601# VSS.t78 sg13_lv_nmos ad=0.12665p pd=1.145u as=0.1428p ps=1.52u w=0.42u l=0.13u
X89 a_9712_1285# a_6854_2827# a_9444_1285# VSS.t16 sg13_lv_nmos ad=0.38p pd=2.38u as=0.68p ps=4.68u w=2u l=1u
X90 VDD.t63 VDD.t61 VDD.t1 VDD.t0 sg13_lv_pmos ad=0.68p pd=4.68u as=0 ps=0 w=2u l=1u
X91 VDD.t26 a_13019_3204# a_12943_3240# VDD.t0 sg13_lv_pmos ad=0.2128p pd=1.5u as=0.2128p ps=1.5u w=1.12u l=0.13u
X92 VSS.t80 a_15108_3482# a_14757_3601# VSS.t78 sg13_lv_nmos ad=79.8f pd=0.8u as=0.1428p ps=1.52u w=0.42u l=0.13u
X93 VDD.t41 a_12849_3240# a_13306_2478# VDD.t0 sg13_lv_pmos ad=0.36237p pd=2.605u as=79.8f ps=0.8u w=0.42u l=0.13u
X94 a_10520_3665# a_10232_3244# a_10458_3665# VSS.t61 sg13_lv_nmos ad=0.1428p pd=1.52u as=37.8f ps=0.6u w=0.42u l=0.13u
X95 a_15053_2793# a_14111_2600# a_14851_2555# VDD.t0 sg13_lv_pmos ad=93.45f pd=0.865u as=0.2048p ps=1.63u w=0.42u l=0.13u
X96 a_12656_3237# DLL_RESETN VDD.t54 VDD.t0 sg13_lv_pmos ad=0.3808p pd=2.92u as=0.3808p ps=2.92u w=1.12u l=0.13u
X97 a_11491_3601# a_10649_3251# a_11397_3601# VSS.t2 sg13_lv_nmos ad=0.12665p pd=1.145u as=0.1428p ps=1.52u w=0.42u l=0.13u
X98 VSS.t21 a_13121_3204# a_13045_3588# VSS.t72 sg13_lv_nmos ad=0.2516p pd=2.16u as=0.1406p ps=1.12u w=0.74u l=0.13u
X99 VDD.t47 a_14851_2555# a_15688_2776# VDD.t0 sg13_lv_pmos ad=0.2128p pd=1.5u as=0.3864p ps=2.93u w=1.12u l=0.13u
X100 a_14009_2457# DELAY_OUT_LAST VSS.t74 VSS.t73 sg13_lv_nmos ad=0.2516p pd=2.16u as=1.45407p ps=9.445u w=0.74u l=0.13u
X101 VDD.t35 a_14851_3601# a_15108_3482# VDD.t0 sg13_lv_pmos ad=0.2639p pd=1.81u as=79.8f ps=0.8u w=0.42u l=0.13u
X102 a_13592_2796# a_13566_2701# VDD.t41 VDD.t0 sg13_lv_pmos ad=0.34p pd=2.68u as=0.36237p ps=2.605u w=1u l=0.13u
X103 VSS.t112 a_9444_1963# a_9444_1963# VSS.t107 sg13_lv_nmos ad=0.68p pd=4.68u as=0.38p ps=2.38u w=2u l=1u
X104 a_12355_3240# a_12158_3240# VDD.t21 VDD.t0 sg13_lv_pmos ad=0.3808p pd=2.92u as=0.2128p ps=1.5u w=1.12u l=0.13u
X105 VSS.t38 DELAY_VBIASN VSS.t40 VSS.t39 sg13_lv_nmos ad=1.33p pd=7.38u as=0 ps=0 w=7u l=7u
X106 a_14009_2457# DELAY_OUT_LAST VDD.t18 VDD.t0 sg13_lv_pmos ad=0.4088p pd=2.97u as=1.10612p ps=6.66u w=1.12u l=0.13u
X107 a_10206_3208# a_10649_3251# a_10589_3287# VDD.t0 sg13_lv_pmos ad=79.8f pd=0.8u as=63f ps=0.72u w=0.42u l=0.13u
X108 a_12355_3240# a_12158_3240# VSS.t21 VSS.t70 sg13_lv_nmos ad=0.2516p pd=2.16u as=0.1406p ps=1.12u w=0.74u l=0.13u
X109 VDD.t37 a_12849_3240# a_13306_3678# VDD.t0 sg13_lv_pmos ad=0.36237p pd=2.605u as=79.8f ps=0.8u w=0.42u l=0.13u
X110 a_10040_3678# a_9772_3216# a_9946_3678# VSS.t22 sg13_lv_nmos ad=60.89999f pd=0.71u as=0.1428p ps=1.52u w=0.42u l=0.13u
X111 a_10520_3665# a_10751_3251# a_10206_3208# VSS.t1 sg13_lv_nmos ad=0.2373p pd=1.97u as=79.8f ps=0.8u w=0.42u l=0.13u
X112 VSS.t34 DELAY_VBIASN VSS.t36 VSS.t35 sg13_lv_nmos ad=1.33p pd=7.38u as=0 ps=0 w=7u l=7u
X113 a_15464_1057# a_14851_2555# VSS.t91 VSS.t97 sg13_lv_nmos ad=0.2849p pd=2.25u as=0.2516p ps=2.16u w=0.74u l=0.13u
X114 a_6126_1189# a_5974_3096# a_6326_1963# VSS.t0 sg13_lv_nmos ad=0.68p pd=4.68u as=0.38p ps=2.38u w=2u l=1u
X115 VSS.t77 a_14009_3251# a_14111_3251# VSS.t76 sg13_lv_nmos ad=2.39977p pd=15.495u as=0.2516p ps=2.16u w=0.74u l=0.13u
X116 a_9444_1963# a_6854_2827# a_6854_2827# VSS.t17 sg13_lv_nmos ad=0.68p pd=4.68u as=0.38p ps=2.38u w=2u l=1u
X117 a_13592_2796# a_14111_2600# a_14851_2555# VSS.t130 sg13_lv_nmos ad=0.3473p pd=2.71u as=0.12665p ps=1.145u w=0.74u l=0.13u
X118 VSS.t150 VSS.t147 VSS.t149 VSS.t148 sg13_lv_nmos ad=0.2516p pd=2.16u as=0 ps=0 w=0.74u l=0.13u
X119 VSS.t144 VSS.t144 VSS.t146 VSS.t145 sg13_lv_nmos ad=0.1406p pd=1.12u as=0 ps=0 w=0.74u l=0.13u
X120 a_15053_3363# a_14111_3251# a_14851_3601# VDD.t0 sg13_lv_pmos ad=93.45f pd=0.865u as=0.2048p ps=1.63u w=0.42u l=0.13u
X121 VDD.t18 a_9547_3545# a_9547_3315# VDD.t0 sg13_lv_pmos ad=1.10612p pd=6.66u as=0.2442p ps=2.06u w=0.66u l=0.13u
X122 VSS.t69 a_10649_3251# a_10751_3251# VSS.t68 sg13_lv_nmos ad=2.39977p pd=15.495u as=0.2516p ps=2.16u w=0.74u l=0.13u
X123 VSS.t52 DELAY_VBIASN VSS.t50 VSS.t35 sg13_lv_nmos ad=1.33p pd=7.38u as=0 ps=0 w=7u l=7u
X124 a_9444_1963# a_9444_1963# VSS.t111 VSS.t105 sg13_lv_nmos ad=0.38p pd=2.38u as=0.68p ps=4.68u w=2u l=1u
X125 a_14851_2555# a_14009_2457# a_14757_2555# VSS.t123 sg13_lv_nmos ad=0.12665p pd=1.145u as=0.1428p ps=1.52u w=0.42u l=0.13u
X126 VDD.t5 VDD.t64 VDD.t71 VDD.t0 sg13_lv_pmos ad=0.38p pd=2.38u as=0 ps=0 w=2u l=1u
X127 a_14851_2555# a_14009_2457# a_13592_2796# VDD.t0 sg13_lv_pmos ad=0.2048p pd=1.63u as=0.34p ps=2.68u w=1u l=0.13u
X128 VSS.t30 DELAY_VBIASN VSS.t29 VSS.t28 sg13_lv_nmos ad=2.38p pd=14.68u as=0 ps=0 w=7u l=7u
X129 VSS.t27 DELAY_VBIASN DELAY_VBIASP VSS.t26 sg13_lv_nmos ad=0.2516p pd=2.16u as=0.6808p ps=3.32u w=0.74u l=0.6u
X130 DELAY_VBIASN DLL_RESETN VDD.t52 VDD.t31 sg13_lv_pmos ad=0.158p pd=1.245u as=0.272p ps=2.28u w=0.8u l=0.2u
X131 VDD.t74 VDD.t72 VDD.t73 VDD.t31 sg13_lv_pmos ad=0.3808p pd=2.92u as=0 ps=0 w=1.12u l=0.13u
X132 a_13949_3287# a_13592_3244# VDD.t38 VDD.t0 sg13_lv_pmos ad=63f pd=0.72u as=0.1563p ps=1.22u w=0.42u l=0.13u
X133 VDD.t79 VDD.t80 VDD.t81 VDD.t31 sg13_lv_pmos ad=0.2128p pd=1.5u as=0 ps=0 w=1.12u l=0.13u
X134 a_10232_3244# a_10206_3208# VDD.t19 VDD.t0 sg13_lv_pmos ad=0.34p pd=2.68u as=0.36237p ps=2.605u w=1u l=0.13u
X135 VSS.t71 a_13121_3204# a_6854_3359# VDD.t31 sg13_lv_pmos ad=0.232p pd=2.08u as=0.136p ps=1.14u w=0.4u l=0.2u
X136 a_5778_740# a_6126_1189# a_6326_1963# VSS.t3 sg13_lv_nmos ad=0.68p pd=4.68u as=0.38p ps=2.38u w=2u l=1u
X137 VDD.t24 DLL_RESETN a_10206_3208# VDD.t0 sg13_lv_pmos ad=0.1563p pd=1.22u as=0.147p ps=1.54u w=0.42u l=0.13u
X138 a_13592_3244# a_14111_3251# a_14851_3601# VSS.t78 sg13_lv_nmos ad=0.3473p pd=2.71u as=0.12665p ps=1.145u w=0.74u l=0.13u
X139 a_6854_2827# a_6854_2827# a_9444_1963# VSS.t16 sg13_lv_nmos ad=0.38p pd=2.38u as=0.68p ps=4.68u w=2u l=1u
X140 a_5778_740# a_6126_1189# a_6326_1963# VSS.t3 sg13_lv_nmos ad=0.68p pd=4.68u as=0.38p ps=2.38u w=2u l=1u
X141 VSS.t29 DELAY_VBIASN VSS.t32 VSS.t31 sg13_lv_nmos ad=1.33p pd=7.38u as=0 ps=0 w=7u l=7u
X142 a_10589_3287# a_10232_3244# VDD.t24 VDD.t0 sg13_lv_pmos ad=63f pd=0.72u as=0.1563p ps=1.22u w=0.42u l=0.13u
X143 a_15270_3678# a_12849_3240# VSS.t80 VSS.t78 sg13_lv_nmos ad=37.8f pd=0.6u as=79.8f ps=0.8u w=0.42u l=0.13u
X144 VDD.t18 a_14009_3251# a_14111_3251# VDD.t0 sg13_lv_pmos ad=1.10612p pd=6.66u as=0.3864p ps=2.93u w=1.12u l=0.13u
X145 a_6326_1963# a_6126_1189# a_5778_740# VSS.t3 sg13_lv_nmos ad=0.42p pd=2.42u as=0.68p ps=4.68u w=2u l=1u
X146 a_6326_1963# a_6326_1963# VDD.t12 VDD.t0 sg13_lv_pmos ad=0.38p pd=2.38u as=0.38p ps=2.38u w=2u l=1u
X147 a_10232_3244# a_10751_3251# a_11491_3601# VSS.t2 sg13_lv_nmos ad=0.3473p pd=2.71u as=0.12665p ps=1.145u w=0.74u l=0.13u
X148 VDD.t5 a_6326_1963# a_6854_3359# VDD.t0 sg13_lv_pmos ad=0.38p pd=2.38u as=0.38p ps=2.38u w=2u l=1u
X149 VDD.t18 a_11748_3482# a_11693_3363# VDD.t0 sg13_lv_pmos ad=1.10612p pd=6.66u as=93.45f ps=0.865u w=0.42u l=0.13u
X150 VSS.t87 a_12849_3240# a_13400_2478# VSS.t86 sg13_lv_nmos ad=0.1626p pd=1.415u as=60.89999f ps=0.71u w=0.42u l=0.13u
X151 a_13400_3678# a_12355_3240# a_13306_3678# VSS.t66 sg13_lv_nmos ad=60.89999f pd=0.71u as=0.1428p ps=1.52u w=0.42u l=0.13u
X152 a_13019_3204# a_15688_2776# VDD.t47 VDD.t0 sg13_lv_pmos ad=0.3808p pd=2.92u as=0.2128p ps=1.5u w=1.12u l=0.13u
X153 VDD.t18 a_10649_3251# a_10751_3251# VDD.t0 sg13_lv_pmos ad=1.10612p pd=6.66u as=0.3864p ps=2.93u w=1.12u l=0.13u
X154 a_9444_1963# a_6854_2827# a_6854_2827# VSS.t15 sg13_lv_nmos ad=0.68p pd=4.68u as=0.38p ps=2.38u w=2u l=1u
X155 a_10458_3665# DLL_RESETN VSS.t19 VSS.t115 sg13_lv_nmos ad=37.8f pd=0.6u as=0.1701p ps=1.65u w=0.42u l=0.13u
X156 a_13566_2701# a_14009_2457# a_13306_2478# VSS.t121 sg13_lv_nmos ad=79.8f pd=0.8u as=0.1296p ps=1.52u w=0.42u l=0.13u
X157 a_13306_2478# a_14111_2600# a_13566_2701# VDD.t0 sg13_lv_pmos ad=0.1428p pd=1.52u as=79.8f ps=0.8u w=0.42u l=0.13u
X158 a_6326_1963# a_6126_1189# a_5778_740# VSS.t3 sg13_lv_nmos ad=0.38p pd=2.38u as=0.68p ps=4.68u w=2u l=1u
X159 a_13880_2491# a_13592_2796# a_13818_2491# VSS.t125 sg13_lv_nmos ad=0.1428p pd=1.52u as=37.8f ps=0.6u w=0.42u l=0.13u
X160 a_15108_2698# a_14851_2555# a_15270_2478# VSS.t95 sg13_lv_nmos ad=0.1428p pd=1.52u as=37.8f ps=0.6u w=0.42u l=0.13u
X161 a_13566_3208# a_14009_3251# a_13949_3287# VDD.t0 sg13_lv_pmos ad=79.8f pd=0.8u as=63f ps=0.72u w=0.42u l=0.13u
X162 a_11491_3601# a_10649_3251# a_10232_3244# VDD.t0 sg13_lv_pmos ad=0.2048p pd=1.63u as=0.34p ps=2.68u w=1u l=0.13u
X163 a_5778_740# a_6126_1189# a_6326_1963# VSS.t3 sg13_lv_nmos ad=0.68p pd=4.68u as=0.42p ps=2.42u w=2u l=1u
X164 a_13880_3665# a_14111_3251# a_13566_3208# VSS.t94 sg13_lv_nmos ad=0.2373p pd=1.97u as=79.8f ps=0.8u w=0.42u l=0.13u
X165 VSS.t6 a_6126_1189# a_6126_1189# VSS.t3 sg13_lv_nmos ad=0.68p pd=4.68u as=0.38p ps=2.38u w=2u l=1u
X166 a_6854_3359# a_6326_1963# VDD.t15 VDD.t0 sg13_lv_pmos ad=0.38p pd=2.38u as=0.38p ps=2.38u w=2u l=1u
X167 a_11748_3482# a_11491_3601# a_11910_3678# VSS.t2 sg13_lv_nmos ad=0.1428p pd=1.52u as=37.8f ps=0.6u w=0.42u l=0.13u
X168 VSS.t104 a_9444_1963# a_9444_1963# VSS.t103 sg13_lv_nmos ad=0.68p pd=4.68u as=0.38p ps=2.38u w=2u l=1u
X169 a_12943_3240# a_12656_3237# a_12849_3240# VDD.t0 sg13_lv_pmos ad=0.2128p pd=1.5u as=0.3808p ps=2.92u w=1.12u l=0.13u
X170 a_13592_3244# a_13566_3208# VDD.t37 VDD.t0 sg13_lv_pmos ad=0.34p pd=2.68u as=0.36237p ps=2.605u w=1u l=0.13u
X171 a_6854_2827# a_6854_2827# a_9444_1963# VSS.t14 sg13_lv_nmos ad=0.38p pd=2.38u as=0.68p ps=4.68u w=2u l=1u
X172 VDD.t38 a_12849_3240# a_13566_3208# VDD.t0 sg13_lv_pmos ad=0.1563p pd=1.22u as=0.147p ps=1.54u w=0.42u l=0.13u
X173 a_9444_1963# a_9444_1963# VSS.t102 VSS.t101 sg13_lv_nmos ad=0.38p pd=2.38u as=0.68p ps=4.68u w=2u l=1u
X174 VDD.t34 a_14851_3601# a_15688_3240# VDD.t0 sg13_lv_pmos ad=0.2128p pd=1.5u as=0.3864p ps=2.93u w=1.12u l=0.13u
X175 VSS.t9 a_6126_1189# a_5974_3096# VSS.t0 sg13_lv_nmos ad=0.68p pd=4.68u as=0.38p ps=2.38u w=2u l=1u
X176 VDD.t66 VDD.t64 VDD.t9 VDD.t0 sg13_lv_pmos ad=0.38p pd=2.38u as=0 ps=0 w=2u l=1u
X177 VSS.t82 a_14851_3601# a_15688_3240# VSS.t81 sg13_lv_nmos ad=0.1406p pd=1.12u as=0.2516p ps=2.16u w=0.74u l=0.13u
X178 VDD.t49 a_15464_1057# a_9712_1285# VSS.t100 sg13_lv_nmos ad=0.232p pd=2.08u as=0.136p ps=1.14u w=0.4u l=0.2u
X179 VSS.t136 VSS.t134 VSS.t134 VSS.t135 sg13_lv_nmos ad=0.68p pd=4.68u as=0 ps=0 w=2u l=1u
X180 VDD.t18 a_15108_2698# a_15053_2793# VDD.t0 sg13_lv_pmos ad=1.10612p pd=6.66u as=93.45f ps=0.865u w=0.42u l=0.13u
X181 VSS.t40 DELAY_VBIASN VSS.t42 VSS.t41 sg13_lv_nmos ad=1.33p pd=7.38u as=0 ps=0 w=7u l=7u
X182 a_10649_3251# DELAY_IN VSS.t69 VSS.t117 sg13_lv_nmos ad=0.2516p pd=2.16u as=1.9998p ps=12.915u w=0.74u l=0.13u
X183 VSS.t7 a_6126_1189# a_5974_3096# VSS.t0 sg13_lv_nmos ad=0.68p pd=4.68u as=0.38p ps=2.38u w=2u l=1u
X184 VSS.t131 VSS.t131 VSS.t133 VSS.t132 sg13_lv_nmos ad=0.68p pd=4.68u as=0 ps=0 w=2u l=1u
X185 VSS.t74 a_14009_2457# a_14111_2600# VSS.t122 sg13_lv_nmos ad=1.45407p pd=9.445u as=0.2516p ps=2.16u w=0.74u l=0.13u
X186 a_6126_1189# a_6326_1963# VDD.t11 VDD.t0 sg13_lv_pmos ad=0.38p pd=2.38u as=0.38p ps=2.38u w=2u l=1u
X187 VDD.t15 a_6326_1963# a_6326_1963# VDD.t0 sg13_lv_pmos ad=0.38p pd=2.38u as=0.38p ps=2.38u w=2u l=1u
X188 a_12943_3240# a_13121_3204# VDD.t26 VDD.t0 sg13_lv_pmos ad=0.3808p pd=2.92u as=0.2128p ps=1.5u w=1.12u l=0.13u
X189 VDD.t18 a_14009_2457# a_14111_2600# VDD.t0 sg13_lv_pmos ad=1.10612p pd=6.66u as=0.3864p ps=2.93u w=1.12u l=0.13u
X190 VDD.t11 a_6326_1963# a_6854_2827# VDD.t0 sg13_lv_pmos ad=0.38p pd=2.38u as=0.38p ps=2.38u w=2u l=1u
X191 a_11748_3482# DLL_RESETN VDD.t18 VDD.t0 sg13_lv_pmos ad=79.8f pd=0.8u as=1.10612p ps=6.66u w=0.42u l=0.13u
X192 a_13818_3665# a_12849_3240# VSS.t84 VSS.t88 sg13_lv_nmos ad=37.8f pd=0.6u as=0.1701p ps=1.65u w=0.42u l=0.13u
X193 a_15464_1057# a_14851_2555# VDD.t45 VDD.t0 sg13_lv_pmos ad=0.4312p pd=3.01u as=0.2639p ps=1.81u w=1.12u l=0.13u
X194 a_9444_1285# a_6854_2827# a_9712_1285# VSS.t15 sg13_lv_nmos ad=0.68p pd=4.68u as=0.38p ps=2.38u w=2u l=1u
X195 a_6126_1189# a_6326_1963# VDD.t4 VDD.t0 sg13_lv_pmos ad=0.38p pd=2.38u as=0.38p ps=2.38u w=2u l=1u
X196 VSS.t24 a_9547_3545# a_9547_3545# VSS.t23 sg13_lv_nmos ad=2.39977p pd=15.495u as=0.111p ps=1.34u w=0.3u l=0.13u
X197 VDD.t9 a_6326_1963# a_6854_2827# VDD.t0 sg13_lv_pmos ad=0.38p pd=2.38u as=0.38p ps=2.38u w=2u l=1u
X198 a_13045_3588# a_13019_3204# a_12849_3240# VSS.t63 sg13_lv_nmos ad=0.1406p pd=1.12u as=0.1406p ps=1.12u w=0.74u l=0.13u
X199 a_10232_3244# a_10206_3208# VSS.t19 VSS.t18 sg13_lv_nmos ad=0.2516p pd=2.16u as=0.1626p ps=1.415u w=0.74u l=0.13u
X200 VDD.t18 a_15108_3482# a_15053_3363# VDD.t0 sg13_lv_pmos ad=1.10612p pd=6.66u as=93.45f ps=0.865u w=0.42u l=0.13u
X201 a_5974_3096# a_6126_1189# VSS.t4 VSS.t0 sg13_lv_nmos ad=0.38p pd=2.38u as=0.68p ps=4.68u w=2u l=1u
X202 a_9946_3678# a_10751_3251# a_10206_3208# VDD.t0 sg13_lv_pmos ad=0.1428p pd=1.52u as=79.8f ps=0.8u w=0.42u l=0.13u
X203 a_14851_3601# a_14009_3251# a_13592_3244# VDD.t0 sg13_lv_pmos ad=0.2048p pd=1.63u as=0.34p ps=2.68u w=1u l=0.13u
X204 a_10206_3208# a_10649_3251# a_9946_3678# VSS.t67 sg13_lv_nmos ad=79.8f pd=0.8u as=0.1296p ps=1.52u w=0.42u l=0.13u
X205 VSS.t13 a_6126_1189# a_5974_3096# VSS.t0 sg13_lv_nmos ad=0.68p pd=4.68u as=0.38p ps=2.38u w=2u l=1u
X206 a_10649_3251# DELAY_IN VDD.t18 VDD.t0 sg13_lv_pmos ad=0.4088p pd=2.97u as=1.03698p ps=6.245u w=1.12u l=0.13u
X207 VSS.t144 VSS.t142 VSS.t142 VSS.t143 sg13_lv_nmos ad=0.2516p pd=2.16u as=0 ps=0 w=0.74u l=0.13u
X208 VSS.t11 a_6126_1189# a_5974_3096# VSS.t0 sg13_lv_nmos ad=0.76p pd=4.76u as=0.38p ps=2.38u w=2u l=1u
C0 VDD a_15108_3482# 0.1349f
C1 a_6854_3359# a_13132_2793# 0.01367f
C2 a_13121_3204# a_15108_3482# 0.03701f
C3 VDD a_6854_2827# 1.03678f
C4 a_14111_2600# a_13592_2796# 0.34114f
C5 a_6854_3359# a_13592_2796# 0.01958f
C6 a_14851_2555# a_15108_2698# 0.29858f
C7 a_5778_740# a_6854_2827# 0.02695f
C8 a_13019_3204# a_9712_1285# 0.03275f
C9 a_14111_2600# a_14009_2457# 0.47622f
C10 DELAY_VBIASN DLL_RESETN 0.12904f
C11 a_10751_3251# VDD 0.20377f
C12 a_10649_3251# DELAY_IN 0.25484f
C13 DELAY_IN DLL_RESETN 10.4683f
C14 a_9444_1963# VDD 0.01443f
C15 a_10751_3251# a_9946_3678# 0.097f
C16 a_13306_3678# VDD 0.77573f
C17 DELAY_IN a_11491_3601# 0.01827f
C18 a_9746_3178# a_9547_3545# 0.02437f
C19 a_13121_3204# a_13306_3678# 0.01008f
C20 a_13880_2491# VDD 0.02994f
C21 a_10751_3251# a_10232_3244# 0.34102f
C22 a_13592_3244# a_13566_3208# 0.36952f
C23 a_12355_3240# a_12656_3237# 0.03277f
C24 a_12849_3240# DELAY_IN 0.26382f
C25 a_5778_740# a_9444_1963# 0.19787f
C26 a_15108_3482# a_14111_3251# 0.03093f
C27 a_10649_3251# a_11397_3601# 0.01058f
C28 VDD a_9712_1285# 0.21174f
C29 a_13019_3204# a_13592_3244# 0.04178f
C30 a_5974_3096# a_6126_1189# 1.74589f
C31 a_11397_3601# a_11491_3601# 0.28931f
C32 DLL_RESETN a_13132_2793# 0.01689f
C33 a_10649_3251# a_10520_3665# 0.01562f
C34 a_14111_2600# VDD 0.33926f
C35 a_6854_3359# VDD 1.20794f
C36 a_13121_3204# a_6854_3359# 0.10056f
C37 a_13306_2478# DELAY_IN 0.06166f
C38 a_12849_3240# a_13132_2793# 0.06758f
C39 a_13880_3665# a_14009_3251# 0.01562f
C40 a_13592_3244# a_14851_3601# 0.01529f
C41 a_13306_3678# a_12355_3240# 0.26489f
C42 a_6854_2827# a_6126_1189# 0.22705f
C43 a_13306_3678# a_14111_3251# 0.097f
C44 a_15304_1978# DELAY_OUT_LAST 0.05582f
C45 a_5974_3096# a_6854_2827# 0.01757f
C46 VDD a_12158_3240# 0.37862f
C47 a_12849_3240# a_13592_2796# 0.38497f
C48 VDD a_13592_3244# 0.07242f
C49 a_13121_3204# a_13592_3244# 0.01445f
C50 a_12849_3240# a_13566_3208# 0.27346f
C51 a_14111_2600# a_15108_2698# 0.03012f
C52 a_12907_2793# DLL_RESETN 0.04234f
C53 a_12849_3240# a_14009_2457# 0.03463f
C54 a_13019_3204# DLL_RESETN 0.01429f
C55 a_10649_3251# a_10206_3208# 0.02242f
C56 a_10206_3208# DLL_RESETN 0.27343f
C57 DELAY_OUT_LAST DELAY_VBIASP 0.82908f
C58 DELAY_IN a_11748_3482# 0.0148f
C59 a_13306_2478# a_13132_2793# 0.27179f
C60 a_12943_3240# DLL_RESETN 0.03616f
C61 a_12849_3240# a_13019_3204# 0.12838f
C62 a_9444_1963# a_6126_1189# 0.03029f
C63 a_14757_3601# a_14851_3601# 0.28931f
C64 a_13306_2478# a_13592_2796# 0.41329f
C65 a_13019_3204# a_15464_1057# 0.59875f
C66 a_12907_2559# DLL_RESETN 0.02177f
C67 a_13566_2701# DELAY_IN 0.01093f
C68 a_12849_3240# a_12943_3240# 0.16706f
C69 a_13306_2478# a_14009_2457# 0.02454f
C70 a_15688_2776# a_15464_1057# 0.1999f
C71 a_10649_3251# VDD 0.23431f
C72 VDD DLL_RESETN 2.28901f
C73 a_12849_3240# a_14851_3601# 0.13392f
C74 a_13121_3204# DLL_RESETN 0.04337f
C75 a_5864_740# a_6326_1963# 0.01889f
C76 a_12355_3240# a_12158_3240# 0.12454f
C77 a_9547_3545# VDD 0.08695f
C78 a_13019_3204# a_15688_3240# 0.0195f
C79 a_10649_3251# a_9946_3678# 0.02432f
C80 a_9946_3678# DLL_RESETN 0.09997f
C81 a_9444_1963# a_6854_2827# 1.24134f
C82 VDD a_11491_3601# 0.16753f
C83 a_5974_3096# a_9712_1285# 0.01152f
C84 a_13592_3244# a_14111_3251# 0.34102f
C85 a_5778_740# DLL_RESETN 0.01215f
C86 a_12849_3240# VDD 2.56972f
C87 a_12849_3240# a_13121_3204# 0.55272f
C88 a_10649_3251# a_10232_3244# 0.37583f
C89 a_10232_3244# DLL_RESETN 0.39088f
C90 DELAY_VBIASN a_15304_1978# 0.07802f
C91 a_6854_3359# a_6126_1189# 0.18536f
C92 a_6854_3359# a_5974_3096# 0.029f
C93 a_13106_2730# DLL_RESETN 0.01263f
C94 VDD a_15464_1057# 0.52426f
C95 DELAY_IN a_15304_1978# 0.01066f
C96 a_10232_3244# a_11491_3601# 0.01529f
C97 a_13121_3204# a_15464_1057# 0.33256f
C98 a_15688_3240# a_14851_3601# 0.08776f
C99 a_13045_3588# a_13019_3204# 0.01249f
C100 DELAY_VBIASN DELAY_VBIASP 5.10609f
C101 a_9712_1285# a_6854_2827# 0.67835f
C102 a_14111_2600# a_14851_2555# 0.26905f
C103 DELAY_VBIASN DELAY_OUT_LAST 3.14505f
C104 a_13566_2701# a_13592_2796# 0.36952f
C105 a_12849_3240# a_15108_2698# 0.10521f
C106 a_9547_3315# a_9772_3216# 0.02416f
C107 a_5864_740# a_9444_1285# 0.02483f
C108 VDD a_15688_3240# 0.30345f
C109 a_13121_3204# a_15688_3240# 0.17255f
C110 a_13306_2478# VDD 0.79678f
C111 a_13566_2701# a_14009_2457# 0.02242f
C112 a_6854_3359# a_6854_2827# 0.30877f
C113 a_12355_3240# DLL_RESETN 0.04879f
C114 a_15464_1057# a_15108_2698# 0.12158f
C115 DELAY_IN a_14009_3251# 0.25847f
C116 a_9444_1963# a_9712_1285# 0.68929f
C117 a_12849_3240# a_12355_3240# 0.07687f
C118 a_12849_3240# a_14111_3251# 0.42174f
C119 a_15304_1978# a_13592_2796# 0.01817f
C120 VDD a_11748_3482# 0.16819f
C121 a_9746_3178# a_9547_3315# 0.14994f
C122 a_6854_3359# a_9444_1963# 0.05054f
C123 DLL_RESETN a_6126_1189# 0.06398f
C124 a_14111_2600# a_13880_2491# 0.12701f
C125 a_9746_3178# a_9772_3216# 0.1657f
C126 a_5974_3096# DLL_RESETN 0.02002f
C127 DELAY_OUT_LAST a_13592_2796# 0.08062f
C128 a_14757_2555# a_15304_1978# 0.02225f
C129 a_13019_3204# a_15304_1978# 0.07025f
C130 a_13566_2701# VDD 0.0947f
C131 DELAY_OUT_LAST a_14009_2457# 0.25594f
C132 a_6854_3359# a_9712_1285# 0.13962f
C133 DLL_RESETN a_12656_3237# 0.11782f
C134 a_13019_3204# DELAY_VBIASP 0.02377f
C135 a_13306_3678# a_13592_3244# 0.41329f
C136 a_14009_3251# a_13566_3208# 0.02242f
C137 DLL_RESETN a_6854_2827# 0.03626f
C138 a_12849_3240# a_14851_2555# 0.13376f
C139 a_13019_3204# DELAY_OUT_LAST 0.08017f
C140 a_15304_1978# a_14851_3601# 0.12139f
C141 a_12849_3240# a_12656_3237# 0.33075f
C142 a_15688_2776# DELAY_OUT_LAST 0.01699f
C143 a_15464_1057# a_14851_2555# 0.04797f
C144 a_12849_3240# a_15108_3482# 0.10225f
C145 VDD a_15304_1978# 0.72158f
C146 a_13121_3204# a_15304_1978# 0.40921f
C147 a_10649_3251# a_10751_3251# 0.47795f
C148 a_10751_3251# DLL_RESETN 0.45018f
C149 a_9444_1963# DLL_RESETN 0.10269f
C150 VDD DELAY_VBIASP 1.07078f
C151 VDD a_6326_1963# 7.53039f
C152 a_10751_3251# a_11491_3601# 0.26905f
C153 DELAY_IN a_13132_2793# 0.02025f
C154 VDD DELAY_OUT_LAST 0.17745f
C155 a_13121_3204# DELAY_OUT_LAST 0.13178f
C156 a_5778_740# a_6326_1963# 0.8779f
C157 a_15304_1978# a_15108_2698# 0.01986f
C158 a_13880_3665# a_14111_3251# 0.12701f
C159 DELAY_IN a_13592_2796# 0.03445f
C160 a_12849_3240# a_13306_3678# 0.12097f
C161 VDD a_14009_3251# 0.23872f
C162 a_13121_3204# a_14009_3251# 0.01604f
C163 DLL_RESETN a_9712_1285# 0.43103f
C164 DELAY_IN a_13566_3208# 0.01538f
C165 a_13019_3204# DELAY_VBIASN 1.23663f
C166 DELAY_OUT_LAST a_15108_2698# 0.01399f
C167 VDD a_9547_3315# 0.1511f
C168 a_6854_3359# DLL_RESETN 0.50331f
C169 a_15304_1978# a_14111_3251# 0.01811f
C170 a_13019_3204# DELAY_IN 0.35409f
C171 VDD a_9772_3216# 0.24701f
C172 a_15464_1057# a_9712_1285# 0.01237f
C173 a_12849_3240# a_14111_2600# 0.42064f
C174 a_12849_3240# a_6854_3359# 0.06216f
C175 a_9946_3678# a_9772_3216# 0.27179f
C176 a_13880_2491# a_13306_2478# 0.31978f
C177 a_5778_740# a_5864_740# 0.07306f
C178 DLL_RESETN a_12158_3240# 0.02442f
C179 a_14757_3601# a_13592_3244# 0.43239f
C180 a_10751_3251# a_11748_3482# 0.03061f
C181 a_12158_3240# a_11491_3601# 0.0894f
C182 DELAY_VBIASN VDD 0.23309f
C183 a_14111_3251# a_14009_3251# 0.47795f
C184 a_14009_2457# a_13592_2796# 0.3749f
C185 a_12907_2793# a_13132_2793# 0.02416f
C186 a_12849_3240# a_13592_3244# 0.38817f
C187 DELAY_IN VDD 0.28486f
C188 a_13121_3204# DELAY_IN 1.40135f
C189 a_9746_3178# VDD 0.0918f
C190 a_6326_1963# a_6126_1189# 2.84014f
C191 a_14757_2555# a_13592_2796# 0.43239f
C192 a_14111_2600# a_13306_2478# 0.097f
C193 a_15304_1978# a_14851_2555# 0.05156f
C194 a_5974_3096# a_6326_1963# 0.33136f
C195 a_14757_2555# a_14009_2457# 0.01058f
C196 a_10232_3244# DELAY_IN 0.08086f
C197 a_15304_1978# a_15108_3482# 0.17528f
C198 a_10649_3251# DLL_RESETN 0.05713f
C199 DELAY_OUT_LAST a_14851_2555# 0.02109f
C200 DLL_RESETN a_11491_3601# 0.14622f
C201 VDD a_13132_2793# 0.23863f
C202 a_6326_1963# a_6854_2827# 1.25249f
C203 a_13880_3665# a_13306_3678# 0.31978f
C204 a_12849_3240# DLL_RESETN 0.3501f
C205 a_11397_3601# a_10232_3244# 0.43239f
C206 a_15688_2776# a_13019_3204# 0.1287f
C207 VDD a_13592_2796# 0.11685f
C208 a_9444_1285# a_6126_1189# 0.25721f
C209 a_9946_3678# a_10520_3665# 0.31978f
C210 a_12943_3240# a_13019_3204# 0.03346f
C211 DELAY_IN a_12355_3240# 1.0042f
C212 a_5864_740# a_6126_1189# 0.23738f
C213 a_11748_3482# a_12158_3240# 0.10373f
C214 VDD a_13566_3208# 0.09466f
C215 DELAY_IN a_14111_3251# 0.02263f
C216 a_5864_740# a_5974_3096# 0.01697f
C217 a_13121_3204# a_13566_3208# 0.01158f
C218 a_13019_3204# a_14851_3601# 0.01651f
C219 VDD a_14009_2457# 0.31815f
C220 a_10232_3244# a_10520_3665# 0.43707f
C221 a_12907_2559# a_12907_2793# 0.1117f
C222 a_13106_2730# a_13132_2793# 0.1657f
C223 a_9444_1963# a_6326_1963# 0.01269f
C224 a_12907_2793# VDD 0.07751f
C225 a_13019_3204# VDD 0.4182f
C226 a_13121_3204# a_13019_3204# 0.56469f
C227 a_10206_3208# VDD 0.09392f
C228 a_9444_1285# a_6854_2827# 0.8486f
C229 a_5864_740# a_6854_2827# 0.03661f
C230 a_15688_2776# VDD 0.30345f
C231 a_10206_3208# a_9946_3678# 0.75507f
C232 a_15688_2776# a_13121_3204# 0.01441f
C233 a_12943_3240# VDD 0.29479f
C234 a_13121_3204# a_12943_3240# 0.09118f
C235 a_12849_3240# a_13306_2478# 0.10976f
C236 DELAY_VBIASP a_9712_1285# 0.11086f
C237 a_9712_1285# a_6326_1963# 0.04737f
C238 a_10206_3208# a_10232_3244# 0.36952f
C239 a_13306_3678# a_14009_3251# 0.02432f
C240 VDD a_14851_3601# 0.25326f
C241 a_13121_3204# a_14851_3601# 0.03404f
C242 a_14111_2600# a_15304_1978# 0.01761f
C243 a_6854_3359# a_15304_1978# 0.08165f
C244 a_13106_2730# a_12907_2793# 0.14994f
C245 a_13880_3665# a_13592_3244# 0.43707f
C246 a_12907_2559# VDD 0.06323f
C247 DLL_RESETN a_11748_3482# 0.11133f
C248 a_6854_3359# DELAY_VBIASP 0.01478f
C249 a_9444_1963# a_9444_1285# 2.19249f
C250 a_6854_3359# a_6326_1963# 1.31745f
C251 DELAY_IN a_12656_3237# 0.01215f
C252 a_11748_3482# a_11491_3601# 0.34468f
C253 a_13121_3204# VDD 0.99724f
C254 a_9444_1963# a_5864_740# 0.06832f
C255 a_14111_2600# DELAY_OUT_LAST 0.02024f
C256 a_6854_3359# DELAY_OUT_LAST 0.08491f
C257 a_9946_3678# VDD 0.77198f
C258 a_13019_3204# a_12355_3240# 0.3846f
C259 a_12907_2559# a_13106_2730# 0.02437f
C260 a_10232_3244# VDD 0.07206f
C261 a_9444_1285# a_9712_1285# 0.81869f
C262 a_13106_2730# VDD 0.09228f
C263 a_10232_3244# a_9946_3678# 0.41329f
C264 VDD a_15108_2698# 0.13728f
C265 a_13121_3204# a_15108_2698# 0.05903f
C266 a_10751_3251# DELAY_IN 0.01931f
C267 a_12849_3240# a_13566_2701# 0.26617f
C268 a_14111_3251# a_14851_3601# 0.26905f
C269 a_6854_3359# a_9444_1285# 0.01142f
C270 a_14851_2555# a_13592_2796# 0.01529f
C271 a_13592_3244# a_14009_3251# 0.37583f
C272 a_13306_3678# DELAY_IN 0.05059f
C273 a_12355_3240# VDD 0.37639f
C274 a_13121_3204# a_12355_3240# 0.05795f
C275 DLL_RESETN a_15304_1978# 0.03137f
C276 VDD a_14111_3251# 0.21331f
C277 DELAY_VBIASN a_9712_1285# 0.22281f
C278 a_13121_3204# a_14111_3251# 0.0235f
C279 a_14757_2555# a_14851_2555# 0.28931f
C280 DELAY_IN a_9712_1285# 0.06514f
C281 DLL_RESETN DELAY_VBIASP 0.05659f
C282 a_13566_2701# a_13306_2478# 0.75507f
C283 a_12849_3240# a_15304_1978# 0.0606f
C284 a_6854_3359# DELAY_VBIASN 0.15808f
C285 a_13019_3204# a_12656_3237# 0.04193f
C286 a_10751_3251# a_10520_3665# 0.12701f
C287 a_15688_2776# a_14851_2555# 0.08776f
C288 a_6854_3359# DELAY_IN 0.05061f
C289 a_14757_3601# a_14009_3251# 0.01058f
C290 a_12849_3240# DELAY_OUT_LAST 0.01791f
C291 VDD a_6126_1189# 0.81494f
C292 a_5974_3096# VDD 0.91576f
C293 a_13880_2491# a_13592_2796# 0.43707f
C294 a_15304_1978# a_15688_3240# 0.19136f
C295 a_13306_3678# a_13566_3208# 0.75507f
C296 a_15464_1057# DELAY_OUT_LAST 0.02565f
C297 DELAY_IN a_12158_3240# 0.01309f
C298 a_12849_3240# a_14009_3251# 0.03525f
C299 a_15108_3482# a_14851_3601# 0.29858f
C300 a_5778_740# a_6126_1189# 1.6143f
C301 VDD a_14851_2555# 0.26676f
C302 DELAY_IN a_13592_3244# 0.11539f
C303 a_13121_3204# a_14851_2555# 0.03337f
C304 a_13880_2491# a_14009_2457# 0.01562f
C305 DLL_RESETN a_9444_1285# 0.03031f
C306 a_5778_740# a_5974_3096# 2.88221f
C307 a_9547_3545# a_9547_3315# 0.1117f
C308 VDD a_12656_3237# 0.26066f
C309 a_5864_740# DLL_RESETN 0.1727f
C310 DLL_RESETN a_9772_3216# 0.06592f
R0 VDD.n23 VDD.t24 17.3693
R1 VDD.n11 VDD.t42 17.3693
R2 VDD.n11 VDD.t38 17.3693
R3 VDD.n22 VDD.t22 17.3517
R4 VDD.n14 VDD.t84 17.3517
R5 VDD.n13 VDD.t27 17.3517
R6 VDD.n17 VDD.t26 17.2247
R7 VDD.n22 VDD.t19 17.0005
R8 VDD.n14 VDD.t41 17.0005
R9 VDD.n13 VDD.t37 17.0005
R10 VDD.t31 VDD.t72 15.0005
R11 VDD.t31 VDD.t77 15.0005
R12 VDD.t31 VDD.t80 15.0005
R13 VDD.t31 VDD.t49 17.9449
R14 VDD.n32 VDD.t17 9.02285
R15 VDD.t31 VDD.t52 8.95516
R16 VDD.n7 VDD.t45 8.76054
R17 VDD.n7 VDD.t35 8.76054
R18 VDD.n0 VDD.t0 1.78925
R19 VDD.n21 VDD.t21 5.9886
R20 VDD.n5 VDD.t47 5.97675
R21 VDD.n5 VDD.t34 5.97675
R22 VDD.n19 VDD.t54 5.96478
R23 VDD.t0 VDD.n33 5.62581
R24 VDD.t18 VDD.n16 5.61485
R25 VDD.t18 VDD.n20 5.61485
R26 VDD.t31 VDD.t73 5.71133
R27 VDD.t31 VDD.t79 5.59179
R28 VDD.n2 VDD.t64 4.9462
R29 VDD.n42 VDD.t61 4.9462
R30 VDD.n9 VDD.t31 7.13279
R31 VDD.t0 VDD.n25 4.19238
R32 VDD.t0 VDD.n34 4.19225
R33 VDD.t0 VDD.n62 4.19225
R34 VDD.t0 VDD.n30 4.19225
R35 VDD.t18 VDD.n18 3.31208
R36 VDD.t18 VDD.n10 3.30706
R37 VDD.t18 VDD.n12 3.30706
R38 VDD.t18 VDD.n24 3.30688
R39 VDD.t18 VDD.n6 2.7751
R40 VDD.t18 VDD 1.47683
R41 VDD.n69 VDD.t66 2.69937
R42 VDD.n40 VDD.t69 2.69937
R43 VDD.n38 VDD.t63 2.69937
R44 VDD.n1 VDD.t71 2.69937
R45 VDD.n67 VDD.t5 2.6992
R46 VDD.n65 VDD.t9 2.6992
R47 VDD.n36 VDD.t10 2.6992
R48 VDD.n44 VDD.t1 2.6992
R49 VDD.n49 VDD.t2 2.6992
R50 VDD.n48 VDD.t11 2.6992
R51 VDD.n54 VDD.t4 2.6992
R52 VDD.n53 VDD.t12 2.6992
R53 VDD.n59 VDD.t7 2.6992
R54 VDD.n58 VDD.t15 2.6992
R55 VDD.t0 VDD.n56 2.32425
R56 VDD.t0 VDD.n61 2.32417
R57 VDD.t0 VDD.n29 2.32417
R58 VDD.t0 VDD.n26 2.32417
R59 VDD.t0 VDD.n46 2.32417
R60 VDD.t0 VDD.n28 2.32406
R61 VDD.t0 VDD.n51 2.0061
R62 VDD.t0 VDD.n27 2.0061
R63 VDD.t0 VDD.n71 1.75938
R64 VDD.t18 VDD.n8 1.20461
R65 VDD.n49 VDD.n48 1.11007
R66 VDD.n54 VDD.n53 1.11007
R67 VDD.n59 VDD.n58 1.11007
R68 VDD.n23 VDD.n4 0.975304
R69 VDD.n39 VDD.n31 0.896769
R70 VDD.n32 VDD.n31 0.879646
R71 VDD.n4 VDD.n21 0.817678
R72 VDD.n9 VDD.n8 0.671512
R73 VDD.n8 VDD.n7 0.6645
R74 VDD.n70 VDD.n69 0.570444
R75 VDD.n38 VDD.n37 0.570444
R76 VDD.n65 VDD.n64 0.570274
R77 VDD.n45 VDD.n44 0.570274
R78 VDD.n50 VDD.n49 0.570274
R79 VDD.n55 VDD.n54 0.570274
R80 VDD.n60 VDD.n59 0.570274
R81 VDD.n67 VDD.n66 0.569912
R82 VDD.n36 VDD.n35 0.569912
R83 VDD.n48 VDD.n47 0.569912
R84 VDD.n53 VDD.n52 0.569912
R85 VDD.n58 VDD.n57 0.569912
R86 VDD.n40 VDD.n39 0.569733
R87 VDD.n1 VDD.n63 0.569733
R88 VDD.t18 VDD.n4 0.49685
R89 VDD.n41 VDD.n40 0.492175
R90 VDD VDD.n1 0.492175
R91 VDD.n68 VDD.n67 0.492005
R92 VDD.n43 VDD.n36 0.492005
R93 VDD.n68 VDD.n65 0.491643
R94 VDD.n44 VDD.n43 0.491643
R95 VDD.n69 VDD 0.491464
R96 VDD.n41 VDD.n38 0.491464
R97 VDD.t0 VDD.n31 0.487679
R98 VDD.n71 VDD.n70 0.43335
R99 VDD.n71 VDD 0.403558
R100 VDD.t0 VDD.t18 0.383639
R101 VDD.n56 VDD.n55 0.372812
R102 VDD.n52 VDD.n28 0.372571
R103 VDD.n50 VDD.n46 0.35515
R104 VDD.n47 VDD.n26 0.354692
R105 VDD.n61 VDD.n60 0.347655
R106 VDD.n57 VDD.n29 0.347655
R107 VDD.n51 VDD.n50 0.347254
R108 VDD.n47 VDD.n27 0.347254
R109 VDD.n24 VDD.n23 0.335799
R110 VDD.n12 VDD.n11 0.335496
R111 VDD.n64 VDD.n61 0.334692
R112 VDD.n66 VDD.n29 0.334692
R113 VDD.n15 VDD.n12 0.332368
R114 VDD.n24 VDD.n3 0.332058
R115 VDD.n63 VDD.n0 0.383516
R116 VDD.n52 VDD.n27 0.328947
R117 VDD.n55 VDD.n51 0.328947
R118 VDD.n35 VDD.n26 0.327655
R119 VDD.n19 VDD.n18 0.327354
R120 VDD.n46 VDD.n45 0.327197
R121 VDD.n57 VDD.n28 0.309771
R122 VDD.n60 VDD.n56 0.309557
R123 VDD.n7 VDD.n6 0.306614
R124 VDD.n10 VDD.n9 0.298721
R125 VDD VDD.n3 0.423614
R126 VDD.n18 VDD.n17 0.282297
R127 VDD.n11 VDD.n10 0.260496
R128 VDD.n2 VDD.n68 0.253639
R129 VDD.n42 VDD.n41 0.253639
R130 VDD.n43 VDD.n42 0.253298
R131 VDD.n21 VDD.n20 0.202075
R132 VDD.n45 VDD.n34 0.191924
R133 VDD.n35 VDD.n25 0.191793
R134 VDD.n64 VDD.n62 0.184424
R135 VDD.n66 VDD.n30 0.184424
R136 VDD.n37 VDD.n33 0.17955
R137 VDD.n20 VDD.n19 0.175486
R138 VDD.n17 VDD.n16 0.171736
R139 VDD.n63 VDD.n30 0.161924
R140 VDD.n70 VDD.n62 0.161924
R141 VDD.n39 VDD.n25 0.154552
R142 VDD.n37 VDD.n34 0.154424
R143 VDD.n3 VDD.n22 0.152808
R144 VDD.n15 VDD.n14 0.152808
R145 VDD.n15 VDD.n13 0.152808
R146 VDD.n16 VDD.n15 0.147075
R147 VDD.n6 VDD.n5 0.127628
R148 VDD.n33 VDD.n32 0.117388
R149 VDD.t31 VDD.t75 15.0334
R150 VDD.t78 VDD.t31 5.76644
R151 VDD VDD.n2 0.612395
R152 VDD VDD.n0 0.543771
R153 VDD.t81 VDD.t31 5.75163
R154 VDD.t76 VDD.t31 5.77389
R155 VDD.t83 VDD.t31 6.09264
R156 VDD.t31 VDD.t74 5.81814
R157 VSS.n247 VSS.t132 119321
R158 VSS.n169 VSS.n168 22369.4
R159 VSS.n226 VSS.n200 1028.14
R160 VSS.n242 VSS.n221 1028.14
R161 VSS.t97 VSS.n150 849.322
R162 VSS.n475 VSS.n192 572.005
R163 VSS.t3 VSS.t0 571.348
R164 VSS.n232 VSS.t116 566.691
R165 VSS.n231 VSS.t65 560.899
R166 VSS.n206 VSS.t79 550.193
R167 VSS.n495 VSS.t130 539.653
R168 VSS.t63 VSS.n229 532.819
R169 VSS.n498 VSS.t122 522.508
R170 VSS.n245 VSS.t25 521.236
R171 VSS.t72 VSS.n228 514.091
R172 VSS.n238 VSS.t68 504.839
R173 VSS.n212 VSS.t76 504.839
R174 VSS.n496 VSS.t123 491.87
R175 VSS.n233 VSS.t70 474.904
R176 VSS.t124 VSS.n152 470.019
R177 VSS.n234 VSS.t20 456.175
R178 VSS.n244 VSS.t22 427.695
R179 VSS.n228 VSS.t66 427.219
R180 VSS.n207 VSS.n202 412.791
R181 VSS.n236 VSS.n235 412.791
R182 VSS.n209 VSS.n207 404.192
R183 VSS.n235 VSS.n225 404.192
R184 VSS.t73 VSS.n496 401.591
R185 VSS.t97 VSS.n151 388.781
R186 VSS.n246 VSS.t23 375.276
R187 VSS.t118 VSS.n202 372.094
R188 VSS.t117 VSS.n236 372.094
R189 VSS.n67 VSS.n568 370.009
R190 VSS.t83 VSS.n214 363.339
R191 VSS.t18 VSS.n241 363.339
R192 VSS.t90 VSS.t95 359.769
R193 VSS.n204 VSS.t93 347.49
R194 VSS.n205 VSS.t81 329.238
R195 VSS.n543 VSS.t3 327.81
R196 VSS.n499 VSS.t121 313.659
R197 VSS.t88 VSS.t153 304.42
R198 VSS.t75 VSS.n201 304.42
R199 VSS.t115 VSS.t61 304.42
R200 VSS.t67 VSS.n239 304.42
R201 VSS.t129 VSS.n498 299.735
R202 VSS.n212 VSS.t94 291.37
R203 VSS.t1 VSS.n238 291.37
R204 VSS.n227 VSS.n226 249.036
R205 VSS.n243 VSS.n242 249.036
R206 VSS.t81 VSS.n204 243.244
R207 VSS.t93 VSS.n192 224.516
R208 VSS.n497 VSS.t73 208.828
R209 VSS.n499 VSS.t129 202.362
R210 VSS.n211 VSS.t118 202.071
R211 VSS.n237 VSS.t117 202.071
R212 VSS.t23 VSS.n245 196.911
R213 VSS.t94 VSS.n201 196.399
R214 VSS.n239 VSS.t1 196.399
R215 VSS.t121 VSS.n148 187.895
R216 VSS.n45 VSS.t132 27.7447
R217 VSS.t2 VSS.n234 183.975
R218 VSS.n213 VSS.t75 182.797
R219 VSS.n240 VSS.t67 182.797
R220 VSS.t78 VSS.n206 167.954
R221 VSS.n5 VSS.n169 157.912
R222 VSS.t97 VSS.n0 154.968
R223 VSS.t66 VSS.n227 144.788
R224 VSS.t22 VSS.n243 144.788
R225 VSS.t100 VSS.n2 143.149
R226 VSS.t0 VSS.t132 142.417
R227 VSS.t153 VSS.n213 138.607
R228 VSS.t61 VSS.n240 138.607
R229 VSS.n173 VSS.t143 123.18
R230 VSS.n183 VSS.t148 123.18
R231 VSS.n169 VSS.n148 122.129
R232 VSS.n152 VSS.t90 121.858
R233 VSS.n476 VSS.n475 118.993
R234 VSS.n8 VSS.t64 118.9
R235 VSS.t20 VSS.n233 115.831
R236 VSS.n226 VSS.t83 112.361
R237 VSS.n242 VSS.t18 112.361
R238 VSS.n494 VSS.t124 103.538
R239 VSS.n4 VSS.t26 101.448
R240 VSS.t98 VSS.n142 99.4847
R241 VSS.n475 VSS.n474 98.6652
R242 VSS.t70 VSS.n232 97.5777
R243 VSS.n501 VSS.t128 93.1365
R244 VSS.t122 VSS.n497 88.3462
R245 VSS.n500 VSS.t120 87.3255
R246 VSS.t76 VSS.n211 85.7923
R247 VSS.t68 VSS.n237 85.7923
R248 VSS.t123 VSS.n495 81.2384
R249 VSS.t145 VSS.n4 79.5956
R250 VSS.n7 VSS.t151 79.5939
R251 VSS.n173 VSS.t145 79.4707
R252 VSS.t151 VSS.n183 79.4707
R253 VSS.t95 VSS.n151 75.4357
R254 VSS.t14 VSS.n116 70.0202
R255 VSS.n568 VSS.t119 68.534
R256 VSS.t125 VSS.t89 68.534
R257 VSS.n477 VSS.t99 66.3233
R258 VSS.t26 VSS.n3 65.6868
R259 VSS.t86 VSS.n143 65.2179
R260 VSS.n168 VSS.n144 65.2179
R261 VSS.n131 VSS.t107 62.1307
R262 VSS.t16 VSS.n119 60.1583
R263 VSS.n229 VSS.t72 57.9156
R264 VSS.n379 VSS.n194 56.3803
R265 VSS.n473 VSS.n472 56.3803
R266 VSS.n168 VSS.n147 53.7749
R267 VSS.t28 VSS.n376 53.413
R268 VSS.n407 VSS.t39 53.413
R269 VSS.t99 VSS.n476 52.6695
R270 VSS.n507 VSS.t103 52.2687
R271 VSS.t25 VSS.n244 51.2456
R272 VSS.t43 VSS.n339 50.4456
R273 VSS.t101 VSS.n122 50.2964
R274 VSS.n524 VSS.t132 48.324
R275 VSS.t64 VSS.n7 47.8071
R276 VSS.n477 VSS.t96 46.4264
R277 VSS.t33 VSS.n276 44.5109
R278 VSS.n288 VSS.t35 44.5109
R279 VSS.t135 VSS.n134 44.3792
R280 VSS.n214 VSS.t88 44.1903
R281 VSS.n241 VSS.t115 44.1903
R282 VSS.t15 VSS.n118 42.4068
R283 VSS.n520 VSS.t17 42.4068
R284 VSS.n500 VSS.t86 40.8995
R285 VSS.t105 VSS.n127 40.4344
R286 VSS.n230 VSS.t63 39.1873
R287 VSS.n142 VSS.t119 37.5834
R288 VSS.t148 VSS.n3 35.8845
R289 VSS.t143 VSS.n5 35.882
R290 VSS.n386 VSS.t31 35.6088
R291 VSS.t37 VSS.n353 35.6088
R292 VSS.n128 VSS.t105 34.5173
R293 VSS.n44 VSS.n45 1.27308
R294 VSS.t130 VSS.n494 33.9067
R295 VSS.n502 VSS.t15 32.5449
R296 VSS.t17 VSS.n121 32.5449
R297 VSS.n515 VSS.t135 30.5725
R298 VSS.n318 VSS.t41 29.6741
R299 VSS.t128 VSS.n143 27.635
R300 VSS.t65 VSS.n230 27.6043
R301 VSS.t41 VSS.n317 26.7067
R302 VSS.n123 VSS.t101 24.6553
R303 VSS.n8 VSS.t100 23.5358
R304 VSS.t89 VSS.n147 22.8243
R305 VSS.t103 VSS.n124 22.6829
R306 VSS.t79 VSS.n205 22.2881
R307 VSS.t116 VSS.n231 22.2881
R308 VSS.n501 VSS.t98 21.2859
R309 VSS.n416 VSS.n325 21.211
R310 VSS.n415 VSS.n323 21.211
R311 VSS.n413 VSS.n316 21.211
R312 VSS.n412 VSS.n314 21.211
R313 VSS.n411 VSS.n312 21.211
R314 VSS.n410 VSS.n311 21.211
R315 VSS.n409 VSS.n309 21.211
R316 VSS.n408 VSS.n308 21.211
R317 VSS.n406 VSS.n306 21.211
R318 VSS.n405 VSS.n303 21.211
R319 VSS.n404 VSS.n302 21.211
R320 VSS.n403 VSS.n300 21.211
R321 VSS.n402 VSS.n299 21.211
R322 VSS.n401 VSS.n298 21.211
R323 VSS.n399 VSS.n293 21.211
R324 VSS.n398 VSS.n291 21.211
R325 VSS.n396 VSS.n286 21.211
R326 VSS.n395 VSS.n285 21.211
R327 VSS.n394 VSS.n283 21.211
R328 VSS.n393 VSS.n281 21.211
R329 VSS.n392 VSS.n278 21.211
R330 VSS.n390 VSS.n275 21.211
R331 VSS.n389 VSS.n273 21.211
R332 VSS.n388 VSS.n272 21.211
R333 VSS.n387 VSS.n270 21.211
R334 VSS.n385 VSS.n265 21.211
R335 VSS.n384 VSS.n264 21.211
R336 VSS.n383 VSS.n259 21.211
R337 VSS.n381 VSS.n254 21.211
R338 VSS.n380 VSS.n253 21.211
R339 VSS.n378 VSS.n195 21.211
R340 VSS.n378 VSS.n253 21.211
R341 VSS.n380 VSS.n254 21.211
R342 VSS.n381 VSS.n255 21.211
R343 VSS.n377 VSS.n255 21.211
R344 VSS.n377 VSS.n256 21.211
R345 VSS.n375 VSS.n257 21.211
R346 VSS.n375 VSS.n258 21.211
R347 VSS.n374 VSS.n258 21.211
R348 VSS.n374 VSS.n259 21.211
R349 VSS.n383 VSS.n260 21.211
R350 VSS.n373 VSS.n260 21.211
R351 VSS.n373 VSS.n261 21.211
R352 VSS.n372 VSS.n261 21.211
R353 VSS.n372 VSS.n262 21.211
R354 VSS.n371 VSS.n262 21.211
R355 VSS.n371 VSS.n263 21.211
R356 VSS.n370 VSS.n263 21.211
R357 VSS.n370 VSS.n264 21.211
R358 VSS.n384 VSS.n265 21.211
R359 VSS.n385 VSS.n266 21.211
R360 VSS.n368 VSS.n267 21.211
R361 VSS.n368 VSS.n268 21.211
R362 VSS.n367 VSS.n268 21.211
R363 VSS.n367 VSS.n269 21.211
R364 VSS.n366 VSS.n269 21.211
R365 VSS.n366 VSS.n270 21.211
R366 VSS.n387 VSS.n271 21.211
R367 VSS.n365 VSS.n271 21.211
R368 VSS.n365 VSS.n272 21.211
R369 VSS.n388 VSS.n273 21.211
R370 VSS.n389 VSS.n274 21.211
R371 VSS.n364 VSS.n274 21.211
R372 VSS.n364 VSS.n275 21.211
R373 VSS.n391 VSS.n278 21.211
R374 VSS.n392 VSS.n279 21.211
R375 VSS.n363 VSS.n279 21.211
R376 VSS.n363 VSS.n280 21.211
R377 VSS.n362 VSS.n280 21.211
R378 VSS.n362 VSS.n281 21.211
R379 VSS.n393 VSS.n282 21.211
R380 VSS.n361 VSS.n282 21.211
R381 VSS.n361 VSS.n283 21.211
R382 VSS.n394 VSS.n284 21.211
R383 VSS.n360 VSS.n284 21.211
R384 VSS.n360 VSS.n285 21.211
R385 VSS.n395 VSS.n286 21.211
R386 VSS.n397 VSS.n289 21.211
R387 VSS.n359 VSS.n289 21.211
R388 VSS.n359 VSS.n290 21.211
R389 VSS.n358 VSS.n290 21.211
R390 VSS.n358 VSS.n291 21.211
R391 VSS.n398 VSS.n292 21.211
R392 VSS.n357 VSS.n292 21.211
R393 VSS.n357 VSS.n293 21.211
R394 VSS.n399 VSS.n294 21.211
R395 VSS.n356 VSS.n294 21.211
R396 VSS.n356 VSS.n295 21.211
R397 VSS.n355 VSS.n295 21.211
R398 VSS.n355 VSS.n296 21.211
R399 VSS.n354 VSS.n296 21.211
R400 VSS.n354 VSS.n297 21.211
R401 VSS.n401 VSS.n299 21.211
R402 VSS.n402 VSS.n300 21.211
R403 VSS.n403 VSS.n301 21.211
R404 VSS.n352 VSS.n301 21.211
R405 VSS.n352 VSS.n302 21.211
R406 VSS.n404 VSS.n303 21.211
R407 VSS.n405 VSS.n304 21.211
R408 VSS.n351 VSS.n304 21.211
R409 VSS.n351 VSS.n305 21.211
R410 VSS.n350 VSS.n305 21.211
R411 VSS.n350 VSS.n306 21.211
R412 VSS.n406 VSS.n307 21.211
R413 VSS.n408 VSS.n309 21.211
R414 VSS.n409 VSS.n310 21.211
R415 VSS.n348 VSS.n310 21.211
R416 VSS.n348 VSS.n311 21.211
R417 VSS.n410 VSS.n312 21.211
R418 VSS.n411 VSS.n313 21.211
R419 VSS.n347 VSS.n313 21.211
R420 VSS.n347 VSS.n314 21.211
R421 VSS.n412 VSS.n315 21.211
R422 VSS.n346 VSS.n315 21.211
R423 VSS.n346 VSS.n316 21.211
R424 VSS.n414 VSS.n319 21.211
R425 VSS.n345 VSS.n319 21.211
R426 VSS.n345 VSS.n320 21.211
R427 VSS.n344 VSS.n320 21.211
R428 VSS.n344 VSS.n321 21.211
R429 VSS.n343 VSS.n321 21.211
R430 VSS.n343 VSS.n322 21.211
R431 VSS.n342 VSS.n322 21.211
R432 VSS.n342 VSS.n323 21.211
R433 VSS.n415 VSS.n324 21.211
R434 VSS.n341 VSS.n324 21.211
R435 VSS.n341 VSS.n325 21.211
R436 VSS.n416 VSS.n326 21.211
R437 VSS.n340 VSS.n326 21.211
R438 VSS.n340 VSS.n327 21.211
R439 VSS.n338 VSS.n328 21.211
R440 VSS.n338 VSS.n329 21.211
R441 VSS.n337 VSS.n329 21.211
R442 VSS.n337 VSS.n330 21.211
R443 VSS.n336 VSS.n330 21.211
R444 VSS.n336 VSS.n331 21.211
R445 VSS.n335 VSS.n331 21.211
R446 VSS.n335 VSS.n332 21.211
R447 VSS.t31 VSS.n369 20.772
R448 VSS.n400 VSS.t37 20.772
R449 VSS.t120 VSS.n144 18.792
R450 VSS.n513 VSS.n30 18.6257
R451 VSS.n523 VSS.n32 18.6249
R452 VSS.n521 VSS.n33 18.6249
R453 VSS.n503 VSS.n34 18.6249
R454 VSS.n504 VSS.n35 18.6249
R455 VSS.n506 VSS.n36 18.6249
R456 VSS.n518 VSS.n38 18.6249
R457 VSS.n517 VSS.n39 18.6249
R458 VSS.n508 VSS.n40 18.6249
R459 VSS.n508 VSS.n41 18.6249
R460 VSS.n510 VSS.n42 18.6249
R461 VSS.n513 VSS.n43 18.6249
R462 VSS.n522 VSS.n33 18.6249
R463 VSS.n503 VSS.n35 18.6249
R464 VSS.n505 VSS.n36 18.6249
R465 VSS.n519 VSS.n37 18.6249
R466 VSS.n519 VSS.n38 18.6249
R467 VSS.n516 VSS.n39 18.6249
R468 VSS.n509 VSS.n41 18.6249
R469 VSS.n511 VSS.n42 18.6249
R470 VSS.n512 VSS.n43 18.6249
R471 VSS.n514 VSS.n135 18.0386
R472 VSS.t96 VSS.t97 17.6866
R473 VSS.n472 VSS.n471 17.0005
R474 VSS.n471 VSS.n417 17.0005
R475 VSS.n471 VSS.n339 17.0005
R476 VSS.n471 VSS.n407 17.0005
R477 VSS.n471 VSS.n349 17.0005
R478 VSS.n471 VSS.n400 17.0005
R479 VSS.n471 VSS.n353 17.0005
R480 VSS.n471 VSS.n386 17.0005
R481 VSS.n471 VSS.n369 17.0005
R482 VSS.n471 VSS.n382 17.0005
R483 VSS.n471 VSS.n376 17.0005
R484 VSS.n471 VSS.n379 17.0005
R485 VSS.n44 VSS.n126 17.0005
R486 VSS.n525 VSS.n524 17.0005
R487 VSS.n525 VSS.n502 17.0005
R488 VSS.n525 VSS.n520 17.0005
R489 VSS.n525 VSS.n507 17.0005
R490 VSS.n563 VSS.n525 17.0005
R491 VSS.n525 VSS.n515 17.0005
R492 VSS.n525 VSS.n141 17.0005
R493 VSS.n568 VSS.t74 17.0005
R494 VSS.t74 VSS.n142 17.0005
R495 VSS.t74 VSS.n143 17.0005
R496 VSS.t74 VSS.n500 17.0005
R497 VSS.t74 VSS.n144 17.0005
R498 VSS.t74 VSS.n499 17.0005
R499 VSS.n478 VSS.n477 17.0005
R500 VSS.t74 VSS.n151 17.0005
R501 VSS.t74 VSS.n152 17.0005
R502 VSS.t74 VSS.n495 17.0005
R503 VSS.n245 VSS.t24 17.0005
R504 VSS.n243 VSS.t24 17.0005
R505 VSS.n241 VSS.t69 17.0005
R506 VSS.n239 VSS.t69 17.0005
R507 VSS.n236 VSS.t69 17.0005
R508 VSS.n233 VSS.n216 17.0005
R509 VSS.n229 VSS.n216 17.0005
R510 VSS.n227 VSS.n216 17.0005
R511 VSS.t77 VSS.n214 17.0005
R512 VSS.t77 VSS.n201 17.0005
R513 VSS.t77 VSS.n202 17.0005
R514 VSS.n206 VSS.n196 17.0005
R515 VSS.n204 VSS.n196 17.0005
R516 VSS.n76 VSS.n473 17.0005
R517 VSS.n76 VSS.n318 17.0005
R518 VSS.n76 VSS.n317 17.0005
R519 VSS.n76 VSS.n288 17.0005
R520 VSS.n76 VSS.n287 17.0005
R521 VSS.n76 VSS.n277 17.0005
R522 VSS.n76 VSS.n276 17.0005
R523 VSS.n76 VSS.n194 17.0005
R524 VSS.n76 VSS.n333 17.0005
R525 VSS.n44 VSS.n136 17.0005
R526 VSS.n9 VSS.n160 17.0005
R527 VSS.n9 VSS.n161 17.0005
R528 VSS.n9 VSS.n164 17.0005
R529 VSS.n9 VSS.n172 17.0005
R530 VSS.n9 VSS.n182 17.0005
R531 VSS.n9 VSS.n190 17.0005
R532 VSS.n247 VSS.n246 16.2018
R533 VSS.n120 VSS.t16 14.7934
R534 VSS.t107 VSS.n130 12.821
R535 VSS.n141 VSS.n135 12.6861
R536 VSS.n277 VSS.t33 11.8699
R537 VSS.t35 VSS.n287 11.8699
R538 VSS.n522 VSS.n117 11.6958
R539 VSS.n505 VSS.n120 11.6958
R540 VSS.n517 VSS.n123 11.6958
R541 VSS.n510 VSS.n128 11.6958
R542 VSS.n512 VSS.n131 11.6958
R543 VSS.n514 VSS.n134 11.6958
R544 VSS.n523 VSS.n116 11.6958
R545 VSS.n521 VSS.n118 11.6958
R546 VSS.n504 VSS.n119 11.6958
R547 VSS.n506 VSS.n121 11.6958
R548 VSS.n518 VSS.n122 11.6958
R549 VSS.n516 VSS.n124 11.6958
R550 VSS.n509 VSS.n127 11.6958
R551 VSS.n511 VSS.n130 11.6958
R552 VSS.n67 VSS.n141 13.2721
R553 VSS.n414 VSS.n318 10.6058
R554 VSS.n397 VSS.n288 10.6058
R555 VSS.n391 VSS.n277 10.6058
R556 VSS.n472 VSS.n332 10.6058
R557 VSS.n339 VSS.n327 10.6058
R558 VSS.n349 VSS.n307 10.6058
R559 VSS.n353 VSS.n297 10.6058
R560 VSS.n369 VSS.n266 10.6058
R561 VSS.n376 VSS.n256 10.6058
R562 VSS.n334 VSS.n333 10.6058
R563 VSS.n379 VSS.n195 10.6058
R564 VSS.n382 VSS.n257 10.6058
R565 VSS.n386 VSS.n267 10.6058
R566 VSS.n390 VSS.n276 10.6058
R567 VSS.n396 VSS.n287 10.6058
R568 VSS.n400 VSS.n298 10.6058
R569 VSS.n407 VSS.n308 10.6058
R570 VSS.n413 VSS.n317 10.6058
R571 VSS.n417 VSS.n328 10.6058
R572 VSS.n473 VSS.n334 10.6058
R573 VSS.n468 VSS.n333 10.3863
R574 VSS.n90 VSS.n89 9.81769
R575 VSS.n90 VSS.n79 9.53935
R576 VSS.n91 VSS.n90 9.39094
R577 VSS.n488 VSS.t71 9.08698
R578 VSS.t71 VSS.n487 9.0445
R579 VSS.n492 VSS.n154 9.0005
R580 VSS.n165 VSS.n155 9.0005
R581 VSS.n157 VSS.n155 9.0005
R582 VSS.n492 VSS.n491 9.0005
R583 VSS.n115 VSS.n11 2.83417
R584 VSS.n11 VSS.n10 0.00166658
R585 VSS.n10 VSS.n12 0.00149997
R586 VSS.n115 VSS.n14 4.251
R587 VSS.n14 VSS.n13 0.00149997
R588 VSS.n115 VSS.n16 4.251
R589 VSS.n16 VSS.n15 0.00149997
R590 VSS.n115 VSS.n18 2.12569
R591 VSS.n18 VSS.n17 0.00170812
R592 VSS.n17 VSS.n19 0.00166658
R593 VSS.n19 VSS.n20 0.00149997
R594 VSS.n115 VSS.n22 1.06279
R595 VSS.n22 VSS.n23 0.00291472
R596 VSS.n23 VSS.n24 0.00173273
R597 VSS.n24 VSS.n25 0.00172462
R598 VSS.n25 VSS.n26 0.00170812
R599 VSS.n26 VSS.n27 0.00166658
R600 VSS.n27 VSS.n28 0.00149997
R601 VSS.n45 VSS.n115 6.91252
R602 VSS.n543 VSS.n44 8.501
R603 VSS.n543 VSS.n48 3.40102
R604 VSS.n50 VSS.n49 0.00214918
R605 VSS.n49 VSS.n51 0.00172539
R606 VSS.n51 VSS.n52 0.00171613
R607 VSS.n52 VSS.n53 0.00169968
R608 VSS.n53 VSS.n54 0.00166651
R609 VSS.n54 VSS.n56 0.00158329
R610 VSS.n543 VSS.n60 3.40102
R611 VSS.n543 VSS.n62 8.501
R612 VSS.n543 VSS.n64 2.83439
R613 VSS.n64 VSS.n66 0.00141665
R614 VSS.n474 VSS.n72 2.42968
R615 VSS.n474 VSS.n69 1.309
R616 VSS.n225 VSS.n223 8.501
R617 VSS.n225 VSS.n222 8.501
R618 VSS.n210 VSS.n209 8.501
R619 VSS.n209 VSS.n203 8.501
R620 VSS.n468 VSS.n418 8.501
R621 VSS.n469 VSS.n468 8.501
R622 VSS.n468 VSS.n430 8.501
R623 VSS.n468 VSS.n429 8.501
R624 VSS.n468 VSS.n428 8.501
R625 VSS.n468 VSS.n427 8.501
R626 VSS.n468 VSS.n426 8.501
R627 VSS.n468 VSS.n425 8.501
R628 VSS.n468 VSS.n424 8.501
R629 VSS.n468 VSS.n423 8.501
R630 VSS.n468 VSS.n432 8.501
R631 VSS.n468 VSS.n433 8.501
R632 VSS.n468 VSS.n434 8.501
R633 VSS.n468 VSS.n422 8.501
R634 VSS.n468 VSS.n75 8.501
R635 VSS.n0 VSS.n2 5.35126
R636 VSS.n44 VSS.n116 8.5005
R637 VSS.n44 VSS.n117 8.5005
R638 VSS.n44 VSS.n118 8.5005
R639 VSS.n44 VSS.n119 8.5005
R640 VSS.n44 VSS.n120 8.5005
R641 VSS.n44 VSS.n121 8.5005
R642 VSS.n44 VSS.n122 8.5005
R643 VSS.n44 VSS.n123 8.5005
R644 VSS.n44 VSS.n124 8.5005
R645 VSS.n44 VSS.n127 8.5005
R646 VSS.n44 VSS.n128 8.5005
R647 VSS.n44 VSS.n130 8.5005
R648 VSS.n44 VSS.n131 8.5005
R649 VSS.n44 VSS.n134 8.5005
R650 VSS.n9 VSS.n173 8.5005
R651 VSS.n9 VSS.n183 8.5005
R652 VSS.n9 VSS.n167 8.48883
R653 VSS.n9 VSS.n6 8.48883
R654 VSS.t60 VSS.n470 8.47784
R655 VSS.n420 VSS.n419 8.47784
R656 VSS.n452 VSS.n451 8.47784
R657 VSS.n453 VSS.n450 8.47784
R658 VSS.n454 VSS.n449 8.47784
R659 VSS.n455 VSS.n448 8.47784
R660 VSS.n456 VSS.n447 8.47784
R661 VSS.n457 VSS.n446 8.47784
R662 VSS.n459 VSS.n444 8.47784
R663 VSS.n460 VSS.n443 8.47784
R664 VSS.n461 VSS.n442 8.47784
R665 VSS.n462 VSS.n441 8.47784
R666 VSS.n464 VSS.n439 8.47784
R667 VSS.t44 VSS.n437 8.47784
R668 VSS.n44 VSS.n81 8.47732
R669 VSS.t139 VSS.n10 8.47732
R670 VSS.t4 VSS.n12 8.47732
R671 VSS.n104 VSS.n105 8.47732
R672 VSS.t7 VSS.n13 8.47732
R673 VSS.n103 VSS.n102 8.47732
R674 VSS.n108 VSS.n15 8.47732
R675 VSS.n100 VSS.n101 8.47732
R676 VSS.t9 VSS.n17 8.47732
R677 VSS.t10 VSS.n19 8.47732
R678 VSS.n109 VSS.n20 8.47732
R679 VSS.n110 VSS.n99 8.47732
R680 VSS.n98 VSS.n21 8.47732
R681 VSS.t11 VSS.n23 8.47732
R682 VSS.n97 VSS.n24 8.47732
R683 VSS.n111 VSS.n25 8.47732
R684 VSS.n96 VSS.n26 8.47732
R685 VSS.t13 VSS.n27 8.47732
R686 VSS.n95 VSS.n28 8.47732
R687 VSS.n94 VSS.n29 8.47732
R688 VSS.n44 VSS.n132 8.47732
R689 VSS.n44 VSS.n84 8.47732
R690 VSS.n44 VSS.n83 8.47732
R691 VSS.n545 VSS.n47 8.47732
R692 VSS.n548 VSS.n49 8.47732
R693 VSS.n549 VSS.n51 8.47732
R694 VSS.n550 VSS.n52 8.47732
R695 VSS.n551 VSS.n53 8.47732
R696 VSS.t5 VSS.n54 8.47732
R697 VSS.n538 VSS.n56 8.47732
R698 VSS.n552 VSS.n55 8.47732
R699 VSS.t6 VSS.n59 8.47732
R700 VSS.n554 VSS.n61 8.47732
R701 VSS.n555 VSS.n62 8.47732
R702 VSS.n556 VSS.n63 8.47732
R703 VSS.n557 VSS.n66 8.47732
R704 VSS.n530 VSS.n525 8.47732
R705 VSS.n76 VSS.n252 8.47732
R706 VSS.n9 VSS.n159 8.47732
R707 VSS.n9 VSS.n163 8.47732
R708 VSS.n9 VSS.n170 8.47732
R709 VSS.n9 VSS.n174 8.47732
R710 VSS.n9 VSS.n181 8.47732
R711 VSS.n9 VSS.n184 8.47732
R712 VSS.n480 VSS.n73 8.47677
R713 VSS.n481 VSS.n70 8.47677
R714 VSS.n483 VSS.n68 8.47677
R715 VSS.n249 VSS.n219 8.47111
R716 VSS.t21 VSS.n218 8.47111
R717 VSS.n251 VSS.n199 8.47111
R718 VSS.t80 VSS.n198 8.47111
R719 VSS.n567 VSS.n525 8.46924
R720 VSS.n44 VSS.t126 8.1859
R721 VSS.n115 VSS.t126 8.1722
R722 VSS.n515 VSS.n30 6.92973
R723 VSS.n520 VSS.n37 6.92951
R724 VSS.n524 VSS.n32 6.92951
R725 VSS.n502 VSS.n34 6.92951
R726 VSS.n507 VSS.n40 6.92951
R727 VSS.n194 VSS.n193 6.44807
R728 VSS.n474 VSS.n193 6.44807
R729 VSS.n417 VSS.t43 5.93522
R730 VSS.n248 VSS.n247 5.66985
R731 VSS.n115 VSS.n93 5.66778
R732 VSS.n115 VSS.n114 5.66778
R733 VSS.n544 VSS.n48 0.00229996
R734 VSS.n543 VSS.n540 5.66778
R735 VSS.n543 VSS.n50 1
R736 VSS.n60 VSS.n57 0.00229996
R737 VSS.n543 VSS.n541 5.66778
R738 VSS.n72 VSS.n68 0.0026428
R739 VSS.n468 VSS.n431 5.66778
R740 VSS.n468 VSS.n435 5.66778
R741 VSS.n468 VSS.n467 5.66778
R742 VSS.n468 VSS.n421 5.66778
R743 VSS.n225 VSS.n224 5.66767
R744 VSS.n209 VSS.n208 5.66767
R745 VSS.n484 VSS.n69 5.63736
R746 VSS.n458 VSS.n445 5.62674
R747 VSS.n463 VSS.n440 5.62674
R748 VSS.n466 VSS.n465 5.62674
R749 VSS.n438 VSS.n436 5.62674
R750 VSS.n44 VSS.n82 5.62581
R751 VSS.n107 VSS.n106 5.62581
R752 VSS.n113 VSS.n112 5.62581
R753 VSS.t133 VSS.n544 5.62581
R754 VSS.n546 VSS.n46 5.62581
R755 VSS.n547 VSS.n539 5.62581
R756 VSS.n537 VSS.n57 5.62581
R757 VSS.n553 VSS.n58 5.62581
R758 VSS.n558 VSS.n65 5.62581
R759 VSS.n44 VSS.n138 5.62581
R760 VSS.n9 VSS.n489 5.62581
R761 VSS.n482 VSS.n71 5.62484
R762 VSS.n471 VSS.n193 5.27747
R763 VSS.n493 VSS.n153 5.13648
R764 VSS.n117 VSS.t14 4.93147
R765 VSS.n155 VSS.n77 4.63796
R766 VSS.n207 VSS.t78 4.49152
R767 VSS.n235 VSS.t2 4.49152
R768 VSS.t87 VSS.n493 4.4712
R769 VSS.n169 VSS.t125 4.42202
R770 VSS.n543 VSS.n542 4.25119
R771 VSS.n526 VSS.n525 4.19244
R772 VSS.n9 VSS.n189 4.19238
R773 VSS.n44 VSS.n133 4.19225
R774 VSS.t91 VSS.n478 4.177
R775 VSS.n44 VSS.t127 3.37895
R776 VSS.n490 VSS.n9 3.32697
R777 VSS.n44 VSS.n80 3.32633
R778 VSS.n9 VSS.n179 3.32615
R779 VSS.t77 VSS.n215 3.30696
R780 VSS.n471 VSS.n334 3.19862
R781 VSS.n471 VSS.n335 3.19862
R782 VSS.n471 VSS.n336 3.19862
R783 VSS.n471 VSS.n337 3.19862
R784 VSS.n471 VSS.n338 3.19862
R785 VSS.n471 VSS.n340 3.19862
R786 VSS.n471 VSS.n416 3.19862
R787 VSS.n471 VSS.n341 3.19862
R788 VSS.n471 VSS.n415 3.19862
R789 VSS.n471 VSS.n342 3.19862
R790 VSS.n471 VSS.n343 3.19862
R791 VSS.n471 VSS.n344 3.19862
R792 VSS.n471 VSS.n345 3.19862
R793 VSS.n471 VSS.n414 3.19862
R794 VSS.n471 VSS.n413 3.19862
R795 VSS.n471 VSS.n346 3.19862
R796 VSS.n471 VSS.n412 3.19862
R797 VSS.n471 VSS.n347 3.19862
R798 VSS.n471 VSS.n411 3.19862
R799 VSS.n471 VSS.n410 3.19862
R800 VSS.n471 VSS.n348 3.19862
R801 VSS.n471 VSS.n409 3.19862
R802 VSS.n471 VSS.n408 3.19862
R803 VSS.n471 VSS.n406 3.19862
R804 VSS.n471 VSS.n350 3.19862
R805 VSS.n471 VSS.n351 3.19862
R806 VSS.n471 VSS.n405 3.19862
R807 VSS.n471 VSS.n404 3.19862
R808 VSS.n471 VSS.n352 3.19862
R809 VSS.n471 VSS.n403 3.19862
R810 VSS.n471 VSS.n402 3.19862
R811 VSS.n471 VSS.n401 3.19862
R812 VSS.n471 VSS.n354 3.19862
R813 VSS.n471 VSS.n355 3.19862
R814 VSS.n471 VSS.n356 3.19862
R815 VSS.n471 VSS.n399 3.19862
R816 VSS.n471 VSS.n357 3.19862
R817 VSS.n471 VSS.n398 3.19862
R818 VSS.n471 VSS.n358 3.19862
R819 VSS.n471 VSS.n359 3.19862
R820 VSS.n471 VSS.n397 3.19862
R821 VSS.n471 VSS.n396 3.19862
R822 VSS.n471 VSS.n395 3.19862
R823 VSS.n471 VSS.n360 3.19862
R824 VSS.n471 VSS.n394 3.19862
R825 VSS.n471 VSS.n361 3.19862
R826 VSS.n471 VSS.n393 3.19862
R827 VSS.n471 VSS.n362 3.19862
R828 VSS.n471 VSS.n363 3.19862
R829 VSS.n471 VSS.n392 3.19862
R830 VSS.n471 VSS.n391 3.19862
R831 VSS.n471 VSS.n390 3.19862
R832 VSS.n471 VSS.n364 3.19862
R833 VSS.n471 VSS.n389 3.19862
R834 VSS.n471 VSS.n388 3.19862
R835 VSS.n471 VSS.n365 3.19862
R836 VSS.n471 VSS.n387 3.19862
R837 VSS.n471 VSS.n366 3.19862
R838 VSS.n471 VSS.n367 3.19862
R839 VSS.n471 VSS.n368 3.19862
R840 VSS.n471 VSS.n385 3.19862
R841 VSS.n471 VSS.n384 3.19862
R842 VSS.n471 VSS.n370 3.19862
R843 VSS.n471 VSS.n371 3.19862
R844 VSS.n471 VSS.n372 3.19862
R845 VSS.n471 VSS.n373 3.19862
R846 VSS.n471 VSS.n383 3.19862
R847 VSS.n471 VSS.n374 3.19862
R848 VSS.n471 VSS.n375 3.19862
R849 VSS.n471 VSS.n377 3.19862
R850 VSS.n471 VSS.n381 3.19862
R851 VSS.n471 VSS.n380 3.19862
R852 VSS.n471 VSS.n378 3.19862
R853 VSS.n76 VSS.n332 3.19862
R854 VSS.n76 VSS.n331 3.19862
R855 VSS.n76 VSS.n330 3.19862
R856 VSS.n76 VSS.n329 3.19862
R857 VSS.n76 VSS.n328 3.19862
R858 VSS.n76 VSS.n327 3.19862
R859 VSS.n76 VSS.n326 3.19862
R860 VSS.n76 VSS.n325 3.19862
R861 VSS.n76 VSS.n324 3.19862
R862 VSS.n76 VSS.n323 3.19862
R863 VSS.n76 VSS.n322 3.19862
R864 VSS.n76 VSS.n321 3.19862
R865 VSS.n76 VSS.n320 3.19862
R866 VSS.n76 VSS.n319 3.19862
R867 VSS.n76 VSS.n316 3.19862
R868 VSS.n76 VSS.n315 3.19862
R869 VSS.n76 VSS.n314 3.19862
R870 VSS.n76 VSS.n313 3.19862
R871 VSS.n76 VSS.n312 3.19862
R872 VSS.n76 VSS.n311 3.19862
R873 VSS.n76 VSS.n310 3.19862
R874 VSS.n76 VSS.n309 3.19862
R875 VSS.n76 VSS.n308 3.19862
R876 VSS.n76 VSS.n307 3.19862
R877 VSS.n76 VSS.n306 3.19862
R878 VSS.n76 VSS.n305 3.19862
R879 VSS.n76 VSS.n304 3.19862
R880 VSS.n76 VSS.n303 3.19862
R881 VSS.n76 VSS.n302 3.19862
R882 VSS.n76 VSS.n301 3.19862
R883 VSS.n76 VSS.n300 3.19862
R884 VSS.n76 VSS.n299 3.19862
R885 VSS.n76 VSS.n298 3.19862
R886 VSS.n76 VSS.n297 3.19862
R887 VSS.n76 VSS.n296 3.19862
R888 VSS.n76 VSS.n295 3.19862
R889 VSS.n76 VSS.n294 3.19862
R890 VSS.n76 VSS.n293 3.19862
R891 VSS.n76 VSS.n292 3.19862
R892 VSS.n76 VSS.n291 3.19862
R893 VSS.n76 VSS.n290 3.19862
R894 VSS.n76 VSS.n289 3.19862
R895 VSS.n76 VSS.n286 3.19862
R896 VSS.n76 VSS.n285 3.19862
R897 VSS.n76 VSS.n284 3.19862
R898 VSS.n76 VSS.n283 3.19862
R899 VSS.n76 VSS.n282 3.19862
R900 VSS.n76 VSS.n281 3.19862
R901 VSS.n76 VSS.n280 3.19862
R902 VSS.n76 VSS.n279 3.19862
R903 VSS.n76 VSS.n278 3.19862
R904 VSS.n76 VSS.n275 3.19862
R905 VSS.n76 VSS.n274 3.19862
R906 VSS.n76 VSS.n273 3.19862
R907 VSS.n76 VSS.n272 3.19862
R908 VSS.n76 VSS.n271 3.19862
R909 VSS.n76 VSS.n270 3.19862
R910 VSS.n76 VSS.n269 3.19862
R911 VSS.n76 VSS.n268 3.19862
R912 VSS.n76 VSS.n267 3.19862
R913 VSS.n76 VSS.n266 3.19862
R914 VSS.n76 VSS.n265 3.19862
R915 VSS.n76 VSS.n264 3.19862
R916 VSS.n76 VSS.n263 3.19862
R917 VSS.n76 VSS.n262 3.19862
R918 VSS.n76 VSS.n261 3.19862
R919 VSS.n76 VSS.n260 3.19862
R920 VSS.n76 VSS.n259 3.19862
R921 VSS.n76 VSS.n258 3.19862
R922 VSS.n76 VSS.n257 3.19862
R923 VSS.n76 VSS.n256 3.19862
R924 VSS.n76 VSS.n255 3.19862
R925 VSS.n76 VSS.n254 3.19862
R926 VSS.n76 VSS.n253 3.19862
R927 VSS.n76 VSS.n195 3.19862
R928 VSS.n382 VSS.t28 2.96786
R929 VSS.t39 VSS.n349 2.96786
R930 VSS.n44 VSS.n139 2.75566
R931 VSS.t45 VSS.n77 2.7456
R932 VSS.n9 VSS.n162 2.74386
R933 VSS.n525 VSS.n523 2.65358
R934 VSS.n525 VSS.n522 2.65358
R935 VSS.n525 VSS.n521 2.65358
R936 VSS.n525 VSS.n503 2.65358
R937 VSS.n525 VSS.n504 2.65358
R938 VSS.n525 VSS.n505 2.65358
R939 VSS.n525 VSS.n506 2.65358
R940 VSS.n525 VSS.n519 2.65358
R941 VSS.n525 VSS.n518 2.65358
R942 VSS.n525 VSS.n517 2.65358
R943 VSS.n525 VSS.n516 2.65358
R944 VSS.n525 VSS.n508 2.65358
R945 VSS.n525 VSS.n509 2.65358
R946 VSS.n525 VSS.n510 2.65358
R947 VSS.n525 VSS.n511 2.65358
R948 VSS.n525 VSS.n512 2.65358
R949 VSS.n525 VSS.n513 2.65358
R950 VSS.n525 VSS.n514 2.65358
R951 VSS.n565 VSS.n525 2.32483
R952 VSS.n44 VSS.n129 2.32414
R953 VSS.t74 VSS.n147 2.06357
R954 VSS.n478 VSS.n476 2.06357
R955 VSS.n44 VSS.n140 2.01633
R956 VSS.n561 VSS.n525 2.00687
R957 VSS.n44 VSS.n125 2.00604
R958 VSS.n250 VSS.t77 1.97699
R959 VSS.t19 VSS.n248 1.80539
R960 VSS VSS.n77 1.77935
R961 VSS.n44 VSS.n85 1.7562
R962 VSS.n44 VSS.n92 1.75596
R963 VSS.n9 VSS.n158 1.75483
R964 VSS.t82 VSS.n196 1.72287
R965 VSS.n491 VSS.n156 1.66925
R966 VSS.n471 VSS.n191 1.55041
R967 VSS.n44 VSS.n135 1.43974
R968 VSS.n531 VSS.t134 1.43372
R969 VSS.n527 VSS.t136 1.43372
R970 VSS.t136 VSS.n528 1.42949
R971 VSS.t134 VSS.n532 1.42949
R972 VSS.t108 VSS.t112 1.41892
R973 VSS.t106 VSS.t111 1.41892
R974 VSS.t104 VSS.t110 1.41892
R975 VSS.t102 VSS.t109 1.41892
R976 VSS.t131 VSS.n86 1.37661
R977 VSS.t131 VSS.n87 1.37661
R978 VSS.n569 VSS.n79 1.32707
R979 VSS.n78 VSS.n569 1.30246
R980 VSS.t44 VSS.t42 1.24904
R981 VSS.t58 VSS.t60 1.24802
R982 VSS.t50 VSS.t48 1.18726
R983 VSS.t34 VSS.t32 1.18293
R984 VSS.t36 VSS.t34 1.17925
R985 VSS.t50 VSS.t52 1.17786
R986 VSS.t29 VSS.t30 1.1778
R987 VSS.t40 VSS.t38 1.17364
R988 VSS.t56 VSS.t54 1.17241
R989 VSS.t46 VSS.t45 1.16092
R990 VSS.t58 VSS.t56 1.15743
R991 VSS.t42 VSS.t40 1.15262
R992 VSS.t46 VSS.t48 1.12501
R993 VSS.n149 VSS.t91 1.12148
R994 VSS.t52 VSS.t54 1.11752
R995 VSS.t38 VSS.t36 1.11316
R996 VSS.t32 VSS.t29 1.10881
R997 VSS.t74 VSS.n145 1.09664
R998 VSS.n220 VSS.t69 1.08287
R999 VSS.n217 VSS.t84 1.04142
R1000 VSS.n217 VSS.t21 1.0392
R1001 VSS.n145 VSS.n146 1.02454
R1002 VSS.n559 VSS.n558 0.980375
R1003 VSS.n94 VSS.n31 0.911352
R1004 VSS.n149 VSS.t87 0.884808
R1005 VSS.n560 VSS.n559 0.881792
R1006 VSS.n536 VSS.n31 0.84534
R1007 VSS.n249 VSS.n220 0.839803
R1008 VSS.n197 VSS.n74 0.832641
R1009 VSS.n474 VSS.n76 0.810524
R1010 VSS.t147 VSS.t149 0.806856
R1011 VSS.n166 VSS.t142 0.806855
R1012 VSS.t27 VSS.n180 0.802775
R1013 VSS.n44 VSS.n30 0.787095
R1014 VSS.n44 VSS.n32 0.786747
R1015 VSS.n44 VSS.n33 0.786747
R1016 VSS.n44 VSS.n34 0.786747
R1017 VSS.n44 VSS.n35 0.786747
R1018 VSS.n44 VSS.n36 0.786747
R1019 VSS.n44 VSS.n37 0.786747
R1020 VSS.n44 VSS.n38 0.786747
R1021 VSS.n44 VSS.n39 0.786747
R1022 VSS.n44 VSS.n40 0.786747
R1023 VSS.n44 VSS.n41 0.786747
R1024 VSS.n44 VSS.n42 0.786747
R1025 VSS.n44 VSS.n43 0.786747
R1026 VSS.n67 VSS.n44 0.156514
R1027 VSS.n220 VSS.t19 0.756052
R1028 VSS.n197 VSS.t82 0.745491
R1029 VSS.t74 VSS.n149 0.728098
R1030 VSS.n566 VSS.t108 0.722582
R1031 VSS.n564 VSS.t106 0.722582
R1032 VSS.n562 VSS.t104 0.722582
R1033 VSS.n560 VSS.t102 0.722582
R1034 VSS.t112 VSS.n533 0.72222
R1035 VSS.t111 VSS.n534 0.72222
R1036 VSS.t110 VSS.n535 0.72222
R1037 VSS.t109 VSS.n536 0.72222
R1038 VSS.n479 VSS.n74 0.710589
R1039 VSS.t87 VSS.n145 0.699997
R1040 VSS.n486 VSS.n485 0.6955
R1041 VSS.n217 VSS.n216 0.662806
R1042 VSS.t82 VSS.t80 0.640187
R1043 VSS.n44 VSS.n31 0.601638
R1044 VSS.n76 VSS.n74 0.600028
R1045 VSS.n185 VSS.t152 0.595317
R1046 VSS.t150 VSS.n187 0.595317
R1047 VSS.n175 VSS.t146 0.595317
R1048 VSS.t144 VSS.n177 0.595317
R1049 VSS.n251 VSS.n250 0.588545
R1050 VSS.n240 VSS.t69 0.572871
R1051 VSS.t77 VSS.n213 0.572871
R1052 VSS.t74 VSS.n148 0.557126
R1053 VSS.n559 VSS.n525 0.556483
R1054 VSS.n171 VSS.n158 0.522138
R1055 VSS.t134 VSS.t136 0.492336
R1056 VSS.n234 VSS.n216 0.490843
R1057 VSS.n230 VSS.n216 0.490843
R1058 VSS.n228 VSS.n216 0.490843
R1059 VSS.n196 VSS.n192 0.490843
R1060 VSS.n237 VSS.t69 0.489061
R1061 VSS.t77 VSS.n211 0.489061
R1062 VSS.t45 VSS.n191 0.47741
R1063 VSS.t74 VSS.n496 0.477286
R1064 VSS.t74 VSS.n497 0.472981
R1065 VSS.n250 VSS.n153 0.465582
R1066 VSS.n479 VSS.t91 0.464894
R1067 VSS.n485 VSS.n191 0.460744
R1068 VSS.n186 VSS.n158 0.447055
R1069 VSS.n9 VSS.n8 0.431438
R1070 VSS.n88 VSS.n85 0.417336
R1071 VSS.n92 VSS.n91 0.417043
R1072 VSS.n92 VSS.n88 0.416074
R1073 VSS.n89 VSS.n85 0.415796
R1074 VSS.n493 VSS.n492 0.41014
R1075 VSS.n246 VSS.t24 0.400619
R1076 VSS.n566 VSS.n565 0.376066
R1077 VSS.n533 VSS.n129 0.374928
R1078 VSS.n529 VSS.n140 0.36227
R1079 VSS.n536 VSS.n125 0.339481
R1080 VSS.n562 VSS.n561 0.338265
R1081 VSS.n561 VSS.n560 0.338019
R1082 VSS.n535 VSS.n125 0.336696
R1083 VSS.n176 VSS.n162 0.312137
R1084 VSS.n534 VSS.n129 0.307436
R1085 VSS.n565 VSS.n564 0.306341
R1086 VSS.n215 VSS.n153 0.298621
R1087 VSS.n490 VSS.n157 0.291601
R1088 VSS.n491 VSS.n490 0.287886
R1089 VSS.n547 VSS.n546 0.286439
R1090 VSS.n465 VSS.n438 0.280152
R1091 VSS.t27 VSS.n179 0.276107
R1092 VSS.n529 VSS.n139 0.267988
R1093 VSS.n179 VSS.n175 0.2661
R1094 VSS.n91 VSS.n80 0.265797
R1095 VSS.n80 VSS.n79 0.263915
R1096 VSS.t74 VSS.n501 0.255045
R1097 VSS.n146 VSS.n140 0.248324
R1098 VSS.n483 VSS.n482 0.244498
R1099 VSS.n482 VSS.n481 0.24416
R1100 VSS.t21 VSS.n249 0.241078
R1101 VSS.t80 VSS.n251 0.241078
R1102 VSS.n104 VSS.n107 0.239006
R1103 VSS.n112 VSS.n94 0.239006
R1104 VSS.n548 VSS.n547 0.239006
R1105 VSS.n554 VSS.n553 0.239006
R1106 VSS.t6 VSS.n537 0.239006
R1107 VSS.n545 VSS.t133 0.239006
R1108 VSS.t139 VSS.n82 0.239006
R1109 VSS.n107 VSS.t4 0.238668
R1110 VSS.n112 VSS.n95 0.238668
R1111 VSS.n546 VSS.n545 0.238668
R1112 VSS.n537 VSS.n552 0.238668
R1113 VSS.n553 VSS.t6 0.238668
R1114 VSS.n558 VSS.n557 0.238668
R1115 VSS.t133 VSS.n83 0.238668
R1116 VSS.n180 VSS.n162 0.238387
R1117 VSS.n459 VSS.n458 0.233757
R1118 VSS.n464 VSS.n463 0.233757
R1119 VSS.n438 VSS.t44 0.233757
R1120 VSS.n458 VSS.n457 0.233419
R1121 VSS.n463 VSS.n462 0.233419
R1122 VSS.n465 VSS.n464 0.233419
R1123 VSS.n484 VSS.n483 0.225607
R1124 VSS.n487 VSS.n189 0.225543
R1125 VSS.n189 VSS.n185 0.219552
R1126 VSS.n492 VSS.n155 0.20686
R1127 VSS.n481 VSS.n480 0.195641
R1128 VSS.n108 VSS.n103 0.191235
R1129 VSS.n100 VSS.n108 0.191235
R1130 VSS.t9 VSS.n100 0.191235
R1131 VSS.n109 VSS.t10 0.191235
R1132 VSS.n110 VSS.n109 0.191235
R1133 VSS.n98 VSS.n110 0.191235
R1134 VSS.n111 VSS.n97 0.191235
R1135 VSS.n96 VSS.n111 0.191235
R1136 VSS.t13 VSS.n96 0.191235
R1137 VSS.n549 VSS.n548 0.191235
R1138 VSS.n550 VSS.n549 0.191235
R1139 VSS.n551 VSS.n550 0.191235
R1140 VSS.t5 VSS.n551 0.191235
R1141 VSS.n552 VSS.n538 0.191235
R1142 VSS.n555 VSS.n554 0.191235
R1143 VSS.n556 VSS.n555 0.191235
R1144 VSS.n557 VSS.n556 0.191235
R1145 VSS.n171 VSS.n170 0.191235
R1146 VSS.n538 VSS.t5 0.191235
R1147 VSS.n97 VSS.t11 0.191235
R1148 VSS.t11 VSS.n98 0.191235
R1149 VSS.n103 VSS.t7 0.191235
R1150 VSS.t7 VSS.n104 0.191235
R1151 VSS.t4 VSS.t139 0.191235
R1152 VSS.t10 VSS.t9 0.191235
R1153 VSS.n95 VSS.t13 0.191235
R1154 VSS.t152 VSS.t150 0.1875
R1155 VSS.t146 VSS.t144 0.1875
R1156 VSS.t60 VSS.n419 0.187025
R1157 VSS.n452 VSS.n419 0.187025
R1158 VSS.n453 VSS.n452 0.187025
R1159 VSS.n454 VSS.n453 0.187025
R1160 VSS.n455 VSS.n454 0.187025
R1161 VSS.n456 VSS.n455 0.187025
R1162 VSS.n457 VSS.n456 0.187025
R1163 VSS.n460 VSS.n459 0.187025
R1164 VSS.n461 VSS.n460 0.187025
R1165 VSS.n462 VSS.n461 0.187025
R1166 VSS.n532 VSS.n133 0.181924
R1167 VSS.n526 VSS.n531 0.181543
R1168 VSS.t84 VSS.n215 0.177814
R1169 VSS.n156 VSS.n138 0.1683
R1170 VSS.n88 VSS.t131 0.167615
R1171 VSS.n527 VSS.n526 0.164808
R1172 VSS.n156 VSS.n139 0.164582
R1173 VSS.n528 VSS.n133 0.164424
R1174 VSS.n86 VSS.n82 0.15955
R1175 VSS.n489 VSS.n486 0.156138
R1176 VSS.n471 VSS.t50 0.150099
R1177 VSS.n76 VSS.t34 0.149428
R1178 VSS.n137 VSS.t127 0.146613
R1179 VSS.t127 VSS.n78 0.145809
R1180 VSS.n138 VSS.n137 0.143638
R1181 VSS.n146 VSS.n567 0.142012
R1182 VSS.n471 VSS.t54 0.139355
R1183 VSS.n76 VSS.t38 0.13875
R1184 VSS.n76 VSS.t29 0.138705
R1185 VSS.n567 VSS.n527 0.138262
R1186 VSS.n471 VSS.t46 0.119905
R1187 VSS.t136 VSS.n529 0.1171
R1188 VSS.n480 VSS.n479 0.115978
R1189 VSS.n87 VSS.n83 0.112118
R1190 VSS.n471 VSS.t58 0.111764
R1191 VSS.n76 VSS.t42 0.111207
R1192 VSS.n532 VSS.n132 0.104618
R1193 VSS.n531 VSS.n530 0.104618
R1194 VSS.t147 VSS.n181 0.0971176
R1195 VSS.n486 VSS.n170 0.0971176
R1196 VSS.n489 VSS.n488 0.0958002
R1197 VSS.n488 VSS.n190 0.0955
R1198 VSS.n180 VSS.n161 0.093
R1199 VSS.t144 VSS.n178 0.0851154
R1200 VSS.t146 VSS.n176 0.0851154
R1201 VSS.t150 VSS.n188 0.0851154
R1202 VSS.t152 VSS.n186 0.0851154
R1203 VSS.n252 VSS.n197 0.0846176
R1204 VSS.n535 VSS.n126 0.08425
R1205 VSS.n563 VSS.n562 0.08425
R1206 VSS.n177 VSS.n172 0.08175
R1207 VSS.n187 VSS.n182 0.08175
R1208 VSS.n178 VSS.n164 0.08175
R1209 VSS.n188 VSS.n160 0.08175
R1210 VSS.n137 VSS.n136 0.0805
R1211 VSS.n86 VSS.n81 0.0796176
R1212 VSS.n87 VSS.n84 0.0796176
R1213 VSS.n91 VSS.n81 0.0758676
R1214 VSS.n89 VSS.n84 0.0758676
R1215 VSS.n528 VSS.n136 0.07425
R1216 VSS.t142 VSS.n6 0.0740901
R1217 VSS.n167 VSS.n166 0.0740901
R1218 VSS.t30 VSS.n252 0.0708676
R1219 VSS.n534 VSS.n126 0.06925
R1220 VSS.n564 VSS.n563 0.06925
R1221 VSS.n175 VSS.n174 0.0671176
R1222 VSS.n185 VSS.n184 0.0671176
R1223 VSS.n176 VSS.n163 0.0671176
R1224 VSS.n186 VSS.n159 0.0671176
R1225 VSS.n177 VSS.n174 0.0621177
R1226 VSS.n187 VSS.n184 0.0621177
R1227 VSS.n178 VSS.n163 0.0621177
R1228 VSS.n188 VSS.n159 0.0621177
R1229 VSS.n9 VSS.n2 0.0235439
R1230 VSS.n485 VSS.n484 0.0611136
R1231 VSS.n181 VSS.t27 0.0571176
R1232 VSS VSS.n78 0.0555
R1233 VSS.n533 VSS.n132 0.0496177
R1234 VSS.n530 VSS.n566 0.0496177
R1235 VSS.t149 VSS.n161 0.04925
R1236 VSS.n182 VSS.t147 0.04675
R1237 VSS.t149 VSS.n160 0.04675
R1238 VSS.n172 VSS.n154 0.0305
R1239 VSS.n165 VSS.n164 0.0305
R1240 VSS.n167 VSS.n157 0.0253401
R1241 VSS.n491 VSS.n6 0.0253401
R1242 VSS.n238 VSS.t69 0.0184075
R1243 VSS.t77 VSS.n212 0.0184075
R1244 VSS.t74 VSS.n498 0.0173993
R1245 VSS.t142 VSS.n154 0.01675
R1246 VSS.n166 VSS.n165 0.01675
R1247 VSS.n244 VSS.t24 0.0151406
R1248 VSS.n232 VSS.n216 0.0151406
R1249 VSS.n231 VSS.n216 0.0151406
R1250 VSS.n205 VSS.n196 0.0151406
R1251 VSS.t74 VSS.n494 0.0150892
R1252 VSS.n487 VSS.n190 0.013
R1253 VSS.n569 VSS.n44 0.00994139
R1254 VSS.n539 VSS.n50 0.0071972
R1255 VSS.n22 VSS.n21 0.00574332
R1256 VSS.n9 VSS.n5 0.00419011
R1257 VSS.n18 VSS.n101 0.00362425
R1258 VSS.n71 VSS.n70 0.00249999
R1259 VSS.n69 VSS.n68 0.00242304
R1260 VSS.n66 VSS.n65 0.00224999
R1261 VSS.n9 VSS.n3 0.00212213
R1262 VSS.n444 VSS.n431 0.00166667
R1263 VSS.n439 VSS.n435 0.00166667
R1264 VSS.n467 VSS.n436 0.00166667
R1265 VSS.n437 VSS.n421 0.00166667
R1266 VSS.n105 VSS.n93 0.00166667
R1267 VSS.n114 VSS.n29 0.00166667
R1268 VSS.n48 VSS.n47 0.00169993
R1269 VSS.n540 VSS.n539 0.00166667
R1270 VSS.n60 VSS.n59 0.00169993
R1271 VSS.n541 VSS.n61 0.00166667
R1272 VSS.n542 VSS.n525 0.00162501
R1273 VSS.n76 VSS.n73 0.0015
R1274 VSS.n70 VSS.n73 0.0015
R1275 VSS.n542 VSS.n65 0.00137498
R1276 VSS.n248 VSS.t24 0.00136832
R1277 VSS.n106 VSS.n93 0.00133332
R1278 VSS.n114 VSS.n113 0.00133332
R1279 VSS.n540 VSS.n46 0.00133332
R1280 VSS.n541 VSS.n58 0.00133332
R1281 VSS.n72 VSS.n71 0.00135712
R1282 VSS.n445 VSS.n431 0.00133332
R1283 VSS.n440 VSS.n435 0.00133332
R1284 VSS.n467 VSS.n466 0.00133332
R1285 VSS.n436 VSS.n421 0.00133332
R1286 VSS.n9 VSS.n4 0.00132021
R1287 VSS.n9 VSS.n7 0.00106993
R1288 VSS.n106 VSS.n12 0.001
R1289 VSS.n102 VSS.n13 0.001
R1290 VSS.n101 VSS.n15 0.001
R1291 VSS.n99 VSS.n20 0.001
R1292 VSS.n113 VSS.n28 0.001
R1293 VSS.n44 VSS.n29 0.001
R1294 VSS.n56 VSS.n55 0.00124999
R1295 VSS.n64 VSS.n63 0.00183322
R1296 VSS.n478 VSS.n150 0.001
R1297 VSS.t74 VSS.n150 0.001
R1298 VSS.n221 VSS.t69 0.001
R1299 VSS.n223 VSS.t69 0.001
R1300 VSS.n222 VSS.n219 0.001
R1301 VSS.n224 VSS.n216 0.001
R1302 VSS.t77 VSS.n200 0.001
R1303 VSS.t77 VSS.n210 0.001
R1304 VSS.n203 VSS.n199 0.001
R1305 VSS.n208 VSS.n196 0.001
R1306 VSS.n221 VSS.t24 0.001
R1307 VSS.n223 VSS.n219 0.001
R1308 VSS.n222 VSS.n218 0.001
R1309 VSS.n224 VSS.n218 0.001
R1310 VSS.n216 VSS.n200 0.001
R1311 VSS.n210 VSS.n199 0.001
R1312 VSS.n203 VSS.n198 0.001
R1313 VSS.n208 VSS.n198 0.001
R1314 VSS.n470 VSS.n418 0.001
R1315 VSS.n469 VSS.n420 0.001
R1316 VSS.n451 VSS.n430 0.001
R1317 VSS.n450 VSS.n429 0.001
R1318 VSS.n449 VSS.n428 0.001
R1319 VSS.n448 VSS.n427 0.001
R1320 VSS.n447 VSS.n426 0.001
R1321 VSS.n446 VSS.n425 0.001
R1322 VSS.n445 VSS.n424 0.001
R1323 VSS.n444 VSS.n423 0.001
R1324 VSS.n442 VSS.n432 0.001
R1325 VSS.n441 VSS.n433 0.001
R1326 VSS.n440 VSS.n434 0.001
R1327 VSS.n466 VSS.n422 0.001
R1328 VSS.n76 VSS.n75 0.001
R1329 VSS.n471 VSS.n418 0.001
R1330 VSS.n470 VSS.n469 0.001
R1331 VSS.n430 VSS.n420 0.001
R1332 VSS.n451 VSS.n429 0.001
R1333 VSS.n450 VSS.n428 0.001
R1334 VSS.n449 VSS.n427 0.001
R1335 VSS.n448 VSS.n426 0.001
R1336 VSS.n447 VSS.n425 0.001
R1337 VSS.n446 VSS.n424 0.001
R1338 VSS.n443 VSS.n423 0.001
R1339 VSS.n443 VSS.n432 0.001
R1340 VSS.n442 VSS.n433 0.001
R1341 VSS.n441 VSS.n434 0.001
R1342 VSS.n439 VSS.n422 0.001
R1343 VSS.n437 VSS.n75 0.001
R1344 VSS.n471 VSS.n69 0.00157694
R1345 VSS.n44 VSS.n11 0.00333308
R1346 VSS.n63 VSS.n62 0.0015
R1347 VSS.n62 VSS.n61 0.0015
R1348 VSS.n59 VSS.n58 0.0015
R1349 VSS.n55 VSS.n57 0.0015
R1350 VSS.n47 VSS.n46 0.0015
R1351 VSS.n525 VSS.n44 0.0015
R1352 VSS.n544 VSS.n44 0.0015
R1353 VSS.n99 VSS.n21 0.0015
R1354 VSS.n16 VSS.n102 0.00199997
R1355 VSS.n14 VSS.n105 0.00199997
R1356 VSS.n1 VSS.n0 8.50175
R1357 VSS.n9 VSS.n1 0.00125
R1358 VSS.n171 VSS.n1 8.47794
C311 DELAY_VBIASP VSS 4.41492f
C312 DELAY_OUT_LAST VSS 2.65853f
C313 DELAY_VBIASN VSS 99.4221f
C314 DELAY_IN VSS 3.31101f
C315 DLL_RESETN VSS 4.65231f
C316 VDD VSS 14.20084f
C317 a_9712_1285# VSS 1.32888f ; **FLOATING
C318 a_9444_1285# VSS 2.15703f ; **FLOATING
C319 a_5778_740# VSS 5.33396f ; **FLOATING
C320 a_15464_1057# VSS 0.75544f ; **FLOATING
C321 a_14757_2555# VSS 0.09495f ; **FLOATING
C322 a_13880_2491# VSS 0.06985f ; **FLOATING
C323 a_15688_2776# VSS 0.26291f ; **FLOATING
C324 a_15108_2698# VSS 0.24458f ; **FLOATING
C325 a_14851_2555# VSS 0.38123f ; **FLOATING
C326 a_9444_1963# VSS 6.04048f ; **FLOATING
C327 a_14111_2600# VSS 0.19866f ; **FLOATING
C328 a_14009_2457# VSS 0.44622f ; **FLOATING
C329 a_13592_2796# VSS 1.57456f ; **FLOATING
C330 a_13306_2478# VSS 0.30095f ; **FLOATING
C331 a_13566_2701# VSS 0.15441f ; **FLOATING
C332 a_13132_2793# VSS 0.13036f ; **FLOATING
C333 a_12907_2793# VSS 0.14377f ; **FLOATING
C334 a_12907_2559# VSS 0.14861f ; **FLOATING
C335 a_13106_2730# VSS 0.06343f ; **FLOATING
C336 a_15304_1978# VSS 0.37009f ; **FLOATING
C337 a_14757_3601# VSS 0.09586f ; **FLOATING
C338 a_15688_3240# VSS 0.26405f ; **FLOATING
C339 a_14851_3601# VSS 0.39588f ; **FLOATING
C340 a_15108_3482# VSS 0.24582f ; **FLOATING
C341 a_14111_3251# VSS 0.21915f ; **FLOATING
C342 a_13880_3665# VSS 0.07345f ; **FLOATING
C343 a_14009_3251# VSS 0.48187f ; **FLOATING
C344 a_13592_3244# VSS 1.58208f ; **FLOATING
C345 a_13566_3208# VSS 0.15442f ; **FLOATING
C346 a_13045_3588# VSS 0.01124f ; **FLOATING
C347 a_13306_3678# VSS 0.31701f ; **FLOATING
C348 a_12849_3240# VSS 1.40248f ; **FLOATING
C349 a_13121_3204# VSS 0.80439f ; **FLOATING
C350 a_13019_3204# VSS 2.18888f ; **FLOATING
C351 a_12656_3237# VSS 0.28393f ; **FLOATING
C352 a_12355_3240# VSS 0.62262f ; **FLOATING
C353 a_11397_3601# VSS 0.09495f ; **FLOATING
C354 a_12158_3240# VSS 0.25874f ; **FLOATING
C355 a_11491_3601# VSS 0.30073f ; **FLOATING
C356 a_11748_3482# VSS 0.17021f ; **FLOATING
C357 a_10751_3251# VSS 0.19918f ; **FLOATING
C358 a_10520_3665# VSS 0.03671f ; **FLOATING
C359 a_10649_3251# VSS 0.47308f ; **FLOATING
C360 a_10232_3244# VSS 1.52123f ; **FLOATING
C361 a_10206_3208# VSS 0.08466f ; **FLOATING
C362 a_9946_3678# VSS 0.18126f ; **FLOATING
C363 a_9772_3216# VSS 0.12435f ; **FLOATING
C364 a_9746_3178# VSS 0.06613f ; **FLOATING
C365 a_9547_3545# VSS 0.16037f ; **FLOATING
C366 a_9547_3315# VSS 0.11966f ; **FLOATING
C367 a_6854_2827# VSS 3.66026f ; **FLOATING
C368 a_6126_1189# VSS 13.8075f ; **FLOATING
C369 a_6854_3359# VSS 1.41376f ; **FLOATING
C370 a_5974_3096# VSS 2.40124f ; **FLOATING
C371 a_6326_1963# VSS 1.03474f ; **FLOATING
C372 VSS.t127 VSS 3.31349f ; **FLOATING
C373 VDD.t31 VSS 4.06673f ; **FLOATING
C374 VDD.n0 VSS 0.02183f ; **FLOATING
C375 VDD.n1 VSS 0.01768f ; **FLOATING
C376 VDD.n2 VSS 0.01157f ; **FLOATING
C377 VDD.n3 VSS 0.0589f ; **FLOATING
C378 VDD.t75 VSS 0.01494f ; **FLOATING
C379 VDD.n4 VSS 0.10529f ; **FLOATING
C380 VDD.t18 VSS 6.60803f ; **FLOATING
C381 VDD.t34 VSS 0.02945f ; **FLOATING
C382 VDD.t47 VSS 0.02945f ; **FLOATING
C383 VDD.n5 VSS 0.10057f ; **FLOATING
C384 VDD.n6 VSS 0.01265f ; **FLOATING
C385 VDD.t35 VSS 0.03562f ; **FLOATING
C386 VDD.t45 VSS 0.03562f ; **FLOATING
C387 VDD.n7 VSS 0.11341f ; **FLOATING
C388 VDD.n8 VSS 0.06003f ; **FLOATING
C389 VDD.t73 VSS 0.0257f ; **FLOATING
C390 VDD.t72 VSS 0.01833f ; **FLOATING
C391 VDD.t74 VSS 0.02838f ; **FLOATING
C392 VDD.t76 VSS 0.02584f ; **FLOATING
C393 VDD.t83 VSS 0.02693f ; **FLOATING
C394 VDD.t78 VSS 0.02586f ; **FLOATING
C395 VDD.t77 VSS 0.01833f ; **FLOATING
C396 VDD.t79 VSS 0.02838f ; **FLOATING
C397 VDD.t80 VSS 0.01493f ; **FLOATING
C398 VDD.t81 VSS 0.02578f ; **FLOATING
C399 VDD.t49 VSS 0.02788f ; **FLOATING
C400 VDD.t52 VSS 0.01896f ; **FLOATING
C401 VDD.n9 VSS 0.25448f ; **FLOATING
C402 VDD.n10 VSS 0.02181f ; **FLOATING
C403 VDD.t38 VSS 0.02094f ; **FLOATING
C404 VDD.t42 VSS 0.02094f ; **FLOATING
C405 VDD.n11 VSS 0.06218f ; **FLOATING
C406 VDD.n12 VSS 0.02951f ; **FLOATING
C407 VDD.t37 VSS 0.04832f ; **FLOATING
C408 VDD.n13 VSS 0.01957f ; **FLOATING
C409 VDD.t41 VSS 0.04832f ; **FLOATING
C410 VDD.n14 VSS 0.01957f ; **FLOATING
C411 VDD.n15 VSS 0.04321f ; **FLOATING
C412 VDD.n16 VSS 0.01149f ; **FLOATING
C413 VDD.t26 VSS 0.02847f ; **FLOATING
C414 VDD.n17 VSS 0.05118f ; **FLOATING
C415 VDD.n18 VSS 0.02815f ; **FLOATING
C416 VDD.t54 VSS 0.02629f ; **FLOATING
C417 VDD.n19 VSS 0.06099f ; **FLOATING
C418 VDD.n20 VSS 0.01605f ; **FLOATING
C419 VDD.t21 VSS 0.02945f ; **FLOATING
C420 VDD.n21 VSS 0.1316f ; **FLOATING
C421 VDD.t19 VSS 0.04832f ; **FLOATING
C422 VDD.n22 VSS 0.01957f ; **FLOATING
C423 VDD.t24 VSS 0.02094f ; **FLOATING
C424 VDD.n23 VSS 0.11787f ; **FLOATING
C425 VDD.n24 VSS 0.02952f ; **FLOATING
C426 VDD.n25 VSS 0.01246f ; **FLOATING
C427 VDD.n26 VSS 0.02857f ; **FLOATING
C428 VDD.n27 VSS 0.02491f ; **FLOATING
C429 VDD.n28 VSS 0.0285f ; **FLOATING
C430 VDD.n29 VSS 0.02859f ; **FLOATING
C431 VDD.n30 VSS 0.01257f ; **FLOATING
C432 VDD.n31 VSS 1.40137f ; **FLOATING
C433 VDD.t17 VSS 0.01734f ; **FLOATING
C434 VDD.n32 VSS 1.37924f ; **FLOATING
C435 VDD.n33 VSS 0.01228f ; **FLOATING
C436 VDD.n34 VSS 0.01251f ; **FLOATING
C437 VDD.n35 VSS 0.05418f ; **FLOATING
C438 VDD.t10 VSS 0.05068f ; **FLOATING
C439 VDD.n36 VSS 0.01769f ; **FLOATING
C440 VDD.n37 VSS 0.03964f ; **FLOATING
C441 VDD.t63 VSS 0.04534f ; **FLOATING
C442 VDD.n38 VSS 0.01768f ; **FLOATING
C443 VDD.t69 VSS 0.04534f ; **FLOATING
C444 VDD.n39 VSS 0.91487f ; **FLOATING
C445 VDD.n40 VSS 0.01768f ; **FLOATING
C446 VDD.n41 VSS 0.03581f ; **FLOATING
C447 VDD.t61 VSS 0.28673f ; **FLOATING
C448 VDD.n42 VSS 0.01157f ; **FLOATING
C449 VDD.n43 VSS 0.03579f ; **FLOATING
C450 VDD.t1 VSS 0.05068f ; **FLOATING
C451 VDD.n44 VSS 0.01769f ; **FLOATING
C452 VDD.n45 VSS 0.05417f ; **FLOATING
C453 VDD.n46 VSS 0.02857f ; **FLOATING
C454 VDD.n47 VSS 0.06892f ; **FLOATING
C455 VDD.t11 VSS 0.05068f ; **FLOATING
C456 VDD.n48 VSS 0.03288f ; **FLOATING
C457 VDD.t2 VSS 0.05068f ; **FLOATING
C458 VDD.n49 VSS 0.03288f ; **FLOATING
C459 VDD.n50 VSS 0.06891f ; **FLOATING
C460 VDD.n51 VSS 0.02491f ; **FLOATING
C461 VDD.n52 VSS 0.06909f ; **FLOATING
C462 VDD.t12 VSS 0.05068f ; **FLOATING
C463 VDD.n53 VSS 0.03288f ; **FLOATING
C464 VDD.t4 VSS 0.05068f ; **FLOATING
C465 VDD.n54 VSS 0.03288f ; **FLOATING
C466 VDD.n55 VSS 0.06908f ; **FLOATING
C467 VDD.n56 VSS 0.02851f ; **FLOATING
C468 VDD.n57 VSS 0.06527f ; **FLOATING
C469 VDD.t15 VSS 0.05068f ; **FLOATING
C470 VDD.n58 VSS 0.03288f ; **FLOATING
C471 VDD.t7 VSS 0.05068f ; **FLOATING
C472 VDD.n59 VSS 0.03288f ; **FLOATING
C473 VDD.n60 VSS 0.06527f ; **FLOATING
C474 VDD.n61 VSS 0.02859f ; **FLOATING
C475 VDD.n62 VSS 0.01257f ; **FLOATING
C476 VDD.t0 VSS 9.98286f ; **FLOATING
C477 VDD.t66 VSS 0.04534f ; **FLOATING
C478 VDD.t71 VSS 0.04534f ; **FLOATING
C479 VDD.n63 VSS 0.05874f ; **FLOATING
C480 VDD.t9 VSS 0.05068f ; **FLOATING
C481 VDD.n64 VSS 0.05416f ; **FLOATING
C482 VDD.n65 VSS 0.01769f ; **FLOATING
C483 VDD.n66 VSS 0.05416f ; **FLOATING
C484 VDD.t5 VSS 0.05068f ; **FLOATING
C485 VDD.n67 VSS 0.01769f ; **FLOATING
C486 VDD.n68 VSS 0.03579f ; **FLOATING
C487 VDD.t64 VSS 0.28673f ; **FLOATING
C488 VDD.n69 VSS 0.01768f ; **FLOATING
C489 VDD.n70 VSS 0.06453f ; **FLOATING
C490 VDD.n71 VSS 0.03758f ; **FLOATING
.ends
