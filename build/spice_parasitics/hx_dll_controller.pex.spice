* NGSPICE file created from hx_dll_controller.ext - technology: ihp-sg13g2

.subckt hx_dll_controller VDD VSS DLL_RESETN DELAY_OUT_LAST DELAY_IN DELAY_VBIASN
+ DELAY_VBIASP
X0 VSS.t82 a_12849_3240# a_13400_3678# VSS.t81 sg13_lv_nmos ad=0.1626p pd=1.415u as=60.89999f ps=0.71u w=0.42u l=0.13u
X1 VSS.t147 VSS.t147 VSS.t149 VSS.t148 sg13_lv_nmos ad=0.1406p pd=1.12u as=0 ps=0 w=0.74u l=0.13u
X2 VSS.t89 a_14851_2555# a_15688_2776# VSS.t94 sg13_lv_nmos ad=0.1406p pd=1.12u as=0.2516p ps=2.16u w=0.74u l=0.13u
X3 a_6854_2827# a_6326_1963# VDD.t10 VDD.t0 sg13_lv_pmos ad=0.38p pd=2.38u as=0.38p ps=2.38u w=2u l=1u
X4 VSS.t108 a_9444_1963# a_9444_1285# VSS.t101 sg13_lv_nmos ad=0.68p pd=4.68u as=0.38p ps=2.38u w=2u l=1u
X5 VDD.t12 a_6326_1963# a_6126_1189# VDD.t0 sg13_lv_pmos ad=0.38p pd=2.38u as=0.38p ps=2.38u w=2u l=1u
X6 a_9946_3678# a_9772_3216# VDD.t22 VDD.t0 sg13_lv_pmos ad=79.8f pd=0.8u as=0.1428p ps=1.52u w=0.42u l=0.13u
X7 a_9712_1285# a_6854_2827# a_9444_1285# VSS.t14 sg13_lv_nmos ad=0.38p pd=2.38u as=0.68p ps=4.68u w=2u l=1u
X8 a_6854_3359# a_15304_1978# DELAY_VBIASN VDD.t31 sg13_lv_pmos ad=0.136p pd=1.14u as=0.158p ps=1.245u w=0.4u l=0.2u
X9 a_9444_1285# a_9444_1963# VSS.t107 VSS.t99 sg13_lv_nmos ad=0.38p pd=2.38u as=0.68p ps=4.68u w=2u l=1u
X10 a_6326_1963# a_6126_1189# a_5778_740# VSS.t3 sg13_lv_nmos ad=0.38p pd=2.38u as=0.68p ps=4.68u w=2u l=1u
X11 a_6854_2827# a_6326_1963# VDD.t7 VDD.t0 sg13_lv_pmos ad=0.38p pd=2.38u as=0.38p ps=2.38u w=2u l=1u
X12 VSS.t89 a_15108_2698# a_14757_2555# VSS.t122 sg13_lv_nmos ad=79.8f pd=0.8u as=0.1428p ps=1.52u w=0.42u l=0.13u
X13 a_14009_3251# DELAY_IN VSS.t24 VSS.t116 sg13_lv_nmos ad=0.2516p pd=2.16u as=1.9998p ps=12.915u w=0.74u l=0.13u
X14 VSS.t58 DELAY_VBIASN VSS.t56 VSS.t41 sg13_lv_nmos ad=1.33p pd=7.38u as=0 ps=0 w=7u l=7u
X15 a_9746_3178# a_9547_3315# VSS.t24 VSS.t25 sg13_lv_nmos ad=0.27427p pd=2.28u as=2.39977p ps=15.495u w=0.795u l=0.13u
X16 VSS.t19 DLL_RESETN a_10040_3678# VSS.t18 sg13_lv_nmos ad=0.1626p pd=1.415u as=60.89999f ps=0.71u w=0.42u l=0.13u
X17 a_13949_2869# a_13592_2796# VDD.t42 VDD.t0 sg13_lv_pmos ad=63f pd=0.72u as=0.1563p ps=1.22u w=0.42u l=0.13u
X18 VSS.t134 VSS.t132 VSS.t132 VSS.t133 sg13_lv_nmos ad=0.68p pd=4.68u as=0 ps=0 w=2u l=1u
X19 a_9772_3216# a_9746_3178# VDD.t18 VDD.t0 sg13_lv_pmos ad=0.3927p pd=2.99u as=1.10612p ps=6.66u w=1.155u l=0.13u
X20 a_13121_3204# a_15688_3240# VDD.t34 VDD.t0 sg13_lv_pmos ad=0.3808p pd=2.92u as=0.2128p ps=1.5u w=1.12u l=0.13u
X21 a_15108_3482# a_14851_3601# a_15270_3678# VSS.t76 sg13_lv_nmos ad=0.1428p pd=1.52u as=37.8f ps=0.6u w=0.42u l=0.13u
X22 VSS.t73 a_12907_2559# a_12907_2559# VSS.t117 sg13_lv_nmos ad=1.45407p pd=9.445u as=0.111p ps=1.34u w=0.3u l=0.13u
X23 VDD.t79 VDD.t77 VDD.t78 VDD.t31 sg13_lv_pmos ad=0.3808p pd=2.92u as=0 ps=0 w=1.12u l=0.13u
X24 VSS.t4 VSS.t129 VSS.t129 VSS.t130 sg13_lv_nmos ad=0.68p pd=4.68u as=0 ps=0 w=2u l=1u
X25 a_15108_2698# a_12849_3240# VDD.t18 VDD.t0 sg13_lv_pmos ad=79.8f pd=0.8u as=1.03698p ps=6.245u w=0.42u l=0.13u
X26 a_13121_3204# a_15688_3240# VSS.t80 VSS.t91 sg13_lv_nmos ad=0.2516p pd=2.16u as=0.1406p ps=1.12u w=0.74u l=0.13u
X27 VDD.t74 VDD.t75 VDD.t76 VDD.t31 sg13_lv_pmos ad=0.2128p pd=1.5u as=0 ps=0 w=1.12u l=0.13u
X28 a_5974_3096# a_6126_1189# VSS.t11 VSS.t0 sg13_lv_nmos ad=0.38p pd=2.38u as=0.68p ps=4.68u w=2u l=1u
X29 VDD.t17 a_5974_3096# a_5974_3096# VDD.t0 sg13_lv_pmos ad=0.2448p pd=2.08u as=0.2826p ps=2.29u w=0.36u l=2u
X30 VSS.t21 a_11748_3482# a_11397_3601# VSS.t2 sg13_lv_nmos ad=79.8f pd=0.8u as=0.1428p ps=1.52u w=0.42u l=0.13u
X31 VSS.t60 DELAY_VBIASN VSS.t58 VSS.t43 sg13_lv_nmos ad=1.33p pd=7.38u as=0 ps=0 w=7u l=7u
X32 a_6326_1963# a_6126_1189# a_5778_740# VSS.t3 sg13_lv_nmos ad=0.38p pd=2.38u as=0.68p ps=4.68u w=2u l=1u
X33 VDD.t69 VDD.t61 VDD.t10 VDD.t0 sg13_lv_pmos ad=0.68p pd=4.68u as=0 ps=0 w=2u l=1u
X34 VSS.t36 DELAY_VBIASN VSS.t38 VSS.t37 sg13_lv_nmos ad=1.33p pd=7.38u as=0 ps=0 w=7u l=7u
X35 a_13306_2478# a_13132_2793# VDD.t84 VDD.t0 sg13_lv_pmos ad=79.8f pd=0.8u as=0.1428p ps=1.52u w=0.42u l=0.13u
X36 a_6126_1189# a_6126_1189# VSS.t5 VSS.t3 sg13_lv_nmos ad=0.38p pd=2.38u as=0.68p ps=4.68u w=2u l=1u
X37 a_6326_1963# a_6326_1963# VDD.t2 VDD.t0 sg13_lv_pmos ad=0.38p pd=2.38u as=0.38p ps=2.38u w=2u l=1u
X38 a_13592_3244# a_13566_3208# VSS.t82 VSS.t81 sg13_lv_nmos ad=0.2516p pd=2.16u as=0.1626p ps=1.415u w=0.74u l=0.13u
X39 VSS.t54 DELAY_VBIASN VSS.t52 VSS.t37 sg13_lv_nmos ad=1.33p pd=7.38u as=0 ps=0 w=7u l=7u
X40 VDD.t7 a_6326_1963# a_6126_1189# VDD.t0 sg13_lv_pmos ad=0.38p pd=2.38u as=0.38p ps=2.38u w=2u l=1u
X41 VDD.t18 a_11491_3601# a_11748_3482# VDD.t0 sg13_lv_pmos ad=1.10612p pd=6.66u as=79.8f ps=0.8u w=0.42u l=0.13u
X42 VSS.t50 DELAY_VBIASN VSS.t48 VSS.t33 sg13_lv_nmos ad=1.33p pd=7.38u as=0 ps=0 w=7u l=7u
X43 VDD.t83 DELAY_VBIASP DELAY_VBIASP VDD.t31 sg13_lv_pmos ad=0.3808p pd=2.92u as=1.0304p ps=4.08u w=1.12u l=0.6u
X44 VSS.t42 DELAY_VBIASN VSS.t44 VSS.t43 sg13_lv_nmos ad=1.33p pd=7.38u as=0 ps=0 w=7u l=7u
X45 VDD.t2 a_6326_1963# a_6854_3359# VDD.t0 sg13_lv_pmos ad=0.38p pd=2.38u as=0.38p ps=2.38u w=2u l=1u
X46 a_13132_2793# a_13106_2730# VDD.t18 VDD.t0 sg13_lv_pmos ad=0.3927p pd=2.99u as=1.10612p ps=6.66u w=1.155u l=0.13u
X47 a_14009_3251# DELAY_IN VDD.t18 VDD.t0 sg13_lv_pmos ad=0.4088p pd=2.97u as=1.03698p ps=6.245u w=1.12u l=0.13u
X48 a_15108_3482# a_12849_3240# VDD.t18 VDD.t0 sg13_lv_pmos ad=79.8f pd=0.8u as=1.03698p ps=6.245u w=0.42u l=0.13u
X49 VSS.t56 DELAY_VBIASN VSS.t54 VSS.t39 sg13_lv_nmos ad=1.33p pd=7.38u as=0 ps=0 w=7u l=7u
X50 VDD.t21 a_11491_3601# a_12158_3240# VDD.t0 sg13_lv_pmos ad=0.2128p pd=1.5u as=0.3864p ps=2.93u w=1.12u l=0.13u
X51 a_5778_740# VSS.t125 VSS.t124 rppd l=32u w=1u
X52 VSS.t106 a_9444_1963# a_9444_1285# VSS.t105 sg13_lv_nmos ad=0.68p pd=4.68u as=0.38p ps=2.38u w=2u l=1u
X53 a_13880_2491# a_14111_2600# a_13566_2701# VSS.t127 sg13_lv_nmos ad=0.2373p pd=1.97u as=79.8f ps=0.8u w=0.42u l=0.13u
X54 VSS.t21 a_11491_3601# a_12158_3240# VSS.t20 sg13_lv_nmos ad=0.1406p pd=1.12u as=0.2516p ps=2.16u w=0.74u l=0.13u
X55 a_11693_3363# a_10751_3251# a_11491_3601# VDD.t0 sg13_lv_pmos ad=93.45f pd=0.865u as=0.2048p ps=1.63u w=0.42u l=0.13u
X56 a_13306_3678# a_12355_3240# VDD.t27 VDD.t0 sg13_lv_pmos ad=79.8f pd=0.8u as=0.1428p ps=1.52u w=0.42u l=0.13u
X57 VDD.t18 a_12907_2559# a_12907_2793# VDD.t0 sg13_lv_pmos ad=1.10612p pd=6.66u as=0.2442p ps=2.06u w=0.66u l=0.13u
X58 a_13566_2701# a_14009_2457# a_13949_2869# VDD.t0 sg13_lv_pmos ad=79.8f pd=0.8u as=63f ps=0.72u w=0.42u l=0.13u
X59 a_13306_3678# a_14111_3251# a_13566_3208# VDD.t0 sg13_lv_pmos ad=0.1428p pd=1.52u as=79.8f ps=0.8u w=0.42u l=0.13u
X60 a_13106_2730# a_12907_2793# VSS.t73 VSS.t96 sg13_lv_nmos ad=0.27427p pd=2.28u as=1.45407p ps=9.445u w=0.795u l=0.13u
X61 VSS.t46 DELAY_VBIASN VSS.t45 VSS.t28 sg13_lv_nmos ad=2.38p pd=14.68u as=0 ps=0 w=7u l=7u
X62 a_13566_3208# a_14009_3251# a_13306_3678# VSS.t74 sg13_lv_nmos ad=79.8f pd=0.8u as=0.1296p ps=1.52u w=0.42u l=0.13u
X63 a_13019_3204# a_15688_2776# VSS.t89 VSS.t97 sg13_lv_nmos ad=0.2516p pd=2.16u as=0.1406p ps=1.12u w=0.74u l=0.13u
X64 VDD.t19 DLL_RESETN a_9946_3678# VDD.t0 sg13_lv_pmos ad=0.36237p pd=2.605u as=79.8f ps=0.8u w=0.42u l=0.13u
X65 a_6326_1963# a_5974_3096# a_6126_1189# VSS.t0 sg13_lv_nmos ad=0.38p pd=2.38u as=0.68p ps=4.68u w=2u l=1u
X66 a_5778_740# a_6126_1189# a_6326_1963# VSS.t3 sg13_lv_nmos ad=0.68p pd=4.68u as=0.38p ps=2.38u w=2u l=1u
X67 a_9444_1285# a_6854_2827# a_9712_1285# VSS.t17 sg13_lv_nmos ad=0.68p pd=4.68u as=0.38p ps=2.38u w=2u l=1u
X68 a_6854_3359# a_6326_1963# VDD.t1 VDD.t0 sg13_lv_pmos ad=0.38p pd=2.38u as=0.38p ps=2.38u w=2u l=1u
X69 a_9712_1285# a_13019_3204# DELAY_VBIASN VSS.t64 sg13_lv_nmos ad=0.136p pd=1.14u as=0.232p ps=2.08u w=0.4u l=0.2u
X70 a_13818_2491# a_12849_3240# VSS.t85 VSS.t87 sg13_lv_nmos ad=37.8f pd=0.6u as=0.1701p ps=1.65u w=0.42u l=0.13u
X71 VDD.t4 a_6326_1963# a_6326_1963# VDD.t0 sg13_lv_pmos ad=0.38p pd=2.38u as=0.38p ps=2.38u w=2u l=1u
X72 VDD.t42 a_12849_3240# a_13566_2701# VDD.t0 sg13_lv_pmos ad=0.1563p pd=1.22u as=0.147p ps=1.54u w=0.42u l=0.13u
X73 VSS.t32 DELAY_VBIASN VSS.t34 VSS.t33 sg13_lv_nmos ad=1.33p pd=7.38u as=0 ps=0 w=7u l=7u
X74 a_15270_2478# a_12849_3240# VSS.t89 VSS.t88 sg13_lv_nmos ad=37.8f pd=0.6u as=79.8f ps=0.8u w=0.42u l=0.13u
X75 a_15304_1978# a_14851_3601# VDD.t35 VDD.t0 sg13_lv_pmos ad=0.4312p pd=3.01u as=0.2639p ps=1.81u w=1.12u l=0.13u
X76 a_15304_1978# a_14851_3601# VSS.t78 VSS.t77 sg13_lv_nmos ad=0.2849p pd=2.25u as=0.2516p ps=2.16u w=0.74u l=0.13u
X77 a_9444_1285# a_9444_1963# VSS.t104 VSS.t103 sg13_lv_nmos ad=0.38p pd=2.38u as=0.68p ps=4.68u w=2u l=1u
X78 VDD.t45 a_14851_2555# a_15108_2698# VDD.t0 sg13_lv_pmos ad=0.2639p pd=1.81u as=79.8f ps=0.8u w=0.42u l=0.13u
X79 a_13400_2478# a_13132_2793# a_13306_2478# VSS.t126 sg13_lv_nmos ad=60.89999f pd=0.71u as=0.1428p ps=1.52u w=0.42u l=0.13u
X80 a_11910_3678# DLL_RESETN VSS.t21 VSS.t2 sg13_lv_nmos ad=37.8f pd=0.6u as=79.8f ps=0.8u w=0.42u l=0.13u
X81 a_12849_3240# a_12656_3237# VSS.t21 VSS.t65 sg13_lv_nmos ad=0.1406p pd=1.12u as=0.2516p ps=2.16u w=0.74u l=0.13u
X82 a_5974_3096# a_6126_1189# VSS.t7 VSS.t0 sg13_lv_nmos ad=0.38p pd=2.38u as=0.68p ps=4.68u w=2u l=1u
X83 a_13880_3665# a_13592_3244# a_13818_3665# VSS.t150 sg13_lv_nmos ad=0.1428p pd=1.52u as=37.8f ps=0.6u w=0.42u l=0.13u
X84 VSS.t48 DELAY_VBIASN VSS.t46 VSS.t31 sg13_lv_nmos ad=1.33p pd=7.38u as=0 ps=0 w=7u l=7u
X85 a_5974_3096# a_6126_1189# VSS.t9 VSS.t0 sg13_lv_nmos ad=0.38p pd=2.38u as=0.68p ps=4.68u w=2u l=1u
X86 a_13592_2796# a_13566_2701# VSS.t85 VSS.t118 sg13_lv_nmos ad=0.2516p pd=2.16u as=0.1626p ps=1.415u w=0.74u l=0.13u
X87 a_12656_3237# DLL_RESETN VSS.t21 VSS.t114 sg13_lv_nmos ad=0.2516p pd=2.16u as=0.2516p ps=2.16u w=0.74u l=0.13u
X88 a_14851_3601# a_14009_3251# a_14757_3601# VSS.t76 sg13_lv_nmos ad=0.12665p pd=1.145u as=0.1428p ps=1.52u w=0.42u l=0.13u
X89 a_9712_1285# a_6854_2827# a_9444_1285# VSS.t16 sg13_lv_nmos ad=0.38p pd=2.38u as=0.68p ps=4.68u w=2u l=1u
X90 VDD.t63 VDD.t61 VDD.t1 VDD.t0 sg13_lv_pmos ad=0.68p pd=4.68u as=0 ps=0 w=2u l=1u
X91 VDD.t26 a_13019_3204# a_12943_3240# VDD.t0 sg13_lv_pmos ad=0.2128p pd=1.5u as=0.2128p ps=1.5u w=1.12u l=0.13u
X92 VSS.t78 a_15108_3482# a_14757_3601# VSS.t76 sg13_lv_nmos ad=79.8f pd=0.8u as=0.1428p ps=1.52u w=0.42u l=0.13u
X93 VDD.t41 a_12849_3240# a_13306_2478# VDD.t0 sg13_lv_pmos ad=0.36237p pd=2.605u as=79.8f ps=0.8u w=0.42u l=0.13u
X94 a_10520_3665# a_10232_3244# a_10458_3665# VSS.t61 sg13_lv_nmos ad=0.1428p pd=1.52u as=37.8f ps=0.6u w=0.42u l=0.13u
X95 a_15053_2793# a_14111_2600# a_14851_2555# VDD.t0 sg13_lv_pmos ad=93.45f pd=0.865u as=0.2048p ps=1.63u w=0.42u l=0.13u
X96 a_12656_3237# DLL_RESETN VDD.t54 VDD.t0 sg13_lv_pmos ad=0.3808p pd=2.92u as=0.3808p ps=2.92u w=1.12u l=0.13u
X97 a_11491_3601# a_10649_3251# a_11397_3601# VSS.t2 sg13_lv_nmos ad=0.12665p pd=1.145u as=0.1428p ps=1.52u w=0.42u l=0.13u
X98 VSS.t21 a_13121_3204# a_13045_3588# VSS.t71 sg13_lv_nmos ad=0.2516p pd=2.16u as=0.1406p ps=1.12u w=0.74u l=0.13u
X99 VDD.t47 a_14851_2555# a_15688_2776# VDD.t0 sg13_lv_pmos ad=0.2128p pd=1.5u as=0.3864p ps=2.93u w=1.12u l=0.13u
X100 a_14009_2457# DELAY_OUT_LAST VSS.t73 VSS.t72 sg13_lv_nmos ad=0.2516p pd=2.16u as=1.45407p ps=9.445u w=0.74u l=0.13u
X101 VDD.t35 a_14851_3601# a_15108_3482# VDD.t0 sg13_lv_pmos ad=0.2639p pd=1.81u as=79.8f ps=0.8u w=0.42u l=0.13u
X102 a_13592_2796# a_13566_2701# VDD.t41 VDD.t0 sg13_lv_pmos ad=0.34p pd=2.68u as=0.36237p ps=2.605u w=1u l=0.13u
X103 VSS.t110 a_9444_1963# a_9444_1963# VSS.t105 sg13_lv_nmos ad=0.68p pd=4.68u as=0.38p ps=2.38u w=2u l=1u
X104 a_12355_3240# a_12158_3240# VDD.t21 VDD.t0 sg13_lv_pmos ad=0.3808p pd=2.92u as=0.2128p ps=1.5u w=1.12u l=0.13u
X105 VSS.t38 DELAY_VBIASN VSS.t40 VSS.t39 sg13_lv_nmos ad=1.33p pd=7.38u as=0 ps=0 w=7u l=7u
X106 a_14009_2457# DELAY_OUT_LAST VDD.t18 VDD.t0 sg13_lv_pmos ad=0.4088p pd=2.97u as=1.10612p ps=6.66u w=1.12u l=0.13u
X107 a_10206_3208# a_10649_3251# a_10589_3287# VDD.t0 sg13_lv_pmos ad=79.8f pd=0.8u as=63f ps=0.72u w=0.42u l=0.13u
X108 a_12355_3240# a_12158_3240# VSS.t21 VSS.t69 sg13_lv_nmos ad=0.2516p pd=2.16u as=0.1406p ps=1.12u w=0.74u l=0.13u
X109 VDD.t37 a_12849_3240# a_13306_3678# VDD.t0 sg13_lv_pmos ad=0.36237p pd=2.605u as=79.8f ps=0.8u w=0.42u l=0.13u
X110 a_10040_3678# a_9772_3216# a_9946_3678# VSS.t22 sg13_lv_nmos ad=60.89999f pd=0.71u as=0.1428p ps=1.52u w=0.42u l=0.13u
X111 a_10520_3665# a_10751_3251# a_10206_3208# VSS.t1 sg13_lv_nmos ad=0.2373p pd=1.97u as=79.8f ps=0.8u w=0.42u l=0.13u
X112 VSS.t34 DELAY_VBIASN VSS.t36 VSS.t35 sg13_lv_nmos ad=1.33p pd=7.38u as=0 ps=0 w=7u l=7u
X113 a_15464_1057# a_14851_2555# VSS.t89 VSS.t95 sg13_lv_nmos ad=0.2849p pd=2.25u as=0.2516p ps=2.16u w=0.74u l=0.13u
X114 a_6126_1189# a_5974_3096# a_6326_1963# VSS.t0 sg13_lv_nmos ad=0.68p pd=4.68u as=0.38p ps=2.38u w=2u l=1u
X115 VSS.t24 a_14009_3251# a_14111_3251# VSS.t75 sg13_lv_nmos ad=2.39977p pd=15.495u as=0.2516p ps=2.16u w=0.74u l=0.13u
X116 a_9444_1963# a_6854_2827# a_6854_2827# VSS.t17 sg13_lv_nmos ad=0.68p pd=4.68u as=0.38p ps=2.38u w=2u l=1u
X117 a_13592_2796# a_14111_2600# a_14851_2555# VSS.t128 sg13_lv_nmos ad=0.3473p pd=2.71u as=0.12665p ps=1.145u w=0.74u l=0.13u
X118 VSS.t147 VSS.t144 VSS.t146 VSS.t145 sg13_lv_nmos ad=0.2516p pd=2.16u as=0 ps=0 w=0.74u l=0.13u
X119 VSS.t141 VSS.t141 VSS.t143 VSS.t142 sg13_lv_nmos ad=0.1406p pd=1.12u as=0 ps=0 w=0.74u l=0.13u
X120 a_15053_3363# a_14111_3251# a_14851_3601# VDD.t0 sg13_lv_pmos ad=93.45f pd=0.865u as=0.2048p ps=1.63u w=0.42u l=0.13u
X121 VDD.t18 a_9547_3545# a_9547_3315# VDD.t0 sg13_lv_pmos ad=1.10612p pd=6.66u as=0.2442p ps=2.06u w=0.66u l=0.13u
X122 VSS.t24 a_10649_3251# a_10751_3251# VSS.t68 sg13_lv_nmos ad=2.39977p pd=15.495u as=0.2516p ps=2.16u w=0.74u l=0.13u
X123 VSS.t52 DELAY_VBIASN VSS.t50 VSS.t35 sg13_lv_nmos ad=1.33p pd=7.38u as=0 ps=0 w=7u l=7u
X124 a_9444_1963# a_9444_1963# VSS.t109 VSS.t103 sg13_lv_nmos ad=0.38p pd=2.38u as=0.68p ps=4.68u w=2u l=1u
X125 a_14851_2555# a_14009_2457# a_14757_2555# VSS.t121 sg13_lv_nmos ad=0.12665p pd=1.145u as=0.1428p ps=1.52u w=0.42u l=0.13u
X126 VDD.t5 VDD.t64 VDD.t71 VDD.t0 sg13_lv_pmos ad=0.38p pd=2.38u as=0 ps=0 w=2u l=1u
X127 a_14851_2555# a_14009_2457# a_13592_2796# VDD.t0 sg13_lv_pmos ad=0.2048p pd=1.63u as=0.34p ps=2.68u w=1u l=0.13u
X128 VSS.t30 DELAY_VBIASN VSS.t29 VSS.t28 sg13_lv_nmos ad=2.38p pd=14.68u as=0 ps=0 w=7u l=7u
X129 VSS.t27 DELAY_VBIASN DELAY_VBIASP VSS.t26 sg13_lv_nmos ad=0.2516p pd=2.16u as=0.6808p ps=3.32u w=0.74u l=0.6u
X130 DELAY_VBIASN DLL_RESETN VDD.t52 VDD.t31 sg13_lv_pmos ad=0.158p pd=1.245u as=0.272p ps=2.28u w=0.8u l=0.2u
X131 VDD.t74 VDD.t72 VDD.t73 VDD.t31 sg13_lv_pmos ad=0.3808p pd=2.92u as=0 ps=0 w=1.12u l=0.13u
X132 a_13949_3287# a_13592_3244# VDD.t38 VDD.t0 sg13_lv_pmos ad=63f pd=0.72u as=0.1563p ps=1.22u w=0.42u l=0.13u
X133 VDD.t79 VDD.t80 VDD.t81 VDD.t31 sg13_lv_pmos ad=0.2128p pd=1.5u as=0 ps=0 w=1.12u l=0.13u
X134 a_10232_3244# a_10206_3208# VDD.t19 VDD.t0 sg13_lv_pmos ad=0.34p pd=2.68u as=0.36237p ps=2.605u w=1u l=0.13u
X135 VSS.t70 a_13121_3204# a_6854_3359# VDD.t31 sg13_lv_pmos ad=0.232p pd=2.08u as=0.136p ps=1.14u w=0.4u l=0.2u
X136 a_5778_740# a_6126_1189# a_6326_1963# VSS.t3 sg13_lv_nmos ad=0.68p pd=4.68u as=0.38p ps=2.38u w=2u l=1u
X137 VDD.t24 DLL_RESETN a_10206_3208# VDD.t0 sg13_lv_pmos ad=0.1563p pd=1.22u as=0.147p ps=1.54u w=0.42u l=0.13u
X138 a_13592_3244# a_14111_3251# a_14851_3601# VSS.t76 sg13_lv_nmos ad=0.3473p pd=2.71u as=0.12665p ps=1.145u w=0.74u l=0.13u
X139 a_6854_2827# a_6854_2827# a_9444_1963# VSS.t16 sg13_lv_nmos ad=0.38p pd=2.38u as=0.68p ps=4.68u w=2u l=1u
X140 a_5778_740# a_6126_1189# a_6326_1963# VSS.t3 sg13_lv_nmos ad=0.68p pd=4.68u as=0.38p ps=2.38u w=2u l=1u
X141 VSS.t29 DELAY_VBIASN VSS.t32 VSS.t31 sg13_lv_nmos ad=1.33p pd=7.38u as=0 ps=0 w=7u l=7u
X142 a_10589_3287# a_10232_3244# VDD.t24 VDD.t0 sg13_lv_pmos ad=63f pd=0.72u as=0.1563p ps=1.22u w=0.42u l=0.13u
X143 a_15270_3678# a_12849_3240# VSS.t78 VSS.t76 sg13_lv_nmos ad=37.8f pd=0.6u as=79.8f ps=0.8u w=0.42u l=0.13u
X144 VDD.t18 a_14009_3251# a_14111_3251# VDD.t0 sg13_lv_pmos ad=1.10612p pd=6.66u as=0.3864p ps=2.93u w=1.12u l=0.13u
X145 a_6326_1963# a_6126_1189# a_5778_740# VSS.t3 sg13_lv_nmos ad=0.42p pd=2.42u as=0.68p ps=4.68u w=2u l=1u
X146 a_6326_1963# a_6326_1963# VDD.t12 VDD.t0 sg13_lv_pmos ad=0.38p pd=2.38u as=0.38p ps=2.38u w=2u l=1u
X147 a_10232_3244# a_10751_3251# a_11491_3601# VSS.t2 sg13_lv_nmos ad=0.3473p pd=2.71u as=0.12665p ps=1.145u w=0.74u l=0.13u
X148 VDD.t5 a_6326_1963# a_6854_3359# VDD.t0 sg13_lv_pmos ad=0.38p pd=2.38u as=0.38p ps=2.38u w=2u l=1u
X149 VDD.t18 a_11748_3482# a_11693_3363# VDD.t0 sg13_lv_pmos ad=1.10612p pd=6.66u as=93.45f ps=0.865u w=0.42u l=0.13u
X150 VSS.t85 a_12849_3240# a_13400_2478# VSS.t84 sg13_lv_nmos ad=0.1626p pd=1.415u as=60.89999f ps=0.71u w=0.42u l=0.13u
X151 a_13400_3678# a_12355_3240# a_13306_3678# VSS.t66 sg13_lv_nmos ad=60.89999f pd=0.71u as=0.1428p ps=1.52u w=0.42u l=0.13u
X152 a_13019_3204# a_15688_2776# VDD.t47 VDD.t0 sg13_lv_pmos ad=0.3808p pd=2.92u as=0.2128p ps=1.5u w=1.12u l=0.13u
X153 VDD.t18 a_10649_3251# a_10751_3251# VDD.t0 sg13_lv_pmos ad=1.10612p pd=6.66u as=0.3864p ps=2.93u w=1.12u l=0.13u
X154 a_9444_1963# a_6854_2827# a_6854_2827# VSS.t15 sg13_lv_nmos ad=0.68p pd=4.68u as=0.38p ps=2.38u w=2u l=1u
X155 a_10458_3665# DLL_RESETN VSS.t19 VSS.t113 sg13_lv_nmos ad=37.8f pd=0.6u as=0.1701p ps=1.65u w=0.42u l=0.13u
X156 a_13566_2701# a_14009_2457# a_13306_2478# VSS.t119 sg13_lv_nmos ad=79.8f pd=0.8u as=0.1296p ps=1.52u w=0.42u l=0.13u
X157 a_13306_2478# a_14111_2600# a_13566_2701# VDD.t0 sg13_lv_pmos ad=0.1428p pd=1.52u as=79.8f ps=0.8u w=0.42u l=0.13u
X158 a_6326_1963# a_6126_1189# a_5778_740# VSS.t3 sg13_lv_nmos ad=0.38p pd=2.38u as=0.68p ps=4.68u w=2u l=1u
X159 a_13880_2491# a_13592_2796# a_13818_2491# VSS.t123 sg13_lv_nmos ad=0.1428p pd=1.52u as=37.8f ps=0.6u w=0.42u l=0.13u
X160 a_15108_2698# a_14851_2555# a_15270_2478# VSS.t93 sg13_lv_nmos ad=0.1428p pd=1.52u as=37.8f ps=0.6u w=0.42u l=0.13u
X161 a_13566_3208# a_14009_3251# a_13949_3287# VDD.t0 sg13_lv_pmos ad=79.8f pd=0.8u as=63f ps=0.72u w=0.42u l=0.13u
X162 a_11491_3601# a_10649_3251# a_10232_3244# VDD.t0 sg13_lv_pmos ad=0.2048p pd=1.63u as=0.34p ps=2.68u w=1u l=0.13u
X163 a_5778_740# a_6126_1189# a_6326_1963# VSS.t3 sg13_lv_nmos ad=0.68p pd=4.68u as=0.42p ps=2.42u w=2u l=1u
X164 a_13880_3665# a_14111_3251# a_13566_3208# VSS.t92 sg13_lv_nmos ad=0.2373p pd=1.97u as=79.8f ps=0.8u w=0.42u l=0.13u
X165 VSS.t6 a_6126_1189# a_6126_1189# VSS.t3 sg13_lv_nmos ad=0.68p pd=4.68u as=0.38p ps=2.38u w=2u l=1u
X166 a_6854_3359# a_6326_1963# VDD.t15 VDD.t0 sg13_lv_pmos ad=0.38p pd=2.38u as=0.38p ps=2.38u w=2u l=1u
X167 a_11748_3482# a_11491_3601# a_11910_3678# VSS.t2 sg13_lv_nmos ad=0.1428p pd=1.52u as=37.8f ps=0.6u w=0.42u l=0.13u
X168 VSS.t102 a_9444_1963# a_9444_1963# VSS.t101 sg13_lv_nmos ad=0.68p pd=4.68u as=0.38p ps=2.38u w=2u l=1u
X169 a_12943_3240# a_12656_3237# a_12849_3240# VDD.t0 sg13_lv_pmos ad=0.2128p pd=1.5u as=0.3808p ps=2.92u w=1.12u l=0.13u
X170 a_13592_3244# a_13566_3208# VDD.t37 VDD.t0 sg13_lv_pmos ad=0.34p pd=2.68u as=0.36237p ps=2.605u w=1u l=0.13u
X171 a_6854_2827# a_6854_2827# a_9444_1963# VSS.t14 sg13_lv_nmos ad=0.38p pd=2.38u as=0.68p ps=4.68u w=2u l=1u
X172 VDD.t38 a_12849_3240# a_13566_3208# VDD.t0 sg13_lv_pmos ad=0.1563p pd=1.22u as=0.147p ps=1.54u w=0.42u l=0.13u
X173 a_9444_1963# a_9444_1963# VSS.t100 VSS.t99 sg13_lv_nmos ad=0.38p pd=2.38u as=0.68p ps=4.68u w=2u l=1u
X174 VDD.t34 a_14851_3601# a_15688_3240# VDD.t0 sg13_lv_pmos ad=0.2128p pd=1.5u as=0.3864p ps=2.93u w=1.12u l=0.13u
X175 VSS.t9 a_6126_1189# a_5974_3096# VSS.t0 sg13_lv_nmos ad=0.68p pd=4.68u as=0.38p ps=2.38u w=2u l=1u
X176 VDD.t66 VDD.t64 VDD.t9 VDD.t0 sg13_lv_pmos ad=0.38p pd=2.38u as=0 ps=0 w=2u l=1u
X177 VSS.t80 a_14851_3601# a_15688_3240# VSS.t79 sg13_lv_nmos ad=0.1406p pd=1.12u as=0.2516p ps=2.16u w=0.74u l=0.13u
X178 VDD.t49 a_15464_1057# a_9712_1285# VSS.t98 sg13_lv_nmos ad=0.232p pd=2.08u as=0.136p ps=1.14u w=0.4u l=0.2u
X179 VSS.t134 VSS.t132 VSS.t132 VSS.t133 sg13_lv_nmos ad=0.68p pd=4.68u as=0 ps=0 w=2u l=1u
X180 VDD.t18 a_15108_2698# a_15053_2793# VDD.t0 sg13_lv_pmos ad=1.10612p pd=6.66u as=93.45f ps=0.865u w=0.42u l=0.13u
X181 VSS.t40 DELAY_VBIASN VSS.t42 VSS.t41 sg13_lv_nmos ad=1.33p pd=7.38u as=0 ps=0 w=7u l=7u
X182 a_10649_3251# DELAY_IN VSS.t24 VSS.t115 sg13_lv_nmos ad=0.2516p pd=2.16u as=1.9998p ps=12.915u w=0.74u l=0.13u
X183 VSS.t7 a_6126_1189# a_5974_3096# VSS.t0 sg13_lv_nmos ad=0.68p pd=4.68u as=0.38p ps=2.38u w=2u l=1u
X184 VSS.t129 VSS.t129 VSS.t131 VSS.t130 sg13_lv_nmos ad=0.68p pd=4.68u as=0 ps=0 w=2u l=1u
X185 VSS.t73 a_14009_2457# a_14111_2600# VSS.t120 sg13_lv_nmos ad=1.45407p pd=9.445u as=0.2516p ps=2.16u w=0.74u l=0.13u
X186 a_6126_1189# a_6326_1963# VDD.t11 VDD.t0 sg13_lv_pmos ad=0.38p pd=2.38u as=0.38p ps=2.38u w=2u l=1u
X187 VDD.t15 a_6326_1963# a_6326_1963# VDD.t0 sg13_lv_pmos ad=0.38p pd=2.38u as=0.38p ps=2.38u w=2u l=1u
X188 a_12943_3240# a_13121_3204# VDD.t26 VDD.t0 sg13_lv_pmos ad=0.3808p pd=2.92u as=0.2128p ps=1.5u w=1.12u l=0.13u
X189 VDD.t18 a_14009_2457# a_14111_2600# VDD.t0 sg13_lv_pmos ad=1.10612p pd=6.66u as=0.3864p ps=2.93u w=1.12u l=0.13u
X190 VDD.t11 a_6326_1963# a_6854_2827# VDD.t0 sg13_lv_pmos ad=0.38p pd=2.38u as=0.38p ps=2.38u w=2u l=1u
X191 a_11748_3482# DLL_RESETN VDD.t18 VDD.t0 sg13_lv_pmos ad=79.8f pd=0.8u as=1.10612p ps=6.66u w=0.42u l=0.13u
X192 a_13818_3665# a_12849_3240# VSS.t82 VSS.t86 sg13_lv_nmos ad=37.8f pd=0.6u as=0.1701p ps=1.65u w=0.42u l=0.13u
X193 a_15464_1057# a_14851_2555# VDD.t45 VDD.t0 sg13_lv_pmos ad=0.4312p pd=3.01u as=0.2639p ps=1.81u w=1.12u l=0.13u
X194 a_9444_1285# a_6854_2827# a_9712_1285# VSS.t15 sg13_lv_nmos ad=0.68p pd=4.68u as=0.38p ps=2.38u w=2u l=1u
X195 a_6126_1189# a_6326_1963# VDD.t4 VDD.t0 sg13_lv_pmos ad=0.38p pd=2.38u as=0.38p ps=2.38u w=2u l=1u
X196 VSS.t24 a_9547_3545# a_9547_3545# VSS.t23 sg13_lv_nmos ad=2.39977p pd=15.495u as=0.111p ps=1.34u w=0.3u l=0.13u
X197 VDD.t9 a_6326_1963# a_6854_2827# VDD.t0 sg13_lv_pmos ad=0.38p pd=2.38u as=0.38p ps=2.38u w=2u l=1u
X198 a_13045_3588# a_13019_3204# a_12849_3240# VSS.t63 sg13_lv_nmos ad=0.1406p pd=1.12u as=0.1406p ps=1.12u w=0.74u l=0.13u
X199 a_10232_3244# a_10206_3208# VSS.t19 VSS.t18 sg13_lv_nmos ad=0.2516p pd=2.16u as=0.1626p ps=1.415u w=0.74u l=0.13u
X200 VDD.t18 a_15108_3482# a_15053_3363# VDD.t0 sg13_lv_pmos ad=1.10612p pd=6.66u as=93.45f ps=0.865u w=0.42u l=0.13u
X201 a_5974_3096# a_6126_1189# VSS.t4 VSS.t0 sg13_lv_nmos ad=0.38p pd=2.38u as=0.68p ps=4.68u w=2u l=1u
X202 a_9946_3678# a_10751_3251# a_10206_3208# VDD.t0 sg13_lv_pmos ad=0.1428p pd=1.52u as=79.8f ps=0.8u w=0.42u l=0.13u
X203 a_14851_3601# a_14009_3251# a_13592_3244# VDD.t0 sg13_lv_pmos ad=0.2048p pd=1.63u as=0.34p ps=2.68u w=1u l=0.13u
X204 a_10206_3208# a_10649_3251# a_9946_3678# VSS.t67 sg13_lv_nmos ad=79.8f pd=0.8u as=0.1296p ps=1.52u w=0.42u l=0.13u
X205 VSS.t13 a_6126_1189# a_5974_3096# VSS.t0 sg13_lv_nmos ad=0.68p pd=4.68u as=0.38p ps=2.38u w=2u l=1u
X206 a_10649_3251# DELAY_IN VDD.t18 VDD.t0 sg13_lv_pmos ad=0.4088p pd=2.97u as=1.03698p ps=6.245u w=1.12u l=0.13u
X207 VSS.t141 VSS.t139 VSS.t139 VSS.t140 sg13_lv_nmos ad=0.2516p pd=2.16u as=0 ps=0 w=0.74u l=0.13u
X208 VSS.t11 a_6126_1189# a_5974_3096# VSS.t0 sg13_lv_nmos ad=0.76p pd=4.76u as=0.38p ps=2.38u w=2u l=1u
C0 a_6326_1963# VDD 7.53039f
C1 a_13566_3208# a_13121_3204# 0.01158f
C2 a_13019_3204# a_15688_3240# 0.0195f
C3 a_15108_3482# a_14851_3601# 0.29858f
C4 a_6854_3359# a_13121_3204# 0.10056f
C5 a_11748_3482# a_10751_3251# 0.03061f
C6 a_13592_3244# DELAY_IN 0.11539f
C7 DELAY_IN a_14009_3251# 0.25847f
C8 a_13121_3204# a_13306_3678# 0.01008f
C9 a_12158_3240# a_11748_3482# 0.10373f
C10 a_14009_2457# a_13880_2491# 0.01562f
C11 a_12849_3240# DELAY_OUT_LAST 0.01791f
C12 a_14851_3601# a_14111_3251# 0.26905f
C13 a_14757_2555# a_14851_2555# 0.28931f
C14 a_13880_3665# a_13306_3678# 0.31978f
C15 a_11748_3482# a_11491_3601# 0.34468f
C16 a_10751_3251# VDD 0.20377f
C17 a_13121_3204# VDD 0.99724f
C18 a_15688_2776# VDD 0.30345f
C19 a_12158_3240# VDD 0.37862f
C20 a_6854_3359# a_15304_1978# 0.08165f
C21 a_13019_3204# a_12849_3240# 0.12838f
C22 a_15108_2698# DELAY_OUT_LAST 0.01399f
C23 a_13592_2796# a_12849_3240# 0.38497f
C24 a_10649_3251# a_10232_3244# 0.37583f
C25 a_13306_2478# a_14009_2457# 0.02454f
C26 a_6854_2827# a_6126_1189# 0.22705f
C27 a_6854_2827# a_5864_740# 0.03661f
C28 a_9712_1285# DELAY_VBIASN 0.22281f
C29 DLL_RESETN a_12943_3240# 0.03616f
C30 VDD a_11491_3601# 0.16753f
C31 VDD a_13106_2730# 0.09228f
C32 DLL_RESETN a_10649_3251# 0.05713f
C33 DELAY_IN a_13019_3204# 0.35409f
C34 a_14851_2555# a_15464_1057# 0.04797f
C35 a_13592_2796# DELAY_IN 0.03445f
C36 a_14757_2555# a_14009_2457# 0.01058f
C37 a_13566_2701# VDD 0.0947f
C38 a_13121_3204# a_15688_2776# 0.01441f
C39 a_15304_1978# VDD 0.72158f
C40 a_9712_1285# a_15464_1057# 0.01237f
C41 DLL_RESETN DELAY_VBIASN 0.12904f
C42 a_14111_2600# VDD 0.33926f
C43 DLL_RESETN a_9712_1285# 0.43103f
C44 a_13592_3244# a_14851_3601# 0.01529f
C45 DLL_RESETN a_10232_3244# 0.39088f
C46 a_9547_3315# a_9772_3216# 0.02416f
C47 a_12849_3240# a_12355_3240# 0.07687f
C48 a_10751_3251# a_11491_3601# 0.26905f
C49 VDD a_12907_2793# 0.07751f
C50 a_12656_3237# a_12849_3240# 0.33075f
C51 a_15108_3482# a_14111_3251# 0.03093f
C52 a_12158_3240# a_11491_3601# 0.0894f
C53 a_13045_3588# a_13019_3204# 0.01249f
C54 a_15304_1978# a_13121_3204# 0.40921f
C55 a_10206_3208# a_9946_3678# 0.75507f
C56 a_6854_3359# a_13132_2793# 0.01367f
C57 a_5778_740# a_6126_1189# 1.6143f
C58 a_5864_740# a_5778_740# 0.07306f
C59 DELAY_IN a_12355_3240# 1.0042f
C60 a_10520_3665# a_10649_3251# 0.01562f
C61 DELAY_IN a_12656_3237# 0.01215f
C62 a_13592_2796# a_13880_2491# 0.43707f
C63 a_6854_3359# a_6126_1189# 0.18536f
C64 a_9712_1285# a_9444_1963# 0.68929f
C65 a_9712_1285# a_5974_3096# 0.01152f
C66 VDD a_13132_2793# 0.23863f
C67 a_10520_3665# a_10232_3244# 0.43707f
C68 a_14757_3601# a_14851_3601# 0.28931f
C69 VDD a_15688_3240# 0.30345f
C70 a_6326_1963# a_6126_1189# 2.84014f
C71 a_6326_1963# a_5864_740# 0.01889f
C72 a_13019_3204# a_14851_3601# 0.01651f
C73 a_13566_3208# a_12849_3240# 0.27346f
C74 VDD a_6126_1189# 0.81494f
C75 DLL_RESETN a_9444_1963# 0.10269f
C76 a_14111_2600# a_15304_1978# 0.01761f
C77 DLL_RESETN a_5974_3096# 0.02002f
C78 a_13306_2478# a_13592_2796# 0.41329f
C79 a_6854_3359# a_12849_3240# 0.06216f
C80 a_13106_2730# a_12907_2793# 0.14994f
C81 a_12849_3240# a_13306_3678# 0.12097f
C82 a_13566_3208# DELAY_IN 0.01538f
C83 a_13121_3204# a_15688_3240# 0.17255f
C84 a_14851_2555# DELAY_OUT_LAST 0.02109f
C85 a_13592_3244# a_14111_3251# 0.34102f
C86 a_14757_2555# a_13592_2796# 0.43239f
C87 DELAY_VBIASN DELAY_OUT_LAST 3.14505f
C88 a_11748_3482# DELAY_IN 0.0148f
C89 a_6854_3359# DELAY_IN 0.05061f
C90 a_10649_3251# a_9946_3678# 0.02432f
C91 a_14009_3251# a_14111_3251# 0.47795f
C92 a_9547_3315# VDD 0.1511f
C93 VDD a_12849_3240# 2.56972f
C94 a_9712_1285# a_9444_1285# 0.81869f
C95 DELAY_IN a_13306_3678# 0.05059f
C96 a_13019_3204# a_12943_3240# 0.03346f
C97 a_11397_3601# a_11491_3601# 0.28931f
C98 a_15464_1057# DELAY_OUT_LAST 0.02565f
C99 a_13106_2730# a_13132_2793# 0.1657f
C100 a_10232_3244# a_9946_3678# 0.41329f
C101 a_14851_2555# a_13592_2796# 0.01529f
C102 DELAY_IN VDD 0.28486f
C103 DLL_RESETN a_9444_1285# 0.03031f
C104 DELAY_VBIASN a_13019_3204# 1.23663f
C105 DLL_RESETN a_12907_2559# 0.02177f
C106 a_9712_1285# a_13019_3204# 0.03275f
C107 a_9772_3216# a_9746_3178# 0.1657f
C108 a_15108_2698# VDD 0.13728f
C109 a_15304_1978# a_15688_3240# 0.19136f
C110 a_13121_3204# a_12849_3240# 0.55272f
C111 DLL_RESETN a_9946_3678# 0.09997f
C112 a_13019_3204# a_15464_1057# 0.59875f
C113 a_14009_2457# DELAY_OUT_LAST 0.25594f
C114 a_13132_2793# a_12907_2793# 0.02416f
C115 DLL_RESETN a_13019_3204# 0.01429f
C116 a_10751_3251# DELAY_IN 0.01931f
C117 a_13121_3204# DELAY_IN 1.40135f
C118 a_15108_2698# a_13121_3204# 0.05903f
C119 a_12158_3240# DELAY_IN 0.01309f
C120 a_13592_3244# a_14009_3251# 0.37583f
C121 a_6854_2827# a_9712_1285# 0.67835f
C122 a_13566_2701# a_12849_3240# 0.26617f
C123 a_13880_2491# VDD 0.02994f
C124 a_15304_1978# a_12849_3240# 0.0606f
C125 a_9444_1285# a_9444_1963# 2.19249f
C126 a_10206_3208# VDD 0.09392f
C127 a_14009_2457# a_13592_2796# 0.3749f
C128 a_14111_2600# a_12849_3240# 0.42064f
C129 DELAY_IN a_11491_3601# 0.01827f
C130 DLL_RESETN a_6854_2827# 0.03626f
C131 a_10520_3665# a_9946_3678# 0.31978f
C132 a_13566_2701# DELAY_IN 0.01093f
C133 a_15304_1978# DELAY_IN 0.01066f
C134 DLL_RESETN a_12355_3240# 0.04879f
C135 VDD a_9547_3545# 0.08695f
C136 VDD a_14851_3601# 0.25326f
C137 DLL_RESETN a_9772_3216# 0.06592f
C138 DLL_RESETN a_12656_3237# 0.11782f
C139 a_15304_1978# a_15108_2698# 0.01986f
C140 a_13306_2478# VDD 0.79678f
C141 a_14111_2600# a_15108_2698# 0.03012f
C142 a_5864_740# a_6126_1189# 0.23738f
C143 a_9746_3178# VDD 0.0918f
C144 a_13592_3244# a_14757_3601# 0.43239f
C145 a_13592_3244# a_13019_3204# 0.04178f
C146 a_14757_3601# a_14009_3251# 0.01058f
C147 a_13121_3204# a_14851_3601# 0.03404f
C148 DELAY_VBIASP DELAY_VBIASN 5.10609f
C149 a_6854_3359# DELAY_VBIASN 0.15808f
C150 a_9712_1285# DELAY_VBIASP 0.11086f
C151 a_12849_3240# a_13132_2793# 0.06758f
C152 a_6854_3359# a_9712_1285# 0.13962f
C153 a_6854_2827# a_9444_1963# 1.24134f
C154 a_6854_2827# a_5974_3096# 0.01757f
C155 VDD a_12943_3240# 0.29479f
C156 VDD a_10649_3251# 0.23431f
C157 a_13019_3204# DELAY_OUT_LAST 0.08017f
C158 a_14111_2600# a_13880_2491# 0.12701f
C159 DLL_RESETN a_5778_740# 0.01215f
C160 a_13592_2796# DELAY_OUT_LAST 0.08062f
C161 DLL_RESETN DELAY_VBIASP 0.05659f
C162 a_6326_1963# a_9712_1285# 0.04737f
C163 a_14851_2555# VDD 0.26676f
C164 DELAY_IN a_13132_2793# 0.02025f
C165 DLL_RESETN a_11748_3482# 0.11133f
C166 DLL_RESETN a_6854_3359# 0.50331f
C167 DELAY_VBIASN VDD 0.23309f
C168 a_9712_1285# VDD 0.21174f
C169 a_15304_1978# a_14851_3601# 0.12139f
C170 a_14111_3251# a_13306_3678# 0.097f
C171 VDD a_10232_3244# 0.07206f
C172 a_13121_3204# a_12943_3240# 0.09118f
C173 a_15108_3482# VDD 0.1349f
C174 a_13306_2478# a_13566_2701# 0.75507f
C175 a_10751_3251# a_10649_3251# 0.47795f
C176 VDD a_15464_1057# 0.52426f
C177 DLL_RESETN VDD 2.28901f
C178 a_13306_2478# a_14111_2600# 0.097f
C179 VDD a_14111_3251# 0.21331f
C180 a_14851_2555# a_13121_3204# 0.03337f
C181 a_6854_2827# a_9444_1285# 0.8486f
C182 a_14851_2555# a_15688_2776# 0.08776f
C183 a_5778_740# a_9444_1963# 0.19787f
C184 a_14757_2555# a_15304_1978# 0.02225f
C185 a_5778_740# a_5974_3096# 2.88221f
C186 a_10751_3251# a_10232_3244# 0.34102f
C187 DELAY_IN a_12849_3240# 0.26382f
C188 a_6854_3359# a_9444_1963# 0.05054f
C189 a_15108_3482# a_13121_3204# 0.03701f
C190 a_6854_3359# a_5974_3096# 0.029f
C191 a_15108_2698# a_12849_3240# 0.10521f
C192 a_14009_2457# VDD 0.31815f
C193 a_13121_3204# a_15464_1057# 0.33256f
C194 a_9772_3216# a_9946_3678# 0.27179f
C195 DLL_RESETN a_10751_3251# 0.45018f
C196 DLL_RESETN a_13121_3204# 0.04337f
C197 a_13566_3208# a_13592_3244# 0.36952f
C198 a_15688_2776# a_15464_1057# 0.1999f
C199 a_13566_3208# a_14009_3251# 0.02242f
C200 a_13121_3204# a_14111_3251# 0.0235f
C201 a_13019_3204# a_12355_3240# 0.3846f
C202 a_12158_3240# DLL_RESETN 0.02442f
C203 a_6326_1963# a_9444_1963# 0.01269f
C204 a_10232_3244# a_11491_3601# 0.01529f
C205 a_13019_3204# a_12656_3237# 0.04193f
C206 a_14851_2555# a_15304_1978# 0.05156f
C207 a_15304_1978# DELAY_VBIASN 0.07802f
C208 a_6326_1963# a_5974_3096# 0.33136f
C209 a_14111_3251# a_13880_3665# 0.12701f
C210 VDD a_9444_1963# 0.01443f
C211 a_14111_2600# a_14851_2555# 0.26905f
C212 VDD a_5974_3096# 0.91576f
C213 a_13592_3244# a_13306_3678# 0.41329f
C214 a_14851_3601# a_15688_3240# 0.08776f
C215 a_14009_3251# a_13306_3678# 0.02432f
C216 a_13306_2478# a_13132_2793# 0.27179f
C217 DLL_RESETN a_11491_3601# 0.14622f
C218 DLL_RESETN a_13106_2730# 0.01263f
C219 a_15304_1978# a_15108_3482# 0.17528f
C220 a_13592_3244# VDD 0.07242f
C221 DELAY_VBIASP DELAY_OUT_LAST 0.82908f
C222 DLL_RESETN a_15304_1978# 0.03137f
C223 VDD a_14009_3251# 0.23872f
C224 a_6854_3359# DELAY_OUT_LAST 0.08491f
C225 a_15304_1978# a_14111_3251# 0.01811f
C226 a_6854_3359# a_9444_1285# 0.01142f
C227 a_10520_3665# a_10751_3251# 0.12701f
C228 a_9547_3315# a_9547_3545# 0.1117f
C229 a_12656_3237# a_12355_3240# 0.03277f
C230 a_11397_3601# a_10649_3251# 0.01058f
C231 DLL_RESETN a_12907_2793# 0.04234f
C232 a_14851_3601# a_12849_3240# 0.13392f
C233 a_13566_2701# a_14009_2457# 0.02242f
C234 VDD DELAY_OUT_LAST 0.17745f
C235 DELAY_VBIASP a_13019_3204# 0.02377f
C236 a_13592_3244# a_13121_3204# 0.01445f
C237 a_13306_2478# a_12849_3240# 0.10976f
C238 a_6854_3359# a_13592_2796# 0.01958f
C239 VDD a_12907_2559# 0.06323f
C240 a_14111_2600# a_14009_2457# 0.47622f
C241 a_13121_3204# a_14009_3251# 0.01604f
C242 a_9547_3315# a_9746_3178# 0.14994f
C243 a_13592_3244# a_13880_3665# 0.43707f
C244 a_11397_3601# a_10232_3244# 0.43239f
C245 VDD a_9946_3678# 0.77198f
C246 a_14009_3251# a_13880_3665# 0.01562f
C247 a_13306_2478# DELAY_IN 0.06166f
C248 VDD a_13019_3204# 0.4182f
C249 a_13592_2796# VDD 0.11685f
C250 a_13121_3204# DELAY_OUT_LAST 0.13178f
C251 a_6854_2827# a_5778_740# 0.02695f
C252 DLL_RESETN a_13132_2793# 0.01689f
C253 a_12849_3240# a_12943_3240# 0.16706f
C254 a_15688_2776# DELAY_OUT_LAST 0.01699f
C255 a_6854_2827# a_6854_3359# 0.30877f
C256 DLL_RESETN a_6126_1189# 0.06398f
C257 a_10751_3251# a_9946_3678# 0.097f
C258 DLL_RESETN a_5864_740# 0.1727f
C259 a_14851_2555# a_12849_3240# 0.13376f
C260 a_12355_3240# a_13306_3678# 0.26489f
C261 a_13121_3204# a_13019_3204# 0.56469f
C262 a_6326_1963# a_6854_2827# 1.25249f
C263 a_13106_2730# a_12907_2559# 0.02437f
C264 DELAY_IN a_10649_3251# 0.25484f
C265 a_6854_2827# VDD 1.03678f
C266 a_15688_2776# a_13019_3204# 0.1287f
C267 a_15304_1978# DELAY_OUT_LAST 0.05582f
C268 a_15108_3482# a_12849_3240# 0.10225f
C269 a_13306_2478# a_13880_2491# 0.31978f
C270 VDD a_12355_3240# 0.37639f
C271 a_14111_2600# DELAY_OUT_LAST 0.02024f
C272 a_9772_3216# VDD 0.24701f
C273 VDD a_12656_3237# 0.26066f
C274 DLL_RESETN a_12849_3240# 0.3501f
C275 a_9712_1285# DELAY_IN 0.06514f
C276 a_14851_2555# a_15108_2698# 0.29858f
C277 a_12849_3240# a_14111_3251# 0.42174f
C278 DELAY_IN a_10232_3244# 0.08086f
C279 a_9444_1963# a_6126_1189# 0.03029f
C280 a_5864_740# a_9444_1963# 0.06832f
C281 a_12907_2559# a_12907_2793# 0.1117f
C282 a_6126_1189# a_5974_3096# 1.74589f
C283 a_5864_740# a_5974_3096# 0.01697f
C284 a_13566_2701# a_13592_2796# 0.36952f
C285 a_15304_1978# a_13019_3204# 0.07025f
C286 a_15304_1978# a_13592_2796# 0.01817f
C287 DLL_RESETN DELAY_IN 10.4683f
C288 a_15108_2698# a_15464_1057# 0.12158f
C289 a_9746_3178# a_9547_3545# 0.02437f
C290 a_13121_3204# a_12355_3240# 0.05795f
C291 DELAY_IN a_14111_3251# 0.02263f
C292 a_14009_2457# a_12849_3240# 0.03463f
C293 a_14111_2600# a_13592_2796# 0.34114f
C294 a_13566_3208# a_13306_3678# 0.75507f
C295 a_6854_3359# DELAY_VBIASP 0.01478f
C296 a_12158_3240# a_12355_3240# 0.12454f
C297 a_10206_3208# a_10649_3251# 0.02242f
C298 a_6326_1963# a_5778_740# 0.8779f
C299 a_13566_3208# VDD 0.09466f
C300 a_6326_1963# a_6854_3359# 1.31745f
C301 DELAY_VBIASP VDD 1.07078f
C302 a_6854_3359# VDD 1.20794f
C303 a_11748_3482# VDD 0.16819f
C304 a_10206_3208# a_10232_3244# 0.36952f
C305 VDD a_13306_3678# 0.77573f
C306 a_9444_1285# a_6126_1189# 0.25721f
C307 a_13592_3244# a_12849_3240# 0.38817f
C308 a_9444_1285# a_5864_740# 0.02483f
C309 a_14009_3251# a_12849_3240# 0.03525f
C310 DLL_RESETN a_10206_3208# 0.27343f
R0 VDD.n22 VDD.t24 17.3693
R1 VDD.n11 VDD.t42 17.3693
R2 VDD.n11 VDD.t38 17.3693
R3 VDD.n23 VDD.t22 17.3517
R4 VDD.n14 VDD.t84 17.3517
R5 VDD.n13 VDD.t27 17.3517
R6 VDD.n17 VDD.t26 17.2247
R7 VDD.n23 VDD.t19 17.0005
R8 VDD.n14 VDD.t41 17.0005
R9 VDD.n13 VDD.t37 17.0005
R10 VDD.t31 VDD.t72 15.0005
R11 VDD.t31 VDD.t77 15.0005
R12 VDD.t31 VDD.t80 15.0005
R13 VDD.t31 VDD.t49 17.9449
R14 VDD.n32 VDD.t17 9.02285
R15 VDD.t31 VDD.t52 8.95516
R16 VDD.n7 VDD.t45 8.76054
R17 VDD.n7 VDD.t35 8.76054
R18 VDD.n0 VDD.t0 1.78925
R19 VDD.n21 VDD.t21 5.9886
R20 VDD.n5 VDD.t47 5.97675
R21 VDD.n5 VDD.t34 5.97675
R22 VDD.n19 VDD.t54 5.96478
R23 VDD.t0 VDD.n33 5.62581
R24 VDD.t18 VDD.n16 5.61485
R25 VDD.t18 VDD.n20 5.61485
R26 VDD.t31 VDD.t73 5.71133
R27 VDD.t31 VDD.t79 5.59179
R28 VDD.n2 VDD.t64 4.9462
R29 VDD.n42 VDD.t61 4.9462
R30 VDD.n9 VDD.t31 7.13279
R31 VDD.t0 VDD.n25 4.19238
R32 VDD.t0 VDD.n34 4.19225
R33 VDD.t0 VDD.n62 4.19225
R34 VDD.t0 VDD.n30 4.19225
R35 VDD.t18 VDD.n18 3.31226
R36 VDD.t18 VDD.n10 3.30706
R37 VDD.t18 VDD.n12 3.30706
R38 VDD.t18 VDD.n24 3.30688
R39 VDD.t18 VDD.n6 2.7751
R40 VDD.t18 VDD 1.47683
R41 VDD.n69 VDD.t66 2.69937
R42 VDD.n40 VDD.t69 2.69937
R43 VDD.n38 VDD.t63 2.69937
R44 VDD.n1 VDD.t71 2.69937
R45 VDD.n67 VDD.t5 2.6992
R46 VDD.n65 VDD.t9 2.6992
R47 VDD.n36 VDD.t10 2.6992
R48 VDD.n44 VDD.t1 2.6992
R49 VDD.n49 VDD.t2 2.6992
R50 VDD.n48 VDD.t11 2.6992
R51 VDD.n54 VDD.t4 2.6992
R52 VDD.n53 VDD.t12 2.6992
R53 VDD.n59 VDD.t7 2.6992
R54 VDD.n58 VDD.t15 2.6992
R55 VDD.t0 VDD.n28 2.32439
R56 VDD.t0 VDD.n56 2.32425
R57 VDD.t0 VDD.n61 2.32425
R58 VDD.t0 VDD.n46 2.32417
R59 VDD.t0 VDD.n29 2.32417
R60 VDD.t0 VDD.n26 2.32417
R61 VDD.t0 VDD.n51 2.00616
R62 VDD.t0 VDD.n27 2.0061
R63 VDD.t0 VDD.n71 1.75938
R64 VDD.t18 VDD.n8 1.20461
R65 VDD.n49 VDD.n48 1.11007
R66 VDD.n54 VDD.n53 1.11007
R67 VDD.n59 VDD.n58 1.11007
R68 VDD.n22 VDD.n4 0.975304
R69 VDD.n39 VDD.n31 0.896401
R70 VDD.n32 VDD.n31 0.88004
R71 VDD.n4 VDD.n21 0.817678
R72 VDD.n9 VDD.n8 0.671512
R73 VDD.n8 VDD.n7 0.6645
R74 VDD.n70 VDD.n69 0.570444
R75 VDD.n38 VDD.n37 0.570444
R76 VDD.n65 VDD.n64 0.570274
R77 VDD.n45 VDD.n44 0.570274
R78 VDD.n50 VDD.n49 0.570274
R79 VDD.n55 VDD.n54 0.570274
R80 VDD.n60 VDD.n59 0.570274
R81 VDD.n67 VDD.n66 0.569912
R82 VDD.n36 VDD.n35 0.569912
R83 VDD.n48 VDD.n47 0.569912
R84 VDD.n53 VDD.n52 0.569912
R85 VDD.n58 VDD.n57 0.569912
R86 VDD.n40 VDD.n39 0.569733
R87 VDD.n1 VDD.n63 0.569733
R88 VDD.t18 VDD.n4 0.49685
R89 VDD.n41 VDD.n40 0.492175
R90 VDD VDD.n1 0.492175
R91 VDD.n68 VDD.n67 0.492005
R92 VDD.n43 VDD.n36 0.492005
R93 VDD.n68 VDD.n65 0.491643
R94 VDD.n44 VDD.n43 0.491643
R95 VDD.n69 VDD 0.491464
R96 VDD.n41 VDD.n38 0.491464
R97 VDD.t0 VDD.n31 0.487325
R98 VDD.t31 VDD.t83 5.73801
R99 VDD.n71 VDD.n70 0.43335
R100 VDD.n71 VDD 0.403558
R101 VDD.t0 VDD.t18 0.383639
R102 VDD.n52 VDD.n28 0.372952
R103 VDD.n56 VDD.n55 0.372812
R104 VDD.n50 VDD.n46 0.354692
R105 VDD.n47 VDD.n26 0.354692
R106 VDD.n57 VDD.n29 0.347655
R107 VDD.n51 VDD.n50 0.347324
R108 VDD.n47 VDD.n27 0.347254
R109 VDD.n61 VDD.n60 0.347057
R110 VDD.n24 VDD.n22 0.335799
R111 VDD.n12 VDD.n11 0.335496
R112 VDD.n64 VDD.n61 0.335312
R113 VDD.n66 VDD.n29 0.334692
R114 VDD.n15 VDD.n12 0.332368
R115 VDD.n24 VDD.n3 0.332058
R116 VDD.n63 VDD.n0 0.383516
R117 VDD.n52 VDD.n27 0.328947
R118 VDD.n55 VDD.n51 0.328884
R119 VDD.n46 VDD.n45 0.327655
R120 VDD.n35 VDD.n26 0.327655
R121 VDD.n19 VDD.n18 0.32704
R122 VDD.n60 VDD.n56 0.309557
R123 VDD.n57 VDD.n28 0.309405
R124 VDD.n7 VDD.n6 0.306614
R125 VDD.n10 VDD.n9 0.298721
R126 VDD VDD.n3 0.423614
R127 VDD.n18 VDD.n17 0.282613
R128 VDD.n11 VDD.n10 0.260496
R129 VDD.n2 VDD.n68 0.253639
R130 VDD.n42 VDD.n41 0.253639
R131 VDD.n43 VDD.n42 0.253298
R132 VDD.n21 VDD.n20 0.202075
R133 VDD.n35 VDD.n25 0.192052
R134 VDD.n45 VDD.n34 0.191924
R135 VDD.n64 VDD.n62 0.184424
R136 VDD.n66 VDD.n30 0.184424
R137 VDD.n37 VDD.n33 0.179888
R138 VDD.n20 VDD.n19 0.175486
R139 VDD.n17 VDD.n16 0.171736
R140 VDD.n63 VDD.n30 0.161924
R141 VDD.n70 VDD.n62 0.161924
R142 VDD.n37 VDD.n34 0.154424
R143 VDD.n39 VDD.n25 0.154293
R144 VDD.n3 VDD.n23 0.152808
R145 VDD.n15 VDD.n14 0.152808
R146 VDD.n15 VDD.n13 0.152808
R147 VDD.n16 VDD.n15 0.147075
R148 VDD.n6 VDD.n5 0.127628
R149 VDD.n33 VDD.n32 0.11705
R150 VDD.t31 VDD.t75 15.0334
R151 VDD.t31 VDD.t74 6.07816
R152 VDD.t78 VDD.t31 5.76644
R153 VDD VDD.n2 0.612395
R154 VDD VDD.n0 0.543771
R155 VDD.t81 VDD.t31 5.75163
R156 VDD.t76 VDD.t31 5.77389
R157 VSS.n100 VSS.n99 22369.4
R158 VSS.n55 VSS.t24 13.5064
R159 VSS.t95 VSS.n52 263.087
R160 VSS.n125 VSS.n124 572.005
R161 VSS.t3 VSS.t0 571.348
R162 VSS.n9 VSS.t114 21.4432
R163 VSS.t24 VSS.n8 0.467955
R164 VSS.n128 VSS.t77 550.193
R165 VSS.n149 VSS.t128 539.653
R166 VSS.t63 VSS.n132 532.819
R167 VSS.n43 VSS.t120 522.508
R168 VSS.n13 VSS.t25 45.3134
R169 VSS.t71 VSS.n131 514.091
R170 VSS.n136 VSS.t68 504.839
R171 VSS.n6 VSS.t75 504.839
R172 VSS.n45 VSS.t121 491.87
R173 VSS.n133 VSS.t69 474.904
R174 VSS.t122 VSS.n84 470.019
R175 VSS.n134 VSS.t20 456.175
R176 VSS.n12 VSS.t22 107.465
R177 VSS.n131 VSS.t66 427.219
R178 VSS.t76 VSS.n31 205.169
R179 VSS.t115 VSS.n28 380.483
R180 VSS.t72 VSS.n45 401.591
R181 VSS.n52 VSS.t93 80.7021
R182 VSS.t116 VSS.n31 380.483
R183 VSS.n1 VSS.n168 370.168
R184 VSS.t81 VSS.n129 363.339
R185 VSS.t18 VSS.n139 363.339
R186 VSS.t88 VSS.t93 359.769
R187 VSS.n126 VSS.t91 347.49
R188 VSS.n127 VSS.t79 329.238
R189 VSS.n1 VSS.t3 328.17
R190 VSS.n150 VSS.t119 313.659
R191 VSS.t86 VSS.t150 304.42
R192 VSS.t74 VSS.n121 304.42
R193 VSS.t113 VSS.t61 304.42
R194 VSS.t67 VSS.n137 304.42
R195 VSS.t127 VSS.n43 299.735
R196 VSS.n6 VSS.t92 291.37
R197 VSS.t1 VSS.n136 291.37
R198 VSS.n55 VSS.t81 310.202
R199 VSS.n12 VSS.t18 313.596
R200 VSS.t79 VSS.n126 243.244
R201 VSS.t91 VSS.n125 224.516
R202 VSS.n1 VSS.t124 108.029
R203 VSS.n44 VSS.t72 208.828
R204 VSS.n150 VSS.t127 202.362
R205 VSS.n7 VSS.t116 202.071
R206 VSS.n135 VSS.t115 202.071
R207 VSS.t23 VSS.n13 211.945
R208 VSS.t92 VSS.n121 196.399
R209 VSS.n137 VSS.t1 196.399
R210 VSS.t119 VSS.n47 187.895
R211 VSS.n1 VSS.t130 18.7321
R212 VSS.t2 VSS.n134 183.975
R213 VSS.n5 VSS.t74 182.797
R214 VSS.n138 VSS.t67 182.797
R215 VSS.t76 VSS.n128 167.954
R216 VSS.n32 VSS.n100 157.911
R217 VSS.t95 VSS.n50 158.246
R218 VSS.t66 VSS.n55 148.06
R219 VSS.t0 VSS.t130 142.417
R220 VSS.t150 VSS.n5 138.607
R221 VSS.t61 VSS.n138 138.607
R222 VSS.n36 VSS.t140 127.212
R223 VSS.n100 VSS.n47 122.129
R224 VSS.n84 VSS.t88 121.858
R225 VSS.n124 VSS.n123 118.993
R226 VSS.n33 VSS.t98 23.8428
R227 VSS.t20 VSS.n133 115.831
R228 VSS.n46 VSS.t122 103.538
R229 VSS.n50 VSS.t98 143.157
R230 VSS.n34 VSS.n35 0.00330064
R231 VSS.t96 VSS.n78 99.4847
R232 VSS.n124 VSS.n21 99.0684
R233 VSS.n42 VSS.t126 93.1365
R234 VSS.t120 VSS.n44 88.3462
R235 VSS.n151 VSS.t118 87.3255
R236 VSS.t75 VSS.n7 85.7923
R237 VSS.t68 VSS.n135 85.7923
R238 VSS.t121 VSS.n149 81.2384
R239 VSS.n36 VSS.n34 4.03858
R240 VSS.t148 VSS.n41 37.7499
R241 VSS.n36 VSS.t142 37.7501
R242 VSS.t145 VSS.n41 127.212
R243 VSS.n168 VSS.t117 68.534
R244 VSS.t123 VSS.t87 68.534
R245 VSS.t97 VSS.n122 66.3233
R246 VSS.t26 VSS.n35 39.8706
R247 VSS.t84 VSS.n79 65.2179
R248 VSS.n99 VSS.n80 65.2179
R249 VSS.t16 VSS.n1 15.3713
R250 VSS.n132 VSS.t71 57.9156
R251 VSS.n99 VSS.n83 53.7749
R252 VSS.n123 VSS.t97 52.6695
R253 VSS.n13 VSS.t24 1.47886
R254 VSS.n33 VSS.t64 34.0095
R255 VSS.n122 VSS.t94 46.4264
R256 VSS.n18 VSS.t35 52.0148
R257 VSS.n129 VSS.t86 44.1903
R258 VSS.n139 VSS.t113 44.1903
R259 VSS.t15 VSS.n1 21.1014
R260 VSS.n151 VSS.t84 40.8995
R261 VSS.t103 VSS.n1 21.2845
R262 VSS.n78 VSS.t117 37.5834
R263 VSS.t140 VSS.n32 35.8827
R264 VSS.t128 VSS.n46 33.9067
R265 VSS.t17 VSS.n1 21.101
R266 VSS.t126 VSS.n79 27.635
R267 VSS.t65 VSS.n8 26.2882
R268 VSS.t87 VSS.n83 22.8243
R269 VSS.t101 VSS.n1 18.8277
R270 VSS.t77 VSS.n127 22.2881
R271 VSS.n9 VSS.t24 0.00314878
R272 VSS.n42 VSS.t96 21.2859
R273 VSS.t43 VSS.n22 10.9123
R274 VSS.t118 VSS.n80 18.792
R275 VSS.t99 VSS.n1 19.4643
R276 VSS.t94 VSS.t95 17.6866
R277 VSS.n15 VSS.n22 0.00100001
R278 VSS.n16 VSS.t39 60.9189
R279 VSS.n20 VSS.t37 28.2779
R280 VSS.n1 VSS.n69 17.0005
R281 VSS.n163 VSS.n1 17.0005
R282 VSS.n168 VSS.t73 17.0005
R283 VSS.t73 VSS.n78 17.0005
R284 VSS.t73 VSS.n79 17.0005
R285 VSS.t73 VSS.n151 17.0005
R286 VSS.t73 VSS.n80 17.0005
R287 VSS.t73 VSS.n150 17.0005
R288 VSS.n122 VSS.t73 17.0005
R289 VSS.t73 VSS.n52 11.5048
R290 VSS.t73 VSS.n84 17.0005
R291 VSS.t73 VSS.n149 17.0005
R292 VSS.n12 VSS.t24 9.80382
R293 VSS.n139 VSS.t24 17.0005
R294 VSS.n137 VSS.t24 17.0005
R295 VSS.n28 VSS.t24 8.26554
R296 VSS.n133 VSS.t24 17.0005
R297 VSS.n132 VSS.t24 17.0005
R298 VSS.t24 VSS.n129 17.0005
R299 VSS.t24 VSS.n121 17.0005
R300 VSS.n128 VSS.t24 17.0005
R301 VSS.n126 VSS.t24 17.0005
R302 VSS.n22 VSS.t41 37.1816
R303 VSS.n15 VSS.n23 0.0012832
R304 VSS.n23 VSS.t33 19.3772
R305 VSS.n1 VSS.n73 17.0005
R306 VSS.n34 VSS.n91 17.0005
R307 VSS.n34 VSS.n92 17.0005
R308 VSS.n34 VSS.n95 17.0005
R309 VSS.n34 VSS.n101 17.0005
R310 VSS.n34 VSS.n110 17.0005
R311 VSS.n34 VSS.n117 17.0005
R312 VSS.n38 VSS.t23 375.567
R313 VSS.t105 VSS.n1 14.2788
R314 VSS.t35 VSS.n23 19.3729
R315 VSS.n1 VSS.t133 20.8283
R316 VSS.t28 VSS.n21 60.9165
R317 VSS.n10 VSS.n63 14.4593
R318 VSS.n64 VSS.n10 0.215425
R319 VSS.n143 VSS.t70 9.08698
R320 VSS.t70 VSS.n142 9.0445
R321 VSS.n147 VSS.n86 9.0005
R322 VSS.n96 VSS.n87 9.0005
R323 VSS.n89 VSS.n87 9.0005
R324 VSS.n147 VSS.n146 9.0005
R325 VSS.t2 VSS.n28 205.169
R326 VSS.t24 VSS.n31 8.26554
R327 VSS.n50 VSS.n34 0.0149253
R328 VSS.n34 VSS.n41 4.03856
R329 VSS.n34 VSS.n98 8.48883
R330 VSS.n34 VSS.n58 8.48883
R331 VSS.t60 VSS.n25 1.02037
R332 VSS.n25 VSS.n15 0.164075
R333 VSS.n25 VSS.t44 1.20669
R334 VSS.n1 VSS.n60 8.47732
R335 VSS.n1 VSS.n40 3.32623
R336 VSS.n27 VSS.n1 2.32702
R337 VSS.t7 VSS.n30 0.363485
R338 VSS.n29 VSS.n1 1.55334
R339 VSS.t11 VSS.n29 0.363385
R340 VSS.n3 VSS.n1 0.576637
R341 VSS.n1 VSS.n71 8.47732
R342 VSS.n1 VSS.n61 8.47732
R343 VSS.n1 VSS.n51 3.32623
R344 VSS.t5 VSS.n0 0.593755
R345 VSS.n156 VSS.n1 8.47732
R346 VSS.n15 VSS.n119 8.47732
R347 VSS.n34 VSS.n90 8.47732
R348 VSS.n34 VSS.n94 8.47732
R349 VSS.n34 VSS.n49 1.12158
R350 VSS.n34 VSS.n102 8.47732
R351 VSS.n34 VSS.n109 8.47732
R352 VSS.n34 VSS.n111 8.47732
R353 VSS.t21 VSS.n54 0.866001
R354 VSS.t78 VSS.n39 0.501203
R355 VSS.n167 VSS.n1 8.46924
R356 VSS.n38 VSS.t130 119325
R357 VSS.t4 VSS.n40 0.0944268
R358 VSS.n30 VSS.n1 1.55325
R359 VSS.t131 VSS.n51 0.0944268
R360 VSS.n26 VSS.n1 0.857076
R361 VSS.n34 VSS.n144 5.62581
R362 VSS.n148 VSS.n85 5.13648
R363 VSS.n87 VSS.n59 4.63796
R364 VSS.t85 VSS.n148 4.4712
R365 VSS.n100 VSS.t123 4.42202
R366 VSS.n24 VSS.n15 1.24475
R367 VSS.n1 VSS.n75 4.19652
R368 VSS.n152 VSS.n1 4.19244
R369 VSS.n1 VSS.n72 4.19225
R370 VSS.n34 VSS.n116 4.19225
R371 VSS.n48 VSS.t89 0.777874
R372 VSS.n1 VSS.n11 0.912493
R373 VSS.n145 VSS.n34 3.32697
R374 VSS.n1 VSS.n76 3.32633
R375 VSS.n34 VSS.n107 3.32633
R376 VSS.t24 VSS.n130 3.30696
R377 VSS.n15 VSS.n16 0.00100001
R378 VSS.n18 VSS.t37 43.1164
R379 VSS.n15 VSS.n18 0.00100387
R380 VSS.n15 VSS.n19 0.00100001
R381 VSS.n19 VSS.t31 43.1157
R382 VSS.t41 VSS.n16 34.2123
R383 VSS.n15 VSS.n20 0.00103327
R384 VSS.t33 VSS.n19 52.0164
R385 VSS.n15 VSS.n17 0.00100001
R386 VSS.t31 VSS.n17 28.2766
R387 VSS.n17 VSS.t28 10.4748
R388 VSS.n15 VSS.n21 0.00103327
R389 VSS.t39 VSS.n20 10.4714
R390 VSS.t45 VSS.n59 2.7456
R391 VSS.n34 VSS.n93 2.74386
R392 VSS.n1 VSS.t14 9.00293
R393 VSS.n165 VSS.n1 2.32483
R394 VSS.n1 VSS.n70 2.32439
R395 VSS.t73 VSS.n83 2.06357
R396 VSS.n123 VSS.t73 2.06357
R397 VSS.n1 VSS.n77 2.01633
R398 VSS.n4 VSS.n1 0.6701
R399 VSS.n1 VSS.n2 0.615042
R400 VSS.n53 VSS.t24 1.51816
R401 VSS.n37 VSS.t24 0.452198
R402 VSS VSS.n59 1.77935
R403 VSS.n1 VSS.n62 1.7562
R404 VSS.n1 VSS.n68 1.75596
R405 VSS.n49 VSS.n113 0.612342
R406 VSS.n39 VSS.t24 1.34781
R407 VSS.n146 VSS.n88 1.66925
R408 VSS.n15 VSS.n57 1.55041
R409 VSS.n157 VSS.t132 1.43372
R410 VSS.n153 VSS.t134 1.43372
R411 VSS.t134 VSS.n154 1.42949
R412 VSS.t132 VSS.n158 1.42949
R413 VSS.t106 VSS.t110 1.41892
R414 VSS.t104 VSS.t109 1.41892
R415 VSS.t102 VSS.t108 1.41892
R416 VSS.t100 VSS.t107 1.41892
R417 VSS.t129 VSS.n65 1.37661
R418 VSS.t129 VSS.n66 1.37661
R419 VSS.t58 VSS.t60 1.25614
R420 VSS.t44 VSS.n56 1.07695
R421 VSS.t50 VSS.t48 1.18726
R422 VSS.t34 VSS.t32 1.18357
R423 VSS.t36 VSS.t34 1.17915
R424 VSS.t50 VSS.t52 1.17786
R425 VSS.t29 VSS.t30 1.1778
R426 VSS.t40 VSS.t38 1.17364
R427 VSS.t56 VSS.t54 1.17241
R428 VSS.t58 VSS.t56 1.16468
R429 VSS.t46 VSS.t45 1.16092
R430 VSS.t42 VSS.t40 1.15329
R431 VSS.t46 VSS.t48 1.12501
R432 VSS.t85 VSS.n48 1.02114
R433 VSS.t52 VSS.t54 1.11752
R434 VSS.t38 VSS.t36 1.11316
R435 VSS.t32 VSS.t29 1.10881
R436 VSS.t73 VSS.n81 1.09664
R437 VSS.t82 VSS.n54 1.10955
R438 VSS.n81 VSS.n82 1.02454
R439 VSS.n14 VSS.n120 0.832641
R440 VSS.t144 VSS.t146 0.806856
R441 VSS.n97 VSS.t139 0.806855
R442 VSS.t27 VSS.n108 0.802775
R443 VSS.n37 VSS.t19 0.432133
R444 VSS.n120 VSS.t80 0.745491
R445 VSS.t73 VSS.n48 0.505538
R446 VSS.n166 VSS.t106 0.722582
R447 VSS.n164 VSS.t104 0.722582
R448 VSS.n162 VSS.t102 0.722582
R449 VSS.n4 VSS.t100 0.83564
R450 VSS.t110 VSS.n159 0.72222
R451 VSS.t109 VSS.n160 0.72222
R452 VSS.t108 VSS.n161 0.72222
R453 VSS.t107 VSS.n2 0.826635
R454 VSS.n14 VSS.n118 0.710589
R455 VSS.t85 VSS.n81 0.699997
R456 VSS.n141 VSS.n140 0.6955
R457 VSS.n54 VSS.t24 0.552548
R458 VSS.t80 VSS.n39 0.102709
R459 VSS.n15 VSS.n14 0.600028
R460 VSS.n112 VSS.t149 0.595317
R461 VSS.t147 VSS.n114 0.595317
R462 VSS.n103 VSS.t143 0.595317
R463 VSS.t141 VSS.n105 0.595317
R464 VSS.n53 VSS.n85 0.571406
R465 VSS.n138 VSS.t24 0.572871
R466 VSS.t24 VSS.n5 0.572871
R467 VSS.t73 VSS.n47 0.557126
R468 VSS.t132 VSS.t134 0.492336
R469 VSS.n134 VSS.t24 0.490843
R470 VSS.t63 VSS.n8 39.2108
R471 VSS.n131 VSS.t24 0.490843
R472 VSS.n125 VSS.t24 0.490843
R473 VSS.n135 VSS.t24 0.489061
R474 VSS.t24 VSS.n7 0.489061
R475 VSS.t45 VSS.n57 0.47741
R476 VSS.t73 VSS.n45 0.477286
R477 VSS.t73 VSS.n44 0.472981
R478 VSS.n118 VSS.t89 0.464894
R479 VSS.n140 VSS.n57 0.460744
R480 VSS.n34 VSS.n33 0.124261
R481 VSS.n67 VSS.n62 0.417336
R482 VSS.n68 VSS.n64 0.417043
R483 VSS.n68 VSS.n67 0.416074
R484 VSS.n63 VSS.n62 0.415796
R485 VSS.n148 VSS.n147 0.41014
R486 VSS.n38 VSS.t24 0.102856
R487 VSS.n166 VSS.n165 0.376066
R488 VSS.n159 VSS.n70 0.374405
R489 VSS.n155 VSS.n77 0.36227
R490 VSS.n2 VSS.n161 0.538187
R491 VSS.n162 VSS.n4 0.531331
R492 VSS.n104 VSS.n93 0.312137
R493 VSS.n160 VSS.n70 0.307952
R494 VSS.n165 VSS.n164 0.306341
R495 VSS.n130 VSS.n85 0.298621
R496 VSS.n145 VSS.n89 0.291601
R497 VSS.n146 VSS.n145 0.287886
R498 VSS.n26 VSS.t131 0.8309
R499 VSS.t27 VSS.n107 0.275797
R500 VSS.n107 VSS.n103 0.266415
R501 VSS.n10 VSS.n1 1.11845
R502 VSS.t73 VSS.n42 0.255045
R503 VSS.n82 VSS.n77 0.248324
R504 VSS.t21 VSS.n37 1.13704
R505 VSS.t78 VSS.n53 0.692963
R506 VSS.n27 VSS.t4 0.472156
R507 VSS.t5 VSS.n26 0.783269
R508 VSS.n51 VSS.n66 0.253403
R509 VSS.n40 VSS.n65 0.253403
R510 VSS.t9 VSS.n30 0.55442
R511 VSS.n108 VSS.n93 0.238387
R512 VSS.n155 VSS.n76 0.235797
R513 VSS.n142 VSS.n116 0.225674
R514 VSS.n116 VSS.n112 0.219424
R515 VSS.n147 VSS.n87 0.20686
R516 VSS.n88 VSS.n76 0.197665
R517 VSS.n29 VSS.t9 0.363831
R518 VSS.n3 VSS.t13 0.105964
R519 VSS.t6 VSS.n0 0.16104
R520 VSS.n3 VSS.t11 0.693958
R521 VSS.t7 VSS.n27 0.423702
R522 VSS.t149 VSS.t147 0.1875
R523 VSS.t143 VSS.t141 0.1875
R524 VSS.n75 VSS.n74 0.185296
R525 VSS.n158 VSS.n72 0.181924
R526 VSS.n152 VSS.n157 0.181543
R527 VSS.t82 VSS.n130 0.177814
R528 VSS.n67 VSS.t129 0.167615
R529 VSS.n153 VSS.n152 0.164808
R530 VSS.n154 VSS.n72 0.164424
R531 VSS.n144 VSS.n141 0.156138
R532 VSS.n15 VSS.t50 0.150099
R533 VSS.n15 VSS.t34 0.14953
R534 VSS.n74 VSS.t125 0.146613
R535 VSS.n11 VSS.t125 0.102729
R536 VSS.n82 VSS.n167 0.142012
R537 VSS.n15 VSS.t54 0.139355
R538 VSS.n15 VSS.t38 0.13875
R539 VSS.n15 VSS.t29 0.138705
R540 VSS.n167 VSS.n153 0.138262
R541 VSS.n88 VSS.n75 0.126402
R542 VSS.n15 VSS.t46 0.119905
R543 VSS.t134 VSS.n155 0.1171
R544 VSS.n56 VSS.t42 0.0150615
R545 VSS.n140 VSS.n24 0.454403
R546 VSS.n158 VSS.n71 0.104618
R547 VSS.n157 VSS.n156 0.104618
R548 VSS.n15 VSS.t58 0.103851
R549 VSS.t144 VSS.n109 0.0971176
R550 VSS.n141 VSS.n49 0.586178
R551 VSS.n144 VSS.n143 0.0958002
R552 VSS.n143 VSS.n117 0.0955
R553 VSS.n108 VSS.n92 0.093
R554 VSS.t141 VSS.n106 0.0851154
R555 VSS.t143 VSS.n104 0.0851154
R556 VSS.t147 VSS.n115 0.0851154
R557 VSS.t149 VSS.n113 0.0851154
R558 VSS.n120 VSS.n119 0.0846176
R559 VSS.n161 VSS.n69 0.08425
R560 VSS.n163 VSS.n162 0.08425
R561 VSS.n105 VSS.n101 0.08175
R562 VSS.n114 VSS.n110 0.08175
R563 VSS.n106 VSS.n95 0.08175
R564 VSS.n115 VSS.n91 0.08175
R565 VSS.n74 VSS.n73 0.0805
R566 VSS.n65 VSS.n60 0.0796176
R567 VSS.n66 VSS.n61 0.0796176
R568 VSS.n64 VSS.n60 0.0758676
R569 VSS.n63 VSS.n61 0.0758676
R570 VSS.n154 VSS.n73 0.07425
R571 VSS.t139 VSS.n58 0.0740901
R572 VSS.n98 VSS.n97 0.0740901
R573 VSS.t30 VSS.n119 0.0708676
R574 VSS.n160 VSS.n69 0.06925
R575 VSS.n164 VSS.n163 0.06925
R576 VSS.n103 VSS.n102 0.0671176
R577 VSS.n112 VSS.n111 0.0671176
R578 VSS.n104 VSS.n94 0.0671176
R579 VSS.n113 VSS.n90 0.0671176
R580 VSS.n24 VSS.n118 0.565745
R581 VSS.n105 VSS.n102 0.0621177
R582 VSS.n114 VSS.n111 0.0621177
R583 VSS.n106 VSS.n94 0.0621177
R584 VSS.n115 VSS.n90 0.0621177
R585 VSS.n109 VSS.t27 0.0571176
R586 VSS VSS.n11 0.0952037
R587 VSS.n159 VSS.n71 0.0496177
R588 VSS.n156 VSS.n166 0.0496177
R589 VSS.t146 VSS.n92 0.04925
R590 VSS.n110 VSS.t144 0.04675
R591 VSS.t146 VSS.n91 0.04675
R592 VSS.n101 VSS.n86 0.0305
R593 VSS.n96 VSS.n95 0.0305
R594 VSS.n98 VSS.n89 0.0253401
R595 VSS.n146 VSS.n58 0.0253401
R596 VSS.n136 VSS.t24 0.0184075
R597 VSS.t24 VSS.n6 0.0184075
R598 VSS.t73 VSS.n43 0.0173993
R599 VSS.t139 VSS.n86 0.01675
R600 VSS.n97 VSS.n96 0.01675
R601 VSS.t73 VSS.n46 0.0160892
R602 VSS.n127 VSS.t24 0.0151406
R603 VSS.n142 VSS.n117 0.013
R604 VSS.n34 VSS.n32 0.00394024
R605 VSS.n35 VSS.t145 35.8865
R606 VSS.n56 VSS.n15 0.110065
R607 VSS.t69 VSS.n9 97.6328
R608 VSS.n1 VSS.n0 1.07793
C311 DELAY_VBIASP VSS 4.41492f
C312 DELAY_OUT_LAST VSS 2.65853f
C313 DELAY_VBIASN VSS 99.4221f
C314 DELAY_IN VSS 3.31101f
C315 DLL_RESETN VSS 4.65231f
C316 VDD VSS 14.20084f
C317 a_9712_1285# VSS 1.32888f ; **FLOATING
C318 a_9444_1285# VSS 2.15703f ; **FLOATING
C319 a_5778_740# VSS 5.33396f ; **FLOATING
C320 a_15464_1057# VSS 0.75544f ; **FLOATING
C321 a_14757_2555# VSS 0.09495f ; **FLOATING
C322 a_13880_2491# VSS 0.06985f ; **FLOATING
C323 a_15688_2776# VSS 0.26291f ; **FLOATING
C324 a_15108_2698# VSS 0.24458f ; **FLOATING
C325 a_14851_2555# VSS 0.38123f ; **FLOATING
C326 a_9444_1963# VSS 6.04048f ; **FLOATING
C327 a_14111_2600# VSS 0.19866f ; **FLOATING
C328 a_14009_2457# VSS 0.44622f ; **FLOATING
C329 a_13592_2796# VSS 1.57456f ; **FLOATING
C330 a_13306_2478# VSS 0.30095f ; **FLOATING
C331 a_13566_2701# VSS 0.15441f ; **FLOATING
C332 a_13132_2793# VSS 0.13036f ; **FLOATING
C333 a_12907_2793# VSS 0.14377f ; **FLOATING
C334 a_12907_2559# VSS 0.14861f ; **FLOATING
C335 a_13106_2730# VSS 0.06343f ; **FLOATING
C336 a_15304_1978# VSS 0.37009f ; **FLOATING
C337 a_14757_3601# VSS 0.09586f ; **FLOATING
C338 a_15688_3240# VSS 0.26405f ; **FLOATING
C339 a_14851_3601# VSS 0.39588f ; **FLOATING
C340 a_15108_3482# VSS 0.24582f ; **FLOATING
C341 a_14111_3251# VSS 0.21915f ; **FLOATING
C342 a_13880_3665# VSS 0.07345f ; **FLOATING
C343 a_14009_3251# VSS 0.48187f ; **FLOATING
C344 a_13592_3244# VSS 1.58208f ; **FLOATING
C345 a_13566_3208# VSS 0.15442f ; **FLOATING
C346 a_13045_3588# VSS 0.01124f ; **FLOATING
C347 a_13306_3678# VSS 0.31701f ; **FLOATING
C348 a_12849_3240# VSS 1.40248f ; **FLOATING
C349 a_13121_3204# VSS 0.80439f ; **FLOATING
C350 a_13019_3204# VSS 2.18888f ; **FLOATING
C351 a_12656_3237# VSS 0.28393f ; **FLOATING
C352 a_12355_3240# VSS 0.62262f ; **FLOATING
C353 a_11397_3601# VSS 0.09495f ; **FLOATING
C354 a_12158_3240# VSS 0.25874f ; **FLOATING
C355 a_11491_3601# VSS 0.30073f ; **FLOATING
C356 a_11748_3482# VSS 0.17021f ; **FLOATING
C357 a_10751_3251# VSS 0.19918f ; **FLOATING
C358 a_10520_3665# VSS 0.03671f ; **FLOATING
C359 a_10649_3251# VSS 0.47308f ; **FLOATING
C360 a_10232_3244# VSS 1.52123f ; **FLOATING
C361 a_10206_3208# VSS 0.08466f ; **FLOATING
C362 a_9946_3678# VSS 0.18126f ; **FLOATING
C363 a_9772_3216# VSS 0.12435f ; **FLOATING
C364 a_9746_3178# VSS 0.06613f ; **FLOATING
C365 a_9547_3545# VSS 0.16037f ; **FLOATING
C366 a_9547_3315# VSS 0.11966f ; **FLOATING
C367 a_6854_2827# VSS 3.66026f ; **FLOATING
C368 a_6126_1189# VSS 13.8075f ; **FLOATING
C369 a_6854_3359# VSS 1.41376f ; **FLOATING
C370 a_5974_3096# VSS 2.40124f ; **FLOATING
C371 a_6326_1963# VSS 1.03474f ; **FLOATING
C372 VSS.t125 VSS 3.31349f ; **FLOATING
C373 VDD.t31 VSS 4.0678f ; **FLOATING
C374 VDD.t83 VSS 0.02586f ; **FLOATING
C375 VDD.n0 VSS 0.02183f ; **FLOATING
C376 VDD.n1 VSS 0.01768f ; **FLOATING
C377 VDD.n2 VSS 0.01157f ; **FLOATING
C378 VDD.n3 VSS 0.0589f ; **FLOATING
C379 VDD.t75 VSS 0.01494f ; **FLOATING
C380 VDD.n4 VSS 0.10529f ; **FLOATING
C381 VDD.t18 VSS 6.60803f ; **FLOATING
C382 VDD.t34 VSS 0.02945f ; **FLOATING
C383 VDD.t47 VSS 0.02945f ; **FLOATING
C384 VDD.n5 VSS 0.10057f ; **FLOATING
C385 VDD.n6 VSS 0.01265f ; **FLOATING
C386 VDD.t35 VSS 0.03562f ; **FLOATING
C387 VDD.t45 VSS 0.03562f ; **FLOATING
C388 VDD.n7 VSS 0.11341f ; **FLOATING
C389 VDD.n8 VSS 0.06003f ; **FLOATING
C390 VDD.t73 VSS 0.0257f ; **FLOATING
C391 VDD.t72 VSS 0.01833f ; **FLOATING
C392 VDD.t74 VSS 0.02838f ; **FLOATING
C393 VDD.t76 VSS 0.02584f ; **FLOATING
C394 VDD.t78 VSS 0.02586f ; **FLOATING
C395 VDD.t77 VSS 0.01833f ; **FLOATING
C396 VDD.t79 VSS 0.02838f ; **FLOATING
C397 VDD.t80 VSS 0.01493f ; **FLOATING
C398 VDD.t81 VSS 0.02578f ; **FLOATING
C399 VDD.t49 VSS 0.02788f ; **FLOATING
C400 VDD.t52 VSS 0.01896f ; **FLOATING
C401 VDD.n9 VSS 0.25448f ; **FLOATING
C402 VDD.n10 VSS 0.02181f ; **FLOATING
C403 VDD.t38 VSS 0.02094f ; **FLOATING
C404 VDD.t42 VSS 0.02094f ; **FLOATING
C405 VDD.n11 VSS 0.06218f ; **FLOATING
C406 VDD.n12 VSS 0.02951f ; **FLOATING
C407 VDD.t37 VSS 0.04832f ; **FLOATING
C408 VDD.n13 VSS 0.01957f ; **FLOATING
C409 VDD.t41 VSS 0.04832f ; **FLOATING
C410 VDD.n14 VSS 0.01957f ; **FLOATING
C411 VDD.n15 VSS 0.04321f ; **FLOATING
C412 VDD.n16 VSS 0.01149f ; **FLOATING
C413 VDD.t26 VSS 0.02847f ; **FLOATING
C414 VDD.n17 VSS 0.05119f ; **FLOATING
C415 VDD.n18 VSS 0.02814f ; **FLOATING
C416 VDD.t54 VSS 0.02629f ; **FLOATING
C417 VDD.n19 VSS 0.061f ; **FLOATING
C418 VDD.n20 VSS 0.01605f ; **FLOATING
C419 VDD.t21 VSS 0.02945f ; **FLOATING
C420 VDD.n21 VSS 0.1316f ; **FLOATING
C421 VDD.t24 VSS 0.02094f ; **FLOATING
C422 VDD.n22 VSS 0.11787f ; **FLOATING
C423 VDD.t19 VSS 0.04832f ; **FLOATING
C424 VDD.n23 VSS 0.01957f ; **FLOATING
C425 VDD.n24 VSS 0.02952f ; **FLOATING
C426 VDD.n25 VSS 0.01245f ; **FLOATING
C427 VDD.n26 VSS 0.02857f ; **FLOATING
C428 VDD.n27 VSS 0.02491f ; **FLOATING
C429 VDD.n28 VSS 0.02845f ; **FLOATING
C430 VDD.n29 VSS 0.02859f ; **FLOATING
C431 VDD.n30 VSS 0.01257f ; **FLOATING
C432 VDD.n31 VSS 1.40218f ; **FLOATING
C433 VDD.t17 VSS 0.01734f ; **FLOATING
C434 VDD.n32 VSS 1.37919f ; **FLOATING
C435 VDD.n33 VSS 0.01226f ; **FLOATING
C436 VDD.n34 VSS 0.01251f ; **FLOATING
C437 VDD.n35 VSS 0.05417f ; **FLOATING
C438 VDD.t10 VSS 0.05068f ; **FLOATING
C439 VDD.n36 VSS 0.01769f ; **FLOATING
C440 VDD.n37 VSS 0.03964f ; **FLOATING
C441 VDD.t63 VSS 0.04534f ; **FLOATING
C442 VDD.n38 VSS 0.01768f ; **FLOATING
C443 VDD.t69 VSS 0.04534f ; **FLOATING
C444 VDD.n39 VSS 0.91414f ; **FLOATING
C445 VDD.n40 VSS 0.01768f ; **FLOATING
C446 VDD.n41 VSS 0.03581f ; **FLOATING
C447 VDD.t61 VSS 0.28673f ; **FLOATING
C448 VDD.n42 VSS 0.01157f ; **FLOATING
C449 VDD.n43 VSS 0.03579f ; **FLOATING
C450 VDD.t1 VSS 0.05068f ; **FLOATING
C451 VDD.n44 VSS 0.01769f ; **FLOATING
C452 VDD.n45 VSS 0.05415f ; **FLOATING
C453 VDD.n46 VSS 0.02857f ; **FLOATING
C454 VDD.n47 VSS 0.06892f ; **FLOATING
C455 VDD.t11 VSS 0.05068f ; **FLOATING
C456 VDD.n48 VSS 0.03288f ; **FLOATING
C457 VDD.t2 VSS 0.05068f ; **FLOATING
C458 VDD.n49 VSS 0.03288f ; **FLOATING
C459 VDD.n50 VSS 0.06892f ; **FLOATING
C460 VDD.n51 VSS 0.02491f ; **FLOATING
C461 VDD.n52 VSS 0.0691f ; **FLOATING
C462 VDD.t12 VSS 0.05068f ; **FLOATING
C463 VDD.n53 VSS 0.03288f ; **FLOATING
C464 VDD.t4 VSS 0.05068f ; **FLOATING
C465 VDD.n54 VSS 0.03288f ; **FLOATING
C466 VDD.n55 VSS 0.06908f ; **FLOATING
C467 VDD.n56 VSS 0.02851f ; **FLOATING
C468 VDD.n57 VSS 0.06531f ; **FLOATING
C469 VDD.t15 VSS 0.05068f ; **FLOATING
C470 VDD.n58 VSS 0.03288f ; **FLOATING
C471 VDD.t7 VSS 0.05068f ; **FLOATING
C472 VDD.n59 VSS 0.03288f ; **FLOATING
C473 VDD.n60 VSS 0.06527f ; **FLOATING
C474 VDD.n61 VSS 0.02862f ; **FLOATING
C475 VDD.n62 VSS 0.01257f ; **FLOATING
C476 VDD.t0 VSS 9.98287f ; **FLOATING
C477 VDD.t66 VSS 0.04534f ; **FLOATING
C478 VDD.t71 VSS 0.04534f ; **FLOATING
C479 VDD.n63 VSS 0.05874f ; **FLOATING
C480 VDD.t9 VSS 0.05068f ; **FLOATING
C481 VDD.n64 VSS 0.05413f ; **FLOATING
C482 VDD.n65 VSS 0.01769f ; **FLOATING
C483 VDD.n66 VSS 0.05416f ; **FLOATING
C484 VDD.t5 VSS 0.05068f ; **FLOATING
C485 VDD.n67 VSS 0.01769f ; **FLOATING
C486 VDD.n68 VSS 0.03579f ; **FLOATING
C487 VDD.t64 VSS 0.28673f ; **FLOATING
C488 VDD.n69 VSS 0.01768f ; **FLOATING
C489 VDD.n70 VSS 0.06453f ; **FLOATING
C490 VDD.n71 VSS 0.03758f ; **FLOATING
.ends
