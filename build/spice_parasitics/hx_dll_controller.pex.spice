* NGSPICE file created from hx_dll_controller.ext - technology: ihp-sg13g2

.subckt hx_dll_controller VDD DLL_RESETN DELAY_OUT_LAST VSS DELAY_IN DELAY_VBIASN
+ DELAY_VBIASP
X0 a_10458_3750# DLL_RESETN VSS.t121 VSS.t120 sg13_lv_nmos ad=37.8f pd=0.6u as=0.1701p ps=1.65u w=0.42u l=0.13u
X1 a_10649_3336# DELAY_IN VDD.t0 VDD.t0 sg13_lv_pmos ad=0.4088p pd=2.97u as=1.03698p ps=6.245u w=1.12u l=0.13u
X2 VSS.t157 VSS.t157 VSS.t159 VSS.t158 sg13_lv_nmos ad=0.1406p pd=1.12u as=0 ps=0 w=0.74u l=0.13u
X3 a_13566_2786# a_14009_2542# a_13306_2563# VSS.t128 sg13_lv_nmos ad=79.8f pd=0.8u as=0.1296p ps=1.52u w=0.42u l=0.13u
X4 a_9946_3763# a_9772_3301# VDD.t22 VDD.t0 sg13_lv_pmos ad=79.8f pd=0.8u as=0.1428p ps=1.52u w=0.42u l=0.13u
X5 a_13306_2563# a_14111_2685# a_13566_2786# VDD.t0 sg13_lv_pmos ad=0.1428p pd=1.52u as=79.8f ps=0.8u w=0.42u l=0.13u
X6 a_15108_2783# a_14851_2640# a_15270_2563# VSS.t99 sg13_lv_nmos ad=0.1428p pd=1.52u as=37.8f ps=0.6u w=0.42u l=0.13u
X7 a_13566_3293# a_14009_3336# a_13949_3372# VDD.t0 sg13_lv_pmos ad=79.8f pd=0.8u as=63f ps=0.72u w=0.42u l=0.13u
X8 a_11491_3686# a_10649_3336# a_10232_3329# VDD.t0 sg13_lv_pmos ad=0.2048p pd=1.63u as=0.34p ps=2.68u w=1u l=0.13u
X9 VSS.t58 DELAY_VBIASN VSS.t56 VSS.t41 sg13_lv_nmos ad=1.33p pd=7.38u as=0 ps=0 w=7u l=7u
X10 a_9746_3263# a_9547_3400# VSS.t24 VSS.t25 sg13_lv_nmos ad=0.27427p pd=2.28u as=2.39977p ps=15.495u w=0.795u l=0.13u
X11 a_14009_3336# DELAY_IN VSS.t79 VSS.t125 sg13_lv_nmos ad=0.2516p pd=2.16u as=1.9998p ps=12.915u w=0.74u l=0.13u
X12 a_13121_3289# a_15688_3325# VDD.t34 VDD.t0 sg13_lv_pmos ad=0.3808p pd=2.92u as=0.2128p ps=1.5u w=1.12u l=0.13u
X13 a_6854_3444# a_6326_2048# VDD.t15 VDD.t0 sg13_lv_pmos ad=0.38p pd=2.38u as=0.38p ps=2.38u w=2u l=1u
X14 VSS.t84 a_14851_3686# a_15688_3325# VSS.t83 sg13_lv_nmos ad=0.1406p pd=1.12u as=0.2516p ps=2.16u w=0.74u l=0.13u
X15 VDD.t79 VDD.t77 VDD.t78 VDD.t31 sg13_lv_pmos ad=0.3808p pd=2.92u as=0 ps=0 w=1.12u l=0.13u
X16 VDD.t74 VDD.t75 VDD.t76 VDD.t31 sg13_lv_pmos ad=0.2128p pd=1.5u as=0 ps=0 w=1.12u l=0.13u
X17 a_6326_2048# a_6126_1274# a_5778_825# VSS.t3 sg13_lv_nmos ad=0.38p pd=2.38u as=0.68p ps=4.68u w=2u l=1u
X18 a_15108_2783# a_12849_3325# VDD.t0 VDD.t0 sg13_lv_pmos ad=79.8f pd=0.8u as=1.03698p ps=6.245u w=0.42u l=0.13u
X19 a_11748_3567# a_11491_3686# a_11910_3763# VSS.t2 sg13_lv_nmos ad=0.1428p pd=1.52u as=37.8f ps=0.6u w=0.42u l=0.13u
X20 VDD.t38 a_12849_3325# a_13566_3293# VDD.t0 sg13_lv_pmos ad=0.1563p pd=1.22u as=0.147p ps=1.54u w=0.42u l=0.13u
X21 VSS.t60 DELAY_VBIASN VSS.t58 VSS.t43 sg13_lv_nmos ad=1.33p pd=7.38u as=0 ps=0 w=7u l=7u
X22 VDD.t66 VDD.t64 VDD.t9 VDD.t0 sg13_lv_pmos ad=0.38p pd=2.38u as=0 ps=0 w=2u l=1u
X23 VSS.t9 a_6126_1274# a_5974_3181# VSS.t0 sg13_lv_nmos ad=0.68p pd=4.68u as=0.38p ps=2.38u w=2u l=1u
X24 VSS.t54 DELAY_VBIASN VSS.t52 VSS.t37 sg13_lv_nmos ad=1.33p pd=7.38u as=0 ps=0 w=7u l=7u
X25 VSS.t7 a_6126_1274# a_5974_3181# VSS.t0 sg13_lv_nmos ad=0.68p pd=4.68u as=0.38p ps=2.38u w=2u l=1u
X26 VSS.t40 DELAY_VBIASN VSS.t42 VSS.t41 sg13_lv_nmos ad=1.33p pd=7.38u as=0 ps=0 w=7u l=7u
X27 VDD.t0 a_11491_3686# a_11748_3567# VDD.t0 sg13_lv_pmos ad=1.10612p pd=6.66u as=79.8f ps=0.8u w=0.42u l=0.13u
X28 VDD.t83 DELAY_VBIASP DELAY_VBIASP VDD.t31 sg13_lv_pmos ad=0.3808p pd=2.92u as=1.0304p ps=4.08u w=1.12u l=0.6u
X29 VSS.t50 DELAY_VBIASN VSS.t48 VSS.t33 sg13_lv_nmos ad=1.33p pd=7.38u as=0 ps=0 w=7u l=7u
X30 a_6326_2048# a_6126_1274# a_5778_825# VSS.t3 sg13_lv_nmos ad=0.38p pd=2.38u as=0.68p ps=4.68u w=2u l=1u
X31 a_6126_1274# a_6326_2048# VDD.t11 VDD.t0 sg13_lv_pmos ad=0.38p pd=2.38u as=0.38p ps=2.38u w=2u l=1u
X32 VSS.t76 a_14009_2542# a_14111_2685# VSS.t129 sg13_lv_nmos ad=1.45407p pd=9.445u as=0.2516p ps=2.16u w=0.74u l=0.13u
X33 VDD.t15 a_6326_2048# a_6326_2048# VDD.t0 sg13_lv_pmos ad=0.38p pd=2.38u as=0.38p ps=2.38u w=2u l=1u
X34 a_13132_2878# a_13106_2815# VDD.t0 VDD.t0 sg13_lv_pmos ad=0.3927p pd=2.99u as=1.10612p ps=6.66u w=1.155u l=0.13u
X35 a_6126_1274# a_6126_1274# VSS.t5 VSS.t3 sg13_lv_nmos ad=0.38p pd=2.38u as=0.68p ps=4.68u w=2u l=1u
X36 a_15108_3567# a_12849_3325# VDD.t0 VDD.t0 sg13_lv_pmos ad=79.8f pd=0.8u as=1.03698p ps=6.245u w=0.42u l=0.13u
X37 VSS.t56 DELAY_VBIASN VSS.t54 VSS.t39 sg13_lv_nmos ad=1.33p pd=7.38u as=0 ps=0 w=7u l=7u
X38 a_15464_1142# a_14851_2640# VDD.t45 VDD.t0 sg13_lv_pmos ad=0.4312p pd=3.01u as=0.2639p ps=1.81u w=1.12u l=0.13u
X39 VDD.t11 a_6326_2048# a_6854_2912# VDD.t0 sg13_lv_pmos ad=0.38p pd=2.38u as=0.38p ps=2.38u w=2u l=1u
X40 VDD.t21 a_11491_3686# a_12158_3325# VDD.t0 sg13_lv_pmos ad=0.2128p pd=1.5u as=0.3864p ps=2.93u w=1.12u l=0.13u
X41 a_13818_3750# a_12849_3325# VSS.t91 VSS.t90 sg13_lv_nmos ad=37.8f pd=0.6u as=0.1701p ps=1.65u w=0.42u l=0.13u
X42 a_14009_3336# DELAY_IN VDD.t0 VDD.t0 sg13_lv_pmos ad=0.4088p pd=2.97u as=1.03698p ps=6.245u w=1.12u l=0.13u
X43 a_5778_825# VSS.t134 VSS.t133 rppd l=32u w=1u
X44 a_9444_1370# a_6854_2912# a_9712_1370# VSS.t15 sg13_lv_nmos ad=0.68p pd=4.68u as=0.38p ps=2.38u w=2u l=1u
X45 a_6126_1274# a_6326_2048# VDD.t4 VDD.t0 sg13_lv_pmos ad=0.38p pd=2.38u as=0.38p ps=2.38u w=2u l=1u
X46 a_13045_3673# a_13019_3289# a_12849_3325# VSS.t63 sg13_lv_nmos ad=0.1406p pd=1.12u as=0.1406p ps=1.12u w=0.74u l=0.13u
X47 a_11693_3448# a_10751_3336# a_11491_3686# VDD.t0 sg13_lv_pmos ad=93.45f pd=0.865u as=0.2048p ps=1.63u w=0.42u l=0.13u
X48 a_13306_3763# a_12355_3325# VDD.t27 VDD.t0 sg13_lv_pmos ad=79.8f pd=0.8u as=0.1428p ps=1.52u w=0.42u l=0.13u
X49 VDD.t0 a_12907_2644# a_12907_2878# VDD.t0 sg13_lv_pmos ad=1.10612p pd=6.66u as=0.2442p ps=2.06u w=0.66u l=0.13u
X50 VDD.t9 a_6326_2048# a_6854_2912# VDD.t0 sg13_lv_pmos ad=0.38p pd=2.38u as=0.38p ps=2.38u w=2u l=1u
X51 a_10232_3329# a_10206_3293# VSS.t19 VSS.t18 sg13_lv_nmos ad=0.2516p pd=2.16u as=0.1626p ps=1.415u w=0.74u l=0.13u
X52 a_13106_2815# a_12907_2878# VSS.t76 VSS.t103 sg13_lv_nmos ad=0.27427p pd=2.28u as=1.45407p ps=9.445u w=0.795u l=0.13u
X53 VSS.t46 DELAY_VBIASN VSS.t45 VSS.t28 sg13_lv_nmos ad=2.38p pd=14.68u as=0 ps=0 w=7u l=7u
X54 a_14851_3686# a_14009_3336# a_13592_3329# VDD.t0 sg13_lv_pmos ad=0.2048p pd=1.63u as=0.34p ps=2.68u w=1u l=0.13u
X55 a_5974_3181# a_6126_1274# VSS.t4 VSS.t0 sg13_lv_nmos ad=0.38p pd=2.38u as=0.68p ps=4.68u w=2u l=1u
X56 VDD.t19 DLL_RESETN a_9946_3763# VDD.t0 sg13_lv_pmos ad=0.36237p pd=2.605u as=79.8f ps=0.8u w=0.42u l=0.13u
X57 a_9946_3763# a_10751_3336# a_10206_3293# VDD.t0 sg13_lv_pmos ad=0.1428p pd=1.52u as=79.8f ps=0.8u w=0.42u l=0.13u
X58 a_13566_3293# a_14009_3336# a_13306_3763# VSS.t77 sg13_lv_nmos ad=79.8f pd=0.8u as=0.1296p ps=1.52u w=0.42u l=0.13u
X59 VSS.t113 a_9444_2048# a_9444_1370# VSS.t112 sg13_lv_nmos ad=0.68p pd=4.68u as=0.38p ps=2.38u w=2u l=1u
X60 a_9712_1370# a_13019_3289# DELAY_VBIASN VSS.t64 sg13_lv_nmos ad=0.136p pd=1.14u as=0.232p ps=2.08u w=0.4u l=0.2u
X61 VSS.t13 a_6126_1274# a_5974_3181# VSS.t0 sg13_lv_nmos ad=0.68p pd=4.68u as=0.38p ps=2.38u w=2u l=1u
X62 a_13818_2576# a_12849_3325# VSS.t93 VSS.t92 sg13_lv_nmos ad=37.8f pd=0.6u as=0.1701p ps=1.65u w=0.42u l=0.13u
X63 a_15304_2063# a_14851_3686# VDD.t35 VDD.t0 sg13_lv_pmos ad=0.4312p pd=3.01u as=0.2639p ps=1.81u w=1.12u l=0.13u
X64 VSS.t11 a_6126_1274# a_5974_3181# VSS.t0 sg13_lv_nmos ad=0.76p pd=4.76u as=0.38p ps=2.38u w=2u l=1u
X65 a_6854_2912# a_6326_2048# VDD.t10 VDD.t0 sg13_lv_pmos ad=0.38p pd=2.38u as=0.38p ps=2.38u w=2u l=1u
X66 VSS.t86 a_12849_3325# a_13400_3763# VSS.t85 sg13_lv_nmos ad=0.1626p pd=1.415u as=60.89999f ps=0.71u w=0.42u l=0.13u
X67 VSS.t115 a_9444_2048# a_9444_1370# VSS.t108 sg13_lv_nmos ad=0.68p pd=4.68u as=0.38p ps=2.38u w=2u l=1u
X68 VSS.t101 a_14851_2640# a_15688_2861# VSS.t100 sg13_lv_nmos ad=0.1406p pd=1.12u as=0.2516p ps=2.16u w=0.74u l=0.13u
X69 a_5778_825# a_6126_1274# a_6326_2048# VSS.t3 sg13_lv_nmos ad=0.68p pd=4.68u as=0.38p ps=2.38u w=2u l=1u
X70 VDD.t12 a_6326_2048# a_6126_1274# VDD.t0 sg13_lv_pmos ad=0.38p pd=2.38u as=0.38p ps=2.38u w=2u l=1u
X71 a_13121_3289# a_15688_3325# VSS.t84 VSS.t97 sg13_lv_nmos ad=0.2516p pd=2.16u as=0.1406p ps=1.12u w=0.74u l=0.13u
X72 a_9444_1370# a_6854_2912# a_9712_1370# VSS.t17 sg13_lv_nmos ad=0.68p pd=4.68u as=0.38p ps=2.38u w=2u l=1u
X73 VDD.t45 a_14851_2640# a_15108_2783# VDD.t0 sg13_lv_pmos ad=0.2639p pd=1.81u as=79.8f ps=0.8u w=0.42u l=0.13u
X74 a_9712_1370# a_6854_2912# a_9444_1370# VSS.t14 sg13_lv_nmos ad=0.38p pd=2.38u as=0.68p ps=4.68u w=2u l=1u
X75 a_6854_3444# a_15304_2063# DELAY_VBIASN VDD.t31 sg13_lv_pmos ad=0.136p pd=1.14u as=0.158p ps=1.245u w=0.4u l=0.2u
X76 a_9444_1370# a_9444_2048# VSS.t114 VSS.t106 sg13_lv_nmos ad=0.38p pd=2.38u as=0.68p ps=4.68u w=2u l=1u
X77 VSS.t95 a_15108_2783# a_14757_2640# VSS.t131 sg13_lv_nmos ad=79.8f pd=0.8u as=0.1428p ps=1.52u w=0.42u l=0.13u
X78 a_6854_2912# a_6326_2048# VDD.t7 VDD.t0 sg13_lv_pmos ad=0.38p pd=2.38u as=0.38p ps=2.38u w=2u l=1u
X79 VSS.t48 DELAY_VBIASN VSS.t46 VSS.t31 sg13_lv_nmos ad=1.33p pd=7.38u as=0 ps=0 w=7u l=7u
X80 VSS.t19 DLL_RESETN a_10040_3763# VSS.t18 sg13_lv_nmos ad=0.1626p pd=1.415u as=60.89999f ps=0.71u w=0.42u l=0.13u
X81 a_9772_3301# a_9746_3263# VDD.t0 VDD.t0 sg13_lv_pmos ad=0.3927p pd=2.99u as=1.10612p ps=6.66u w=1.155u l=0.13u
X82 a_13949_2954# a_13592_2881# VDD.t42 VDD.t0 sg13_lv_pmos ad=63f pd=0.72u as=0.1563p ps=1.22u w=0.42u l=0.13u
X83 VSS.t143 VSS.t141 VSS.t141 VSS.t142 sg13_lv_nmos ad=0.68p pd=4.68u as=0 ps=0 w=2u l=1u
X84 a_13592_2881# a_13566_2786# VSS.t89 VSS.t127 sg13_lv_nmos ad=0.2516p pd=2.16u as=0.1626p ps=1.415u w=0.74u l=0.13u
X85 VSS.t146 VSS.t138 VSS.t138 VSS.t139 sg13_lv_nmos ad=0.68p pd=4.68u as=0 ps=0 w=2u l=1u
X86 a_15108_3567# a_14851_3686# a_15270_3763# VSS.t80 sg13_lv_nmos ad=0.1428p pd=1.52u as=37.8f ps=0.6u w=0.42u l=0.13u
X87 VSS.t76 a_12907_2644# a_12907_2644# VSS.t126 sg13_lv_nmos ad=1.45407p pd=9.445u as=0.111p ps=1.34u w=0.3u l=0.13u
X88 a_9444_1370# a_9444_2048# VSS.t111 VSS.t110 sg13_lv_nmos ad=0.38p pd=2.38u as=0.68p ps=4.68u w=2u l=1u
X89 VDD.t26 a_13019_3289# a_12943_3325# VDD.t0 sg13_lv_pmos ad=0.2128p pd=1.5u as=0.2128p ps=1.5u w=1.12u l=0.13u
X90 a_5974_3181# a_6126_1274# VSS.t12 VSS.t0 sg13_lv_nmos ad=0.38p pd=2.38u as=0.68p ps=4.68u w=2u l=1u
X91 VDD.t17 a_5974_3181# a_5974_3181# VDD.t0 sg13_lv_pmos ad=0.2448p pd=2.08u as=0.2826p ps=2.29u w=0.36u l=2u
X92 a_15053_2878# a_14111_2685# a_14851_2640# VDD.t0 sg13_lv_pmos ad=93.45f pd=0.865u as=0.2048p ps=1.63u w=0.42u l=0.13u
X93 VSS.t62 a_11748_3567# a_11397_3686# VSS.t2 sg13_lv_nmos ad=79.8f pd=0.8u as=0.1428p ps=1.52u w=0.42u l=0.13u
X94 VDD.t69 VDD.t61 VDD.t10 VDD.t0 sg13_lv_pmos ad=0.68p pd=4.68u as=0 ps=0 w=2u l=1u
X95 VSS.t36 DELAY_VBIASN VSS.t38 VSS.t37 sg13_lv_nmos ad=1.33p pd=7.38u as=0 ps=0 w=7u l=7u
X96 a_9712_1370# a_6854_2912# a_9444_1370# VSS.t16 sg13_lv_nmos ad=0.38p pd=2.38u as=0.68p ps=4.68u w=2u l=1u
X97 a_6326_2048# a_6326_2048# VDD.t2 VDD.t0 sg13_lv_pmos ad=0.38p pd=2.38u as=0.38p ps=2.38u w=2u l=1u
X98 a_13592_3329# a_13566_3293# VSS.t86 VSS.t85 sg13_lv_nmos ad=0.2516p pd=2.16u as=0.1626p ps=1.415u w=0.74u l=0.13u
X99 VDD.t35 a_14851_3686# a_15108_3567# VDD.t0 sg13_lv_pmos ad=0.2639p pd=1.81u as=79.8f ps=0.8u w=0.42u l=0.13u
X100 a_13306_2563# a_13132_2878# VDD.t84 VDD.t0 sg13_lv_pmos ad=79.8f pd=0.8u as=0.1428p ps=1.52u w=0.42u l=0.13u
X101 VDD.t7 a_6326_2048# a_6126_1274# VDD.t0 sg13_lv_pmos ad=0.38p pd=2.38u as=0.38p ps=2.38u w=2u l=1u
X102 a_12355_3325# a_12158_3325# VDD.t21 VDD.t0 sg13_lv_pmos ad=0.3808p pd=2.92u as=0.2128p ps=1.5u w=1.12u l=0.13u
X103 VSS.t42 DELAY_VBIASN VSS.t44 VSS.t43 sg13_lv_nmos ad=1.33p pd=7.38u as=0 ps=0 w=7u l=7u
X104 a_14009_2542# DELAY_OUT_LAST VDD.t0 VDD.t0 sg13_lv_pmos ad=0.4088p pd=2.97u as=1.10612p ps=6.66u w=1.12u l=0.13u
X105 VSS.t21 a_11491_3686# a_12158_3325# VSS.t20 sg13_lv_nmos ad=0.1406p pd=1.12u as=0.2516p ps=2.16u w=0.74u l=0.13u
X106 VDD.t37 a_12849_3325# a_13306_3763# VDD.t0 sg13_lv_pmos ad=0.36237p pd=2.605u as=79.8f ps=0.8u w=0.42u l=0.13u
X107 VDD.t2 a_6326_2048# a_6854_3444# VDD.t0 sg13_lv_pmos ad=0.38p pd=2.38u as=0.38p ps=2.38u w=2u l=1u
X108 a_10520_3750# a_10751_3336# a_10206_3293# VSS.t1 sg13_lv_nmos ad=0.2373p pd=1.97u as=79.8f ps=0.8u w=0.42u l=0.13u
X109 VSS.t79 a_14009_3336# a_14111_3336# VSS.t78 sg13_lv_nmos ad=2.39977p pd=15.495u as=0.2516p ps=2.16u w=0.74u l=0.13u
X110 VSS.t157 VSS.t154 VSS.t156 VSS.t155 sg13_lv_nmos ad=0.2516p pd=2.16u as=0 ps=0 w=0.74u l=0.13u
X111 VSS.t151 VSS.t151 VSS.t153 VSS.t152 sg13_lv_nmos ad=0.1406p pd=1.12u as=0 ps=0 w=0.74u l=0.13u
X112 a_13592_2881# a_14111_2685# a_14851_2640# VSS.t137 sg13_lv_nmos ad=0.3473p pd=2.71u as=0.12665p ps=1.145u w=0.74u l=0.13u
X113 a_15053_3448# a_14111_3336# a_14851_3686# VDD.t0 sg13_lv_pmos ad=93.45f pd=0.865u as=0.2048p ps=1.63u w=0.42u l=0.13u
X114 a_13566_2786# a_14009_2542# a_13949_2954# VDD.t0 sg13_lv_pmos ad=79.8f pd=0.8u as=63f ps=0.72u w=0.42u l=0.13u
X115 a_13880_2576# a_14111_2685# a_13566_2786# VSS.t136 sg13_lv_nmos ad=0.2373p pd=1.97u as=79.8f ps=0.8u w=0.42u l=0.13u
X116 VSS.t70 a_10649_3336# a_10751_3336# VSS.t69 sg13_lv_nmos ad=2.39977p pd=15.495u as=0.2516p ps=2.16u w=0.74u l=0.13u
X117 a_13306_3763# a_14111_3336# a_13566_3293# VDD.t0 sg13_lv_pmos ad=0.1428p pd=1.52u as=79.8f ps=0.8u w=0.42u l=0.13u
X118 a_15304_2063# a_14851_3686# VSS.t82 VSS.t81 sg13_lv_nmos ad=0.2849p pd=2.25u as=0.2516p ps=2.16u w=0.74u l=0.13u
X119 a_13019_3289# a_15688_2861# VSS.t101 VSS.t104 sg13_lv_nmos ad=0.2516p pd=2.16u as=0.1406p ps=1.12u w=0.74u l=0.13u
X120 VSS.t52 DELAY_VBIASN VSS.t50 VSS.t35 sg13_lv_nmos ad=1.33p pd=7.38u as=0 ps=0 w=7u l=7u
X121 a_6326_2048# a_5974_3181# a_6126_1274# VSS.t0 sg13_lv_nmos ad=0.38p pd=2.38u as=0.68p ps=4.68u w=2u l=1u
X122 a_14851_2640# a_14009_2542# a_13592_2881# VDD.t0 sg13_lv_pmos ad=0.2048p pd=1.63u as=0.34p ps=2.68u w=1u l=0.13u
X123 DELAY_VBIASN DLL_RESETN VDD.t52 VDD.t31 sg13_lv_pmos ad=0.158p pd=1.245u as=0.272p ps=2.28u w=0.8u l=0.2u
X124 VDD.t74 VDD.t72 VDD.t73 VDD.t31 sg13_lv_pmos ad=0.3808p pd=2.92u as=0 ps=0 w=1.12u l=0.13u
X125 a_6854_3444# a_6326_2048# VDD.t1 VDD.t0 sg13_lv_pmos ad=0.38p pd=2.38u as=0.38p ps=2.38u w=2u l=1u
X126 VDD.t42 a_12849_3325# a_13566_2786# VDD.t0 sg13_lv_pmos ad=0.1563p pd=1.22u as=0.147p ps=1.54u w=0.42u l=0.13u
X127 VSS.t27 DELAY_VBIASN DELAY_VBIASP VSS.t26 sg13_lv_nmos ad=0.2516p pd=2.16u as=0.6808p ps=3.32u w=0.74u l=0.6u
X128 VDD.t79 VDD.t80 VDD.t81 VDD.t31 sg13_lv_pmos ad=0.2128p pd=1.5u as=0 ps=0 w=1.12u l=0.13u
X129 VSS.t32 DELAY_VBIASN VSS.t34 VSS.t33 sg13_lv_nmos ad=1.33p pd=7.38u as=0 ps=0 w=7u l=7u
X130 VDD.t4 a_6326_2048# a_6326_2048# VDD.t0 sg13_lv_pmos ad=0.38p pd=2.38u as=0.38p ps=2.38u w=2u l=1u
X131 a_15270_2563# a_12849_3325# VSS.t95 VSS.t94 sg13_lv_nmos ad=37.8f pd=0.6u as=79.8f ps=0.8u w=0.42u l=0.13u
X132 a_10232_3329# a_10206_3293# VDD.t19 VDD.t0 sg13_lv_pmos ad=0.34p pd=2.68u as=0.36237p ps=2.605u w=1u l=0.13u
X133 a_14851_3686# a_14009_3336# a_14757_3686# VSS.t80 sg13_lv_nmos ad=0.12665p pd=1.145u as=0.1428p ps=1.52u w=0.42u l=0.13u
X134 a_12656_3322# DLL_RESETN VSS.t123 VSS.t122 sg13_lv_nmos ad=0.2516p pd=2.16u as=0.2516p ps=2.16u w=0.74u l=0.13u
X135 a_13400_2563# a_13132_2878# a_13306_2563# VSS.t135 sg13_lv_nmos ad=60.89999f pd=0.71u as=0.1428p ps=1.52u w=0.42u l=0.13u
X136 a_12849_3325# a_12656_3322# VSS.t66 VSS.t65 sg13_lv_nmos ad=0.1406p pd=1.12u as=0.2516p ps=2.16u w=0.74u l=0.13u
X137 a_5974_3181# a_6126_1274# VSS.t8 VSS.t0 sg13_lv_nmos ad=0.38p pd=2.38u as=0.68p ps=4.68u w=2u l=1u
X138 a_11910_3763# DLL_RESETN VSS.t62 VSS.t2 sg13_lv_nmos ad=37.8f pd=0.6u as=79.8f ps=0.8u w=0.42u l=0.13u
X139 a_13880_3750# a_13592_3329# a_13818_3750# VSS.t160 sg13_lv_nmos ad=0.1428p pd=1.52u as=37.8f ps=0.6u w=0.42u l=0.13u
X140 VDD.t0 a_14009_3336# a_14111_3336# VDD.t0 sg13_lv_pmos ad=1.10612p pd=6.66u as=0.3864p ps=2.93u w=1.12u l=0.13u
X141 a_5778_825# a_6126_1274# a_6326_2048# VSS.t3 sg13_lv_nmos ad=0.68p pd=4.68u as=0.38p ps=2.38u w=2u l=1u
X142 VDD.t0 a_11748_3567# a_11693_3448# VDD.t0 sg13_lv_pmos ad=1.10612p pd=6.66u as=93.45f ps=0.865u w=0.42u l=0.13u
X143 a_5974_3181# a_6126_1274# VSS.t10 VSS.t0 sg13_lv_nmos ad=0.38p pd=2.38u as=0.68p ps=4.68u w=2u l=1u
X144 a_11491_3686# a_10649_3336# a_11397_3686# VSS.t2 sg13_lv_nmos ad=0.12665p pd=1.145u as=0.1428p ps=1.52u w=0.42u l=0.13u
X145 a_5778_825# a_6126_1274# a_6326_2048# VSS.t3 sg13_lv_nmos ad=0.68p pd=4.68u as=0.38p ps=2.38u w=2u l=1u
X146 VDD.t63 VDD.t61 VDD.t1 VDD.t0 sg13_lv_pmos ad=0.68p pd=4.68u as=0 ps=0 w=2u l=1u
X147 VDD.t41 a_12849_3325# a_13306_2563# VDD.t0 sg13_lv_pmos ad=0.36237p pd=2.605u as=79.8f ps=0.8u w=0.42u l=0.13u
X148 VDD.t0 a_10649_3336# a_10751_3336# VDD.t0 sg13_lv_pmos ad=1.10612p pd=6.66u as=0.3864p ps=2.93u w=1.12u l=0.13u
X149 VSS.t87 a_15108_3567# a_14757_3686# VSS.t80 sg13_lv_nmos ad=79.8f pd=0.8u as=0.1428p ps=1.52u w=0.42u l=0.13u
X150 a_10520_3750# a_10232_3329# a_10458_3750# VSS.t61 sg13_lv_nmos ad=0.1428p pd=1.52u as=37.8f ps=0.6u w=0.42u l=0.13u
X151 a_6326_2048# a_6126_1274# a_5778_825# VSS.t3 sg13_lv_nmos ad=0.42p pd=2.42u as=0.68p ps=4.68u w=2u l=1u
X152 a_12355_3325# a_12158_3325# VSS.t21 VSS.t71 sg13_lv_nmos ad=0.2516p pd=2.16u as=0.1406p ps=1.12u w=0.74u l=0.13u
X153 a_12656_3322# DLL_RESETN VDD.t54 VDD.t0 sg13_lv_pmos ad=0.3808p pd=2.92u as=0.3808p ps=2.92u w=1.12u l=0.13u
X154 a_13880_2576# a_13592_2881# a_13818_2576# VSS.t132 sg13_lv_nmos ad=0.1428p pd=1.52u as=37.8f ps=0.6u w=0.42u l=0.13u
X155 VSS.t74 a_13121_3289# a_13045_3673# VSS.t73 sg13_lv_nmos ad=0.2516p pd=2.16u as=0.1406p ps=1.12u w=0.74u l=0.13u
X156 VDD.t47 a_14851_2640# a_15688_2861# VDD.t0 sg13_lv_pmos ad=0.2128p pd=1.5u as=0.3864p ps=2.93u w=1.12u l=0.13u
X157 a_13592_2881# a_13566_2786# VDD.t41 VDD.t0 sg13_lv_pmos ad=0.34p pd=2.68u as=0.36237p ps=2.605u w=1u l=0.13u
X158 VSS.t117 a_9444_2048# a_9444_2048# VSS.t112 sg13_lv_nmos ad=0.68p pd=4.68u as=0.38p ps=2.38u w=2u l=1u
X159 a_9444_2048# a_6854_2912# a_6854_2912# VSS.t15 sg13_lv_nmos ad=0.68p pd=4.68u as=0.38p ps=2.38u w=2u l=1u
X160 a_14009_2542# DELAY_OUT_LAST VSS.t76 VSS.t75 sg13_lv_nmos ad=0.2516p pd=2.16u as=1.45407p ps=9.445u w=0.74u l=0.13u
X161 VSS.t38 DELAY_VBIASN VSS.t40 VSS.t39 sg13_lv_nmos ad=1.33p pd=7.38u as=0 ps=0 w=7u l=7u
X162 a_10206_3293# a_10649_3336# a_10589_3372# VDD.t0 sg13_lv_pmos ad=79.8f pd=0.8u as=63f ps=0.72u w=0.42u l=0.13u
X163 a_13880_3750# a_14111_3336# a_13566_3293# VSS.t98 sg13_lv_nmos ad=0.2373p pd=1.97u as=79.8f ps=0.8u w=0.42u l=0.13u
X164 a_10040_3763# a_9772_3301# a_9946_3763# VSS.t22 sg13_lv_nmos ad=60.89999f pd=0.71u as=0.1428p ps=1.52u w=0.42u l=0.13u
X165 a_6326_2048# a_6126_1274# a_5778_825# VSS.t3 sg13_lv_nmos ad=0.38p pd=2.38u as=0.68p ps=4.68u w=2u l=1u
X166 a_15464_1142# a_14851_2640# VSS.t95 VSS.t102 sg13_lv_nmos ad=0.2849p pd=2.25u as=0.2516p ps=2.16u w=0.74u l=0.13u
X167 VSS.t34 DELAY_VBIASN VSS.t36 VSS.t35 sg13_lv_nmos ad=1.33p pd=7.38u as=0 ps=0 w=7u l=7u
X168 a_6126_1274# a_5974_3181# a_6326_2048# VSS.t0 sg13_lv_nmos ad=0.68p pd=4.68u as=0.38p ps=2.38u w=2u l=1u
X169 a_13592_3329# a_13566_3293# VDD.t37 VDD.t0 sg13_lv_pmos ad=0.34p pd=2.68u as=0.36237p ps=2.605u w=1u l=0.13u
X170 a_9444_2048# a_6854_2912# a_6854_2912# VSS.t17 sg13_lv_nmos ad=0.68p pd=4.68u as=0.38p ps=2.38u w=2u l=1u
X171 a_12943_3325# a_12656_3322# a_12849_3325# VDD.t0 sg13_lv_pmos ad=0.2128p pd=1.5u as=0.3808p ps=2.92u w=1.12u l=0.13u
X172 a_5778_825# a_6126_1274# a_6326_2048# VSS.t3 sg13_lv_nmos ad=0.68p pd=4.68u as=0.42p ps=2.42u w=2u l=1u
X173 VDD.t34 a_14851_3686# a_15688_3325# VDD.t0 sg13_lv_pmos ad=0.2128p pd=1.5u as=0.3864p ps=2.93u w=1.12u l=0.13u
X174 VSS.t6 a_6126_1274# a_6126_1274# VSS.t3 sg13_lv_nmos ad=0.68p pd=4.68u as=0.38p ps=2.38u w=2u l=1u
X175 VDD.t0 a_15108_2783# a_15053_2878# VDD.t0 sg13_lv_pmos ad=1.10612p pd=6.66u as=93.45f ps=0.865u w=0.42u l=0.13u
X176 VDD.t0 a_9547_3630# a_9547_3400# VDD.t0 sg13_lv_pmos ad=1.10612p pd=6.66u as=0.2442p ps=2.06u w=0.66u l=0.13u
X177 VDD.t49 a_15464_1142# a_9712_1370# VSS.t105 sg13_lv_nmos ad=0.232p pd=2.08u as=0.136p ps=1.14u w=0.4u l=0.2u
X178 VSS.t109 a_9444_2048# a_9444_2048# VSS.t108 sg13_lv_nmos ad=0.68p pd=4.68u as=0.38p ps=2.38u w=2u l=1u
X179 a_13592_3329# a_14111_3336# a_14851_3686# VSS.t80 sg13_lv_nmos ad=0.3473p pd=2.71u as=0.12665p ps=1.145u w=0.74u l=0.13u
X180 a_9444_2048# a_9444_2048# VSS.t116 VSS.t110 sg13_lv_nmos ad=0.38p pd=2.38u as=0.68p ps=4.68u w=2u l=1u
X181 a_14851_2640# a_14009_2542# a_14757_2640# VSS.t130 sg13_lv_nmos ad=0.12665p pd=1.145u as=0.1428p ps=1.52u w=0.42u l=0.13u
X182 VDD.t5 VDD.t64 VDD.t71 VDD.t0 sg13_lv_pmos ad=0.38p pd=2.38u as=0 ps=0 w=2u l=1u
X183 a_10649_3336# DELAY_IN VSS.t70 VSS.t124 sg13_lv_nmos ad=0.2516p pd=2.16u as=1.9998p ps=12.915u w=0.74u l=0.13u
X184 a_6854_2912# a_6854_2912# a_9444_2048# VSS.t14 sg13_lv_nmos ad=0.38p pd=2.38u as=0.68p ps=4.68u w=2u l=1u
X185 a_9444_2048# a_9444_2048# VSS.t107 VSS.t106 sg13_lv_nmos ad=0.38p pd=2.38u as=0.68p ps=4.68u w=2u l=1u
X186 VSS.t30 DELAY_VBIASN VSS.t29 VSS.t28 sg13_lv_nmos ad=2.38p pd=14.68u as=0 ps=0 w=7u l=7u
X187 a_13949_3372# a_13592_3329# VDD.t38 VDD.t0 sg13_lv_pmos ad=63f pd=0.72u as=0.1563p ps=1.22u w=0.42u l=0.13u
X188 VSS.t143 VSS.t141 VSS.t141 VSS.t142 sg13_lv_nmos ad=0.68p pd=4.68u as=0 ps=0 w=2u l=1u
X189 a_10232_3329# a_10751_3336# a_11491_3686# VSS.t2 sg13_lv_nmos ad=0.3473p pd=2.71u as=0.12665p ps=1.145u w=0.74u l=0.13u
X190 a_12943_3325# a_13121_3289# VDD.t26 VDD.t0 sg13_lv_pmos ad=0.3808p pd=2.92u as=0.2128p ps=1.5u w=1.12u l=0.13u
X191 VDD.t0 a_14009_2542# a_14111_2685# VDD.t0 sg13_lv_pmos ad=1.10612p pd=6.66u as=0.3864p ps=2.93u w=1.12u l=0.13u
X192 VDD.t24 DLL_RESETN a_10206_3293# VDD.t0 sg13_lv_pmos ad=0.1563p pd=1.22u as=0.147p ps=1.54u w=0.42u l=0.13u
X193 VSS.t72 a_13121_3289# a_6854_3444# VDD.t31 sg13_lv_pmos ad=0.232p pd=2.08u as=0.136p ps=1.14u w=0.4u l=0.2u
X194 a_6854_2912# a_6854_2912# a_9444_2048# VSS.t16 sg13_lv_nmos ad=0.38p pd=2.38u as=0.68p ps=4.68u w=2u l=1u
X195 VSS.t138 VSS.t138 VSS.t140 VSS.t139 sg13_lv_nmos ad=0.68p pd=4.68u as=0 ps=0 w=2u l=1u
X196 a_11748_3567# DLL_RESETN VDD.t0 VDD.t0 sg13_lv_pmos ad=79.8f pd=0.8u as=1.10612p ps=6.66u w=0.42u l=0.13u
X197 VSS.t24 a_9547_3630# a_9547_3630# VSS.t23 sg13_lv_nmos ad=2.39977p pd=15.495u as=0.111p ps=1.34u w=0.3u l=0.13u
X198 VSS.t29 DELAY_VBIASN VSS.t32 VSS.t31 sg13_lv_nmos ad=1.33p pd=7.38u as=0 ps=0 w=7u l=7u
X199 a_10589_3372# a_10232_3329# VDD.t24 VDD.t0 sg13_lv_pmos ad=63f pd=0.72u as=0.1563p ps=1.22u w=0.42u l=0.13u
X200 a_15270_3763# a_12849_3325# VSS.t87 VSS.t80 sg13_lv_nmos ad=37.8f pd=0.6u as=79.8f ps=0.8u w=0.42u l=0.13u
X201 a_6326_2048# a_6326_2048# VDD.t12 VDD.t0 sg13_lv_pmos ad=0.38p pd=2.38u as=0.38p ps=2.38u w=2u l=1u
X202 VDD.t0 a_15108_3567# a_15053_3448# VDD.t0 sg13_lv_pmos ad=1.10612p pd=6.66u as=93.45f ps=0.865u w=0.42u l=0.13u
X203 VDD.t5 a_6326_2048# a_6854_3444# VDD.t0 sg13_lv_pmos ad=0.38p pd=2.38u as=0.38p ps=2.38u w=2u l=1u
X204 a_10206_3293# a_10649_3336# a_9946_3763# VSS.t68 sg13_lv_nmos ad=79.8f pd=0.8u as=0.1296p ps=1.52u w=0.42u l=0.13u
X205 VSS.t89 a_12849_3325# a_13400_2563# VSS.t88 sg13_lv_nmos ad=0.1626p pd=1.415u as=60.89999f ps=0.71u w=0.42u l=0.13u
X206 a_13400_3763# a_12355_3325# a_13306_3763# VSS.t67 sg13_lv_nmos ad=60.89999f pd=0.71u as=0.1428p ps=1.52u w=0.42u l=0.13u
X207 a_13019_3289# a_15688_2861# VDD.t47 VDD.t0 sg13_lv_pmos ad=0.3808p pd=2.92u as=0.2128p ps=1.5u w=1.12u l=0.13u
X208 VSS.t151 VSS.t149 VSS.t149 VSS.t150 sg13_lv_nmos ad=0.2516p pd=2.16u as=0 ps=0 w=0.74u l=0.13u
C0 a_13306_2563# VDD 0.80534f
C1 DELAY_IN a_14111_3336# 0.02263f
C2 a_15108_2783# VDD 0.14081f
C3 a_13566_2786# VDD 0.09979f
C4 a_13132_2878# VDD 0.25347f
C5 a_9444_1370# a_9712_1370# 0.80775f
C6 a_12849_3325# a_12355_3325# 0.07687f
C7 a_9946_3763# a_10751_3336# 0.097f
C8 DELAY_OUT_LAST a_12849_3325# 0.01467f
C9 a_12907_2644# a_12907_2878# 0.1117f
C10 a_9946_3763# DLL_RESETN 0.09997f
C11 a_10649_3336# VDD 0.24968f
C12 a_14851_3686# a_15688_3325# 0.08776f
C13 a_13121_3289# a_12355_3325# 0.05795f
C14 a_9946_3763# a_10520_3750# 0.31978f
C15 a_15304_2063# a_14851_3686# 0.12139f
C16 DELAY_OUT_LAST a_13121_3289# 0.04358f
C17 a_9772_3301# DLL_RESETN 0.06592f
C18 DELAY_IN a_12355_3325# 1.0042f
C19 a_14111_2685# a_12849_3325# 0.42064f
C20 DELAY_IN a_11491_3686# 0.01827f
C21 DLL_RESETN a_12355_3325# 0.04879f
C22 a_10751_3336# a_11491_3686# 0.26905f
C23 a_6854_3444# VDD 2.86504f
C24 DLL_RESETN a_11491_3686# 0.14622f
C25 a_9712_1370# a_5974_3181# 0.01152f
C26 a_9444_2048# a_5864_825# 0.04218f
C27 a_13592_2881# DELAY_OUT_LAST 0.08062f
C28 a_6854_3444# a_6326_2048# 1.17368f
C29 a_15464_1142# DELAY_OUT_LAST 0.01937f
C30 a_15688_2861# DELAY_OUT_LAST 0.01699f
C31 a_14009_3336# a_14757_3686# 0.01058f
C32 a_10206_3293# a_10232_3329# 0.36952f
C33 a_15688_3325# a_13019_3289# 0.0195f
C34 a_15304_2063# a_13019_3289# 0.07025f
C35 a_5778_825# a_5974_3181# 2.87939f
C36 a_13592_2881# a_14111_2685# 0.34114f
C37 a_13592_3329# a_14757_3686# 0.43239f
C38 DLL_RESETN a_12907_2878# 0.04234f
C39 a_14851_2640# VDD 0.27539f
C40 a_12849_3325# a_13306_3763# 0.12097f
C41 VDD a_15688_3325# 0.31235f
C42 a_15304_2063# VDD 0.77714f
C43 a_14009_3336# a_13880_3750# 0.01562f
C44 a_9712_1370# a_13019_3289# 0.03275f
C45 a_13121_3289# a_13306_3763# 0.01008f
C46 a_13592_3329# a_13880_3750# 0.43707f
C47 DELAY_IN a_13306_3763# 0.05059f
C48 a_13106_2815# a_12907_2878# 0.14994f
C49 a_10232_3329# VDD 0.09601f
C50 DELAY_VBIASP a_6854_3444# 0.01478f
C51 a_15304_2063# a_15108_3567# 0.17528f
C52 a_9712_1370# VDD 0.21208f
C53 a_14009_2542# a_12849_3325# 0.03463f
C54 a_11491_3686# a_11397_3686# 0.28931f
C55 DELAY_IN a_11748_3567# 0.0148f
C56 DLL_RESETN DELAY_VBIASN 0.12904f
C57 a_10751_3336# a_11748_3567# 0.03061f
C58 a_9712_1370# a_6326_2048# 0.04737f
C59 DLL_RESETN a_11748_3567# 0.11133f
C60 a_9444_2048# a_9712_1370# 0.57573f
C61 a_13880_3750# a_14111_3336# 0.12701f
C62 a_9444_2048# a_9444_1370# 2.19613f
C63 a_15108_2783# DELAY_OUT_LAST 0.01399f
C64 a_9946_3763# a_10649_3336# 0.02432f
C65 a_14851_3686# a_13019_3289# 0.01651f
C66 a_5778_825# a_6326_2048# 0.87631f
C67 a_9444_2048# a_5778_825# 0.19787f
C68 a_13306_2563# a_14111_2685# 0.097f
C69 a_13592_2881# a_14009_2542# 0.3749f
C70 DLL_RESETN a_12907_2644# 0.02177f
C71 a_14111_2685# a_15108_2783# 0.03012f
C72 VDD a_5974_3181# 1.02019f
C73 a_13880_2576# VDD 0.03137f
C74 VDD a_14851_3686# 0.25849f
C75 a_12943_3325# a_13019_3289# 0.03346f
C76 a_13121_3289# a_12849_3325# 0.54766f
C77 DELAY_VBIASP a_9712_1370# 0.11086f
C78 a_6326_2048# a_5974_3181# 0.32939f
C79 DELAY_IN a_12849_3325# 0.25718f
C80 a_13106_2815# a_12907_2644# 0.02437f
C81 a_13132_2878# a_12907_2878# 0.02416f
C82 a_10206_3293# VDD 0.11162f
C83 a_15108_3567# a_14851_3686# 0.29858f
C84 a_15304_2063# a_14111_3336# 0.01811f
C85 DELAY_IN a_13121_3289# 1.40135f
C86 DLL_RESETN a_12849_3325# 0.34367f
C87 VDD a_13566_3293# 0.09483f
C88 a_12943_3325# VDD 0.3011f
C89 DLL_RESETN a_6854_2912# 0.0112f
C90 DLL_RESETN a_13121_3289# 0.04337f
C91 a_13592_2881# a_12849_3325# 0.38072f
C92 DELAY_IN a_10751_3336# 0.01931f
C93 DLL_RESETN DELAY_IN 2.75059f
C94 VDD a_13019_3289# 0.48803f
C95 DLL_RESETN a_10751_3336# 0.45018f
C96 a_13592_2881# DELAY_IN 0.03445f
C97 a_10520_3750# a_10751_3336# 0.12701f
C98 a_15464_1142# a_13121_3289# 0.31727f
C99 a_14851_2640# DELAY_OUT_LAST 0.02109f
C100 a_9946_3763# a_10232_3329# 0.41329f
C101 DELAY_OUT_LAST a_15304_2063# 0.05183f
C102 a_13306_2563# a_14009_2542# 0.02454f
C103 a_13592_3329# a_14851_3686# 0.01529f
C104 DLL_RESETN a_13106_2815# 0.01263f
C105 a_13880_3750# a_13306_3763# 0.31978f
C106 a_14757_2640# a_14009_2542# 0.01058f
C107 a_14111_2685# a_14851_2640# 0.26905f
C108 a_13566_2786# a_14009_2542# 0.02242f
C109 VDD a_6326_2048# 8.12264f
C110 a_9444_2048# VDD 0.01023f
C111 a_14111_2685# a_15304_2063# 0.01761f
C112 VDD a_15108_3567# 0.13564f
C113 a_14009_3336# a_13566_3293# 0.02242f
C114 a_15464_1142# a_15688_2861# 0.19544f
C115 a_10232_3329# a_11491_3686# 0.01529f
C116 a_13592_3329# a_13566_3293# 0.36952f
C117 a_9444_2048# a_6326_2048# 0.01269f
C118 a_6126_1274# a_6854_2912# 0.19098f
C119 a_12656_3322# a_13019_3289# 0.04193f
C120 DELAY_VBIASP a_13019_3289# 0.02377f
C121 a_14111_3336# a_14851_3686# 0.26905f
C122 DELAY_VBIASN a_6854_3444# 0.15808f
C123 a_13592_3329# a_13019_3289# 0.04178f
C124 a_13306_2563# a_12849_3325# 0.10675f
C125 a_9746_3263# VDD 0.0996f
C126 a_14009_3336# VDD 0.25176f
C127 VDD a_12656_3322# 0.27069f
C128 DELAY_VBIASP VDD 1.07142f
C129 a_15108_2783# a_12849_3325# 0.10521f
C130 a_13566_2786# a_12849_3325# 0.26312f
C131 VDD a_12158_3325# 0.39251f
C132 a_13592_3329# VDD 0.07868f
C133 a_13306_2563# DELAY_IN 0.06166f
C134 a_15108_2783# a_13121_3289# 0.05714f
C135 a_13132_2878# a_12849_3325# 0.06256f
C136 a_13566_2786# DELAY_IN 0.01093f
C137 a_9946_3763# a_10206_3293# 0.75507f
C138 DELAY_VBIASN a_15304_2063# 0.07802f
C139 a_13306_2563# a_13592_2881# 0.41329f
C140 a_13132_2878# DELAY_IN 0.02025f
C141 a_13566_2786# a_13592_2881# 0.36952f
C142 a_13880_2576# a_14111_2685# 0.12701f
C143 a_13132_2878# DLL_RESETN 0.01689f
C144 a_14757_2640# a_13592_2881# 0.43239f
C145 a_10649_3336# DELAY_IN 0.25484f
C146 VDD a_14111_3336# 0.22908f
C147 a_6854_2912# a_5864_825# 0.03661f
C148 a_15464_1142# a_15108_2783# 0.12158f
C149 a_10649_3336# a_10751_3336# 0.47795f
C150 a_13045_3673# a_13019_3289# 0.01249f
C151 a_10649_3336# DLL_RESETN 0.05713f
C152 DELAY_IN a_5864_825# 0.01659f
C153 DELAY_VBIASN a_9712_1370# 0.22281f
C154 a_10649_3336# a_10520_3750# 0.01562f
C155 a_6854_3444# a_6854_2912# 0.27156f
C156 a_6854_3444# a_13121_3289# 0.07016f
C157 a_12355_3325# a_13019_3289# 0.3846f
C158 DLL_RESETN a_5864_825# 0.01688f
C159 DELAY_OUT_LAST a_13019_3289# 0.07707f
C160 a_13132_2878# a_13106_2815# 0.1657f
C161 a_9946_3763# VDD 0.81635f
C162 a_14111_3336# a_15108_3567# 0.03093f
C163 a_13592_3329# a_14009_3336# 0.37583f
C164 DELAY_IN a_6854_3444# 0.04054f
C165 a_9772_3301# VDD 0.26362f
C166 DLL_RESETN a_6854_3444# 0.28237f
C167 a_9547_3630# VDD 0.09227f
C168 VDD a_12355_3325# 0.40041f
C169 DELAY_OUT_LAST VDD 0.30789f
C170 a_14851_2640# a_12849_3325# 0.13376f
C171 VDD a_11491_3686# 0.18135f
C172 a_15304_2063# a_12849_3325# 0.0606f
C173 a_14851_2640# a_13121_3289# 0.02878f
C174 a_15688_3325# a_13121_3289# 0.17255f
C175 a_14009_3336# a_14111_3336# 0.47795f
C176 a_15304_2063# a_13121_3289# 0.40633f
C177 a_14111_2685# VDD 0.35469f
C178 DELAY_IN a_15304_2063# 0.01066f
C179 a_13592_3329# a_14111_3336# 0.34102f
C180 a_13306_3763# a_13566_3293# 0.75507f
C181 DLL_RESETN a_15304_2063# 0.03137f
C182 a_12907_2878# VDD 0.08229f
C183 a_13566_2786# a_13306_2563# 0.75507f
C184 a_13592_2881# a_14851_2640# 0.01529f
C185 a_13880_2576# a_14009_2542# 0.01562f
C186 a_10649_3336# a_11397_3686# 0.01058f
C187 a_10232_3329# DELAY_IN 0.08086f
C188 a_9772_3301# a_9746_3263# 0.1657f
C189 a_13592_2881# a_15304_2063# 0.01817f
C190 a_6126_1274# a_5864_825# 0.12761f
C191 a_6854_2912# a_9712_1370# 0.67825f
C192 a_13132_2878# a_13306_2563# 0.27179f
C193 a_15464_1142# a_14851_2640# 0.04597f
C194 a_14851_2640# a_15688_2861# 0.08776f
C195 a_10232_3329# a_10751_3336# 0.34102f
C196 a_9547_3630# a_9746_3263# 0.02437f
C197 a_10232_3329# DLL_RESETN 0.39088f
C198 DELAY_IN a_9712_1370# 0.04752f
C199 a_6854_2912# a_9444_1370# 0.84817f
C200 a_10232_3329# a_10520_3750# 0.43707f
C201 a_6854_3444# a_6126_1274# 0.11771f
C202 a_12355_3325# a_12656_3322# 0.03277f
C203 DLL_RESETN a_9712_1370# 0.39633f
C204 DELAY_VBIASN a_13019_3289# 1.23663f
C205 a_6854_2912# a_5778_825# 0.02497f
C206 DELAY_OUT_LAST DELAY_VBIASP 1.05783f
C207 a_12158_3325# a_12355_3325# 0.12454f
C208 VDD a_13306_3763# 0.78103f
C209 DLL_RESETN a_9444_1370# 0.02134f
C210 a_11491_3686# a_12158_3325# 0.0894f
C211 a_9547_3400# VDD 0.16041f
C212 a_15464_1142# a_9712_1370# 0.01237f
C213 DELAY_VBIASN VDD 0.23736f
C214 VDD a_11748_3567# 0.1754f
C215 a_14851_3686# a_12849_3325# 0.13392f
C216 a_6854_2912# a_5974_3181# 0.01501f
C217 a_14851_3686# a_13121_3289# 0.03404f
C218 a_14009_2542# VDD 0.33745f
C219 a_9772_3301# a_9946_3763# 0.27179f
C220 a_12849_3325# a_13566_3293# 0.27346f
C221 a_12943_3325# a_12849_3325# 0.16706f
C222 a_12907_2644# VDD 0.0643f
C223 a_13880_2576# a_13592_2881# 0.43707f
C224 a_10232_3329# a_11397_3686# 0.43239f
C225 a_13121_3289# a_13566_3293# 0.01158f
C226 a_12943_3325# a_13121_3289# 0.09118f
C227 a_14009_3336# a_13306_3763# 0.02432f
C228 a_12849_3325# a_13019_3289# 0.12838f
C229 a_14757_2640# a_14851_2640# 0.28931f
C230 a_14851_2640# a_15108_2783# 0.29858f
C231 DELAY_IN a_13566_3293# 0.01538f
C232 a_9547_3400# a_9746_3263# 0.14994f
C233 a_10206_3293# DLL_RESETN 0.27343f
C234 a_14757_2640# a_15304_2063# 0.02225f
C235 a_15108_2783# a_15304_2063# 0.01986f
C236 a_13592_3329# a_13306_3763# 0.41329f
C237 a_6126_1274# a_9444_1370# 0.25721f
C238 a_13121_3289# a_13019_3289# 0.54957f
C239 DLL_RESETN a_12943_3325# 0.03616f
C240 DELAY_IN a_13019_3289# 0.35409f
C241 a_6126_1274# a_5778_825# 1.6143f
C242 DELAY_VBIASN DELAY_VBIASP 5.10528f
C243 VDD a_12849_3325# 2.97867f
C244 DLL_RESETN a_13019_3289# 0.01429f
C245 a_11748_3567# a_12158_3325# 0.10373f
C246 a_6854_2912# VDD 1.80901f
C247 VDD a_13121_3289# 1.4119f
C248 a_14111_2685# DELAY_OUT_LAST 0.02024f
C249 DELAY_IN VDD 0.38958f
C250 a_14111_3336# a_13306_3763# 0.097f
C251 a_15464_1142# a_13019_3289# 0.59356f
C252 a_15108_3567# a_12849_3325# 0.10225f
C253 a_15688_2861# a_13019_3289# 0.12862f
C254 VDD a_10751_3336# 0.23078f
C255 a_6126_1274# a_5974_3181# 1.74557f
C256 a_6854_2912# a_6326_2048# 1.24805f
C257 a_10232_3329# a_10649_3336# 0.37583f
C258 DLL_RESETN VDD 2.81183f
C259 a_9444_2048# a_6854_2912# 1.24089f
C260 a_15108_3567# a_13121_3289# 0.03701f
C261 a_15304_2063# a_6854_3444# 0.07441f
C262 a_13592_2881# VDD 0.13283f
C263 a_9444_2048# DLL_RESETN 0.01688f
C264 a_15688_2861# VDD 0.31892f
C265 a_15464_1142# VDD 0.53655f
C266 a_13106_2815# VDD 0.10008f
C267 a_13880_2576# a_13306_2563# 0.31978f
C268 a_9772_3301# a_9547_3400# 0.02416f
C269 a_6854_3444# a_9712_1370# 0.03156f
C270 a_14009_3336# a_12849_3325# 0.03525f
C271 a_13306_3763# a_12355_3325# 0.26489f
C272 a_12849_3325# a_12656_3322# 0.33075f
C273 a_9547_3400# a_9547_3630# 0.1117f
C274 a_5778_825# a_5864_825# 0.07051f
C275 a_13592_3329# a_12849_3325# 0.38817f
C276 a_14851_2640# a_15304_2063# 0.05156f
C277 a_14009_3336# a_13121_3289# 0.01604f
C278 a_14851_3686# a_14757_3686# 0.28931f
C279 a_15304_2063# a_15688_3325# 0.19136f
C280 DELAY_IN a_14009_3336# 0.25847f
C281 DELAY_IN a_12656_3322# 0.01215f
C282 a_13592_3329# a_13121_3289# 0.01445f
C283 DELAY_VBIASN DELAY_OUT_LAST 3.13021f
C284 DELAY_IN a_12158_3325# 0.01309f
C285 DELAY_IN a_13592_3329# 0.11539f
C286 DLL_RESETN a_12656_3322# 0.11782f
C287 DLL_RESETN DELAY_VBIASP 0.05659f
C288 a_11748_3567# a_11491_3686# 0.34468f
C289 a_6126_1274# VDD 0.9531f
C290 DLL_RESETN a_12158_3325# 0.02442f
C291 a_5864_825# a_5974_3181# 0.01697f
C292 a_14009_2542# DELAY_OUT_LAST 0.25594f
C293 a_14111_3336# a_12849_3325# 0.42174f
C294 a_6854_3444# a_5974_3181# 0.02579f
C295 a_6126_1274# a_6326_2048# 2.74106f
C296 a_10206_3293# a_10649_3336# 0.02242f
C297 a_9444_2048# a_6126_1274# 0.03029f
C298 a_14111_3336# a_13121_3289# 0.0235f
C299 a_14009_2542# a_14111_2685# 0.47622f
R0 VDD.n17 VDD.t24 17.3693
R1 VDD.n5 VDD.t42 17.3693
R2 VDD.n5 VDD.t38 17.3693
R3 VDD VDD.t22 17.3517
R4 VDD.n5 VDD.t84 17.3517
R5 VDD.n4 VDD.t27 17.3517
R6 VDD.n5 VDD.t26 17.2247
R7 VDD VDD.t19 17.0005
R8 VDD.n5 VDD.t41 17.0005
R9 VDD.n4 VDD.t37 17.0005
R10 VDD.t0 VDD.n14 0.511305
R11 VDD.t0 VDD.n7 1.2524
R12 VDD.t0 VDD.n2 0.266625
R13 VDD.t31 VDD.t72 15.0005
R14 VDD.t31 VDD.t77 15.0005
R15 VDD.t31 VDD.t80 15.0005
R16 VDD.n9 VDD.n105 12.3334
R17 VDD.n105 VDD.n104 9.51387
R18 VDD.n9 VDD.t17 9.02285
R19 VDD.n19 VDD 4.46488
R20 VDD.n30 VDD 4.46488
R21 VDD.n100 VDD.n30 0.073243
R22 VDD.n47 VDD.n29 0.073243
R23 VDD.n29 VDD.n17 4.46488
R24 VDD.n17 VDD.n28 4.46488
R25 VDD.n95 VDD.n28 0.073243
R26 VDD.n17 VDD.n20 4.46488
R27 VDD.n91 VDD.n20 0.073243
R28 VDD.n27 VDD.n35 0.073243
R29 VDD.n27 VDD.n17 4.46488
R30 VDD.n17 VDD.n26 4.46488
R31 VDD.n86 VDD.n26 0.073243
R32 VDD.n25 VDD.n37 0.073243
R33 VDD.n25 VDD.n5 4.46488
R34 VDD.n5 VDD.n24 4.46488
R35 VDD.n81 VDD.n24 0.073243
R36 VDD.n23 VDD.n39 0.073243
R37 VDD.n23 VDD.n5 4.46488
R38 VDD.n5 VDD.n22 4.46488
R39 VDD.n76 VDD.n22 0.073243
R40 VDD.n21 VDD.n41 0.073243
R41 VDD.n21 VDD.n5 4.46488
R42 VDD.n53 VDD.n16 0.073243
R43 VDD.n16 VDD.n5 4.46488
R44 VDD.n31 VDD.n5 4.46488
R45 VDD.n69 VDD.n31 0.073243
R46 VDD.n55 VDD.n5 9.0005
R47 VDD.n33 VDD.n5 4.46488
R48 VDD.n33 VDD.n42 0.073243
R49 VDD.n64 VDD.n18 0.073243
R50 VDD.n44 VDD.n5 4.46488
R51 VDD.n60 VDD.n44 0.073243
R52 VDD.n59 VDD.n5 9.0005
R53 VDD.n5 VDD.n18 4.46488
R54 VDD.n103 VDD.n102 9.0005
R55 VDD.n101 VDD.n46 9.0005
R56 VDD.n100 VDD.n99 9.0005
R57 VDD.n98 VDD.n47 9.0005
R58 VDD.n97 VDD.n96 9.0005
R59 VDD.n34 VDD.n48 9.0005
R60 VDD.n95 VDD.n94 9.0005
R61 VDD.n93 VDD.n45 9.0005
R62 VDD.n92 VDD.n91 9.0005
R63 VDD.n35 VDD.n49 9.0005
R64 VDD.n90 VDD.n89 9.0005
R65 VDD.n88 VDD.n36 9.0005
R66 VDD.n87 VDD.n86 9.0005
R67 VDD.n37 VDD.n50 9.0005
R68 VDD.n85 VDD.n84 9.0005
R69 VDD.n83 VDD.n38 9.0005
R70 VDD.n82 VDD.n81 9.0005
R71 VDD.n39 VDD.n51 9.0005
R72 VDD.n80 VDD.n79 9.0005
R73 VDD.n78 VDD.n40 9.0005
R74 VDD.n77 VDD.n76 9.0005
R75 VDD.n41 VDD.n52 9.0005
R76 VDD.n75 VDD.n74 9.0005
R77 VDD.n73 VDD.n53 9.0005
R78 VDD.n72 VDD.n71 9.0005
R79 VDD.n70 VDD.n54 9.0005
R80 VDD.n69 VDD.n68 9.0005
R81 VDD.n67 VDD.n55 9.0005
R82 VDD.n66 VDD.n65 9.0005
R83 VDD.n42 VDD.n56 9.0005
R84 VDD.n64 VDD.n63 9.0005
R85 VDD.n62 VDD.n18 9.07324
R86 VDD.n60 VDD.n57 9.0005
R87 VDD.n59 VDD.n58 9.0005
R88 VDD.t31 VDD.t52 8.95516
R89 VDD.t0 VDD.t45 8.76054
R90 VDD.t0 VDD.t35 8.76054
R91 VDD.n2 VDD.n0 0.845873
R92 VDD.n15 VDD 0.341592
R93 VDD.t0 VDD.n15 0.536971
R94 VDD.n5 VDD.t21 5.9886
R95 VDD.t0 VDD.t47 5.97675
R96 VDD.t0 VDD.t34 5.97675
R97 VDD.n5 VDD.t54 5.96478
R98 VDD.t31 VDD.t73 5.73686
R99 VDD.t31 VDD.t78 5.77256
R100 VDD.t31 VDD.t76 5.60347
R101 VDD.t31 VDD.t74 5.59179
R102 VDD.t31 VDD.t79 5.59179
R103 VDD VDD.t64 4.9462
R104 VDD.n109 VDD.t61 4.9462
R105 VDD VDD.n32 4.48298
R106 VDD.n105 VDD 3.16098
R107 VDD VDD.t66 2.837
R108 VDD.n1 VDD.t5 2.83002
R109 VDD.n10 VDD.t9 2.6992
R110 VDD.n107 VDD.t69 2.6992
R111 VDD.n11 VDD.t10 2.6992
R112 VDD.n12 VDD.t1 2.6992
R113 VDD.n106 VDD.t63 2.6992
R114 VDD.n0 VDD.t11 2.6992
R115 VDD.n13 VDD.t2 2.6992
R116 VDD.n111 VDD.t12 2.6992
R117 VDD.n6 VDD.t4 2.6992
R118 VDD.n43 VDD.t15 2.6992
R119 VDD.n112 VDD.t7 2.6992
R120 VDD.t49 VDD.t31 18.2648
R121 VDD.n13 VDD.n0 1.11007
R122 VDD.n6 VDD.n111 1.11007
R123 VDD.n43 VDD.n112 1.11007
R124 VDD.n14 VDD.n104 0.814398
R125 VDD.n107 VDD.n0 0.570274
R126 VDD.n111 VDD.n0 0.570274
R127 VDD.n6 VDD.n10 0.569912
R128 VDD.n9 VDD.n12 0.569912
R129 VDD.n106 VDD.n9 0.569912
R130 VDD.n9 VDD.n13 0.569912
R131 VDD.t71 VDD 2.85337
R132 VDD.n10 VDD 0.492005
R133 VDD.n11 VDD.n110 0.492005
R134 VDD.n110 VDD.n12 0.492005
R135 VDD.n108 VDD.n106 0.492005
R136 VDD VDD.n1 0.249499
R137 VDD.n108 VDD.n107 0.491643
R138 VDD.t31 VDD.t83 5.77224
R139 VDD.n62 VDD.n61 0.437466
R140 VDD.n110 VDD.n109 0.253639
R141 VDD.n109 VDD.n108 0.253298
R142 VDD.n3 VDD.n7 0.840013
R143 VDD.n6 VDD.n9 0.818625
R144 VDD.n58 VDD.n8 2.6712
R145 VDD.n104 VDD.n2 1.03583
R146 VDD.n102 VDD.n19 0.073243
R147 VDD.n102 VDD.n101 0.146155
R148 VDD.n101 VDD.n30 0.073243
R149 VDD.n100 VDD.n47 0.146155
R150 VDD.n96 VDD.n29 0.073243
R151 VDD.n96 VDD.n34 0.146155
R152 VDD.n34 VDD.n28 0.073243
R153 VDD.n95 VDD.n45 0.146155
R154 VDD.n20 VDD.n45 0.073243
R155 VDD.n91 VDD.n35 0.146155
R156 VDD.n27 VDD.n90 0.073243
R157 VDD.n90 VDD.n36 0.146155
R158 VDD.n26 VDD.n36 0.073243
R159 VDD.n86 VDD.n37 0.146155
R160 VDD.n25 VDD.n85 0.073243
R161 VDD.n85 VDD.n38 0.146155
R162 VDD.n24 VDD.n38 0.073243
R163 VDD.n81 VDD.n39 0.146155
R164 VDD.n23 VDD.n80 0.073243
R165 VDD.n80 VDD.n40 0.146155
R166 VDD.n22 VDD.n40 0.073243
R167 VDD.n76 VDD.n41 0.146155
R168 VDD.n21 VDD.n75 0.073243
R169 VDD.n75 VDD.n53 0.146155
R170 VDD.n71 VDD.n16 0.073243
R171 VDD.n71 VDD.n70 0.146155
R172 VDD.n70 VDD.n31 0.073243
R173 VDD.n69 VDD.n55 0.146155
R174 VDD.n65 VDD.n55 0.146155
R175 VDD.n65 VDD.n33 0.073243
R176 VDD.n42 VDD.n64 0.146155
R177 VDD.n32 VDD.n103 3.16277
R178 VDD.n103 VDD.n46 0.146155
R179 VDD.n99 VDD.n46 0.146155
R180 VDD.n99 VDD.n98 0.146155
R181 VDD.n98 VDD.n97 0.146155
R182 VDD.n97 VDD.n48 0.146155
R183 VDD.n94 VDD.n48 0.146155
R184 VDD.n94 VDD.n93 0.146155
R185 VDD.n93 VDD.n92 0.146155
R186 VDD.n92 VDD.n49 0.146155
R187 VDD.n89 VDD.n49 0.146155
R188 VDD.n89 VDD.n88 0.146155
R189 VDD.n88 VDD.n87 0.146155
R190 VDD.n87 VDD.n50 0.146155
R191 VDD.n84 VDD.n50 0.146155
R192 VDD.n84 VDD.n83 0.146155
R193 VDD.n83 VDD.n82 0.146155
R194 VDD.n82 VDD.n51 0.146155
R195 VDD.n79 VDD.n51 0.146155
R196 VDD.n79 VDD.n78 0.146155
R197 VDD.n78 VDD.n77 0.146155
R198 VDD.n77 VDD.n52 0.146155
R199 VDD.n74 VDD.n52 0.146155
R200 VDD.n74 VDD.n73 0.146155
R201 VDD.n73 VDD.n72 0.146155
R202 VDD.n72 VDD.n54 0.146155
R203 VDD.n68 VDD.n54 0.146155
R204 VDD.n68 VDD.n67 0.146155
R205 VDD.n67 VDD.n66 0.146155
R206 VDD.n66 VDD.n56 0.146155
R207 VDD.n63 VDD.n56 0.146155
R208 VDD.n63 VDD.n62 0.146155
R209 VDD.n61 VDD.n57 0.146155
R210 VDD.n58 VDD.n57 0.146155
R211 VDD.n61 VDD.n44 9.07324
R212 VDD.n32 VDD.n19 0.215146
R213 VDD.n8 VDD.t0 0.93088
R214 VDD.n3 VDD.n0 0.156876
R215 VDD.n60 VDD.n59 0.146155
R216 VDD.t31 VDD.t75 15.0334
R217 VDD.n17 VDD.n15 0.179658
R218 VDD.t81 VDD.t31 5.77491
R219 VDD.n8 VDD.t31 3.35585
R220 VDD.n5 VDD.n4 1.48183
R221 VDD.n0 VDD.n11 1.37713
R222 VDD.n112 VDD.n6 1.31982
R223 VDD.t0 VDD.n5 1.20473
R224 VDD.n3 VDD.n43 0.601902
R225 VDD.n1 VDD.n7 0.289284
R226 VDD VDD.n6 1.04469
R227 VDD.t0 VDD.n6 1.0375
R228 VDD.n9 VDD.n14 1.02671
R229 VSS.n1209 VSS.t139 119321
R230 VSS.n340 VSS.n339 22369.4
R231 VSS.n1188 VSS.n1014 1028.14
R232 VSS.n1204 VSS.n1182 1028.14
R233 VSS.t102 VSS.n246 849.322
R234 VSS.n1270 VSS.n388 572.005
R235 VSS.t3 VSS.t0 571.348
R236 VSS.n1194 VSS.t122 566.691
R237 VSS.n1193 VSS.t65 560.899
R238 VSS.n1273 VSS.t81 550.193
R239 VSS.n248 VSS.t137 539.653
R240 VSS.t63 VSS.n1191 532.819
R241 VSS.t129 VSS.n240 522.509
R242 VSS.n1207 VSS.t25 521.236
R243 VSS.t73 VSS.n1190 514.091
R244 VSS.n1200 VSS.t69 504.839
R245 VSS.n1022 VSS.t78 504.839
R246 VSS.t130 VSS.n242 491.87
R247 VSS.n1195 VSS.t71 474.904
R248 VSS.n247 VSS.t131 470.019
R249 VSS.n1196 VSS.t20 456.175
R250 VSS.n1206 VSS.t22 427.695
R251 VSS.n1190 VSS.t67 427.219
R252 VSS.n1274 VSS.n1269 412.791
R253 VSS.n1198 VSS.n1197 412.791
R254 VSS.n1275 VSS.n1274 404.192
R255 VSS.n1197 VSS.n1187 404.192
R256 VSS.n242 VSS.t75 401.591
R257 VSS.t102 VSS.n244 388.781
R258 VSS.n1208 VSS.t23 375.276
R259 VSS.n1269 VSS.t125 372.094
R260 VSS.t124 VSS.n1198 372.094
R261 VSS.t85 VSS.n1025 363.339
R262 VSS.t18 VSS.n1203 363.339
R263 VSS.t94 VSS.t99 359.769
R264 VSS.n1573 VSS.n1572 359.05
R265 VSS.n1271 VSS.t97 347.49
R266 VSS.n1272 VSS.t83 329.238
R267 VSS.n1603 VSS.t3 327.81
R268 VSS.n251 VSS.t128 313.659
R269 VSS.t90 VSS.t160 304.42
R270 VSS.t77 VSS.n1016 304.42
R271 VSS.t120 VSS.t61 304.42
R272 VSS.t68 VSS.n1201 304.42
R273 VSS.t136 VSS.n240 299.733
R274 VSS.n1022 VSS.t98 291.37
R275 VSS.t1 VSS.n1200 291.37
R276 VSS.n1189 VSS.n1188 249.036
R277 VSS.n1205 VSS.n1204 249.036
R278 VSS.t83 VSS.n1271 243.244
R279 VSS.t97 VSS.n1270 224.516
R280 VSS.n2001 VSS.t133 215.731
R281 VSS.n1824 VSS.t133 215.731
R282 VSS.t75 VSS.n241 208.828
R283 VSS.n251 VSS.t136 202.362
R284 VSS.n1021 VSS.t125 202.071
R285 VSS.n1199 VSS.t124 202.071
R286 VSS.t23 VSS.n1207 196.911
R287 VSS.t98 VSS.n1016 196.399
R288 VSS.n1201 VSS.t1 196.399
R289 VSS.t128 VSS.n239 187.895
R290 VSS.t2 VSS.n1196 183.975
R291 VSS.n1023 VSS.t77 182.797
R292 VSS.n1202 VSS.t68 182.797
R293 VSS.t0 VSS.t139 178.653
R294 VSS.t80 VSS.n1273 167.954
R295 VSS.n0 VSS.n340 149.637
R296 VSS.n1824 VSS.t139 149.157
R297 VSS.n5 VSS.t102 146.708
R298 VSS.t67 VSS.n1189 144.788
R299 VSS.t22 VSS.n1205 144.788
R300 VSS.t160 VSS.n1023 138.607
R301 VSS.t61 VSS.n1202 138.607
R302 VSS.n340 VSS.n239 122.129
R303 VSS.n247 VSS.t94 121.858
R304 VSS.n351 VSS.t150 116.615
R305 VSS.n361 VSS.t155 116.615
R306 VSS.t20 VSS.n1195 115.831
R307 VSS.n388 VSS.n373 115.672
R308 VSS.t64 VSS.n3 112.927
R309 VSS.n1188 VSS.t85 112.361
R310 VSS.n1204 VSS.t18 112.361
R311 VSS.t131 VSS.n243 103.54
R312 VSS.t71 VSS.n1194 97.5777
R313 VSS.n1550 VSS.n388 96.6341
R314 VSS.t103 VSS.n233 96.4635
R315 VSS.t26 VSS.n2 96.451
R316 VSS.n256 VSS.t135 90.6901
R317 VSS.n241 VSS.t129 88.3462
R318 VSS.t78 VSS.n1021 85.7923
R319 VSS.t69 VSS.n1199 85.7923
R320 VSS.n253 VSS.t127 84.6736
R321 VSS.n248 VSS.t130 81.2384
R322 VSS.n9 VSS.t158 75.7611
R323 VSS.t152 VSS.n2 75.7607
R324 VSS.t99 VSS.n244 75.4357
R325 VSS.n351 VSS.t152 75.2356
R326 VSS.t158 VSS.n361 75.2356
R327 VSS.t14 VSS.n97 68.1169
R328 VSS.n1573 VSS.t126 66.4528
R329 VSS.t132 VSS.t92 66.4528
R330 VSS.n1562 VSS.t104 64.3092
R331 VSS.t88 VSS.n234 63.2374
R332 VSS.n339 VSS.n235 63.2374
R333 VSS.n8 VSS.t26 62.5944
R334 VSS.t112 VSS.n114 60.4418
R335 VSS.n161 VSS.t16 58.523
R336 VSS.n1191 VSS.t73 57.9156
R337 VSS.n339 VSS.n237 52.4358
R338 VSS.t28 VSS.n466 52.3134
R339 VSS.n589 VSS.t39 52.3134
R340 VSS.n373 VSS.t104 51.364
R341 VSS.t25 VSS.n1206 51.2456
R342 VSS.n143 VSS.t108 50.848
R343 VSS.t43 VSS.n400 49.4071
R344 VSS.t106 VSS.n106 48.9292
R345 VSS.n96 VSS.t139 47.0104
R346 VSS.n9 VSS.t64 45.667
R347 VSS.t100 VSS.n1562 45.0166
R348 VSS.n1025 VSS.t90 44.1903
R349 VSS.n1203 VSS.t120 44.1903
R350 VSS.n534 VSS.t33 43.5946
R351 VSS.t35 VSS.n558 43.5946
R352 VSS.n125 VSS.t142 43.1729
R353 VSS.t15 VSS.n99 41.2541
R354 VSS.t17 VSS.n104 41.2541
R355 VSS.n253 VSS.t88 39.6575
R356 VSS.n137 VSS.t110 39.3353
R357 VSS.n1192 VSS.t63 39.1873
R358 VSS.t126 VSS.n233 36.4421
R359 VSS.n514 VSS.t31 34.8758
R360 VSS.t37 VSS.n432 34.8758
R361 VSS.t155 VSS.n8 34.3802
R362 VSS.t150 VSS.n0 34.3794
R363 VSS.t137 VSS.n243 33.9057
R364 VSS.t110 VSS.n112 33.579
R365 VSS.n2003 VSS.t139 33.5193
R366 VSS.n167 VSS.t15 31.6602
R367 VSS.n156 VSS.t17 31.6602
R368 VSS.t142 VSS.n116 29.7415
R369 VSS.n612 VSS.t41 29.0632
R370 VSS.t65 VSS.n1192 27.6043
R371 VSS.t135 VSS.n234 26.7958
R372 VSS.t41 VSS.n610 26.157
R373 VSS.n148 VSS.t106 23.9851
R374 VSS.t105 VSS.n3 22.6448
R375 VSS.t92 VSS.n237 22.4251
R376 VSS.t81 VSS.n1272 22.2881
R377 VSS.t122 VSS.n1193 22.2881
R378 VSS.t108 VSS.n108 22.0664
R379 VSS.n884 VSS.n640 21.0446
R380 VSS.n636 VSS.n398 21.0446
R381 VSS.n637 VSS.n636 21.0446
R382 VSS.n631 VSS.n399 21.0446
R383 VSS.n632 VSS.n631 21.0446
R384 VSS.n628 VSS.n627 21.0446
R385 VSS.n624 VSS.n623 21.0446
R386 VSS.n623 VSS.n401 21.0446
R387 VSS.n403 VSS.n402 21.0446
R388 VSS.n405 VSS.n404 21.0446
R389 VSS.n407 VSS.n406 21.0446
R390 VSS.n409 VSS.n408 21.0446
R391 VSS.n617 VSS.n616 21.0446
R392 VSS.n609 VSS.n607 21.0446
R393 VSS.n606 VSS.n604 21.0446
R394 VSS.n603 VSS.n601 21.0446
R395 VSS.n411 VSS.n410 21.0446
R396 VSS.n413 VSS.n412 21.0446
R397 VSS.n415 VSS.n414 21.0446
R398 VSS.n593 VSS.n416 21.0446
R399 VSS.n594 VSS.n593 21.0446
R400 VSS.n592 VSS.n590 21.0446
R401 VSS.n419 VSS.n418 21.0446
R402 VSS.n421 VSS.n420 21.0446
R403 VSS.n423 VSS.n422 21.0446
R404 VSS.n425 VSS.n424 21.0446
R405 VSS.n583 VSS.n582 21.0446
R406 VSS.n579 VSS.n578 21.0446
R407 VSS.n578 VSS.n427 21.0446
R408 VSS.n429 VSS.n428 21.0446
R409 VSS.n431 VSS.n430 21.0446
R410 VSS.n434 VSS.n433 21.0446
R411 VSS.n570 VSS.n569 21.0446
R412 VSS.n569 VSS.n435 21.0446
R413 VSS.n437 VSS.n436 21.0446
R414 VSS.n439 VSS.n438 21.0446
R415 VSS.n441 VSS.n440 21.0446
R416 VSS.n443 VSS.n442 21.0446
R417 VSS.n445 VSS.n444 21.0446
R418 VSS.n447 VSS.n446 21.0446
R419 VSS.n559 VSS.n556 21.0446
R420 VSS.n551 VSS.n448 21.0446
R421 VSS.n552 VSS.n551 21.0446
R422 VSS.n450 VSS.n449 21.0446
R423 VSS.n545 VSS.n451 21.0446
R424 VSS.n546 VSS.n545 21.0446
R425 VSS.n544 VSS.n542 21.0446
R426 VSS.n537 VSS.n452 21.0446
R427 VSS.n538 VSS.n537 21.0446
R428 VSS.n455 VSS.n454 21.0446
R429 VSS.n457 VSS.n456 21.0446
R430 VSS.n459 VSS.n458 21.0446
R431 VSS.n526 VSS.n460 21.0446
R432 VSS.n527 VSS.n526 21.0446
R433 VSS.n525 VSS.n523 21.0446
R434 VSS.n522 VSS.n520 21.0446
R435 VSS.n515 VSS.n461 21.0446
R436 VSS.n516 VSS.n515 21.0446
R437 VSS.n512 VSS.n511 21.0446
R438 VSS.n511 VSS.n463 21.0446
R439 VSS.n507 VSS.n506 21.0446
R440 VSS.n506 VSS.n464 21.0446
R441 VSS.n502 VSS.n501 21.0446
R442 VSS.n501 VSS.n465 21.0446
R443 VSS.n498 VSS.n497 21.0446
R444 VSS.n494 VSS.n493 21.0446
R445 VSS.n491 VSS.n490 21.0446
R446 VSS.n486 VSS.n485 21.0446
R447 VSS.n482 VSS.n481 21.0446
R448 VSS.n481 VSS.n467 21.0446
R449 VSS.n478 VSS.n396 21.0446
R450 VSS.n1548 VSS.n396 21.0446
R451 VSS.n478 VSS.n477 21.0446
R452 VSS.n477 VSS.n467 21.0446
R453 VSS.n485 VSS.n482 21.0446
R454 VSS.n486 VSS.n484 21.0446
R455 VSS.n493 VSS.n491 21.0446
R456 VSS.n497 VSS.n494 21.0446
R457 VSS.n498 VSS.n496 21.0446
R458 VSS.n496 VSS.n465 21.0446
R459 VSS.n502 VSS.n500 21.0446
R460 VSS.n500 VSS.n464 21.0446
R461 VSS.n507 VSS.n505 21.0446
R462 VSS.n505 VSS.n463 21.0446
R463 VSS.n512 VSS.n510 21.0446
R464 VSS.n519 VSS.n461 21.0446
R465 VSS.n520 VSS.n519 21.0446
R466 VSS.n523 VSS.n522 21.0446
R467 VSS.n527 VSS.n525 21.0446
R468 VSS.n460 VSS.n459 21.0446
R469 VSS.n458 VSS.n457 21.0446
R470 VSS.n456 VSS.n455 21.0446
R471 VSS.n533 VSS.n454 21.0446
R472 VSS.n538 VSS.n536 21.0446
R473 VSS.n541 VSS.n452 21.0446
R474 VSS.n542 VSS.n541 21.0446
R475 VSS.n546 VSS.n544 21.0446
R476 VSS.n451 VSS.n450 21.0446
R477 VSS.n550 VSS.n449 21.0446
R478 VSS.n552 VSS.n550 21.0446
R479 VSS.n555 VSS.n448 21.0446
R480 VSS.n556 VSS.n555 21.0446
R481 VSS.n446 VSS.n445 21.0446
R482 VSS.n444 VSS.n443 21.0446
R483 VSS.n442 VSS.n441 21.0446
R484 VSS.n440 VSS.n439 21.0446
R485 VSS.n438 VSS.n437 21.0446
R486 VSS.n436 VSS.n435 21.0446
R487 VSS.n570 VSS.n568 21.0446
R488 VSS.n568 VSS.n434 21.0446
R489 VSS.n573 VSS.n431 21.0446
R490 VSS.n430 VSS.n429 21.0446
R491 VSS.n428 VSS.n427 21.0446
R492 VSS.n582 VSS.n579 21.0446
R493 VSS.n583 VSS.n581 21.0446
R494 VSS.n581 VSS.n425 21.0446
R495 VSS.n424 VSS.n423 21.0446
R496 VSS.n422 VSS.n421 21.0446
R497 VSS.n420 VSS.n419 21.0446
R498 VSS.n594 VSS.n592 21.0446
R499 VSS.n416 VSS.n415 21.0446
R500 VSS.n414 VSS.n413 21.0446
R501 VSS.n412 VSS.n411 21.0446
R502 VSS.n600 VSS.n410 21.0446
R503 VSS.n601 VSS.n600 21.0446
R504 VSS.n604 VSS.n603 21.0446
R505 VSS.n607 VSS.n606 21.0446
R506 VSS.n616 VSS.n613 21.0446
R507 VSS.n617 VSS.n615 21.0446
R508 VSS.n615 VSS.n409 21.0446
R509 VSS.n408 VSS.n407 21.0446
R510 VSS.n406 VSS.n405 21.0446
R511 VSS.n404 VSS.n403 21.0446
R512 VSS.n402 VSS.n401 21.0446
R513 VSS.n627 VSS.n624 21.0446
R514 VSS.n628 VSS.n626 21.0446
R515 VSS.n635 VSS.n399 21.0446
R516 VSS.n637 VSS.n635 21.0446
R517 VSS.n639 VSS.n398 21.0446
R518 VSS.n640 VSS.n639 21.0446
R519 VSS.n1546 VSS.n884 21.0446
R520 VSS.n256 VSS.t103 21.0214
R521 VSS.t31 VSS.n462 20.3444
R522 VSS.n574 VSS.t37 20.3444
R523 VSS.n1549 VSS.n1548 19.5682
R524 VSS.t127 VSS.n235 18.2213
R525 VSS.n2007 VSS.n2006 18.0005
R526 VSS.t102 VSS.t100 17.1495
R527 VSS.n1799 VSS.n1797 17.0005
R528 VSS.n1809 VSS.t12 17.0005
R529 VSS.n1860 VSS.n96 17.0005
R530 VSS.n1860 VSS.n175 17.0005
R531 VSS.n1860 VSS.n97 17.0005
R532 VSS.n1860 VSS.n172 17.0005
R533 VSS.n1860 VSS.n98 17.0005
R534 VSS.n1860 VSS.n170 17.0005
R535 VSS.n1860 VSS.n99 17.0005
R536 VSS.n1860 VSS.n167 17.0005
R537 VSS.n1860 VSS.n100 17.0005
R538 VSS.n1860 VSS.n164 17.0005
R539 VSS.n1860 VSS.n101 17.0005
R540 VSS.n1860 VSS.n161 17.0005
R541 VSS.n1860 VSS.n102 17.0005
R542 VSS.n1860 VSS.n159 17.0005
R543 VSS.n1860 VSS.n103 17.0005
R544 VSS.n1860 VSS.n156 17.0005
R545 VSS.n1860 VSS.n104 17.0005
R546 VSS.n1860 VSS.n154 17.0005
R547 VSS.n1860 VSS.n105 17.0005
R548 VSS.n1860 VSS.n151 17.0005
R549 VSS.n1860 VSS.n106 17.0005
R550 VSS.n1860 VSS.n148 17.0005
R551 VSS.n1860 VSS.n107 17.0005
R552 VSS.n1860 VSS.n146 17.0005
R553 VSS.n1860 VSS.n108 17.0005
R554 VSS.n1860 VSS.n143 17.0005
R555 VSS.n1860 VSS.n109 17.0005
R556 VSS.n1860 VSS.n140 17.0005
R557 VSS.n1860 VSS.n138 17.0005
R558 VSS.n1860 VSS.n110 17.0005
R559 VSS.n1860 VSS.n137 17.0005
R560 VSS.n1860 VSS.n112 17.0005
R561 VSS.n1860 VSS.n136 17.0005
R562 VSS.n1860 VSS.n113 17.0005
R563 VSS.n1860 VSS.n133 17.0005
R564 VSS.n1860 VSS.n114 17.0005
R565 VSS.n1860 VSS.n131 17.0005
R566 VSS.n1860 VSS.n115 17.0005
R567 VSS.n1860 VSS.n128 17.0005
R568 VSS.n1860 VSS.n116 17.0005
R569 VSS.n1860 VSS.n125 17.0005
R570 VSS.n1860 VSS.n117 17.0005
R571 VSS.n1860 VSS.n123 17.0005
R572 VSS.n1860 VSS.n121 17.0005
R573 VSS.n1990 VSS.n52 17.0005
R574 VSS.n1999 VSS.n1998 17.0005
R575 VSS.n97 VSS.n44 17.0005
R576 VSS.n172 VSS.n44 17.0005
R577 VSS.n99 VSS.n44 17.0005
R578 VSS.n161 VSS.n44 17.0005
R579 VSS.n102 VSS.n44 17.0005
R580 VSS.n156 VSS.n44 17.0005
R581 VSS.n106 VSS.n44 17.0005
R582 VSS.n148 VSS.n44 17.0005
R583 VSS.n108 VSS.n44 17.0005
R584 VSS.n137 VSS.n44 17.0005
R585 VSS.n112 VSS.n44 17.0005
R586 VSS.n133 VSS.n44 17.0005
R587 VSS.n116 VSS.n44 17.0005
R588 VSS.n125 VSS.n44 17.0005
R589 VSS.n2003 VSS.n29 17.0005
R590 VSS.n1862 VSS.n44 17.0005
R591 VSS.n1861 VSS.n1860 17.0005
R592 VSS.n1547 VSS.t60 17.0005
R593 VSS.n1547 VSS.n400 17.0005
R594 VSS.n1547 VSS.n610 17.0005
R595 VSS.n1547 VSS.n417 17.0005
R596 VSS.n1547 VSS.n580 17.0005
R597 VSS.n1547 VSS.n574 17.0005
R598 VSS.n1547 VSS.n432 17.0005
R599 VSS.n1547 VSS.t52 17.0005
R600 VSS.n1547 VSS.n560 17.0005
R601 VSS.n1547 VSS.n453 17.0005
R602 VSS.n1547 VSS.n534 17.0005
R603 VSS.n1547 VSS.n528 17.0005
R604 VSS.n1547 VSS.n462 17.0005
R605 VSS.n1547 VSS.t46 17.0005
R606 VSS.n1547 VSS.n488 17.0005
R607 VSS.n1547 VSS.n466 17.0005
R608 VSS.n1563 VSS.n10 17.0005
R609 VSS.n10 VSS.n350 17.0005
R610 VSS.n10 VSS.n360 17.0005
R611 VSS.n10 VSS.n368 17.0005
R612 VSS.n10 VSS.n346 17.0005
R613 VSS.n10 VSS.n345 17.0005
R614 VSS.n10 VSS.n342 17.0005
R615 VSS.t76 VSS.n1573 17.0005
R616 VSS.t76 VSS.n233 17.0005
R617 VSS.t76 VSS.n234 17.0005
R618 VSS.t76 VSS.n253 17.0005
R619 VSS.t76 VSS.n235 17.0005
R620 VSS.t76 VSS.n238 17.0005
R621 VSS.t76 VSS.n251 17.0005
R622 VSS.t76 VSS.n248 17.0005
R623 VSS.t76 VSS.n247 17.0005
R624 VSS.t76 VSS.n244 17.0005
R625 VSS.n1562 VSS.n1561 17.0005
R626 VSS.n1561 VSS.t101 17.0005
R627 VSS.n1207 VSS.t24 17.0005
R628 VSS.n1205 VSS.t24 17.0005
R629 VSS.n1203 VSS.t70 17.0005
R630 VSS.n1165 VSS.t70 17.0005
R631 VSS.n1201 VSS.t70 17.0005
R632 VSS.n1198 VSS.t70 17.0005
R633 VSS.t62 VSS.n1104 17.0005
R634 VSS.n1195 VSS.n1104 17.0005
R635 VSS.n1127 VSS.n1104 17.0005
R636 VSS.n1120 VSS.n1104 17.0005
R637 VSS.n1112 VSS.n1104 17.0005
R638 VSS.n1191 VSS.n1104 17.0005
R639 VSS.n1189 VSS.n1104 17.0005
R640 VSS.t79 VSS.n1025 17.0005
R641 VSS.t79 VSS.n1024 17.0005
R642 VSS.t79 VSS.n1016 17.0005
R643 VSS.n1269 VSS.t79 17.0005
R644 VSS.t87 VSS.n996 17.0005
R645 VSS.n1273 VSS.n996 17.0005
R646 VSS.n1271 VSS.n996 17.0005
R647 VSS.t29 VSS.n395 17.0005
R648 VSS.n514 VSS.n395 17.0005
R649 VSS.n967 VSS.n395 17.0005
R650 VSS.n558 VSS.n395 17.0005
R651 VSS.t36 VSS.n395 17.0005
R652 VSS.n935 VSS.n395 17.0005
R653 VSS.n589 VSS.n395 17.0005
R654 VSS.n612 VSS.n395 17.0005
R655 VSS.n630 VSS.n395 17.0005
R656 VSS.t44 VSS.n395 17.0005
R657 VSS.n1545 VSS.n395 17.0005
R658 VSS.n1667 VSS.n1643 17.0005
R659 VSS.n1680 VSS.n1623 17.0005
R660 VSS.n1693 VSS.n1604 17.0005
R661 VSS.n1706 VSS.n1577 17.0005
R662 VSS.n1577 VSS.n96 17.0005
R663 VSS.n1577 VSS.n167 17.0005
R664 VSS.n1577 VSS.n104 17.0005
R665 VSS.n1577 VSS.n193 17.0005
R666 VSS.n1577 VSS.n143 17.0005
R667 VSS.n1577 VSS.n215 17.0005
R668 VSS.n1577 VSS.n114 17.0005
R669 VSS.n1577 VSS.n225 17.0005
R670 VSS.n1860 VSS.n119 17.0005
R671 VSS.n337 VSS.n336 17.0005
R672 VSS.n336 VSS.n335 17.0005
R673 VSS.n1209 VSS.n1208 16.2018
R674 VSS.n4 VSS.t105 135.924
R675 VSS.t16 VSS.n102 14.3913
R676 VSS.n1658 VSS.n1657 14.1929
R677 VSS.n133 VSS.t112 12.4725
R678 VSS.t33 VSS.n453 11.6256
R679 VSS.n560 VSS.t35 11.6256
R680 VSS.n175 VSS.n174 11.5948
R681 VSS.n169 VSS.n98 11.5948
R682 VSS.n167 VSS.n166 11.5948
R683 VSS.n163 VSS.n101 11.5948
R684 VSS.n158 VSS.n103 11.5948
R685 VSS.n154 VSS.n153 11.5948
R686 VSS.n151 VSS.n150 11.5948
R687 VSS.n145 VSS.n107 11.5948
R688 VSS.n143 VSS.n142 11.5948
R689 VSS.n140 VSS.n139 11.5948
R690 VSS.n136 VSS.n135 11.5948
R691 VSS.n130 VSS.n114 11.5948
R692 VSS.n128 VSS.n127 11.5948
R693 VSS.n123 VSS.n122 11.5948
R694 VSS.n199 VSS.n97 11.5948
R695 VSS.n200 VSS.n98 11.5948
R696 VSS.n201 VSS.n99 11.5948
R697 VSS.n202 VSS.n164 11.5948
R698 VSS.n203 VSS.n161 11.5948
R699 VSS.n204 VSS.n159 11.5948
R700 VSS.n205 VSS.n156 11.5948
R701 VSS.n206 VSS.n105 11.5948
R702 VSS.n207 VSS.n106 11.5948
R703 VSS.n210 VSS.n107 11.5948
R704 VSS.n212 VSS.n108 11.5948
R705 VSS.n214 VSS.n140 11.5948
R706 VSS.n216 VSS.n137 11.5948
R707 VSS.n218 VSS.n136 11.5948
R708 VSS.n220 VSS.n133 11.5948
R709 VSS.n222 VSS.n115 11.5948
R710 VSS.n224 VSS.n116 11.5948
R711 VSS.n227 VSS.n117 11.5948
R712 VSS.n174 VSS.n96 11.5948
R713 VSS.n199 VSS.n175 11.5948
R714 VSS.n200 VSS.n172 11.5948
R715 VSS.n170 VSS.n169 11.5948
R716 VSS.n201 VSS.n170 11.5948
R717 VSS.n166 VSS.n100 11.5948
R718 VSS.n202 VSS.n100 11.5948
R719 VSS.n164 VSS.n163 11.5948
R720 VSS.n203 VSS.n101 11.5948
R721 VSS.n204 VSS.n102 11.5948
R722 VSS.n159 VSS.n158 11.5948
R723 VSS.n205 VSS.n103 11.5948
R724 VSS.n153 VSS.n104 11.5948
R725 VSS.n206 VSS.n154 11.5948
R726 VSS.n150 VSS.n105 11.5948
R727 VSS.n207 VSS.n151 11.5948
R728 VSS.n210 VSS.n148 11.5948
R729 VSS.n146 VSS.n145 11.5948
R730 VSS.n212 VSS.n146 11.5948
R731 VSS.n142 VSS.n109 11.5948
R732 VSS.n214 VSS.n109 11.5948
R733 VSS.n139 VSS.n110 11.5948
R734 VSS.n216 VSS.n110 11.5948
R735 VSS.n218 VSS.n112 11.5948
R736 VSS.n135 VSS.n113 11.5948
R737 VSS.n220 VSS.n113 11.5948
R738 VSS.n131 VSS.n130 11.5948
R739 VSS.n222 VSS.n131 11.5948
R740 VSS.n127 VSS.n115 11.5948
R741 VSS.n224 VSS.n128 11.5948
R742 VSS.n227 VSS.n125 11.5948
R743 VSS.n122 VSS.n117 11.5948
R744 VSS.n229 VSS.n123 10.9423
R745 VSS.n1572 VSS.n229 10.9423
R746 VSS.n613 VSS.n612 10.5226
R747 VSS.n490 VSS.n488 10.5226
R748 VSS.n536 VSS.n453 10.5226
R749 VSS.n574 VSS.n573 10.5226
R750 VSS.n1546 VSS.n1545 10.5226
R751 VSS.n484 VSS.n466 10.5226
R752 VSS.n510 VSS.n462 10.5226
R753 VSS.n516 VSS.n514 10.5226
R754 VSS.n534 VSS.n533 10.5226
R755 VSS.n560 VSS.n559 10.5226
R756 VSS.n558 VSS.n447 10.5226
R757 VSS.n433 VSS.n432 10.5226
R758 VSS.n418 VSS.n417 10.5226
R759 VSS.n590 VSS.n589 10.5226
R760 VSS.n610 VSS.n609 10.5226
R761 VSS.n626 VSS.n400 10.5226
R762 VSS.n632 VSS.n630 10.5226
R763 VSS.n1545 VSS.n1544 10.1725
R764 VSS.n1652 VSS.n11 9.81703
R765 VSS.n1950 VSS.n11 9.54113
R766 VSS.n2005 VSS.n11 9.38994
R767 VSS.n331 VSS.n330 9.11631
R768 VSS.n288 VSS.n285 9.11631
R769 VSS.n1657 VSS.n1653 9.11631
R770 VSS.n645 VSS.n643 9.11631
R771 VSS.n1952 VSS.n1951 9.11631
R772 VSS.n1368 VSS.n1367 9.11631
R773 VSS.n1508 VSS.n902 9.11631
R774 VSS.n1657 VSS.n1656 9.11343
R775 VSS.n370 VSS.t72 9.08698
R776 VSS.n1289 VSS.n1288 9.07383
R777 VSS.n1211 VSS.n1180 9.07383
R778 VSS.n1079 VSS.n232 9.07383
R779 VSS.n1065 VSS.n374 9.07383
R780 VSS.t72 VSS.n369 9.0445
R781 VSS.n1827 VSS.n12 9.0005
R782 VSS.n1828 VSS.n1765 9.0005
R783 VSS.n1830 VSS.n1829 9.0005
R784 VSS.n1831 VSS.n1764 9.0005
R785 VSS.n1833 VSS.n1832 9.0005
R786 VSS.n1834 VSS.n1762 9.0005
R787 VSS.n1836 VSS.n1835 9.0005
R788 VSS.n1846 VSS.n1754 9.0005
R789 VSS.n1848 VSS.n1847 9.0005
R790 VSS.n1748 VSS.n180 9.0005
R791 VSS.n1747 VSS.n1746 9.0005
R792 VSS.n1732 VSS.n188 9.0005
R793 VSS.n1731 VSS.n1730 9.0005
R794 VSS.n324 VSS.n273 9.0005
R795 VSS.n326 VSS.n325 9.0005
R796 VSS.n327 VSS.n268 9.0005
R797 VSS.n329 VSS.n328 9.0005
R798 VSS.n1728 VSS.n190 9.0005
R799 VSS.n317 VSS.n192 9.0005
R800 VSS.n318 VSS.n316 9.0005
R801 VSS.n320 VSS.n319 9.0005
R802 VSS.n321 VSS.n274 9.0005
R803 VSS.n323 VSS.n322 9.0005
R804 VSS.n1744 VSS.n182 9.0005
R805 VSS.n1742 VSS.n1741 9.0005
R806 VSS.n1740 VSS.n184 9.0005
R807 VSS.n1739 VSS.n1738 9.0005
R808 VSS.n1736 VSS.n186 9.0005
R809 VSS.n1734 VSS.n1733 9.0005
R810 VSS.n1849 VSS.n1753 9.0005
R811 VSS.n1851 VSS.n1850 9.0005
R812 VSS.n1852 VSS.n1749 9.0005
R813 VSS.n1854 VSS.n1853 9.0005
R814 VSS.n1855 VSS.n181 9.0005
R815 VSS.n1857 VSS.n1856 9.0005
R816 VSS.n1837 VSS.n1761 9.0005
R817 VSS.n1839 VSS.n1838 9.0005
R818 VSS.n1840 VSS.n1759 9.0005
R819 VSS.n1842 VSS.n1841 9.0005
R820 VSS.n1843 VSS.n1758 9.0005
R821 VSS.n1845 VSS.n1844 9.0005
R822 VSS.n1827 VSS.n1768 9.0005
R823 VSS.n1828 VSS.n1767 9.0005
R824 VSS.n1829 VSS.n1766 9.0005
R825 VSS.n1780 VSS.n1764 9.0005
R826 VSS.n1833 VSS.t7 9.0005
R827 VSS.n1834 VSS.t8 9.0005
R828 VSS.n1835 VSS.n1763 9.0005
R829 VSS.n1846 VSS.t11 9.0005
R830 VSS.n1847 VSS.n1755 9.0005
R831 VSS.n180 VSS.n178 9.0005
R832 VSS.n1746 VSS.n1745 9.0005
R833 VSS.n188 VSS.n187 9.0005
R834 VSS.n1730 VSS.n1729 9.0005
R835 VSS.n273 VSS.n272 9.0005
R836 VSS.n326 VSS.n271 9.0005
R837 VSS.n267 VSS.n266 9.0005
R838 VSS.n328 VSS.n269 9.0005
R839 VSS.n327 VSS.n270 9.0005
R840 VSS.n322 VSS.n275 9.0005
R841 VSS.n321 VSS.n313 9.0005
R842 VSS.n320 VSS.n314 9.0005
R843 VSS.n316 VSS.n315 9.0005
R844 VSS.n192 VSS.n191 9.0005
R845 VSS.n1728 VSS.n1727 9.0005
R846 VSS.n1734 VSS.n189 9.0005
R847 VSS.n1736 VSS.n1735 9.0005
R848 VSS.n1738 VSS.n1737 9.0005
R849 VSS.n184 VSS.n183 9.0005
R850 VSS.n1742 VSS.n185 9.0005
R851 VSS.n1744 VSS.n1743 9.0005
R852 VSS.n1858 VSS.n1857 9.0005
R853 VSS.n1819 VSS.n181 9.0005
R854 VSS.n1853 VSS.n1750 9.0005
R855 VSS.n1852 VSS.n1751 9.0005
R856 VSS.n1851 VSS.n1752 9.0005
R857 VSS.n1811 VSS.n1753 9.0005
R858 VSS.n1845 VSS.n1757 9.0005
R859 VSS.n1804 VSS.n1758 9.0005
R860 VSS.n1841 VSS.n1760 9.0005
R861 VSS.n1840 VSS.t10 9.0005
R862 VSS.n1839 VSS.t9 9.0005
R863 VSS.n1793 VSS.n1761 9.0005
R864 VSS.n1973 VSS.n1972 9.0005
R865 VSS.n1975 VSS.n68 9.0005
R866 VSS.n1979 VSS.n64 9.0005
R867 VSS.n1983 VSS.n60 9.0005
R868 VSS.n1989 VSS.n54 9.0005
R869 VSS.n1993 VSS.n51 9.0005
R870 VSS.n1997 VSS.n47 9.0005
R871 VSS.n1924 VSS.n1923 9.0005
R872 VSS.n1918 VSS.n1917 9.0005
R873 VSS.n1911 VSS.n1910 9.0005
R874 VSS.n1899 VSS.n1898 9.0005
R875 VSS.n1894 VSS.n1893 9.0005
R876 VSS.n1887 VSS.n1886 9.0005
R877 VSS.n1875 VSS.n1874 9.0005
R878 VSS.n1870 VSS.n1869 9.0005
R879 VSS.n1865 VSS.n92 9.0005
R880 VSS.n1867 VSS.n90 9.0005
R881 VSS.n1879 VSS.n86 9.0005
R882 VSS.n1889 VSS.n84 9.0005
R883 VSS.n1891 VSS.n82 9.0005
R884 VSS.n1903 VSS.n78 9.0005
R885 VSS.n1913 VSS.n76 9.0005
R886 VSS.n1915 VSS.n74 9.0005
R887 VSS.n1930 VSS.n46 9.0005
R888 VSS.n1995 VSS.n49 9.0005
R889 VSS.n1991 VSS.n53 9.0005
R890 VSS.n1981 VSS.n62 9.0005
R891 VSS.n1977 VSS.n66 9.0005
R892 VSS.n1954 VSS.n1953 9.0005
R893 VSS.n1956 VSS.n1955 9.0005
R894 VSS.n1958 VSS.n1957 9.0005
R895 VSS.n1960 VSS.n1959 9.0005
R896 VSS.n1962 VSS.n1961 9.0005
R897 VSS.n1964 VSS.n1963 9.0005
R898 VSS.n1966 VSS.n1965 9.0005
R899 VSS.n1968 VSS.n1967 9.0005
R900 VSS.n70 VSS.n69 9.0005
R901 VSS.n1985 VSS.n58 9.0005
R902 VSS.n1987 VSS.n56 9.0005
R903 VSS.n1929 VSS.n1928 9.0005
R904 VSS.n1926 VSS.n72 9.0005
R905 VSS.n1906 VSS.n1905 9.0005
R906 VSS.n1901 VSS.n80 9.0005
R907 VSS.n1882 VSS.n1881 9.0005
R908 VSS.n1877 VSS.n88 9.0005
R909 VSS.n732 VSS.n731 9.0005
R910 VSS.n734 VSS.n733 9.0005
R911 VSS.n736 VSS.n735 9.0005
R912 VSS.n738 VSS.n737 9.0005
R913 VSS.n740 VSS.n739 9.0005
R914 VSS.n742 VSS.n741 9.0005
R915 VSS.n744 VSS.n743 9.0005
R916 VSS.n746 VSS.n745 9.0005
R917 VSS.n748 VSS.n747 9.0005
R918 VSS.n750 VSS.n749 9.0005
R919 VSS.n752 VSS.n751 9.0005
R920 VSS.n754 VSS.n753 9.0005
R921 VSS.n756 VSS.n755 9.0005
R922 VSS.n758 VSS.n757 9.0005
R923 VSS.n760 VSS.n759 9.0005
R924 VSS.n762 VSS.n761 9.0005
R925 VSS.n764 VSS.n763 9.0005
R926 VSS.n766 VSS.n765 9.0005
R927 VSS.n768 VSS.n767 9.0005
R928 VSS.n770 VSS.n769 9.0005
R929 VSS.n771 VSS.t48 9.0005
R930 VSS.n773 VSS.n772 9.0005
R931 VSS.n775 VSS.n774 9.0005
R932 VSS.n777 VSS.n776 9.0005
R933 VSS.n779 VSS.n778 9.0005
R934 VSS.n781 VSS.n780 9.0005
R935 VSS.n783 VSS.n782 9.0005
R936 VSS.n785 VSS.n784 9.0005
R937 VSS.n787 VSS.n786 9.0005
R938 VSS.n789 VSS.n788 9.0005
R939 VSS.n790 VSS.t50 9.0005
R940 VSS.n792 VSS.n791 9.0005
R941 VSS.n794 VSS.n793 9.0005
R942 VSS.n796 VSS.n795 9.0005
R943 VSS.n798 VSS.n797 9.0005
R944 VSS.n800 VSS.n799 9.0005
R945 VSS.n802 VSS.n801 9.0005
R946 VSS.n804 VSS.n803 9.0005
R947 VSS.n806 VSS.n805 9.0005
R948 VSS.n808 VSS.n807 9.0005
R949 VSS.n810 VSS.n809 9.0005
R950 VSS.n812 VSS.n811 9.0005
R951 VSS.n814 VSS.n813 9.0005
R952 VSS.n816 VSS.n815 9.0005
R953 VSS.n818 VSS.n817 9.0005
R954 VSS.n820 VSS.n819 9.0005
R955 VSS.n822 VSS.n821 9.0005
R956 VSS.n824 VSS.n823 9.0005
R957 VSS.n826 VSS.n825 9.0005
R958 VSS.n827 VSS.t54 9.0005
R959 VSS.n829 VSS.n828 9.0005
R960 VSS.n831 VSS.n830 9.0005
R961 VSS.n833 VSS.n832 9.0005
R962 VSS.n835 VSS.n834 9.0005
R963 VSS.n837 VSS.n836 9.0005
R964 VSS.n839 VSS.n838 9.0005
R965 VSS.n841 VSS.n840 9.0005
R966 VSS.n843 VSS.n842 9.0005
R967 VSS.n845 VSS.n844 9.0005
R968 VSS.n846 VSS.t56 9.0005
R969 VSS.n848 VSS.n847 9.0005
R970 VSS.n850 VSS.n849 9.0005
R971 VSS.n852 VSS.n851 9.0005
R972 VSS.n854 VSS.n853 9.0005
R973 VSS.n856 VSS.n855 9.0005
R974 VSS.n858 VSS.n857 9.0005
R975 VSS.n860 VSS.n859 9.0005
R976 VSS.n862 VSS.n861 9.0005
R977 VSS.n864 VSS.n863 9.0005
R978 VSS.n866 VSS.n865 9.0005
R979 VSS.n868 VSS.n867 9.0005
R980 VSS.n870 VSS.n869 9.0005
R981 VSS.n872 VSS.n871 9.0005
R982 VSS.n874 VSS.n873 9.0005
R983 VSS.n876 VSS.n875 9.0005
R984 VSS.n878 VSS.n877 9.0005
R985 VSS.n880 VSS.n879 9.0005
R986 VSS.n882 VSS.n881 9.0005
R987 VSS.n644 VSS.n883 9.0005
R988 VSS.n349 VSS.n338 9.0005
R989 VSS.n726 VSS.n725 9.0005
R990 VSS.n726 VSS.n723 9.0005
R991 VSS.n1564 VSS.n338 9.0005
R992 VSS.n1066 VSS.t101 9.0005
R993 VSS.n1068 VSS.n1067 9.0005
R994 VSS.n1063 VSS.n1062 9.0005
R995 VSS.n1072 VSS.n1064 9.0005
R996 VSS.n1074 VSS.n1073 9.0005
R997 VSS.n1076 VSS.n1075 9.0005
R998 VSS.n1060 VSS.n1059 9.0005
R999 VSS.n1088 VSS.n238 9.0005
R1000 VSS.n1087 VSS.t93 9.0005
R1001 VSS.n1086 VSS.t89 9.0005
R1002 VSS.n1083 VSS.n1082 9.0005
R1003 VSS.n1081 VSS.n1080 9.0005
R1004 VSS.n1213 VSS.n1212 9.0005
R1005 VSS.n1214 VSS.n1175 9.0005
R1006 VSS.n1216 VSS.n1215 9.0005
R1007 VSS.n1218 VSS.n1174 9.0005
R1008 VSS.n1219 VSS.n1173 9.0005
R1009 VSS.n1220 VSS.t19 9.0005
R1010 VSS.n1167 VSS.n1221 9.0005
R1011 VSS.t121 VSS.n1166 9.0005
R1012 VSS.n1165 VSS.n1164 9.0005
R1013 VSS.n1224 VSS.n1223 9.0005
R1014 VSS.n1226 VSS.n1225 9.0005
R1015 VSS.n1227 VSS.n1158 9.0005
R1016 VSS.n1229 VSS.n1157 9.0005
R1017 VSS.n1231 VSS.n1230 9.0005
R1018 VSS.n1233 VSS.n1232 9.0005
R1019 VSS.n1234 VSS.n1151 9.0005
R1020 VSS.n1236 VSS.n1150 9.0005
R1021 VSS.n1238 VSS.n1237 9.0005
R1022 VSS.n1240 VSS.n1239 9.0005
R1023 VSS.n1241 VSS.n1144 9.0005
R1024 VSS.n1243 VSS.n1142 9.0005
R1025 VSS.n1245 VSS.n1244 9.0005
R1026 VSS.n1137 VSS.n1246 9.0005
R1027 VSS.t62 VSS.n1135 9.0005
R1028 VSS.n1248 VSS.n1247 9.0005
R1029 VSS.n1249 VSS.n1129 9.0005
R1030 VSS.n1251 VSS.n1250 9.0005
R1031 VSS.t21 VSS.n1128 9.0005
R1032 VSS.n1127 VSS.n1126 9.0005
R1033 VSS.n1254 VSS.n1253 9.0005
R1034 VSS.t123 VSS.n1255 9.0005
R1035 VSS.n1120 VSS.n1119 9.0005
R1036 VSS.n1256 VSS.n1118 9.0005
R1037 VSS.n1257 VSS.t66 9.0005
R1038 VSS.n1112 VSS.n1258 9.0005
R1039 VSS.n1259 VSS.n1111 9.0005
R1040 VSS.n1110 VSS.n1109 9.0005
R1041 VSS.n1261 VSS.t74 9.0005
R1042 VSS.n1263 VSS.n1262 9.0005
R1043 VSS.n1264 VSS.n1102 9.0005
R1044 VSS.n1265 VSS.t86 9.0005
R1045 VSS.n1266 VSS.n1026 9.0005
R1046 VSS.t91 VSS.n1267 9.0005
R1047 VSS.n1027 VSS.n1024 9.0005
R1048 VSS.n1096 VSS.n1095 9.0005
R1049 VSS.n1057 VSS.n1056 9.0005
R1050 VSS.n1055 VSS.n1029 9.0005
R1051 VSS.n1051 VSS.n1050 9.0005
R1052 VSS.n1049 VSS.n1048 9.0005
R1053 VSS.n1047 VSS.n1046 9.0005
R1054 VSS.n1045 VSS.n1031 9.0005
R1055 VSS.n1041 VSS.n1040 9.0005
R1056 VSS.n1039 VSS.n1033 9.0005
R1057 VSS.n1037 VSS.n1036 9.0005
R1058 VSS.n1010 VSS.n1009 9.0005
R1059 VSS.n1278 VSS.n1003 9.0005
R1060 VSS.t87 VSS.n1279 9.0005
R1061 VSS.n1280 VSS.n1002 9.0005
R1062 VSS.t82 VSS.n1000 9.0005
R1063 VSS.n1282 VSS.n1001 9.0005
R1064 VSS.n1284 VSS.n1283 9.0005
R1065 VSS.n1285 VSS.n993 9.0005
R1066 VSS.n1286 VSS.t84 9.0005
R1067 VSS.n994 VSS.n991 9.0005
R1068 VSS.n989 VSS.n988 9.0005
R1069 VSS.n1372 VSS.n986 9.0005
R1070 VSS.n1376 VSS.n984 9.0005
R1071 VSS.n1380 VSS.n982 9.0005
R1072 VSS.n1384 VSS.n980 9.0005
R1073 VSS.n1386 VSS.n977 9.0005
R1074 VSS.n1390 VSS.n975 9.0005
R1075 VSS.n1394 VSS.n973 9.0005
R1076 VSS.n1398 VSS.n971 9.0005
R1077 VSS.n1402 VSS.n969 9.0005
R1078 VSS.n1404 VSS.n966 9.0005
R1079 VSS.n1408 VSS.n964 9.0005
R1080 VSS.n1412 VSS.n962 9.0005
R1081 VSS.n1416 VSS.n960 9.0005
R1082 VSS.n1420 VSS.n958 9.0005
R1083 VSS.n1422 VSS.n955 9.0005
R1084 VSS.n1426 VSS.n953 9.0005
R1085 VSS.n1430 VSS.n951 9.0005
R1086 VSS.n1434 VSS.n949 9.0005
R1087 VSS.n946 VSS.n947 9.0005
R1088 VSS.n1440 VSS.n944 9.0005
R1089 VSS.n1444 VSS.n942 9.0005
R1090 VSS.n1448 VSS.n940 9.0005
R1091 VSS.n1452 VSS.n938 9.0005
R1092 VSS.t38 VSS.n936 9.0005
R1093 VSS.n1458 VSS.n933 9.0005
R1094 VSS.n1462 VSS.n931 9.0005
R1095 VSS.n1466 VSS.n929 9.0005
R1096 VSS.n1470 VSS.n927 9.0005
R1097 VSS.t40 VSS.n924 9.0005
R1098 VSS.n1476 VSS.n922 9.0005
R1099 VSS.n1480 VSS.n920 9.0005
R1100 VSS.n1484 VSS.n918 9.0005
R1101 VSS.n1488 VSS.n916 9.0005
R1102 VSS.n914 VSS.n913 9.0005
R1103 VSS.n1494 VSS.n911 9.0005
R1104 VSS.n1498 VSS.n909 9.0005
R1105 VSS.n1502 VSS.n907 9.0005
R1106 VSS.n1506 VSS.n905 9.0005
R1107 VSS.n903 VSS.n904 9.0005
R1108 VSS.n1504 VSS.n906 9.0005
R1109 VSS.n1500 VSS.n908 9.0005
R1110 VSS.n1496 VSS.n910 9.0005
R1111 VSS.n1492 VSS.n912 9.0005
R1112 VSS.n1490 VSS.n915 9.0005
R1113 VSS.n1486 VSS.n917 9.0005
R1114 VSS.n1482 VSS.n919 9.0005
R1115 VSS.n1478 VSS.n921 9.0005
R1116 VSS.n1474 VSS.n923 9.0005
R1117 VSS.n1472 VSS.n926 9.0005
R1118 VSS.n1468 VSS.n928 9.0005
R1119 VSS.n1464 VSS.n930 9.0005
R1120 VSS.n1460 VSS.n932 9.0005
R1121 VSS.n1456 VSS.n934 9.0005
R1122 VSS.n1454 VSS.n937 9.0005
R1123 VSS.n1450 VSS.n939 9.0005
R1124 VSS.n1446 VSS.n941 9.0005
R1125 VSS.n1442 VSS.n943 9.0005
R1126 VSS.n1438 VSS.n945 9.0005
R1127 VSS.n1436 VSS.n948 9.0005
R1128 VSS.n1432 VSS.n950 9.0005
R1129 VSS.n1428 VSS.n952 9.0005
R1130 VSS.n1424 VSS.n954 9.0005
R1131 VSS.t34 VSS.n956 9.0005
R1132 VSS.n1418 VSS.n959 9.0005
R1133 VSS.n1414 VSS.n961 9.0005
R1134 VSS.n1410 VSS.n963 9.0005
R1135 VSS.n1406 VSS.n965 9.0005
R1136 VSS.t32 VSS.n968 9.0005
R1137 VSS.n1400 VSS.n970 9.0005
R1138 VSS.n1396 VSS.n972 9.0005
R1139 VSS.n1392 VSS.n974 9.0005
R1140 VSS.n1388 VSS.n976 9.0005
R1141 VSS.n978 VSS.n979 9.0005
R1142 VSS.n1382 VSS.n981 9.0005
R1143 VSS.n1378 VSS.n983 9.0005
R1144 VSS.n1374 VSS.n985 9.0005
R1145 VSS.n1370 VSS.n987 9.0005
R1146 VSS.n1659 VSS.n1658 9.0005
R1147 VSS.n1676 VSS.n1675 9.0005
R1148 VSS.n1628 VSS.n1626 9.0005
R1149 VSS.n1633 VSS.t5 9.0005
R1150 VSS.n1632 VSS.n1631 9.0005
R1151 VSS.n1618 VSS.n1616 9.0005
R1152 VSS.n1609 VSS.n1607 9.0005
R1153 VSS.n1611 VSS.n1610 9.0005
R1154 VSS.n1596 VSS.n1593 9.0005
R1155 VSS.n1698 VSS.n1697 9.0005
R1156 VSS.n1594 VSS.n1590 9.0005
R1157 VSS.n1703 VSS.n1702 9.0005
R1158 VSS.n1710 VSS.n1709 9.0005
R1159 VSS.n1712 VSS.n1582 9.0005
R1160 VSS.n1715 VSS.n1714 9.0005
R1161 VSS.n1717 VSS.n1716 9.0005
R1162 VSS.n1724 VSS.n1723 9.0005
R1163 VSS.n208 VSS.n195 9.0005
R1164 VSS.n306 VSS.n305 9.0005
R1165 VSS.n308 VSS.n307 9.0005
R1166 VSS.n310 VSS.n309 9.0005
R1167 VSS.n279 VSS.n278 9.0005
R1168 VSS.n294 VSS.n293 9.0005
R1169 VSS.n284 VSS.n283 9.0005
R1170 VSS.n287 VSS.n286 9.0005
R1171 VSS.n1651 VSS.n1650 9.0005
R1172 VSS.n1647 VSS.n1646 9.0005
R1173 VSS.n1639 VSS.n1638 9.0005
R1174 VSS.n1674 VSS.n1673 9.0005
R1175 VSS.n1687 VSS.t6 9.0005
R1176 VSS.n1689 VSS.n1688 9.0005
R1177 VSS.n1705 VSS.n1587 9.0005
R1178 VSS.n1708 VSS.n1707 9.0005
R1179 VSS.n1719 VSS.n198 9.0005
R1180 VSS.n1722 VSS.n1721 9.0005
R1181 VSS.n298 VSS.n297 9.0005
R1182 VSS.n296 VSS.n295 9.0005
R1183 VSS.n1584 VSS.n1582 9.0005
R1184 VSS.n1715 VSS.n1581 9.0005
R1185 VSS.n1716 VSS.n1580 9.0005
R1186 VSS.n1579 VSS.n198 9.0005
R1187 VSS.n1722 VSS.n197 9.0005
R1188 VSS.n299 VSS.n298 9.0005
R1189 VSS.n296 VSS.n280 9.0005
R1190 VSS.n294 VSS.n290 9.0005
R1191 VSS.n289 VSS.n284 9.0005
R1192 VSS.n1723 VSS.n196 9.0005
R1193 VSS.n303 VSS.n195 9.0005
R1194 VSS.n306 VSS.n304 9.0005
R1195 VSS.n308 VSS.n302 9.0005
R1196 VSS.n309 VSS.n301 9.0005
R1197 VSS.n300 VSS.n279 9.0005
R1198 VSS.n1648 VSS.n1638 9.0005
R1199 VSS.n1674 VSS.n1637 9.0005
R1200 VSS.n1675 VSS.n1636 9.0005
R1201 VSS.n1635 VSS.n1628 9.0005
R1202 VSS.n1634 VSS.n1633 9.0005
R1203 VSS.n1632 VSS.n1630 9.0005
R1204 VSS.n1629 VSS.n1616 9.0005
R1205 VSS.n1687 VSS.n1615 9.0005
R1206 VSS.n1688 VSS.n1614 9.0005
R1207 VSS.n1591 VSS.n1587 9.0005
R1208 VSS.n1708 VSS.n1586 9.0005
R1209 VSS.n1709 VSS.n1585 9.0005
R1210 VSS.n1613 VSS.n1609 9.0005
R1211 VSS.n1612 VSS.n1611 9.0005
R1212 VSS.n1593 VSS.n1592 9.0005
R1213 VSS.n1699 VSS.n1698 9.0005
R1214 VSS.n1700 VSS.n1590 9.0005
R1215 VSS.n1702 VSS.n1701 9.0005
R1216 VSS.n732 VSS.n729 9.0005
R1217 VSS.n734 VSS.n722 9.0005
R1218 VSS.n736 VSS.n721 9.0005
R1219 VSS.n738 VSS.n720 9.0005
R1220 VSS.n740 VSS.n719 9.0005
R1221 VSS.n742 VSS.n718 9.0005
R1222 VSS.n744 VSS.n717 9.0005
R1223 VSS.n746 VSS.n716 9.0005
R1224 VSS.n748 VSS.n715 9.0005
R1225 VSS.n750 VSS.n714 9.0005
R1226 VSS.n752 VSS.n713 9.0005
R1227 VSS.n754 VSS.n712 9.0005
R1228 VSS.n756 VSS.n711 9.0005
R1229 VSS.n758 VSS.n710 9.0005
R1230 VSS.n760 VSS.n709 9.0005
R1231 VSS.n762 VSS.n708 9.0005
R1232 VSS.n764 VSS.n707 9.0005
R1233 VSS.n766 VSS.n706 9.0005
R1234 VSS.n768 VSS.n705 9.0005
R1235 VSS.n770 VSS.n704 9.0005
R1236 VSS.n771 VSS.n703 9.0005
R1237 VSS.n773 VSS.n702 9.0005
R1238 VSS.n775 VSS.n701 9.0005
R1239 VSS.n777 VSS.n700 9.0005
R1240 VSS.n779 VSS.n699 9.0005
R1241 VSS.n781 VSS.n698 9.0005
R1242 VSS.n783 VSS.n697 9.0005
R1243 VSS.n785 VSS.n696 9.0005
R1244 VSS.n787 VSS.n695 9.0005
R1245 VSS.n789 VSS.n694 9.0005
R1246 VSS.n790 VSS.n693 9.0005
R1247 VSS.n792 VSS.n692 9.0005
R1248 VSS.n794 VSS.n691 9.0005
R1249 VSS.n796 VSS.n690 9.0005
R1250 VSS.n798 VSS.n689 9.0005
R1251 VSS.n800 VSS.n688 9.0005
R1252 VSS.n802 VSS.n687 9.0005
R1253 VSS.n804 VSS.n686 9.0005
R1254 VSS.n806 VSS.n685 9.0005
R1255 VSS.n808 VSS.n684 9.0005
R1256 VSS.n810 VSS.n683 9.0005
R1257 VSS.n812 VSS.n682 9.0005
R1258 VSS.n814 VSS.n681 9.0005
R1259 VSS.n816 VSS.n680 9.0005
R1260 VSS.n818 VSS.n679 9.0005
R1261 VSS.n820 VSS.n678 9.0005
R1262 VSS.n822 VSS.n677 9.0005
R1263 VSS.n824 VSS.n676 9.0005
R1264 VSS.n826 VSS.n675 9.0005
R1265 VSS.n827 VSS.n674 9.0005
R1266 VSS.n829 VSS.n673 9.0005
R1267 VSS.n831 VSS.n672 9.0005
R1268 VSS.n833 VSS.n671 9.0005
R1269 VSS.n835 VSS.n670 9.0005
R1270 VSS.n837 VSS.n669 9.0005
R1271 VSS.n839 VSS.n668 9.0005
R1272 VSS.n841 VSS.n667 9.0005
R1273 VSS.n843 VSS.n666 9.0005
R1274 VSS.n845 VSS.n665 9.0005
R1275 VSS.n846 VSS.n664 9.0005
R1276 VSS.n848 VSS.n663 9.0005
R1277 VSS.n850 VSS.n662 9.0005
R1278 VSS.n852 VSS.n661 9.0005
R1279 VSS.n854 VSS.n660 9.0005
R1280 VSS.n856 VSS.n659 9.0005
R1281 VSS.n858 VSS.n658 9.0005
R1282 VSS.n860 VSS.n657 9.0005
R1283 VSS.n862 VSS.n656 9.0005
R1284 VSS.n864 VSS.n655 9.0005
R1285 VSS.n866 VSS.n654 9.0005
R1286 VSS.n868 VSS.n653 9.0005
R1287 VSS.n870 VSS.n652 9.0005
R1288 VSS.n872 VSS.n651 9.0005
R1289 VSS.n874 VSS.n650 9.0005
R1290 VSS.n876 VSS.n649 9.0005
R1291 VSS.n878 VSS.n648 9.0005
R1292 VSS.n880 VSS.n647 9.0005
R1293 VSS.n882 VSS.n646 9.0005
R1294 VSS.n1943 VSS.n68 9.0005
R1295 VSS.n1942 VSS.n66 9.0005
R1296 VSS.n1941 VSS.n64 9.0005
R1297 VSS.n1940 VSS.n62 9.0005
R1298 VSS.n1939 VSS.n60 9.0005
R1299 VSS.n1938 VSS.n58 9.0005
R1300 VSS.n1937 VSS.n56 9.0005
R1301 VSS.n1929 VSS.n71 9.0005
R1302 VSS.n1921 VSS.n72 9.0005
R1303 VSS.n1907 VSS.n1906 9.0005
R1304 VSS.n80 VSS.n79 9.0005
R1305 VSS.n1883 VSS.n1882 9.0005
R1306 VSS.n88 VSS.n87 9.0005
R1307 VSS.n1874 VSS.n1873 9.0005
R1308 VSS.n1872 VSS.n90 9.0005
R1309 VSS.n1871 VSS.n1870 9.0005
R1310 VSS.n92 VSS.n91 9.0005
R1311 VSS.n1898 VSS.n1897 9.0005
R1312 VSS.n1896 VSS.n82 9.0005
R1313 VSS.n1895 VSS.n1894 9.0005
R1314 VSS.n84 VSS.n83 9.0005
R1315 VSS.n1886 VSS.n1885 9.0005
R1316 VSS.n1884 VSS.n86 9.0005
R1317 VSS.n1923 VSS.n1922 9.0005
R1318 VSS.n1920 VSS.n74 9.0005
R1319 VSS.n1919 VSS.n1918 9.0005
R1320 VSS.n76 VSS.n75 9.0005
R1321 VSS.n1910 VSS.n1909 9.0005
R1322 VSS.n1908 VSS.n78 9.0005
R1323 VSS.n1936 VSS.n54 9.0005
R1324 VSS.n1935 VSS.n53 9.0005
R1325 VSS.n1934 VSS.n51 9.0005
R1326 VSS.n1933 VSS.n49 9.0005
R1327 VSS.n1932 VSS.n47 9.0005
R1328 VSS.n1931 VSS.n1930 9.0005
R1329 VSS.n1956 VSS.n1949 9.0005
R1330 VSS.n1958 VSS.n1948 9.0005
R1331 VSS.n1960 VSS.n1947 9.0005
R1332 VSS.n1962 VSS.n1946 9.0005
R1333 VSS.n1964 VSS.n1945 9.0005
R1334 VSS.n1966 VSS.n1944 9.0005
R1335 VSS.n1969 VSS.n1968 9.0005
R1336 VSS.n1970 VSS.n70 9.0005
R1337 VSS.n1972 VSS.n1971 9.0005
R1338 VSS.n1366 VSS.n987 9.0005
R1339 VSS.n1365 VSS.n986 9.0005
R1340 VSS.n1364 VSS.n985 9.0005
R1341 VSS.n1363 VSS.n984 9.0005
R1342 VSS.n1362 VSS.n983 9.0005
R1343 VSS.n1361 VSS.n982 9.0005
R1344 VSS.n1360 VSS.n981 9.0005
R1345 VSS.n1359 VSS.n980 9.0005
R1346 VSS.n1358 VSS.n979 9.0005
R1347 VSS.n1357 VSS.n977 9.0005
R1348 VSS.n1356 VSS.n976 9.0005
R1349 VSS.n1355 VSS.n975 9.0005
R1350 VSS.n1354 VSS.n974 9.0005
R1351 VSS.n1353 VSS.n973 9.0005
R1352 VSS.n1352 VSS.n972 9.0005
R1353 VSS.n1351 VSS.n971 9.0005
R1354 VSS.n1350 VSS.n970 9.0005
R1355 VSS.n1349 VSS.n969 9.0005
R1356 VSS.n1348 VSS.n968 9.0005
R1357 VSS.n1347 VSS.n966 9.0005
R1358 VSS.n1346 VSS.n965 9.0005
R1359 VSS.n1345 VSS.n964 9.0005
R1360 VSS.n1344 VSS.n963 9.0005
R1361 VSS.n1343 VSS.n962 9.0005
R1362 VSS.n1342 VSS.n961 9.0005
R1363 VSS.n1341 VSS.n960 9.0005
R1364 VSS.n1340 VSS.n959 9.0005
R1365 VSS.n1339 VSS.n958 9.0005
R1366 VSS.n1338 VSS.n956 9.0005
R1367 VSS.n1337 VSS.n955 9.0005
R1368 VSS.n1336 VSS.n954 9.0005
R1369 VSS.n1335 VSS.n953 9.0005
R1370 VSS.n1334 VSS.n952 9.0005
R1371 VSS.n1333 VSS.n951 9.0005
R1372 VSS.n1332 VSS.n950 9.0005
R1373 VSS.n1331 VSS.n949 9.0005
R1374 VSS.n1330 VSS.n948 9.0005
R1375 VSS.n1329 VSS.n947 9.0005
R1376 VSS.n1328 VSS.n945 9.0005
R1377 VSS.n1327 VSS.n944 9.0005
R1378 VSS.n1326 VSS.n943 9.0005
R1379 VSS.n1325 VSS.n942 9.0005
R1380 VSS.n1324 VSS.n941 9.0005
R1381 VSS.n1323 VSS.n940 9.0005
R1382 VSS.n1322 VSS.n939 9.0005
R1383 VSS.n1321 VSS.n938 9.0005
R1384 VSS.n1320 VSS.n937 9.0005
R1385 VSS.n1319 VSS.n936 9.0005
R1386 VSS.n1318 VSS.n934 9.0005
R1387 VSS.n1317 VSS.n933 9.0005
R1388 VSS.n1316 VSS.n932 9.0005
R1389 VSS.n1315 VSS.n931 9.0005
R1390 VSS.n1314 VSS.n930 9.0005
R1391 VSS.n1313 VSS.n929 9.0005
R1392 VSS.n1312 VSS.n928 9.0005
R1393 VSS.n1311 VSS.n927 9.0005
R1394 VSS.n1310 VSS.n926 9.0005
R1395 VSS.n1309 VSS.n924 9.0005
R1396 VSS.n1308 VSS.n923 9.0005
R1397 VSS.n1307 VSS.n922 9.0005
R1398 VSS.n1306 VSS.n921 9.0005
R1399 VSS.n1305 VSS.n920 9.0005
R1400 VSS.n1304 VSS.n919 9.0005
R1401 VSS.n1303 VSS.n918 9.0005
R1402 VSS.n1302 VSS.n917 9.0005
R1403 VSS.n1301 VSS.n916 9.0005
R1404 VSS.n1300 VSS.n915 9.0005
R1405 VSS.n1299 VSS.n913 9.0005
R1406 VSS.n1298 VSS.n912 9.0005
R1407 VSS.n1297 VSS.n911 9.0005
R1408 VSS.n1296 VSS.n910 9.0005
R1409 VSS.n1295 VSS.n909 9.0005
R1410 VSS.n1294 VSS.n908 9.0005
R1411 VSS.n1293 VSS.n907 9.0005
R1412 VSS.n1292 VSS.n906 9.0005
R1413 VSS.n1291 VSS.n905 9.0005
R1414 VSS.n1057 VSS.n1054 9.0005
R1415 VSS.n1053 VSS.n1029 9.0005
R1416 VSS.n1052 VSS.n1051 9.0005
R1417 VSS.n1048 VSS.n1030 9.0005
R1418 VSS.n1047 VSS.n1044 9.0005
R1419 VSS.n1043 VSS.n1031 9.0005
R1420 VSS.n1042 VSS.n1041 9.0005
R1421 VSS.n1033 VSS.n1032 9.0005
R1422 VSS.n1036 VSS.n1035 9.0005
R1423 VSS.n1034 VSS.n1009 9.0005
R1424 VSS.n1278 VSS.n1008 9.0005
R1425 VSS.n1279 VSS.n1007 9.0005
R1426 VSS.n1006 VSS.n1002 9.0005
R1427 VSS.n1005 VSS.n1000 9.0005
R1428 VSS.n1282 VSS.n999 9.0005
R1429 VSS.n1283 VSS.n998 9.0005
R1430 VSS.n993 VSS.n992 9.0005
R1431 VSS.n1287 VSS.n1286 9.0005
R1432 VSS.n1214 VSS.n1179 9.0005
R1433 VSS.n1215 VSS.n1178 9.0005
R1434 VSS.n1177 VSS.n1174 9.0005
R1435 VSS.n1176 VSS.n1173 9.0005
R1436 VSS.n1220 VSS.n1172 9.0005
R1437 VSS.n1221 VSS.n1171 9.0005
R1438 VSS.n1170 VSS.n1166 9.0005
R1439 VSS.n1169 VSS.n1164 9.0005
R1440 VSS.n1224 VSS.n1163 9.0005
R1441 VSS.n1225 VSS.n1162 9.0005
R1442 VSS.n1161 VSS.n1158 9.0005
R1443 VSS.n1160 VSS.n1157 9.0005
R1444 VSS.n1231 VSS.n1156 9.0005
R1445 VSS.n1232 VSS.n1155 9.0005
R1446 VSS.n1154 VSS.n1151 9.0005
R1447 VSS.n1153 VSS.n1150 9.0005
R1448 VSS.n1238 VSS.n1149 9.0005
R1449 VSS.n1239 VSS.n1148 9.0005
R1450 VSS.n1147 VSS.n1144 9.0005
R1451 VSS.n1146 VSS.n1142 9.0005
R1452 VSS.n1245 VSS.n1141 9.0005
R1453 VSS.n1246 VSS.n1140 9.0005
R1454 VSS.n1139 VSS.n1135 9.0005
R1455 VSS.n1248 VSS.n1134 9.0005
R1456 VSS.n1249 VSS.n1133 9.0005
R1457 VSS.n1250 VSS.n1132 9.0005
R1458 VSS.n1131 VSS.n1128 9.0005
R1459 VSS.n1130 VSS.n1126 9.0005
R1460 VSS.n1254 VSS.n1125 9.0005
R1461 VSS.n1255 VSS.n1124 9.0005
R1462 VSS.n1123 VSS.n1119 9.0005
R1463 VSS.n1122 VSS.n1118 9.0005
R1464 VSS.n1257 VSS.n1117 9.0005
R1465 VSS.n1258 VSS.n1116 9.0005
R1466 VSS.n1115 VSS.n1111 9.0005
R1467 VSS.n1114 VSS.n1109 9.0005
R1468 VSS.n1261 VSS.n1108 9.0005
R1469 VSS.n1262 VSS.n1107 9.0005
R1470 VSS.n1106 VSS.n1102 9.0005
R1471 VSS.n1265 VSS.n1101 9.0005
R1472 VSS.n1266 VSS.n1100 9.0005
R1473 VSS.n1267 VSS.n1099 9.0005
R1474 VSS.n1098 VSS.n1027 9.0005
R1475 VSS.n1097 VSS.n1096 9.0005
R1476 VSS.n1084 VSS.n1083 9.0005
R1477 VSS.n1090 VSS.n1060 9.0005
R1478 VSS.n1089 VSS.n1088 9.0005
R1479 VSS.n1087 VSS.n1078 9.0005
R1480 VSS.n1086 VSS.n1085 9.0005
R1481 VSS.n1069 VSS.n1068 9.0005
R1482 VSS.n1070 VSS.n1062 9.0005
R1483 VSS.n1077 VSS.n1076 9.0005
R1484 VSS.n1073 VSS.n1061 9.0005
R1485 VSS.n1072 VSS.n1071 9.0005
R1486 VSS.n1824 VSS.n17 8.501
R1487 VSS.n1825 VSS.n1824 8.501
R1488 VSS.n1824 VSS.n1775 8.501
R1489 VSS.n1824 VSS.n1778 8.501
R1490 VSS.n1824 VSS.n1779 8.501
R1491 VSS.n1824 VSS.n1787 8.501
R1492 VSS.n1824 VSS.n1774 8.501
R1493 VSS.n1824 VSS.n1790 8.501
R1494 VSS.n1824 VSS.n1796 8.501
R1495 VSS.n1824 VSS.n1807 8.501
R1496 VSS.n1824 VSS.n1771 8.501
R1497 VSS.n1824 VSS.n1816 8.501
R1498 VSS.n1824 VSS.n1770 8.501
R1499 VSS.n1824 VSS.n1818 8.501
R1500 VSS.n1824 VSS.n1823 8.501
R1501 VSS.n2001 VSS.n40 8.501
R1502 VSS.n2001 VSS.n39 8.501
R1503 VSS.n2001 VSS.n41 8.501
R1504 VSS.n2001 VSS.n38 8.501
R1505 VSS.n2001 VSS.n42 8.501
R1506 VSS.n2001 VSS.n37 8.501
R1507 VSS.n2001 VSS.n36 8.501
R1508 VSS.n2001 VSS.n35 8.501
R1509 VSS.n2001 VSS.n33 8.501
R1510 VSS.n1572 VSS.n261 8.501
R1511 VSS.n1550 VSS.n389 8.501
R1512 VSS.n1550 VSS.n390 8.501
R1513 VSS.n1550 VSS.n391 8.501
R1514 VSS.n1551 VSS.n1550 8.501
R1515 VSS.n4 VSS.n5 5.33454
R1516 VSS.n1550 VSS.n385 8.501
R1517 VSS.n1550 VSS.n383 8.501
R1518 VSS.n1550 VSS.n392 8.501
R1519 VSS.n1550 VSS.n386 8.501
R1520 VSS.n1550 VSS.n393 8.501
R1521 VSS.n1550 VSS.n394 8.501
R1522 VSS.n1187 VSS.n1184 8.501
R1523 VSS.n1187 VSS.n1183 8.501
R1524 VSS.n1275 VSS.n1013 8.501
R1525 VSS.n1276 VSS.n1275 8.501
R1526 VSS.n1544 VSS.n642 8.501
R1527 VSS.n1544 VSS.n895 8.501
R1528 VSS.n1544 VSS.n894 8.501
R1529 VSS.n1544 VSS.n896 8.501
R1530 VSS.n1544 VSS.n898 8.501
R1531 VSS.n1544 VSS.n891 8.501
R1532 VSS.n1544 VSS.n890 8.501
R1533 VSS.n1544 VSS.n899 8.501
R1534 VSS.n1544 VSS.n889 8.501
R1535 VSS.n1544 VSS.n900 8.501
R1536 VSS.n1544 VSS.n886 8.501
R1537 VSS.n1544 VSS.n885 8.501
R1538 VSS.n1603 VSS.n18 8.501
R1539 VSS.n1662 VSS.n1603 8.501
R1540 VSS.n1664 VSS.n1603 8.501
R1541 VSS.n1670 VSS.n1603 8.501
R1542 VSS.n1625 VSS.n1603 8.501
R1543 VSS.n1679 VSS.n1603 8.501
R1544 VSS.n1683 VSS.n1603 8.501
R1545 VSS.n1685 VSS.n1603 8.501
R1546 VSS.n1620 VSS.n1603 8.501
R1547 VSS.n1692 VSS.n1603 8.501
R1548 VSS.n1603 VSS.n1601 8.501
R1549 VSS.n1603 VSS.n1598 8.501
R1550 VSS.n1603 VSS.n1602 8.501
R1551 VSS.n1572 VSS.n118 8.501
R1552 VSS.n1572 VSS.n1571 8.501
R1553 VSS.n1572 VSS.n260 8.501
R1554 VSS.n1572 VSS.n259 8.501
R1555 VSS.n1572 VSS.n258 8.501
R1556 VSS.n10 VSS.n351 8.5005
R1557 VSS.n10 VSS.n361 8.5005
R1558 VSS.n1553 VSS.n1552 8.49109
R1559 VSS.n10 VSS.n341 8.48883
R1560 VSS.n1528 VSS.n1527 8.47784
R1561 VSS.n1529 VSS.n1526 8.47784
R1562 VSS.n1531 VSS.n1524 8.47784
R1563 VSS.n1534 VSS.n1521 8.47784
R1564 VSS.n1535 VSS.n1520 8.47784
R1565 VSS.n1536 VSS.n1519 8.47784
R1566 VSS.n1537 VSS.n1518 8.47784
R1567 VSS.n1538 VSS.n1517 8.47784
R1568 VSS.n1539 VSS.n1516 8.47784
R1569 VSS.n1513 VSS.n1512 8.47784
R1570 VSS.n1511 VSS.n1510 8.47784
R1571 VSS.n2003 VSS.n16 8.47732
R1572 VSS.t146 VSS.n1826 8.47732
R1573 VSS.n1769 VSS.t4 8.47732
R1574 VSS.n1777 VSS.n1776 8.47732
R1575 VSS.n1783 VSS.n1782 8.47732
R1576 VSS.n1784 VSS.n1781 8.47732
R1577 VSS.n1786 VSS.n1785 8.47732
R1578 VSS.n1789 VSS.n1788 8.47732
R1579 VSS.n1792 VSS.n1791 8.47732
R1580 VSS.n1799 VSS.n1798 8.47732
R1581 VSS.n1806 VSS.n1805 8.47732
R1582 VSS.n1801 VSS.n1756 8.47732
R1583 VSS.n1810 VSS.n1809 8.47732
R1584 VSS.n1813 VSS.n1812 8.47732
R1585 VSS.n1815 VSS.n1814 8.47732
R1586 VSS.n1817 VSS.t13 8.47732
R1587 VSS.n1821 VSS.n1820 8.47732
R1588 VSS.n1860 VSS.n1859 8.47732
R1589 VSS.n1860 VSS.n176 8.47732
R1590 VSS.n1860 VSS.n173 8.47732
R1591 VSS.n1860 VSS.n171 8.47732
R1592 VSS.n1860 VSS.n168 8.47732
R1593 VSS.n1860 VSS.n165 8.47732
R1594 VSS.n1860 VSS.n162 8.47732
R1595 VSS.n1860 VSS.n160 8.47732
R1596 VSS.n1860 VSS.n157 8.47732
R1597 VSS.n1860 VSS.n155 8.47732
R1598 VSS.n1860 VSS.n152 8.47732
R1599 VSS.n1860 VSS.n149 8.47732
R1600 VSS.n1860 VSS.n147 8.47732
R1601 VSS.n1860 VSS.n144 8.47732
R1602 VSS.n1860 VSS.n141 8.47732
R1603 VSS.n1860 VSS.n134 8.47732
R1604 VSS.n1860 VSS.n132 8.47732
R1605 VSS.n1860 VSS.n129 8.47732
R1606 VSS.n2003 VSS.n13 8.47732
R1607 VSS.n1860 VSS.n126 8.47732
R1608 VSS.n1860 VSS.n124 8.47732
R1609 VSS.n1974 VSS.n32 8.47732
R1610 VSS.n1976 VSS.n67 8.47732
R1611 VSS.n1978 VSS.n65 8.47732
R1612 VSS.n1980 VSS.n63 8.47732
R1613 VSS.n1982 VSS.n61 8.47732
R1614 VSS.n1984 VSS.n59 8.47732
R1615 VSS.n1986 VSS.n57 8.47732
R1616 VSS.n1988 VSS.n55 8.47732
R1617 VSS.n1992 VSS.n52 8.47732
R1618 VSS.n1996 VSS.n48 8.47732
R1619 VSS.n1999 VSS.n45 8.47732
R1620 VSS.n1927 VSS.n44 8.47732
R1621 VSS.n1925 VSS.n44 8.47732
R1622 VSS.n73 VSS.n44 8.47732
R1623 VSS.n1916 VSS.n44 8.47732
R1624 VSS.n1914 VSS.n44 8.47732
R1625 VSS.n1912 VSS.n44 8.47732
R1626 VSS.n77 VSS.n44 8.47732
R1627 VSS.n1904 VSS.n44 8.47732
R1628 VSS.n1902 VSS.n44 8.47732
R1629 VSS.n1900 VSS.n44 8.47732
R1630 VSS.n81 VSS.n44 8.47732
R1631 VSS.n1892 VSS.n44 8.47732
R1632 VSS.n1890 VSS.n44 8.47732
R1633 VSS.n1888 VSS.n44 8.47732
R1634 VSS.n85 VSS.n44 8.47732
R1635 VSS.n1880 VSS.n44 8.47732
R1636 VSS.n1878 VSS.n44 8.47732
R1637 VSS.n1876 VSS.n44 8.47732
R1638 VSS.n89 VSS.n44 8.47732
R1639 VSS.n1868 VSS.n44 8.47732
R1640 VSS.n1866 VSS.n44 8.47732
R1641 VSS.n1864 VSS.n44 8.47732
R1642 VSS.n2003 VSS.n22 8.47732
R1643 VSS.n2003 VSS.n23 8.47732
R1644 VSS.n2003 VSS.n25 8.47732
R1645 VSS.n2003 VSS.n26 8.47732
R1646 VSS.n2003 VSS.n27 8.47732
R1647 VSS.n2003 VSS.n28 8.47732
R1648 VSS.n2003 VSS.n30 8.47732
R1649 VSS.n1547 VSS.n638 8.47732
R1650 VSS.n1547 VSS.n634 8.47732
R1651 VSS.n1547 VSS.n633 8.47732
R1652 VSS.n1547 VSS.n629 8.47732
R1653 VSS.n1547 VSS.n625 8.47732
R1654 VSS.n1547 VSS.n622 8.47732
R1655 VSS.n1547 VSS.n621 8.47732
R1656 VSS.n1547 VSS.n620 8.47732
R1657 VSS.n1547 VSS.t58 8.47732
R1658 VSS.n1547 VSS.n619 8.47732
R1659 VSS.n1547 VSS.n618 8.47732
R1660 VSS.n1547 VSS.n614 8.47732
R1661 VSS.n1547 VSS.n611 8.47732
R1662 VSS.n1547 VSS.n608 8.47732
R1663 VSS.n1547 VSS.n605 8.47732
R1664 VSS.n1547 VSS.n602 8.47732
R1665 VSS.n1547 VSS.n599 8.47732
R1666 VSS.n1547 VSS.n598 8.47732
R1667 VSS.n1547 VSS.n597 8.47732
R1668 VSS.n1547 VSS.n596 8.47732
R1669 VSS.n1547 VSS.n595 8.47732
R1670 VSS.n1547 VSS.n591 8.47732
R1671 VSS.n1547 VSS.n588 8.47732
R1672 VSS.n1547 VSS.n587 8.47732
R1673 VSS.n1547 VSS.n586 8.47732
R1674 VSS.n1547 VSS.n585 8.47732
R1675 VSS.n1547 VSS.n584 8.47732
R1676 VSS.n1547 VSS.n577 8.47732
R1677 VSS.n1547 VSS.n576 8.47732
R1678 VSS.n1547 VSS.n575 8.47732
R1679 VSS.n1547 VSS.n572 8.47732
R1680 VSS.n1547 VSS.n571 8.47732
R1681 VSS.n1547 VSS.n567 8.47732
R1682 VSS.n1547 VSS.n566 8.47732
R1683 VSS.n1547 VSS.n565 8.47732
R1684 VSS.n1547 VSS.n563 8.47732
R1685 VSS.n1547 VSS.n562 8.47732
R1686 VSS.n1547 VSS.n561 8.47732
R1687 VSS.n1547 VSS.n557 8.47732
R1688 VSS.n1547 VSS.n554 8.47732
R1689 VSS.n1547 VSS.n553 8.47732
R1690 VSS.n1547 VSS.n549 8.47732
R1691 VSS.n1547 VSS.n548 8.47732
R1692 VSS.n1547 VSS.n547 8.47732
R1693 VSS.n1547 VSS.n543 8.47732
R1694 VSS.n1547 VSS.n540 8.47732
R1695 VSS.n1547 VSS.n539 8.47732
R1696 VSS.n1547 VSS.n535 8.47732
R1697 VSS.n1547 VSS.n532 8.47732
R1698 VSS.n1547 VSS.n531 8.47732
R1699 VSS.n1547 VSS.n530 8.47732
R1700 VSS.n1547 VSS.n529 8.47732
R1701 VSS.n1547 VSS.n521 8.47732
R1702 VSS.n1547 VSS.n518 8.47732
R1703 VSS.n1547 VSS.n517 8.47732
R1704 VSS.n1547 VSS.n513 8.47732
R1705 VSS.n1547 VSS.n509 8.47732
R1706 VSS.n1547 VSS.n508 8.47732
R1707 VSS.n1547 VSS.n504 8.47732
R1708 VSS.n1547 VSS.n503 8.47732
R1709 VSS.n1547 VSS.n495 8.47732
R1710 VSS.n1547 VSS.n492 8.47732
R1711 VSS.n1547 VSS.n489 8.47732
R1712 VSS.n1547 VSS.n487 8.47732
R1713 VSS.n1547 VSS.n483 8.47732
R1714 VSS.n1547 VSS.n480 8.47732
R1715 VSS.n1547 VSS.n479 8.47732
R1716 VSS.n1547 VSS.n476 8.47732
R1717 VSS.n1547 VSS.t45 8.47732
R1718 VSS.n10 VSS.n352 8.47732
R1719 VSS.n10 VSS.n359 8.47732
R1720 VSS.n10 VSS.n362 8.47732
R1721 VSS.n10 VSS.n372 8.47732
R1722 VSS.n10 VSS.n347 8.47732
R1723 VSS.n10 VSS.n343 8.47732
R1724 VSS.t30 VSS.n395 8.47732
R1725 VSS.n1369 VSS.n395 8.47732
R1726 VSS.n1371 VSS.n395 8.47732
R1727 VSS.n1373 VSS.n395 8.47732
R1728 VSS.n1375 VSS.n395 8.47732
R1729 VSS.n1377 VSS.n395 8.47732
R1730 VSS.n1379 VSS.n395 8.47732
R1731 VSS.n1381 VSS.n395 8.47732
R1732 VSS.n1383 VSS.n395 8.47732
R1733 VSS.n1387 VSS.n395 8.47732
R1734 VSS.n1389 VSS.n395 8.47732
R1735 VSS.n1391 VSS.n395 8.47732
R1736 VSS.n1393 VSS.n395 8.47732
R1737 VSS.n1395 VSS.n395 8.47732
R1738 VSS.n1397 VSS.n395 8.47732
R1739 VSS.n1399 VSS.n395 8.47732
R1740 VSS.n1401 VSS.n395 8.47732
R1741 VSS.n1405 VSS.n395 8.47732
R1742 VSS.n1407 VSS.n395 8.47732
R1743 VSS.n1409 VSS.n395 8.47732
R1744 VSS.n1411 VSS.n395 8.47732
R1745 VSS.n1413 VSS.n395 8.47732
R1746 VSS.n1415 VSS.n395 8.47732
R1747 VSS.n1417 VSS.n395 8.47732
R1748 VSS.n1419 VSS.n395 8.47732
R1749 VSS.n957 VSS.n395 8.47732
R1750 VSS.n1421 VSS.n395 8.47732
R1751 VSS.n1423 VSS.n395 8.47732
R1752 VSS.n1425 VSS.n395 8.47732
R1753 VSS.n1427 VSS.n395 8.47732
R1754 VSS.n1429 VSS.n395 8.47732
R1755 VSS.n1431 VSS.n395 8.47732
R1756 VSS.n1433 VSS.n395 8.47732
R1757 VSS.n1435 VSS.n395 8.47732
R1758 VSS.n1439 VSS.n395 8.47732
R1759 VSS.n1441 VSS.n395 8.47732
R1760 VSS.n1443 VSS.n395 8.47732
R1761 VSS.n1445 VSS.n395 8.47732
R1762 VSS.n1447 VSS.n395 8.47732
R1763 VSS.n1449 VSS.n395 8.47732
R1764 VSS.n1451 VSS.n395 8.47732
R1765 VSS.n1453 VSS.n395 8.47732
R1766 VSS.n1457 VSS.n395 8.47732
R1767 VSS.n1459 VSS.n395 8.47732
R1768 VSS.n1461 VSS.n395 8.47732
R1769 VSS.n1463 VSS.n395 8.47732
R1770 VSS.n1465 VSS.n395 8.47732
R1771 VSS.n1467 VSS.n395 8.47732
R1772 VSS.n1469 VSS.n395 8.47732
R1773 VSS.n1471 VSS.n395 8.47732
R1774 VSS.n925 VSS.n395 8.47732
R1775 VSS.n1473 VSS.n395 8.47732
R1776 VSS.n1475 VSS.n395 8.47732
R1777 VSS.n1477 VSS.n395 8.47732
R1778 VSS.n1479 VSS.n395 8.47732
R1779 VSS.n1481 VSS.n395 8.47732
R1780 VSS.n1483 VSS.n395 8.47732
R1781 VSS.n1485 VSS.n395 8.47732
R1782 VSS.n1487 VSS.n395 8.47732
R1783 VSS.n1489 VSS.n395 8.47732
R1784 VSS.t42 VSS.n395 8.47732
R1785 VSS.n1491 VSS.n395 8.47732
R1786 VSS.n1493 VSS.n395 8.47732
R1787 VSS.n1495 VSS.n395 8.47732
R1788 VSS.n1497 VSS.n395 8.47732
R1789 VSS.n1499 VSS.n395 8.47732
R1790 VSS.n1501 VSS.n395 8.47732
R1791 VSS.n1503 VSS.n395 8.47732
R1792 VSS.n1505 VSS.n395 8.47732
R1793 VSS.n2003 VSS.n20 8.47732
R1794 VSS.n2003 VSS.n19 8.47732
R1795 VSS.n1661 VSS.t140 8.47732
R1796 VSS.n1663 VSS.n1660 8.47732
R1797 VSS.n1667 VSS.n1644 8.47732
R1798 VSS.n1669 VSS.n1642 8.47732
R1799 VSS.n1640 VSS.n1627 8.47732
R1800 VSS.n1678 VSS.n1677 8.47732
R1801 VSS.n1680 VSS.n1624 8.47732
R1802 VSS.n1682 VSS.n1622 8.47732
R1803 VSS.n1684 VSS.n1621 8.47732
R1804 VSS.n1617 VSS.n1686 8.47732
R1805 VSS.n1691 VSS.n1690 8.47732
R1806 VSS.n1693 VSS.n1605 8.47732
R1807 VSS.n1600 VSS.n1595 8.47732
R1808 VSS.n1599 VSS.n1589 8.47732
R1809 VSS.n1704 VSS.n1588 8.47732
R1810 VSS.n1583 VSS.n1577 8.47732
R1811 VSS.n1713 VSS.n1577 8.47732
R1812 VSS.n1578 VSS.n1577 8.47732
R1813 VSS.n1718 VSS.n1577 8.47732
R1814 VSS.n1720 VSS.n1577 8.47732
R1815 VSS.n1577 VSS.n209 8.47732
R1816 VSS.n1577 VSS.n211 8.47732
R1817 VSS.n1577 VSS.n217 8.47732
R1818 VSS.n1577 VSS.n219 8.47732
R1819 VSS.n1577 VSS.n223 8.47732
R1820 VSS.n1568 VSS.n263 8.47732
R1821 VSS.n1570 VSS.n1569 8.47732
R1822 VSS.n334 VSS.n333 8.47732
R1823 VSS.n257 VSS.n231 8.47732
R1824 VSS.n1547 VSS.n475 8.47677
R1825 VSS.n474 VSS.n473 8.47677
R1826 VSS.n472 VSS.n471 8.47677
R1827 VSS.n470 VSS.n469 8.47677
R1828 VSS.n468 VSS.n384 8.47677
R1829 VSS.n1554 VSS.n380 8.47677
R1830 VSS.n1555 VSS.n379 8.47677
R1831 VSS.n1556 VSS.n378 8.47677
R1832 VSS.n1557 VSS.n377 8.47677
R1833 VSS.n1558 VSS.n376 8.47677
R1834 VSS.n1547 VSS.n641 8.4742
R1835 VSS.n1509 VSS.n395 8.4742
R1836 VSS.n1561 VSS.n1560 8.47111
R1837 VSS.t76 VSS.n255 8.47111
R1838 VSS.t76 VSS.n236 8.47111
R1839 VSS.t76 VSS.n252 8.47111
R1840 VSS.t76 VSS.n249 8.47111
R1841 VSS.n1561 VSS.t95 8.47111
R1842 VSS.n1217 VSS.t24 8.47111
R1843 VSS.n1168 VSS.t24 8.47111
R1844 VSS.n1222 VSS.t70 8.47111
R1845 VSS.n1159 VSS.t70 8.47111
R1846 VSS.n1228 VSS.t70 8.47111
R1847 VSS.n1152 VSS.t70 8.47111
R1848 VSS.n1235 VSS.t70 8.47111
R1849 VSS.t70 VSS.n1145 8.47111
R1850 VSS.n1242 VSS.n1143 8.47111
R1851 VSS.n1185 VSS.n1138 8.47111
R1852 VSS.n1136 VSS.n1104 8.47111
R1853 VSS.n1252 VSS.n1104 8.47111
R1854 VSS.n1121 VSS.n1104 8.47111
R1855 VSS.n1113 VSS.n1104 8.47111
R1856 VSS.n1260 VSS.n1104 8.47111
R1857 VSS.n1105 VSS.n1104 8.47111
R1858 VSS.n1103 VSS.n1104 8.47111
R1859 VSS.t79 VSS.n1268 8.47111
R1860 VSS.t79 VSS.n1015 8.47111
R1861 VSS.t79 VSS.n1017 8.47111
R1862 VSS.t79 VSS.n1018 8.47111
R1863 VSS.t79 VSS.n1019 8.47111
R1864 VSS.t79 VSS.n1020 8.47111
R1865 VSS.n1038 VSS.n1012 8.47111
R1866 VSS.n1004 VSS.n1277 8.47111
R1867 VSS.n1281 VSS.n996 8.47111
R1868 VSS.n997 VSS.n996 8.47111
R1869 VSS.n995 VSS.n996 8.47111
R1870 VSS.n996 VSS.n990 8.47111
R1871 VSS.n1577 VSS.n228 8.46924
R1872 VSS.n2008 VSS.n2007 7.85649
R1873 VSS.n630 VSS.t43 5.81305
R1874 VSS.n1210 VSS.n1209 5.66923
R1875 VSS.n1824 VSS.n1773 5.66778
R1876 VSS.n1824 VSS.n1800 5.66778
R1877 VSS.n1824 VSS.n1772 5.66778
R1878 VSS.n1824 VSS.n1808 5.66778
R1879 VSS.n2001 VSS.n43 5.66778
R1880 VSS.n2001 VSS.n34 5.66778
R1881 VSS.t134 VSS.n94 5.66778
R1882 VSS.n1572 VSS.n120 5.66778
R1883 VSS.n1550 VSS.n387 5.66778
R1884 VSS.n1544 VSS.n893 5.66778
R1885 VSS.n1544 VSS.n892 5.66778
R1886 VSS.n1544 VSS.n897 5.66778
R1887 VSS.n1544 VSS.n888 5.66778
R1888 VSS.n1544 VSS.n1543 5.66778
R1889 VSS.n1544 VSS.n887 5.66778
R1890 VSS.n1666 VSS.n1603 5.66778
R1891 VSS.n1668 VSS.n1603 5.66778
R1892 VSS.n1641 VSS.n1603 5.66778
R1893 VSS.n1681 VSS.n1603 5.66778
R1894 VSS.n1606 VSS.n1603 5.66778
R1895 VSS.n1694 VSS.n1603 5.66778
R1896 VSS.n1603 VSS.n1597 5.66778
R1897 VSS.n1572 VSS.n262 5.66778
R1898 VSS.n1187 VSS.n1186 5.66767
R1899 VSS.n1275 VSS.n1011 5.66767
R1900 VSS.n1181 VSS.t24 5.66031
R1901 VSS.n1574 VSS.t76 5.65099
R1902 VSS.n1577 VSS.n1576 5.64619
R1903 VSS.n1566 VSS.n1565 5.63075
R1904 VSS.n1530 VSS.n1525 5.62674
R1905 VSS.n1532 VSS.n1523 5.62674
R1906 VSS.n1533 VSS.n1522 5.62674
R1907 VSS.n1540 VSS.n1515 5.62674
R1908 VSS.n1542 VSS.n1541 5.62674
R1909 VSS.n1514 VSS.n901 5.62674
R1910 VSS.n1795 VSS.n1794 5.62581
R1911 VSS.n1803 VSS.n1802 5.62581
R1912 VSS.n1822 VSS.n179 5.62581
R1913 VSS.n1860 VSS.n111 5.62581
R1914 VSS.n1994 VSS.n50 5.62581
R1915 VSS.n2003 VSS.n24 5.62581
R1916 VSS.n2003 VSS.n31 5.62581
R1917 VSS.n1547 VSS.n397 5.62581
R1918 VSS.n1547 VSS.n426 5.62581
R1919 VSS.n1547 VSS.n564 5.62581
R1920 VSS.n1547 VSS.n524 5.62581
R1921 VSS.n1547 VSS.n499 5.62581
R1922 VSS.n10 VSS.n371 5.62581
R1923 VSS.n1385 VSS.n395 5.62581
R1924 VSS.n1403 VSS.n395 5.62581
R1925 VSS.n1437 VSS.n395 5.62581
R1926 VSS.n1455 VSS.n395 5.62581
R1927 VSS.n1507 VSS.n395 5.62581
R1928 VSS.n1665 VSS.n1645 5.62581
R1929 VSS.n1672 VSS.n1671 5.62581
R1930 VSS.n1619 VSS.n1608 5.62581
R1931 VSS.n1696 VSS.n1695 5.62581
R1932 VSS.n1577 VSS.n194 5.62581
R1933 VSS.n1577 VSS.n213 5.62581
R1934 VSS.n1577 VSS.n221 5.62581
R1935 VSS.n1577 VSS.n226 5.62581
R1936 VSS.t76 VSS.n254 5.61485
R1937 VSS.n172 VSS.t14 4.79743
R1938 VSS.n330 VSS.n329 4.73162
R1939 VSS.n1649 VSS.n1648 4.73162
R1940 VSS.n289 VSS.n288 4.73162
R1941 VSS.n1952 VSS.n1949 4.73162
R1942 VSS.n646 VSS.n645 4.73162
R1943 VSS.n1367 VSS.n1366 4.73162
R1944 VSS.n1291 VSS.n902 4.73162
R1945 VSS.n1180 VSS.n1179 4.64666
R1946 VSS.n1288 VSS.n1287 4.64666
R1947 VSS.n1084 VSS.n1079 4.64666
R1948 VSS.n1069 VSS.n1065 4.64666
R1949 VSS.n1274 VSS.t80 4.49152
R1950 VSS.n1197 VSS.t2 4.49152
R1951 VSS.n727 VSS.n93 4.4712
R1952 VSS.n1094 VSS.n1058 4.4712
R1953 VSS.n1093 VSS.n1092 4.4712
R1954 VSS.n1094 VSS.n1028 4.46488
R1955 VSS.n728 VSS.n727 4.46488
R1956 VSS.n1093 VSS.n1091 4.46488
R1957 VSS.n340 VSS.t132 4.28775
R1958 VSS.n2001 VSS.n2000 4.25119
R1959 VSS.n1572 VSS.n230 4.251
R1960 VSS.n10 VSS.n367 4.19225
R1961 VSS.n1211 VSS.n1210 3.52606
R1962 VSS.n1824 VSS.n177 3.40112
R1963 VSS.n729 VSS.n728 3.37628
R1964 VSS.n2003 VSS.n14 3.3265
R1965 VSS.n10 VSS.n357 3.32633
R1966 VSS.n1547 VSS.n1546 3.24021
R1967 VSS.n1547 VSS.n640 3.24021
R1968 VSS.n1547 VSS.n398 3.24021
R1969 VSS.n1547 VSS.n637 3.24021
R1970 VSS.n1547 VSS.n399 3.24021
R1971 VSS.n1547 VSS.n632 3.24021
R1972 VSS.n1547 VSS.n628 3.24021
R1973 VSS.n1547 VSS.n624 3.24021
R1974 VSS.n1547 VSS.n401 3.24021
R1975 VSS.n1547 VSS.n403 3.24021
R1976 VSS.n1547 VSS.n405 3.24021
R1977 VSS.n1547 VSS.n407 3.24021
R1978 VSS.n1547 VSS.n409 3.24021
R1979 VSS.n1547 VSS.n617 3.24021
R1980 VSS.n1547 VSS.n613 3.24021
R1981 VSS.n1547 VSS.n607 3.24021
R1982 VSS.n1547 VSS.n604 3.24021
R1983 VSS.n1547 VSS.n601 3.24021
R1984 VSS.n1547 VSS.n410 3.24021
R1985 VSS.n1547 VSS.n412 3.24021
R1986 VSS.n1547 VSS.n414 3.24021
R1987 VSS.n1547 VSS.n416 3.24021
R1988 VSS.n1547 VSS.n594 3.24021
R1989 VSS.n1547 VSS.n590 3.24021
R1990 VSS.n1547 VSS.n419 3.24021
R1991 VSS.n1547 VSS.n421 3.24021
R1992 VSS.n1547 VSS.n423 3.24021
R1993 VSS.n1547 VSS.n425 3.24021
R1994 VSS.n1547 VSS.n583 3.24021
R1995 VSS.n1547 VSS.n579 3.24021
R1996 VSS.n1547 VSS.n427 3.24021
R1997 VSS.n1547 VSS.n429 3.24021
R1998 VSS.n1547 VSS.n431 3.24021
R1999 VSS.n1547 VSS.n434 3.24021
R2000 VSS.n1547 VSS.n570 3.24021
R2001 VSS.n1547 VSS.n435 3.24021
R2002 VSS.n1547 VSS.n437 3.24021
R2003 VSS.n1547 VSS.n439 3.24021
R2004 VSS.n1547 VSS.n441 3.24021
R2005 VSS.n1547 VSS.n443 3.24021
R2006 VSS.n1547 VSS.n445 3.24021
R2007 VSS.n1547 VSS.n447 3.24021
R2008 VSS.n1547 VSS.n556 3.24021
R2009 VSS.n1547 VSS.n448 3.24021
R2010 VSS.n1547 VSS.n552 3.24021
R2011 VSS.n1547 VSS.n449 3.24021
R2012 VSS.n1547 VSS.n451 3.24021
R2013 VSS.n1547 VSS.n546 3.24021
R2014 VSS.n1547 VSS.n542 3.24021
R2015 VSS.n1547 VSS.n452 3.24021
R2016 VSS.n1547 VSS.n538 3.24021
R2017 VSS.n1547 VSS.n454 3.24021
R2018 VSS.n1547 VSS.n456 3.24021
R2019 VSS.n1547 VSS.n458 3.24021
R2020 VSS.n1547 VSS.n460 3.24021
R2021 VSS.n1547 VSS.n527 3.24021
R2022 VSS.n1547 VSS.n523 3.24021
R2023 VSS.n1547 VSS.n520 3.24021
R2024 VSS.n1547 VSS.n461 3.24021
R2025 VSS.n1547 VSS.n516 3.24021
R2026 VSS.n1547 VSS.n512 3.24021
R2027 VSS.n1547 VSS.n463 3.24021
R2028 VSS.n1547 VSS.n507 3.24021
R2029 VSS.n1547 VSS.n464 3.24021
R2030 VSS.n1547 VSS.n502 3.24021
R2031 VSS.n1547 VSS.n465 3.24021
R2032 VSS.n1547 VSS.n498 3.24021
R2033 VSS.n1547 VSS.n494 3.24021
R2034 VSS.n1547 VSS.n491 3.24021
R2035 VSS.n1547 VSS.n486 3.24021
R2036 VSS.n1547 VSS.n482 3.24021
R2037 VSS.n1547 VSS.n467 3.24021
R2038 VSS.n1547 VSS.n478 3.24021
R2039 VSS.n1548 VSS.n1547 3.24021
R2040 VSS.n396 VSS.n395 3.24021
R2041 VSS.n477 VSS.n395 3.24021
R2042 VSS.n481 VSS.n395 3.24021
R2043 VSS.n485 VSS.n395 3.24021
R2044 VSS.n484 VSS.n395 3.24021
R2045 VSS.n490 VSS.n395 3.24021
R2046 VSS.n493 VSS.n395 3.24021
R2047 VSS.n497 VSS.n395 3.24021
R2048 VSS.n496 VSS.n395 3.24021
R2049 VSS.n501 VSS.n395 3.24021
R2050 VSS.n500 VSS.n395 3.24021
R2051 VSS.n506 VSS.n395 3.24021
R2052 VSS.n505 VSS.n395 3.24021
R2053 VSS.n511 VSS.n395 3.24021
R2054 VSS.n510 VSS.n395 3.24021
R2055 VSS.n515 VSS.n395 3.24021
R2056 VSS.n519 VSS.n395 3.24021
R2057 VSS.n522 VSS.n395 3.24021
R2058 VSS.n525 VSS.n395 3.24021
R2059 VSS.n526 VSS.n395 3.24021
R2060 VSS.n459 VSS.n395 3.24021
R2061 VSS.n457 VSS.n395 3.24021
R2062 VSS.n455 VSS.n395 3.24021
R2063 VSS.n533 VSS.n395 3.24021
R2064 VSS.n536 VSS.n395 3.24021
R2065 VSS.n537 VSS.n395 3.24021
R2066 VSS.n541 VSS.n395 3.24021
R2067 VSS.n544 VSS.n395 3.24021
R2068 VSS.n545 VSS.n395 3.24021
R2069 VSS.n450 VSS.n395 3.24021
R2070 VSS.n550 VSS.n395 3.24021
R2071 VSS.n551 VSS.n395 3.24021
R2072 VSS.n555 VSS.n395 3.24021
R2073 VSS.n559 VSS.n395 3.24021
R2074 VSS.n446 VSS.n395 3.24021
R2075 VSS.n444 VSS.n395 3.24021
R2076 VSS.n442 VSS.n395 3.24021
R2077 VSS.n440 VSS.n395 3.24021
R2078 VSS.n438 VSS.n395 3.24021
R2079 VSS.n436 VSS.n395 3.24021
R2080 VSS.n569 VSS.n395 3.24021
R2081 VSS.n568 VSS.n395 3.24021
R2082 VSS.n433 VSS.n395 3.24021
R2083 VSS.n573 VSS.n395 3.24021
R2084 VSS.n430 VSS.n395 3.24021
R2085 VSS.n428 VSS.n395 3.24021
R2086 VSS.n578 VSS.n395 3.24021
R2087 VSS.n582 VSS.n395 3.24021
R2088 VSS.n581 VSS.n395 3.24021
R2089 VSS.n424 VSS.n395 3.24021
R2090 VSS.n422 VSS.n395 3.24021
R2091 VSS.n420 VSS.n395 3.24021
R2092 VSS.n418 VSS.n395 3.24021
R2093 VSS.n592 VSS.n395 3.24021
R2094 VSS.n593 VSS.n395 3.24021
R2095 VSS.n415 VSS.n395 3.24021
R2096 VSS.n413 VSS.n395 3.24021
R2097 VSS.n411 VSS.n395 3.24021
R2098 VSS.n600 VSS.n395 3.24021
R2099 VSS.n603 VSS.n395 3.24021
R2100 VSS.n606 VSS.n395 3.24021
R2101 VSS.n609 VSS.n395 3.24021
R2102 VSS.n616 VSS.n395 3.24021
R2103 VSS.n615 VSS.n395 3.24021
R2104 VSS.n408 VSS.n395 3.24021
R2105 VSS.n406 VSS.n395 3.24021
R2106 VSS.n404 VSS.n395 3.24021
R2107 VSS.n402 VSS.n395 3.24021
R2108 VSS.n623 VSS.n395 3.24021
R2109 VSS.n627 VSS.n395 3.24021
R2110 VSS.n626 VSS.n395 3.24021
R2111 VSS.n631 VSS.n395 3.24021
R2112 VSS.n635 VSS.n395 3.24021
R2113 VSS.n636 VSS.n395 3.24021
R2114 VSS.n639 VSS.n395 3.24021
R2115 VSS.n884 VSS.n395 3.24021
R2116 VSS.n1577 VSS.n229 3.03033
R2117 VSS.n2008 VSS.n11 2.93359
R2118 VSS.n488 VSS.t28 2.90677
R2119 VSS.t39 VSS.n417 2.90677
R2120 VSS.n730 VSS.n93 2.7456
R2121 VSS.n10 VSS.n1 2.74403
R2122 VSS.n1711 VSS.n1577 2.74397
R2123 VSS.n10 VSS.n344 2.74386
R2124 VSS.t76 VSS.n250 2.72142
R2125 VSS.n174 VSS.n44 2.70412
R2126 VSS.n169 VSS.n44 2.70412
R2127 VSS.n166 VSS.n44 2.70412
R2128 VSS.n163 VSS.n44 2.70412
R2129 VSS.n158 VSS.n44 2.70412
R2130 VSS.n153 VSS.n44 2.70412
R2131 VSS.n150 VSS.n44 2.70412
R2132 VSS.n145 VSS.n44 2.70412
R2133 VSS.n142 VSS.n44 2.70412
R2134 VSS.n139 VSS.n44 2.70412
R2135 VSS.n135 VSS.n44 2.70412
R2136 VSS.n130 VSS.n44 2.70412
R2137 VSS.n127 VSS.n44 2.70412
R2138 VSS.n122 VSS.n44 2.70412
R2139 VSS.n1577 VSS.n199 2.70412
R2140 VSS.n1577 VSS.n200 2.70412
R2141 VSS.n1577 VSS.n201 2.70412
R2142 VSS.n1577 VSS.n202 2.70412
R2143 VSS.n1577 VSS.n203 2.70412
R2144 VSS.n1577 VSS.n204 2.70412
R2145 VSS.n1577 VSS.n205 2.70412
R2146 VSS.n1577 VSS.n206 2.70412
R2147 VSS.n1577 VSS.n207 2.70412
R2148 VSS.n1577 VSS.n210 2.70412
R2149 VSS.n1577 VSS.n212 2.70412
R2150 VSS.n1577 VSS.n214 2.70412
R2151 VSS.n1577 VSS.n216 2.70412
R2152 VSS.n1577 VSS.n218 2.70412
R2153 VSS.n1577 VSS.n220 2.70412
R2154 VSS.n1577 VSS.n222 2.70412
R2155 VSS.n1577 VSS.n224 2.70412
R2156 VSS.n1577 VSS.n227 2.70412
R2157 VSS.n728 VSS.n91 2.43862
R2158 VSS.t76 VSS.n237 2.11212
R2159 VSS.n1561 VSS.n373 2.11212
R2160 VSS.t76 VSS.n245 1.97632
R2161 VSS.n1863 VSS.n93 1.83435
R2162 VSS.n2003 VSS.n21 1.7562
R2163 VSS.n2004 VSS.n2003 1.75596
R2164 VSS.n10 VSS.n348 1.75483
R2165 VSS.n1567 VSS.n1564 1.66925
R2166 VSS.n281 VSS.t141 1.43372
R2167 VSS.n264 VSS.t143 1.43372
R2168 VSS.t143 VSS.n265 1.42949
R2169 VSS.t141 VSS.n282 1.42949
R2170 VSS.t113 VSS.t117 1.41892
R2171 VSS.t111 VSS.t116 1.41892
R2172 VSS.t115 VSS.t109 1.41892
R2173 VSS.t114 VSS.t107 1.41892
R2174 VSS.n1654 VSS.t138 1.37661
R2175 VSS.t138 VSS.n1655 1.37661
R2176 VSS.n1070 VSS.n1069 1.3114
R2177 VSS.n2002 VSS.n2001 0.895737
R2178 VSS.n1290 VSS.n375 0.832974
R2179 VSS.t154 VSS.t156 0.806856
R2180 VSS.n724 VSS.t149 0.806855
R2181 VSS.t27 VSS.n358 0.802775
R2182 VSS.n1091 VSS.n1077 0.801519
R2183 VSS.t117 VSS.n291 0.722582
R2184 VSS.t116 VSS.n276 0.722582
R2185 VSS.n312 VSS.t115 0.722582
R2186 VSS.n1726 VSS.t114 0.722582
R2187 VSS.n292 VSS.t113 0.72222
R2188 VSS.n277 VSS.t111 0.72222
R2189 VSS.t109 VSS.n311 0.72222
R2190 VSS.t107 VSS.n1725 0.72222
R2191 VSS.n1559 VSS.n375 0.710232
R2192 VSS.n382 VSS.n381 0.6955
R2193 VSS.n2007 VSS.n12 0.692362
R2194 VSS.n1585 VSS.n1584 0.692362
R2195 VSS.n1094 VSS.n1093 0.66578
R2196 VSS.n395 VSS.n375 0.599811
R2197 VSS.n363 VSS.t159 0.595317
R2198 VSS.t157 VSS.n365 0.595317
R2199 VSS.n353 VSS.t153 0.595317
R2200 VSS.t151 VSS.n355 0.595317
R2201 VSS.t95 VSS.n245 0.586866
R2202 VSS.n1202 VSS.t70 0.572871
R2203 VSS.t79 VSS.n1023 0.572871
R2204 VSS.t76 VSS.n239 0.557126
R2205 VSS.n1575 VSS.n1574 0.548518
R2206 VSS.n6 VSS.n348 0.522138
R2207 VSS.t141 VSS.t143 0.492336
R2208 VSS.n1196 VSS.n1104 0.490843
R2209 VSS.n1192 VSS.n1104 0.490843
R2210 VSS.n1190 VSS.n1104 0.490843
R2211 VSS.n1270 VSS.n996 0.490843
R2212 VSS.n1199 VSS.t70 0.489061
R2213 VSS.t79 VSS.n1021 0.489061
R2214 VSS.t76 VSS.n242 0.477286
R2215 VSS.n1550 VSS.n1549 0.477022
R2216 VSS.t76 VSS.n241 0.472981
R2217 VSS.n1630 VSS.n1629 0.461741
R2218 VSS.n1658 VSS.n1651 0.461741
R2219 VSS.n10 VSS.n3 0.453073
R2220 VSS.n364 VSS.n348 0.447055
R2221 VSS.n1085 VSS.n1084 0.437466
R2222 VSS.n21 VSS.n15 0.417336
R2223 VSS.n2005 VSS.n2004 0.417043
R2224 VSS.n2004 VSS.n15 0.416074
R2225 VSS.n1652 VSS.n21 0.415796
R2226 VSS.n1093 VSS.n338 0.41058
R2227 VSS.n245 VSS.n1063 0.407016
R2228 VSS.n1208 VSS.t24 0.400619
R2229 VSS.n1549 VSS.n395 0.398785
R2230 VSS.n1092 VSS.n250 0.354963
R2231 VSS.n1560 VSS.n1559 0.345789
R2232 VSS.n723 VSS.n1 0.338123
R2233 VSS.n1712 VSS.n1711 0.330718
R2234 VSS.n354 VSS.n344 0.312137
R2235 VSS.n1075 VSS.n250 0.296592
R2236 VSS.n1290 VSS.n1289 0.2855
R2237 VSS.n1533 VSS.n1532 0.280152
R2238 VSS.n1541 VSS.n1540 0.280152
R2239 VSS.n1541 VSS.n1514 0.280152
R2240 VSS.t27 VSS.n357 0.275797
R2241 VSS.t76 VSS.n256 0.267335
R2242 VSS.n357 VSS.n353 0.266415
R2243 VSS.n2005 VSS.n14 0.265497
R2244 VSS.n1950 VSS.n14 0.264227
R2245 VSS.t89 VSS.n254 0.240825
R2246 VSS.n1645 VSS.n1644 0.239006
R2247 VSS.n358 VSS.n344 0.238387
R2248 VSS.n1564 VSS.n1 0.238347
R2249 VSS.n1711 VSS.n1710 0.236071
R2250 VSS.n1531 VSS.n1530 0.233757
R2251 VSS.n1534 VSS.n1533 0.233757
R2252 VSS.n1514 VSS.n1513 0.233757
R2253 VSS.n1530 VSS.n1529 0.233419
R2254 VSS.n1532 VSS.n1531 0.233419
R2255 VSS.n1540 VSS.n1539 0.233419
R2256 VSS.n1765 VSS.n12 0.231121
R2257 VSS.n1830 VSS.n1765 0.231121
R2258 VSS.n1831 VSS.n1830 0.231121
R2259 VSS.n1832 VSS.n1831 0.231121
R2260 VSS.n1832 VSS.n1762 0.231121
R2261 VSS.n1836 VSS.n1762 0.231121
R2262 VSS.n1837 VSS.n1836 0.231121
R2263 VSS.n1838 VSS.n1837 0.231121
R2264 VSS.n1838 VSS.n1759 0.231121
R2265 VSS.n1842 VSS.n1759 0.231121
R2266 VSS.n1843 VSS.n1842 0.231121
R2267 VSS.n1844 VSS.n1843 0.231121
R2268 VSS.n1844 VSS.n1754 0.231121
R2269 VSS.n1848 VSS.n1754 0.231121
R2270 VSS.n1849 VSS.n1848 0.231121
R2271 VSS.n1850 VSS.n1849 0.231121
R2272 VSS.n1850 VSS.n1749 0.231121
R2273 VSS.n1854 VSS.n1749 0.231121
R2274 VSS.n1855 VSS.n1854 0.231121
R2275 VSS.n1856 VSS.n1855 0.231121
R2276 VSS.n1856 VSS.n1748 0.231121
R2277 VSS.n1748 VSS.n1747 0.231121
R2278 VSS.n1747 VSS.n182 0.231121
R2279 VSS.n1741 VSS.n182 0.231121
R2280 VSS.n1741 VSS.n1740 0.231121
R2281 VSS.n1740 VSS.n1739 0.231121
R2282 VSS.n1739 VSS.n186 0.231121
R2283 VSS.n1733 VSS.n186 0.231121
R2284 VSS.n1733 VSS.n1732 0.231121
R2285 VSS.n1732 VSS.n1731 0.231121
R2286 VSS.n1731 VSS.n190 0.231121
R2287 VSS.n317 VSS.n190 0.231121
R2288 VSS.n318 VSS.n317 0.231121
R2289 VSS.n319 VSS.n318 0.231121
R2290 VSS.n319 VSS.n274 0.231121
R2291 VSS.n323 VSS.n274 0.231121
R2292 VSS.n324 VSS.n323 0.231121
R2293 VSS.n325 VSS.n324 0.231121
R2294 VSS.n325 VSS.n268 0.231121
R2295 VSS.n329 VSS.n268 0.231121
R2296 VSS.n1828 VSS.n1827 0.231121
R2297 VSS.n1829 VSS.n1828 0.231121
R2298 VSS.n1829 VSS.n1764 0.231121
R2299 VSS.n1833 VSS.n1764 0.231121
R2300 VSS.n1834 VSS.n1833 0.231121
R2301 VSS.n1835 VSS.n1834 0.231121
R2302 VSS.n1835 VSS.n1761 0.231121
R2303 VSS.n1839 VSS.n1761 0.231121
R2304 VSS.n1840 VSS.n1839 0.231121
R2305 VSS.n1841 VSS.n1840 0.231121
R2306 VSS.n1841 VSS.n1758 0.231121
R2307 VSS.n1845 VSS.n1758 0.231121
R2308 VSS.n1846 VSS.n1845 0.231121
R2309 VSS.n1847 VSS.n1846 0.231121
R2310 VSS.n1847 VSS.n1753 0.231121
R2311 VSS.n1851 VSS.n1753 0.231121
R2312 VSS.n1852 VSS.n1851 0.231121
R2313 VSS.n1853 VSS.n1852 0.231121
R2314 VSS.n1853 VSS.n181 0.231121
R2315 VSS.n1857 VSS.n181 0.231121
R2316 VSS.n1857 VSS.n180 0.231121
R2317 VSS.n1746 VSS.n180 0.231121
R2318 VSS.n1746 VSS.n1744 0.231121
R2319 VSS.n1744 VSS.n1742 0.231121
R2320 VSS.n1742 VSS.n184 0.231121
R2321 VSS.n1738 VSS.n184 0.231121
R2322 VSS.n1738 VSS.n1736 0.231121
R2323 VSS.n1736 VSS.n1734 0.231121
R2324 VSS.n1734 VSS.n188 0.231121
R2325 VSS.n1730 VSS.n188 0.231121
R2326 VSS.n1730 VSS.n1728 0.231121
R2327 VSS.n1728 VSS.n192 0.231121
R2328 VSS.n316 VSS.n192 0.231121
R2329 VSS.n320 VSS.n316 0.231121
R2330 VSS.n321 VSS.n320 0.231121
R2331 VSS.n322 VSS.n321 0.231121
R2332 VSS.n322 VSS.n273 0.231121
R2333 VSS.n326 VSS.n273 0.231121
R2334 VSS.n327 VSS.n326 0.231121
R2335 VSS.n328 VSS.n327 0.231121
R2336 VSS.n328 VSS.n267 0.231121
R2337 VSS.n1715 VSS.n1582 0.231121
R2338 VSS.n1716 VSS.n1715 0.231121
R2339 VSS.n1716 VSS.n198 0.231121
R2340 VSS.n1722 VSS.n198 0.231121
R2341 VSS.n1723 VSS.n1722 0.231121
R2342 VSS.n1723 VSS.n195 0.231121
R2343 VSS.n306 VSS.n195 0.231121
R2344 VSS.n308 VSS.n306 0.231121
R2345 VSS.n309 VSS.n308 0.231121
R2346 VSS.n309 VSS.n279 0.231121
R2347 VSS.n298 VSS.n279 0.231121
R2348 VSS.n298 VSS.n296 0.231121
R2349 VSS.n296 VSS.n294 0.231121
R2350 VSS.n294 VSS.n284 0.231121
R2351 VSS.n287 VSS.n284 0.231121
R2352 VSS.n1648 VSS.n1637 0.231121
R2353 VSS.n1637 VSS.n1636 0.231121
R2354 VSS.n1636 VSS.n1635 0.231121
R2355 VSS.n1635 VSS.n1634 0.231121
R2356 VSS.n1634 VSS.n1630 0.231121
R2357 VSS.n1629 VSS.n1615 0.231121
R2358 VSS.n1615 VSS.n1614 0.231121
R2359 VSS.n1614 VSS.n1613 0.231121
R2360 VSS.n1613 VSS.n1612 0.231121
R2361 VSS.n1612 VSS.n1592 0.231121
R2362 VSS.n1699 VSS.n1592 0.231121
R2363 VSS.n1700 VSS.n1699 0.231121
R2364 VSS.n1701 VSS.n1700 0.231121
R2365 VSS.n1701 VSS.n1591 0.231121
R2366 VSS.n1591 VSS.n1586 0.231121
R2367 VSS.n1586 VSS.n1585 0.231121
R2368 VSS.n1584 VSS.n1581 0.231121
R2369 VSS.n1581 VSS.n1580 0.231121
R2370 VSS.n1580 VSS.n1579 0.231121
R2371 VSS.n1579 VSS.n197 0.231121
R2372 VSS.n197 VSS.n196 0.231121
R2373 VSS.n303 VSS.n196 0.231121
R2374 VSS.n304 VSS.n303 0.231121
R2375 VSS.n304 VSS.n302 0.231121
R2376 VSS.n302 VSS.n301 0.231121
R2377 VSS.n301 VSS.n300 0.231121
R2378 VSS.n300 VSS.n299 0.231121
R2379 VSS.n299 VSS.n280 0.231121
R2380 VSS.n290 VSS.n280 0.231121
R2381 VSS.n290 VSS.n289 0.231121
R2382 VSS.n1687 VSS.n1616 0.231121
R2383 VSS.n1688 VSS.n1687 0.231121
R2384 VSS.n1688 VSS.n1609 0.231121
R2385 VSS.n1611 VSS.n1609 0.231121
R2386 VSS.n1611 VSS.n1593 0.231121
R2387 VSS.n1698 VSS.n1593 0.231121
R2388 VSS.n1698 VSS.n1590 0.231121
R2389 VSS.n1702 VSS.n1590 0.231121
R2390 VSS.n1702 VSS.n1587 0.231121
R2391 VSS.n1708 VSS.n1587 0.231121
R2392 VSS.n1709 VSS.n1708 0.231121
R2393 VSS.n1647 VSS.n1638 0.231121
R2394 VSS.n1674 VSS.n1638 0.231121
R2395 VSS.n1675 VSS.n1674 0.231121
R2396 VSS.n1675 VSS.n1628 0.231121
R2397 VSS.n1633 VSS.n1628 0.231121
R2398 VSS.n1633 VSS.n1632 0.231121
R2399 VSS.n734 VSS.n732 0.231121
R2400 VSS.n736 VSS.n734 0.231121
R2401 VSS.n738 VSS.n736 0.231121
R2402 VSS.n740 VSS.n738 0.231121
R2403 VSS.n742 VSS.n740 0.231121
R2404 VSS.n744 VSS.n742 0.231121
R2405 VSS.n746 VSS.n744 0.231121
R2406 VSS.n748 VSS.n746 0.231121
R2407 VSS.n750 VSS.n748 0.231121
R2408 VSS.n752 VSS.n750 0.231121
R2409 VSS.n754 VSS.n752 0.231121
R2410 VSS.n756 VSS.n754 0.231121
R2411 VSS.n758 VSS.n756 0.231121
R2412 VSS.n760 VSS.n758 0.231121
R2413 VSS.n762 VSS.n760 0.231121
R2414 VSS.n764 VSS.n762 0.231121
R2415 VSS.n766 VSS.n764 0.231121
R2416 VSS.n768 VSS.n766 0.231121
R2417 VSS.n770 VSS.n768 0.231121
R2418 VSS.n771 VSS.n770 0.231121
R2419 VSS.n773 VSS.n771 0.231121
R2420 VSS.n775 VSS.n773 0.231121
R2421 VSS.n777 VSS.n775 0.231121
R2422 VSS.n779 VSS.n777 0.231121
R2423 VSS.n781 VSS.n779 0.231121
R2424 VSS.n783 VSS.n781 0.231121
R2425 VSS.n785 VSS.n783 0.231121
R2426 VSS.n787 VSS.n785 0.231121
R2427 VSS.n789 VSS.n787 0.231121
R2428 VSS.n790 VSS.n789 0.231121
R2429 VSS.n792 VSS.n790 0.231121
R2430 VSS.n794 VSS.n792 0.231121
R2431 VSS.n796 VSS.n794 0.231121
R2432 VSS.n798 VSS.n796 0.231121
R2433 VSS.n800 VSS.n798 0.231121
R2434 VSS.n802 VSS.n800 0.231121
R2435 VSS.n804 VSS.n802 0.231121
R2436 VSS.n806 VSS.n804 0.231121
R2437 VSS.n808 VSS.n806 0.231121
R2438 VSS.n810 VSS.n808 0.231121
R2439 VSS.n812 VSS.n810 0.231121
R2440 VSS.n814 VSS.n812 0.231121
R2441 VSS.n816 VSS.n814 0.231121
R2442 VSS.n818 VSS.n816 0.231121
R2443 VSS.n820 VSS.n818 0.231121
R2444 VSS.n822 VSS.n820 0.231121
R2445 VSS.n824 VSS.n822 0.231121
R2446 VSS.n826 VSS.n824 0.231121
R2447 VSS.n827 VSS.n826 0.231121
R2448 VSS.n829 VSS.n827 0.231121
R2449 VSS.n831 VSS.n829 0.231121
R2450 VSS.n833 VSS.n831 0.231121
R2451 VSS.n835 VSS.n833 0.231121
R2452 VSS.n837 VSS.n835 0.231121
R2453 VSS.n839 VSS.n837 0.231121
R2454 VSS.n841 VSS.n839 0.231121
R2455 VSS.n843 VSS.n841 0.231121
R2456 VSS.n845 VSS.n843 0.231121
R2457 VSS.n846 VSS.n845 0.231121
R2458 VSS.n848 VSS.n846 0.231121
R2459 VSS.n850 VSS.n848 0.231121
R2460 VSS.n852 VSS.n850 0.231121
R2461 VSS.n854 VSS.n852 0.231121
R2462 VSS.n856 VSS.n854 0.231121
R2463 VSS.n858 VSS.n856 0.231121
R2464 VSS.n860 VSS.n858 0.231121
R2465 VSS.n862 VSS.n860 0.231121
R2466 VSS.n864 VSS.n862 0.231121
R2467 VSS.n866 VSS.n864 0.231121
R2468 VSS.n868 VSS.n866 0.231121
R2469 VSS.n870 VSS.n868 0.231121
R2470 VSS.n872 VSS.n870 0.231121
R2471 VSS.n874 VSS.n872 0.231121
R2472 VSS.n876 VSS.n874 0.231121
R2473 VSS.n878 VSS.n876 0.231121
R2474 VSS.n880 VSS.n878 0.231121
R2475 VSS.n882 VSS.n880 0.231121
R2476 VSS.n883 VSS.n882 0.231121
R2477 VSS.n1949 VSS.n1948 0.231121
R2478 VSS.n1948 VSS.n1947 0.231121
R2479 VSS.n1947 VSS.n1946 0.231121
R2480 VSS.n1946 VSS.n1945 0.231121
R2481 VSS.n1945 VSS.n1944 0.231121
R2482 VSS.n1969 VSS.n1944 0.231121
R2483 VSS.n1970 VSS.n1969 0.231121
R2484 VSS.n1971 VSS.n1970 0.231121
R2485 VSS.n1971 VSS.n1943 0.231121
R2486 VSS.n1943 VSS.n1942 0.231121
R2487 VSS.n1942 VSS.n1941 0.231121
R2488 VSS.n1941 VSS.n1940 0.231121
R2489 VSS.n1940 VSS.n1939 0.231121
R2490 VSS.n1939 VSS.n1938 0.231121
R2491 VSS.n1938 VSS.n1937 0.231121
R2492 VSS.n1937 VSS.n1936 0.231121
R2493 VSS.n1936 VSS.n1935 0.231121
R2494 VSS.n1935 VSS.n1934 0.231121
R2495 VSS.n1934 VSS.n1933 0.231121
R2496 VSS.n1933 VSS.n1932 0.231121
R2497 VSS.n1932 VSS.n1931 0.231121
R2498 VSS.n1931 VSS.n71 0.231121
R2499 VSS.n1921 VSS.n71 0.231121
R2500 VSS.n1922 VSS.n1921 0.231121
R2501 VSS.n1922 VSS.n1920 0.231121
R2502 VSS.n1920 VSS.n1919 0.231121
R2503 VSS.n1919 VSS.n75 0.231121
R2504 VSS.n1909 VSS.n75 0.231121
R2505 VSS.n1909 VSS.n1908 0.231121
R2506 VSS.n1908 VSS.n1907 0.231121
R2507 VSS.n1907 VSS.n79 0.231121
R2508 VSS.n1897 VSS.n79 0.231121
R2509 VSS.n1897 VSS.n1896 0.231121
R2510 VSS.n1896 VSS.n1895 0.231121
R2511 VSS.n1895 VSS.n83 0.231121
R2512 VSS.n1885 VSS.n83 0.231121
R2513 VSS.n1885 VSS.n1884 0.231121
R2514 VSS.n1884 VSS.n1883 0.231121
R2515 VSS.n1883 VSS.n87 0.231121
R2516 VSS.n1873 VSS.n87 0.231121
R2517 VSS.n1873 VSS.n1872 0.231121
R2518 VSS.n1872 VSS.n1871 0.231121
R2519 VSS.n1871 VSS.n91 0.231121
R2520 VSS.n729 VSS.n722 0.231121
R2521 VSS.n722 VSS.n721 0.231121
R2522 VSS.n721 VSS.n720 0.231121
R2523 VSS.n720 VSS.n719 0.231121
R2524 VSS.n719 VSS.n718 0.231121
R2525 VSS.n718 VSS.n717 0.231121
R2526 VSS.n717 VSS.n716 0.231121
R2527 VSS.n716 VSS.n715 0.231121
R2528 VSS.n715 VSS.n714 0.231121
R2529 VSS.n714 VSS.n713 0.231121
R2530 VSS.n713 VSS.n712 0.231121
R2531 VSS.n712 VSS.n711 0.231121
R2532 VSS.n711 VSS.n710 0.231121
R2533 VSS.n710 VSS.n709 0.231121
R2534 VSS.n709 VSS.n708 0.231121
R2535 VSS.n708 VSS.n707 0.231121
R2536 VSS.n707 VSS.n706 0.231121
R2537 VSS.n706 VSS.n705 0.231121
R2538 VSS.n705 VSS.n704 0.231121
R2539 VSS.n704 VSS.n703 0.231121
R2540 VSS.n703 VSS.n702 0.231121
R2541 VSS.n702 VSS.n701 0.231121
R2542 VSS.n701 VSS.n700 0.231121
R2543 VSS.n700 VSS.n699 0.231121
R2544 VSS.n699 VSS.n698 0.231121
R2545 VSS.n698 VSS.n697 0.231121
R2546 VSS.n697 VSS.n696 0.231121
R2547 VSS.n696 VSS.n695 0.231121
R2548 VSS.n695 VSS.n694 0.231121
R2549 VSS.n694 VSS.n693 0.231121
R2550 VSS.n693 VSS.n692 0.231121
R2551 VSS.n692 VSS.n691 0.231121
R2552 VSS.n691 VSS.n690 0.231121
R2553 VSS.n690 VSS.n689 0.231121
R2554 VSS.n689 VSS.n688 0.231121
R2555 VSS.n688 VSS.n687 0.231121
R2556 VSS.n687 VSS.n686 0.231121
R2557 VSS.n686 VSS.n685 0.231121
R2558 VSS.n685 VSS.n684 0.231121
R2559 VSS.n684 VSS.n683 0.231121
R2560 VSS.n683 VSS.n682 0.231121
R2561 VSS.n682 VSS.n681 0.231121
R2562 VSS.n681 VSS.n680 0.231121
R2563 VSS.n680 VSS.n679 0.231121
R2564 VSS.n679 VSS.n678 0.231121
R2565 VSS.n678 VSS.n677 0.231121
R2566 VSS.n677 VSS.n676 0.231121
R2567 VSS.n676 VSS.n675 0.231121
R2568 VSS.n675 VSS.n674 0.231121
R2569 VSS.n674 VSS.n673 0.231121
R2570 VSS.n673 VSS.n672 0.231121
R2571 VSS.n672 VSS.n671 0.231121
R2572 VSS.n671 VSS.n670 0.231121
R2573 VSS.n670 VSS.n669 0.231121
R2574 VSS.n669 VSS.n668 0.231121
R2575 VSS.n668 VSS.n667 0.231121
R2576 VSS.n667 VSS.n666 0.231121
R2577 VSS.n666 VSS.n665 0.231121
R2578 VSS.n665 VSS.n664 0.231121
R2579 VSS.n664 VSS.n663 0.231121
R2580 VSS.n663 VSS.n662 0.231121
R2581 VSS.n662 VSS.n661 0.231121
R2582 VSS.n661 VSS.n660 0.231121
R2583 VSS.n660 VSS.n659 0.231121
R2584 VSS.n659 VSS.n658 0.231121
R2585 VSS.n658 VSS.n657 0.231121
R2586 VSS.n657 VSS.n656 0.231121
R2587 VSS.n656 VSS.n655 0.231121
R2588 VSS.n655 VSS.n654 0.231121
R2589 VSS.n654 VSS.n653 0.231121
R2590 VSS.n653 VSS.n652 0.231121
R2591 VSS.n652 VSS.n651 0.231121
R2592 VSS.n651 VSS.n650 0.231121
R2593 VSS.n650 VSS.n649 0.231121
R2594 VSS.n649 VSS.n648 0.231121
R2595 VSS.n648 VSS.n647 0.231121
R2596 VSS.n647 VSS.n646 0.231121
R2597 VSS.n1956 VSS.n1954 0.231121
R2598 VSS.n1958 VSS.n1956 0.231121
R2599 VSS.n1960 VSS.n1958 0.231121
R2600 VSS.n1962 VSS.n1960 0.231121
R2601 VSS.n1964 VSS.n1962 0.231121
R2602 VSS.n1966 VSS.n1964 0.231121
R2603 VSS.n1968 VSS.n1966 0.231121
R2604 VSS.n1968 VSS.n70 0.231121
R2605 VSS.n1972 VSS.n70 0.231121
R2606 VSS.n1972 VSS.n68 0.231121
R2607 VSS.n68 VSS.n66 0.231121
R2608 VSS.n66 VSS.n64 0.231121
R2609 VSS.n64 VSS.n62 0.231121
R2610 VSS.n62 VSS.n60 0.231121
R2611 VSS.n60 VSS.n58 0.231121
R2612 VSS.n58 VSS.n56 0.231121
R2613 VSS.n56 VSS.n54 0.231121
R2614 VSS.n54 VSS.n53 0.231121
R2615 VSS.n53 VSS.n51 0.231121
R2616 VSS.n51 VSS.n49 0.231121
R2617 VSS.n49 VSS.n47 0.231121
R2618 VSS.n1930 VSS.n47 0.231121
R2619 VSS.n1930 VSS.n1929 0.231121
R2620 VSS.n1929 VSS.n72 0.231121
R2621 VSS.n1923 VSS.n72 0.231121
R2622 VSS.n1923 VSS.n74 0.231121
R2623 VSS.n1918 VSS.n74 0.231121
R2624 VSS.n1918 VSS.n76 0.231121
R2625 VSS.n1910 VSS.n76 0.231121
R2626 VSS.n1910 VSS.n78 0.231121
R2627 VSS.n1906 VSS.n78 0.231121
R2628 VSS.n1906 VSS.n80 0.231121
R2629 VSS.n1898 VSS.n80 0.231121
R2630 VSS.n1898 VSS.n82 0.231121
R2631 VSS.n1894 VSS.n82 0.231121
R2632 VSS.n1894 VSS.n84 0.231121
R2633 VSS.n1886 VSS.n84 0.231121
R2634 VSS.n1886 VSS.n86 0.231121
R2635 VSS.n1882 VSS.n86 0.231121
R2636 VSS.n1882 VSS.n88 0.231121
R2637 VSS.n1874 VSS.n88 0.231121
R2638 VSS.n1874 VSS.n90 0.231121
R2639 VSS.n1870 VSS.n90 0.231121
R2640 VSS.n1870 VSS.n92 0.231121
R2641 VSS.n988 VSS.n987 0.231121
R2642 VSS.n987 VSS.n986 0.231121
R2643 VSS.n986 VSS.n985 0.231121
R2644 VSS.n985 VSS.n984 0.231121
R2645 VSS.n984 VSS.n983 0.231121
R2646 VSS.n983 VSS.n982 0.231121
R2647 VSS.n982 VSS.n981 0.231121
R2648 VSS.n981 VSS.n980 0.231121
R2649 VSS.n980 VSS.n979 0.231121
R2650 VSS.n979 VSS.n977 0.231121
R2651 VSS.n977 VSS.n976 0.231121
R2652 VSS.n976 VSS.n975 0.231121
R2653 VSS.n975 VSS.n974 0.231121
R2654 VSS.n974 VSS.n973 0.231121
R2655 VSS.n973 VSS.n972 0.231121
R2656 VSS.n972 VSS.n971 0.231121
R2657 VSS.n971 VSS.n970 0.231121
R2658 VSS.n970 VSS.n969 0.231121
R2659 VSS.n969 VSS.n968 0.231121
R2660 VSS.n968 VSS.n966 0.231121
R2661 VSS.n966 VSS.n965 0.231121
R2662 VSS.n965 VSS.n964 0.231121
R2663 VSS.n964 VSS.n963 0.231121
R2664 VSS.n963 VSS.n962 0.231121
R2665 VSS.n962 VSS.n961 0.231121
R2666 VSS.n961 VSS.n960 0.231121
R2667 VSS.n960 VSS.n959 0.231121
R2668 VSS.n959 VSS.n958 0.231121
R2669 VSS.n958 VSS.n956 0.231121
R2670 VSS.n956 VSS.n955 0.231121
R2671 VSS.n955 VSS.n954 0.231121
R2672 VSS.n954 VSS.n953 0.231121
R2673 VSS.n953 VSS.n952 0.231121
R2674 VSS.n952 VSS.n951 0.231121
R2675 VSS.n951 VSS.n950 0.231121
R2676 VSS.n950 VSS.n949 0.231121
R2677 VSS.n949 VSS.n948 0.231121
R2678 VSS.n948 VSS.n947 0.231121
R2679 VSS.n947 VSS.n945 0.231121
R2680 VSS.n945 VSS.n944 0.231121
R2681 VSS.n944 VSS.n943 0.231121
R2682 VSS.n943 VSS.n942 0.231121
R2683 VSS.n942 VSS.n941 0.231121
R2684 VSS.n941 VSS.n940 0.231121
R2685 VSS.n940 VSS.n939 0.231121
R2686 VSS.n939 VSS.n938 0.231121
R2687 VSS.n938 VSS.n937 0.231121
R2688 VSS.n937 VSS.n936 0.231121
R2689 VSS.n936 VSS.n934 0.231121
R2690 VSS.n934 VSS.n933 0.231121
R2691 VSS.n933 VSS.n932 0.231121
R2692 VSS.n932 VSS.n931 0.231121
R2693 VSS.n931 VSS.n930 0.231121
R2694 VSS.n930 VSS.n929 0.231121
R2695 VSS.n929 VSS.n928 0.231121
R2696 VSS.n928 VSS.n927 0.231121
R2697 VSS.n927 VSS.n926 0.231121
R2698 VSS.n926 VSS.n924 0.231121
R2699 VSS.n924 VSS.n923 0.231121
R2700 VSS.n923 VSS.n922 0.231121
R2701 VSS.n922 VSS.n921 0.231121
R2702 VSS.n921 VSS.n920 0.231121
R2703 VSS.n920 VSS.n919 0.231121
R2704 VSS.n919 VSS.n918 0.231121
R2705 VSS.n918 VSS.n917 0.231121
R2706 VSS.n917 VSS.n916 0.231121
R2707 VSS.n916 VSS.n915 0.231121
R2708 VSS.n915 VSS.n913 0.231121
R2709 VSS.n913 VSS.n912 0.231121
R2710 VSS.n912 VSS.n911 0.231121
R2711 VSS.n911 VSS.n910 0.231121
R2712 VSS.n910 VSS.n909 0.231121
R2713 VSS.n909 VSS.n908 0.231121
R2714 VSS.n908 VSS.n907 0.231121
R2715 VSS.n907 VSS.n906 0.231121
R2716 VSS.n906 VSS.n905 0.231121
R2717 VSS.n905 VSS.n904 0.231121
R2718 VSS.n1366 VSS.n1365 0.231121
R2719 VSS.n1365 VSS.n1364 0.231121
R2720 VSS.n1364 VSS.n1363 0.231121
R2721 VSS.n1363 VSS.n1362 0.231121
R2722 VSS.n1362 VSS.n1361 0.231121
R2723 VSS.n1361 VSS.n1360 0.231121
R2724 VSS.n1360 VSS.n1359 0.231121
R2725 VSS.n1359 VSS.n1358 0.231121
R2726 VSS.n1358 VSS.n1357 0.231121
R2727 VSS.n1357 VSS.n1356 0.231121
R2728 VSS.n1356 VSS.n1355 0.231121
R2729 VSS.n1355 VSS.n1354 0.231121
R2730 VSS.n1354 VSS.n1353 0.231121
R2731 VSS.n1353 VSS.n1352 0.231121
R2732 VSS.n1352 VSS.n1351 0.231121
R2733 VSS.n1351 VSS.n1350 0.231121
R2734 VSS.n1350 VSS.n1349 0.231121
R2735 VSS.n1349 VSS.n1348 0.231121
R2736 VSS.n1348 VSS.n1347 0.231121
R2737 VSS.n1347 VSS.n1346 0.231121
R2738 VSS.n1346 VSS.n1345 0.231121
R2739 VSS.n1345 VSS.n1344 0.231121
R2740 VSS.n1344 VSS.n1343 0.231121
R2741 VSS.n1343 VSS.n1342 0.231121
R2742 VSS.n1342 VSS.n1341 0.231121
R2743 VSS.n1341 VSS.n1340 0.231121
R2744 VSS.n1340 VSS.n1339 0.231121
R2745 VSS.n1339 VSS.n1338 0.231121
R2746 VSS.n1338 VSS.n1337 0.231121
R2747 VSS.n1337 VSS.n1336 0.231121
R2748 VSS.n1336 VSS.n1335 0.231121
R2749 VSS.n1335 VSS.n1334 0.231121
R2750 VSS.n1334 VSS.n1333 0.231121
R2751 VSS.n1333 VSS.n1332 0.231121
R2752 VSS.n1332 VSS.n1331 0.231121
R2753 VSS.n1331 VSS.n1330 0.231121
R2754 VSS.n1330 VSS.n1329 0.231121
R2755 VSS.n1329 VSS.n1328 0.231121
R2756 VSS.n1328 VSS.n1327 0.231121
R2757 VSS.n1327 VSS.n1326 0.231121
R2758 VSS.n1326 VSS.n1325 0.231121
R2759 VSS.n1325 VSS.n1324 0.231121
R2760 VSS.n1324 VSS.n1323 0.231121
R2761 VSS.n1323 VSS.n1322 0.231121
R2762 VSS.n1322 VSS.n1321 0.231121
R2763 VSS.n1321 VSS.n1320 0.231121
R2764 VSS.n1320 VSS.n1319 0.231121
R2765 VSS.n1319 VSS.n1318 0.231121
R2766 VSS.n1318 VSS.n1317 0.231121
R2767 VSS.n1317 VSS.n1316 0.231121
R2768 VSS.n1316 VSS.n1315 0.231121
R2769 VSS.n1315 VSS.n1314 0.231121
R2770 VSS.n1314 VSS.n1313 0.231121
R2771 VSS.n1313 VSS.n1312 0.231121
R2772 VSS.n1312 VSS.n1311 0.231121
R2773 VSS.n1311 VSS.n1310 0.231121
R2774 VSS.n1310 VSS.n1309 0.231121
R2775 VSS.n1309 VSS.n1308 0.231121
R2776 VSS.n1308 VSS.n1307 0.231121
R2777 VSS.n1307 VSS.n1306 0.231121
R2778 VSS.n1306 VSS.n1305 0.231121
R2779 VSS.n1305 VSS.n1304 0.231121
R2780 VSS.n1304 VSS.n1303 0.231121
R2781 VSS.n1303 VSS.n1302 0.231121
R2782 VSS.n1302 VSS.n1301 0.231121
R2783 VSS.n1301 VSS.n1300 0.231121
R2784 VSS.n1300 VSS.n1299 0.231121
R2785 VSS.n1299 VSS.n1298 0.231121
R2786 VSS.n1298 VSS.n1297 0.231121
R2787 VSS.n1297 VSS.n1296 0.231121
R2788 VSS.n1296 VSS.n1295 0.231121
R2789 VSS.n1295 VSS.n1294 0.231121
R2790 VSS.n1294 VSS.n1293 0.231121
R2791 VSS.n1293 VSS.n1292 0.231121
R2792 VSS.n1292 VSS.n1291 0.231121
R2793 VSS VSS.n2008 0.226636
R2794 VSS.n369 VSS.n367 0.225674
R2795 VSS.n367 VSS.n363 0.219424
R2796 VSS.n1097 VSS.n1028 0.218898
R2797 VSS.n1054 VSS.n1028 0.218898
R2798 VSS.n1091 VSS.n1090 0.218898
R2799 VSS.n1576 VSS.n231 0.208461
R2800 VSS.n726 VSS.n338 0.20686
R2801 VSS.n475 VSS.n474 0.195641
R2802 VSS.n474 VSS.n472 0.195641
R2803 VSS.n472 VSS.n470 0.195641
R2804 VSS.n470 VSS.n468 0.195641
R2805 VSS.n1555 VSS.n1554 0.195641
R2806 VSS.n1556 VSS.n1555 0.195641
R2807 VSS.n1557 VSS.n1556 0.195641
R2808 VSS.n1558 VSS.n1557 0.195641
R2809 VSS.n1528 VSS.n641 0.194315
R2810 VSS.n1511 VSS.n1509 0.194315
R2811 VSS.t146 VSS.n16 0.191235
R2812 VSS.n6 VSS.n372 0.191235
R2813 VSS.t140 VSS.n19 0.191235
R2814 VSS.n1622 VSS.n1621 0.191235
R2815 VSS.n1569 VSS.n1568 0.191235
R2816 VSS.n334 VSS.n231 0.191235
R2817 VSS.t140 VSS.n1660 0.191235
R2818 VSS.t159 VSS.t157 0.1875
R2819 VSS.t153 VSS.t151 0.1875
R2820 VSS.n1529 VSS.n1528 0.187025
R2821 VSS.n1535 VSS.n1534 0.187025
R2822 VSS.n1536 VSS.n1535 0.187025
R2823 VSS.n1537 VSS.n1536 0.187025
R2824 VSS.n1538 VSS.n1537 0.187025
R2825 VSS.n1539 VSS.n1538 0.187025
R2826 VSS.n1513 VSS.n1511 0.187025
R2827 VSS.n1566 VSS.n119 0.183391
R2828 VSS.t138 VSS.n15 0.167615
R2829 VSS.n1554 VSS.n1553 0.167615
R2830 VSS.n727 VSS.n726 0.16726
R2831 VSS.n381 VSS.n371 0.156138
R2832 VSS.n1574 VSS.n232 0.147398
R2833 VSS.n1057 VSS.n1029 0.146155
R2834 VSS.n1051 VSS.n1029 0.146155
R2835 VSS.n1051 VSS.n1048 0.146155
R2836 VSS.n1048 VSS.n1047 0.146155
R2837 VSS.n1047 VSS.n1031 0.146155
R2838 VSS.n1041 VSS.n1031 0.146155
R2839 VSS.n1041 VSS.n1033 0.146155
R2840 VSS.n1036 VSS.n1033 0.146155
R2841 VSS.n1036 VSS.n1009 0.146155
R2842 VSS.n1278 VSS.n1009 0.146155
R2843 VSS.n1279 VSS.n1278 0.146155
R2844 VSS.n1279 VSS.n1002 0.146155
R2845 VSS.n1002 VSS.n1000 0.146155
R2846 VSS.n1282 VSS.n1000 0.146155
R2847 VSS.n1283 VSS.n1282 0.146155
R2848 VSS.n1283 VSS.n993 0.146155
R2849 VSS.n1286 VSS.n993 0.146155
R2850 VSS.n1286 VSS.n991 0.146155
R2851 VSS.n1179 VSS.n1178 0.146155
R2852 VSS.n1178 VSS.n1177 0.146155
R2853 VSS.n1177 VSS.n1176 0.146155
R2854 VSS.n1176 VSS.n1172 0.146155
R2855 VSS.n1172 VSS.n1171 0.146155
R2856 VSS.n1171 VSS.n1170 0.146155
R2857 VSS.n1170 VSS.n1169 0.146155
R2858 VSS.n1169 VSS.n1163 0.146155
R2859 VSS.n1163 VSS.n1162 0.146155
R2860 VSS.n1162 VSS.n1161 0.146155
R2861 VSS.n1161 VSS.n1160 0.146155
R2862 VSS.n1160 VSS.n1156 0.146155
R2863 VSS.n1156 VSS.n1155 0.146155
R2864 VSS.n1155 VSS.n1154 0.146155
R2865 VSS.n1154 VSS.n1153 0.146155
R2866 VSS.n1153 VSS.n1149 0.146155
R2867 VSS.n1149 VSS.n1148 0.146155
R2868 VSS.n1148 VSS.n1147 0.146155
R2869 VSS.n1147 VSS.n1146 0.146155
R2870 VSS.n1146 VSS.n1141 0.146155
R2871 VSS.n1141 VSS.n1140 0.146155
R2872 VSS.n1140 VSS.n1139 0.146155
R2873 VSS.n1139 VSS.n1134 0.146155
R2874 VSS.n1134 VSS.n1133 0.146155
R2875 VSS.n1133 VSS.n1132 0.146155
R2876 VSS.n1132 VSS.n1131 0.146155
R2877 VSS.n1131 VSS.n1130 0.146155
R2878 VSS.n1130 VSS.n1125 0.146155
R2879 VSS.n1125 VSS.n1124 0.146155
R2880 VSS.n1124 VSS.n1123 0.146155
R2881 VSS.n1123 VSS.n1122 0.146155
R2882 VSS.n1122 VSS.n1117 0.146155
R2883 VSS.n1117 VSS.n1116 0.146155
R2884 VSS.n1116 VSS.n1115 0.146155
R2885 VSS.n1115 VSS.n1114 0.146155
R2886 VSS.n1114 VSS.n1108 0.146155
R2887 VSS.n1108 VSS.n1107 0.146155
R2888 VSS.n1107 VSS.n1106 0.146155
R2889 VSS.n1106 VSS.n1101 0.146155
R2890 VSS.n1101 VSS.n1100 0.146155
R2891 VSS.n1100 VSS.n1099 0.146155
R2892 VSS.n1099 VSS.n1098 0.146155
R2893 VSS.n1098 VSS.n1097 0.146155
R2894 VSS.n1054 VSS.n1053 0.146155
R2895 VSS.n1053 VSS.n1052 0.146155
R2896 VSS.n1052 VSS.n1030 0.146155
R2897 VSS.n1044 VSS.n1030 0.146155
R2898 VSS.n1044 VSS.n1043 0.146155
R2899 VSS.n1043 VSS.n1042 0.146155
R2900 VSS.n1042 VSS.n1032 0.146155
R2901 VSS.n1035 VSS.n1032 0.146155
R2902 VSS.n1035 VSS.n1034 0.146155
R2903 VSS.n1034 VSS.n1008 0.146155
R2904 VSS.n1008 VSS.n1007 0.146155
R2905 VSS.n1007 VSS.n1006 0.146155
R2906 VSS.n1006 VSS.n1005 0.146155
R2907 VSS.n1005 VSS.n999 0.146155
R2908 VSS.n999 VSS.n998 0.146155
R2909 VSS.n998 VSS.n992 0.146155
R2910 VSS.n1287 VSS.n992 0.146155
R2911 VSS.n1214 VSS.n1213 0.146155
R2912 VSS.n1215 VSS.n1214 0.146155
R2913 VSS.n1215 VSS.n1174 0.146155
R2914 VSS.n1174 VSS.n1173 0.146155
R2915 VSS.n1220 VSS.n1173 0.146155
R2916 VSS.n1221 VSS.n1220 0.146155
R2917 VSS.n1221 VSS.n1166 0.146155
R2918 VSS.n1166 VSS.n1164 0.146155
R2919 VSS.n1224 VSS.n1164 0.146155
R2920 VSS.n1225 VSS.n1224 0.146155
R2921 VSS.n1225 VSS.n1158 0.146155
R2922 VSS.n1158 VSS.n1157 0.146155
R2923 VSS.n1231 VSS.n1157 0.146155
R2924 VSS.n1232 VSS.n1231 0.146155
R2925 VSS.n1232 VSS.n1151 0.146155
R2926 VSS.n1151 VSS.n1150 0.146155
R2927 VSS.n1238 VSS.n1150 0.146155
R2928 VSS.n1239 VSS.n1238 0.146155
R2929 VSS.n1239 VSS.n1144 0.146155
R2930 VSS.n1144 VSS.n1142 0.146155
R2931 VSS.n1245 VSS.n1142 0.146155
R2932 VSS.n1246 VSS.n1245 0.146155
R2933 VSS.n1246 VSS.n1135 0.146155
R2934 VSS.n1248 VSS.n1135 0.146155
R2935 VSS.n1249 VSS.n1248 0.146155
R2936 VSS.n1250 VSS.n1249 0.146155
R2937 VSS.n1250 VSS.n1128 0.146155
R2938 VSS.n1128 VSS.n1126 0.146155
R2939 VSS.n1254 VSS.n1126 0.146155
R2940 VSS.n1255 VSS.n1254 0.146155
R2941 VSS.n1255 VSS.n1119 0.146155
R2942 VSS.n1119 VSS.n1118 0.146155
R2943 VSS.n1257 VSS.n1118 0.146155
R2944 VSS.n1258 VSS.n1257 0.146155
R2945 VSS.n1258 VSS.n1111 0.146155
R2946 VSS.n1111 VSS.n1109 0.146155
R2947 VSS.n1261 VSS.n1109 0.146155
R2948 VSS.n1262 VSS.n1261 0.146155
R2949 VSS.n1262 VSS.n1102 0.146155
R2950 VSS.n1265 VSS.n1102 0.146155
R2951 VSS.n1266 VSS.n1265 0.146155
R2952 VSS.n1267 VSS.n1266 0.146155
R2953 VSS.n1267 VSS.n1027 0.146155
R2954 VSS.n1096 VSS.n1027 0.146155
R2955 VSS.n1083 VSS.n1080 0.146155
R2956 VSS.n1085 VSS.n1078 0.146155
R2957 VSS.n1089 VSS.n1078 0.146155
R2958 VSS.n1090 VSS.n1089 0.146155
R2959 VSS.n1077 VSS.n1061 0.146155
R2960 VSS.n1071 VSS.n1061 0.146155
R2961 VSS.n1071 VSS.n1070 0.146155
R2962 VSS.n1076 VSS.n1073 0.146155
R2963 VSS.n1073 VSS.n1072 0.146155
R2964 VSS.n1072 VSS.n1062 0.146155
R2965 VSS.n1068 VSS.n1066 0.146155
R2966 VSS.n1087 VSS.n1086 0.146155
R2967 VSS.n1088 VSS.n1087 0.146155
R2968 VSS.n1088 VSS.n1060 0.146155
R2969 VSS.n1776 VSS.n1766 0.143368
R2970 VSS.n1780 VSS.n1783 0.143368
R2971 VSS.n1788 VSS.n1763 0.143368
R2972 VSS.n1793 VSS.n1792 0.143368
R2973 VSS.n1805 VSS.n1804 0.143368
R2974 VSS.n1811 VSS.n1810 0.143368
R2975 VSS.n1812 VSS.n1752 0.143368
R2976 VSS.n1814 VSS.n1751 0.143368
R2977 VSS.n1820 VSS.n1819 0.143368
R2978 VSS.n1859 VSS.n1858 0.143368
R2979 VSS.n178 VSS.n176 0.143368
R2980 VSS.n1745 VSS.n173 0.143368
R2981 VSS.n1743 VSS.n171 0.143368
R2982 VSS.n185 VSS.n168 0.143368
R2983 VSS.n183 VSS.n165 0.143368
R2984 VSS.n1737 VSS.n162 0.143368
R2985 VSS.n1735 VSS.n160 0.143368
R2986 VSS.n189 VSS.n157 0.143368
R2987 VSS.n187 VSS.n155 0.143368
R2988 VSS.n1729 VSS.n152 0.143368
R2989 VSS.n191 VSS.n147 0.143368
R2990 VSS.n315 VSS.n144 0.143368
R2991 VSS.n314 VSS.n141 0.143368
R2992 VSS.n272 VSS.n134 0.143368
R2993 VSS.n271 VSS.n132 0.143368
R2994 VSS.n1953 VSS.n22 0.143368
R2995 VSS.n1955 VSS.n23 0.143368
R2996 VSS.n1957 VSS.n25 0.143368
R2997 VSS.n1959 VSS.n26 0.143368
R2998 VSS.n1961 VSS.n27 0.143368
R2999 VSS.n1963 VSS.n28 0.143368
R3000 VSS.n69 VSS.n30 0.143368
R3001 VSS.n1974 VSS.n1973 0.143368
R3002 VSS.n1976 VSS.n1975 0.143368
R3003 VSS.n1978 VSS.n1977 0.143368
R3004 VSS.n1980 VSS.n1979 0.143368
R3005 VSS.n1982 VSS.n1981 0.143368
R3006 VSS.n1984 VSS.n1983 0.143368
R3007 VSS.n1986 VSS.n1985 0.143368
R3008 VSS.n1988 VSS.n1987 0.143368
R3009 VSS.n1993 VSS.n1992 0.143368
R3010 VSS.n1996 VSS.n1995 0.143368
R3011 VSS.n1928 VSS.n45 0.143368
R3012 VSS.n1927 VSS.n1926 0.143368
R3013 VSS.n1925 VSS.n1924 0.143368
R3014 VSS.n1915 VSS.n73 0.143368
R3015 VSS.n1917 VSS.n1916 0.143368
R3016 VSS.n1914 VSS.n1913 0.143368
R3017 VSS.n1912 VSS.n1911 0.143368
R3018 VSS.n1903 VSS.n77 0.143368
R3019 VSS.n1905 VSS.n1904 0.143368
R3020 VSS.n1902 VSS.n1901 0.143368
R3021 VSS.n1900 VSS.n1899 0.143368
R3022 VSS.n1891 VSS.n81 0.143368
R3023 VSS.n1893 VSS.n1892 0.143368
R3024 VSS.n1890 VSS.n1889 0.143368
R3025 VSS.n1888 VSS.n1887 0.143368
R3026 VSS.n1879 VSS.n85 0.143368
R3027 VSS.n1881 VSS.n1880 0.143368
R3028 VSS.n1878 VSS.n1877 0.143368
R3029 VSS.n1876 VSS.n1875 0.143368
R3030 VSS.n1867 VSS.n89 0.143368
R3031 VSS.n1869 VSS.n1868 0.143368
R3032 VSS.n1866 VSS.n1865 0.143368
R3033 VSS.n735 VSS.n476 0.143368
R3034 VSS.n737 VSS.n479 0.143368
R3035 VSS.n739 VSS.n480 0.143368
R3036 VSS.n741 VSS.n483 0.143368
R3037 VSS.n743 VSS.n487 0.143368
R3038 VSS.n745 VSS.n489 0.143368
R3039 VSS.n747 VSS.n492 0.143368
R3040 VSS.n749 VSS.n495 0.143368
R3041 VSS.n755 VSS.n503 0.143368
R3042 VSS.n757 VSS.n504 0.143368
R3043 VSS.n759 VSS.n508 0.143368
R3044 VSS.n761 VSS.n509 0.143368
R3045 VSS.n763 VSS.n513 0.143368
R3046 VSS.n765 VSS.n517 0.143368
R3047 VSS.n767 VSS.n518 0.143368
R3048 VSS.n769 VSS.n521 0.143368
R3049 VSS.n774 VSS.n529 0.143368
R3050 VSS.n776 VSS.n530 0.143368
R3051 VSS.n778 VSS.n531 0.143368
R3052 VSS.n780 VSS.n532 0.143368
R3053 VSS.n782 VSS.n535 0.143368
R3054 VSS.n784 VSS.n539 0.143368
R3055 VSS.n786 VSS.n540 0.143368
R3056 VSS.n788 VSS.n543 0.143368
R3057 VSS.n791 VSS.n548 0.143368
R3058 VSS.n793 VSS.n549 0.143368
R3059 VSS.n795 VSS.n553 0.143368
R3060 VSS.n797 VSS.n554 0.143368
R3061 VSS.n799 VSS.n557 0.143368
R3062 VSS.n801 VSS.n561 0.143368
R3063 VSS.n803 VSS.n562 0.143368
R3064 VSS.n805 VSS.n563 0.143368
R3065 VSS.n811 VSS.n565 0.143368
R3066 VSS.n813 VSS.n566 0.143368
R3067 VSS.n815 VSS.n567 0.143368
R3068 VSS.n817 VSS.n571 0.143368
R3069 VSS.n819 VSS.n572 0.143368
R3070 VSS.n821 VSS.n575 0.143368
R3071 VSS.n823 VSS.n576 0.143368
R3072 VSS.n825 VSS.n577 0.143368
R3073 VSS.n830 VSS.n584 0.143368
R3074 VSS.n832 VSS.n585 0.143368
R3075 VSS.n834 VSS.n586 0.143368
R3076 VSS.n836 VSS.n587 0.143368
R3077 VSS.n838 VSS.n588 0.143368
R3078 VSS.n840 VSS.n591 0.143368
R3079 VSS.n842 VSS.n595 0.143368
R3080 VSS.n844 VSS.n596 0.143368
R3081 VSS.n847 VSS.n598 0.143368
R3082 VSS.n849 VSS.n599 0.143368
R3083 VSS.n851 VSS.n602 0.143368
R3084 VSS.n853 VSS.n605 0.143368
R3085 VSS.n855 VSS.n608 0.143368
R3086 VSS.n857 VSS.n611 0.143368
R3087 VSS.n859 VSS.n614 0.143368
R3088 VSS.n861 VSS.n618 0.143368
R3089 VSS.n863 VSS.n619 0.143368
R3090 VSS.n867 VSS.n620 0.143368
R3091 VSS.n869 VSS.n621 0.143368
R3092 VSS.n871 VSS.n622 0.143368
R3093 VSS.n873 VSS.n625 0.143368
R3094 VSS.n875 VSS.n629 0.143368
R3095 VSS.n877 VSS.n633 0.143368
R3096 VSS.n879 VSS.n634 0.143368
R3097 VSS.n881 VSS.n638 0.143368
R3098 VSS.n1370 VSS.n1369 0.143368
R3099 VSS.n1372 VSS.n1371 0.143368
R3100 VSS.n1374 VSS.n1373 0.143368
R3101 VSS.n1376 VSS.n1375 0.143368
R3102 VSS.n1378 VSS.n1377 0.143368
R3103 VSS.n1380 VSS.n1379 0.143368
R3104 VSS.n1382 VSS.n1381 0.143368
R3105 VSS.n1384 VSS.n1383 0.143368
R3106 VSS.n1388 VSS.n1387 0.143368
R3107 VSS.n1390 VSS.n1389 0.143368
R3108 VSS.n1392 VSS.n1391 0.143368
R3109 VSS.n1394 VSS.n1393 0.143368
R3110 VSS.n1396 VSS.n1395 0.143368
R3111 VSS.n1398 VSS.n1397 0.143368
R3112 VSS.n1400 VSS.n1399 0.143368
R3113 VSS.n1402 VSS.n1401 0.143368
R3114 VSS.n1406 VSS.n1405 0.143368
R3115 VSS.n1408 VSS.n1407 0.143368
R3116 VSS.n1410 VSS.n1409 0.143368
R3117 VSS.n1412 VSS.n1411 0.143368
R3118 VSS.n1414 VSS.n1413 0.143368
R3119 VSS.n1416 VSS.n1415 0.143368
R3120 VSS.n1418 VSS.n1417 0.143368
R3121 VSS.n1420 VSS.n1419 0.143368
R3122 VSS.n1422 VSS.n1421 0.143368
R3123 VSS.n1424 VSS.n1423 0.143368
R3124 VSS.n1426 VSS.n1425 0.143368
R3125 VSS.n1428 VSS.n1427 0.143368
R3126 VSS.n1430 VSS.n1429 0.143368
R3127 VSS.n1432 VSS.n1431 0.143368
R3128 VSS.n1434 VSS.n1433 0.143368
R3129 VSS.n1436 VSS.n1435 0.143368
R3130 VSS.n1440 VSS.n1439 0.143368
R3131 VSS.n1442 VSS.n1441 0.143368
R3132 VSS.n1444 VSS.n1443 0.143368
R3133 VSS.n1446 VSS.n1445 0.143368
R3134 VSS.n1448 VSS.n1447 0.143368
R3135 VSS.n1450 VSS.n1449 0.143368
R3136 VSS.n1452 VSS.n1451 0.143368
R3137 VSS.n1454 VSS.n1453 0.143368
R3138 VSS.n1458 VSS.n1457 0.143368
R3139 VSS.n1460 VSS.n1459 0.143368
R3140 VSS.n1462 VSS.n1461 0.143368
R3141 VSS.n1464 VSS.n1463 0.143368
R3142 VSS.n1466 VSS.n1465 0.143368
R3143 VSS.n1468 VSS.n1467 0.143368
R3144 VSS.n1470 VSS.n1469 0.143368
R3145 VSS.n1472 VSS.n1471 0.143368
R3146 VSS.n1474 VSS.n1473 0.143368
R3147 VSS.n1476 VSS.n1475 0.143368
R3148 VSS.n1478 VSS.n1477 0.143368
R3149 VSS.n1480 VSS.n1479 0.143368
R3150 VSS.n1482 VSS.n1481 0.143368
R3151 VSS.n1484 VSS.n1483 0.143368
R3152 VSS.n1486 VSS.n1485 0.143368
R3153 VSS.n1488 VSS.n1487 0.143368
R3154 VSS.n1490 VSS.n1489 0.143368
R3155 VSS.n1492 VSS.n1491 0.143368
R3156 VSS.n1494 VSS.n1493 0.143368
R3157 VSS.n1496 VSS.n1495 0.143368
R3158 VSS.n1498 VSS.n1497 0.143368
R3159 VSS.n1500 VSS.n1499 0.143368
R3160 VSS.n1502 VSS.n1501 0.143368
R3161 VSS.n1504 VSS.n1503 0.143368
R3162 VSS.n1506 VSS.n1505 0.143368
R3163 VSS.n1660 VSS.n1659 0.143368
R3164 VSS.n1642 VSS.n1639 0.143368
R3165 VSS.n1673 VSS.n1627 0.143368
R3166 VSS.n1677 VSS.n1676 0.143368
R3167 VSS.n1626 VSS.n1624 0.143368
R3168 VSS.n1621 VSS.n1618 0.143368
R3169 VSS.n1690 VSS.n1689 0.143368
R3170 VSS.n1607 VSS.n1605 0.143368
R3171 VSS.n1697 VSS.n1595 0.143368
R3172 VSS.n1594 VSS.n1589 0.143368
R3173 VSS.n1704 VSS.n1703 0.143368
R3174 VSS.n1710 VSS.n1583 0.143368
R3175 VSS.n1714 VSS.n1713 0.143368
R3176 VSS.n1717 VSS.n1578 0.143368
R3177 VSS.n1719 VSS.n1718 0.143368
R3178 VSS.n1721 VSS.n1720 0.143368
R3179 VSS.n305 VSS.n209 0.143368
R3180 VSS.n307 VSS.n211 0.143368
R3181 VSS.n297 VSS.n217 0.143368
R3182 VSS.n295 VSS.n219 0.143368
R3183 VSS.n1569 VSS.n337 0.143368
R3184 VSS.n335 VSS.n334 0.143368
R3185 VSS.n266 VSS.n124 0.143368
R3186 VSS.t13 VSS.n1750 0.143368
R3187 VSS.n1757 VSS.n1756 0.143368
R3188 VSS.n1798 VSS.t9 0.143368
R3189 VSS.n1785 VSS.t8 0.143368
R3190 VSS.n1781 VSS.t7 0.143368
R3191 VSS.n1768 VSS.t146 0.143368
R3192 VSS.t4 VSS.n1767 0.143368
R3193 VSS.t6 VSS.n1617 0.143368
R3194 VSS.n914 VSS.t42 0.143368
R3195 VSS.t40 VSS.n925 0.143368
R3196 VSS.t34 VSS.n957 0.143368
R3197 VSS.n989 VSS.t30 0.143368
R3198 VSS.n865 VSS.t58 0.143368
R3199 VSS.t56 VSS.n597 0.143368
R3200 VSS.t50 VSS.n547 0.143368
R3201 VSS.n733 VSS.t45 0.143368
R3202 VSS.n1575 VSS.n228 0.142012
R3203 VSS.n264 VSS.n228 0.138262
R3204 VSS.n1864 VSS.n1863 0.128368
R3205 VSS.n1092 VSS.n252 0.120892
R3206 VSS.n1058 VSS.n1015 0.120892
R3207 VSS.n1058 VSS.n1017 0.120892
R3208 VSS.n1082 VSS.n1081 0.1205
R3209 VSS.n1059 VSS.n238 0.1205
R3210 VSS.n1075 VSS.n1074 0.1205
R3211 VSS.n1064 VSS.n1063 0.1205
R3212 VSS.n1067 VSS.t101 0.1205
R3213 VSS.n1212 VSS.n1211 0.1205
R3214 VSS.n1216 VSS.n1175 0.1205
R3215 VSS.n1219 VSS.n1218 0.1205
R3216 VSS.n1223 VSS.n1165 0.1205
R3217 VSS.n1227 VSS.n1226 0.1205
R3218 VSS.n1230 VSS.n1229 0.1205
R3219 VSS.n1234 VSS.n1233 0.1205
R3220 VSS.n1237 VSS.n1236 0.1205
R3221 VSS.n1241 VSS.n1240 0.1205
R3222 VSS.n1244 VSS.n1243 0.1205
R3223 VSS.n1247 VSS.t62 0.1205
R3224 VSS.n1251 VSS.n1129 0.1205
R3225 VSS.n1253 VSS.n1127 0.1205
R3226 VSS.n1256 VSS.n1120 0.1205
R3227 VSS.n1259 VSS.n1112 0.1205
R3228 VSS.n1264 VSS.n1263 0.1205
R3229 VSS.n1095 VSS.n1024 0.1205
R3230 VSS.n1056 VSS.n1055 0.1205
R3231 VSS.n1050 VSS.n1049 0.1205
R3232 VSS.n1046 VSS.n1045 0.1205
R3233 VSS.n1040 VSS.n1039 0.1205
R3234 VSS.n1037 VSS.n1010 0.1205
R3235 VSS.n1280 VSS.t87 0.1205
R3236 VSS.n1285 VSS.n1284 0.1205
R3237 VSS.n1001 VSS.t82 0.1205
R3238 VSS.t74 VSS.n1110 0.1205
R3239 VSS.n1120 VSS.t123 0.1205
R3240 VSS.n1127 VSS.t21 0.1205
R3241 VSS.t62 VSS.n1137 0.1205
R3242 VSS.n1165 VSS.t121 0.1205
R3243 VSS.n1167 VSS.t19 0.1205
R3244 VSS.n1112 VSS.t66 0.1205
R3245 VSS.t86 VSS.n1026 0.1205
R3246 VSS.t93 VSS.n238 0.1205
R3247 VSS.t91 VSS.n1024 0.1205
R3248 VSS.t87 VSS.n1003 0.1205
R3249 VSS.t84 VSS.n994 0.1205
R3250 VSS.n374 VSS.t101 0.1205
R3251 VSS.n1082 VSS.n254 0.120486
R3252 VSS.n332 VSS.t143 0.1171
R3253 VSS.n1651 VSS.n1649 0.11631
R3254 VSS.n1559 VSS.n1558 0.115978
R3255 VSS.n330 VSS.n267 0.113429
R3256 VSS.n288 VSS.n287 0.113429
R3257 VSS.n1649 VSS.n1647 0.113429
R3258 VSS.n883 VSS.n645 0.113429
R3259 VSS.n1954 VSS.n1952 0.113429
R3260 VSS.n1367 VSS.n988 0.113429
R3261 VSS.n904 VSS.n902 0.113429
R3262 VSS.n1655 VSS.n16 0.112118
R3263 VSS.n730 VSS.n475 0.105745
R3264 VSS.t154 VSS.n359 0.0971176
R3265 VSS.n381 VSS.n372 0.0971176
R3266 VSS.n1794 VSS.t9 0.0961384
R3267 VSS.n1804 VSS.n1803 0.0961384
R3268 VSS.n1858 VSS.n179 0.0961384
R3269 VSS.n272 VSS.n111 0.0961384
R3270 VSS.n1973 VSS.n31 0.0961384
R3271 VSS.n1995 VSS.n1994 0.0961384
R3272 VSS.n881 VSS.n397 0.0961384
R3273 VSS.n825 VSS.n426 0.0961384
R3274 VSS.n805 VSS.n564 0.0961384
R3275 VSS.n769 VSS.n524 0.0961384
R3276 VSS.n749 VSS.n499 0.0961384
R3277 VSS.n1955 VSS.n24 0.0961384
R3278 VSS.n978 VSS.n1385 0.0961384
R3279 VSS.t32 VSS.n1403 0.0961384
R3280 VSS.n946 VSS.n1437 0.0961384
R3281 VSS.t38 VSS.n1455 0.0961384
R3282 VSS.n903 VSS.n1507 0.0961384
R3283 VSS.n1673 VSS.n1672 0.0961384
R3284 VSS.n1689 VSS.n1608 0.0961384
R3285 VSS.n1697 VSS.n1696 0.0961384
R3286 VSS.n310 VSS.n213 0.0961384
R3287 VSS.n285 VSS.n226 0.0961384
R3288 VSS.n1721 VSS.n194 0.0961384
R3289 VSS.n295 VSS.n221 0.0961384
R3290 VSS.n1794 VSS.n1793 0.0958002
R3291 VSS.n1803 VSS.n1760 0.0958002
R3292 VSS.n1819 VSS.n179 0.0958002
R3293 VSS.n275 VSS.n111 0.0958002
R3294 VSS.n807 VSS.n564 0.0958002
R3295 VSS.t48 VSS.n524 0.0958002
R3296 VSS.n751 VSS.n499 0.0958002
R3297 VSS.n1957 VSS.n24 0.0958002
R3298 VSS.n69 VSS.n31 0.0958002
R3299 VSS.n1994 VSS.n1993 0.0958002
R3300 VSS.t54 VSS.n426 0.0958002
R3301 VSS.n644 VSS.n397 0.0958002
R3302 VSS.n371 VSS.n370 0.0958002
R3303 VSS.n1385 VSS.n1384 0.0958002
R3304 VSS.n1403 VSS.n1402 0.0958002
R3305 VSS.n1437 VSS.n1436 0.0958002
R3306 VSS.n1455 VSS.n1454 0.0958002
R3307 VSS.n1507 VSS.n1506 0.0958002
R3308 VSS.n1659 VSS.n1645 0.0958002
R3309 VSS.n1672 VSS.n1639 0.0958002
R3310 VSS.t6 VSS.n1608 0.0958002
R3311 VSS.n1696 VSS.n1596 0.0958002
R3312 VSS.n1724 VSS.n194 0.0958002
R3313 VSS.n293 VSS.n221 0.0958002
R3314 VSS.n307 VSS.n213 0.0958002
R3315 VSS.n286 VSS.n226 0.0958002
R3316 VSS.n1797 VSS.n1760 0.0955
R3317 VSS.t12 VSS.t11 0.0955
R3318 VSS.n1965 VSS.n29 0.0955
R3319 VSS.n1967 VSS.n29 0.0955
R3320 VSS.n1990 VSS.n1989 0.0955
R3321 VSS.n1991 VSS.n1990 0.0955
R3322 VSS.n1998 VSS.n1997 0.0955
R3323 VSS.n1998 VSS.n46 0.0955
R3324 VSS.n753 VSS.t46 0.0955
R3325 VSS.n772 VSS.n528 0.0955
R3326 VSS.n809 VSS.t52 0.0955
R3327 VSS.n828 VSS.n580 0.0955
R3328 VSS.n370 VSS.n368 0.0955
R3329 VSS.n1386 VSS.t29 0.0955
R3330 VSS.n1404 VSS.n967 0.0955
R3331 VSS.n1438 VSS.t36 0.0955
R3332 VSS.n1456 VSS.n935 0.0955
R3333 VSS.n1650 VSS.n1643 0.0955
R3334 VSS.n1646 VSS.n1643 0.0955
R3335 VSS.n1631 VSS.n1623 0.0955
R3336 VSS.n1610 VSS.n1604 0.0955
R3337 VSS.n1604 VSS.n1596 0.0955
R3338 VSS.n1706 VSS.n1705 0.0955
R3339 VSS.n1707 VSS.n1706 0.0955
R3340 VSS.n208 VSS.n193 0.0955
R3341 VSS.n286 VSS.n225 0.0955
R3342 VSS.t12 VSS.n1755 0.0955
R3343 VSS.n1797 VSS.t10 0.0955
R3344 VSS.t5 VSS.n1623 0.0955
R3345 VSS.t44 VSS.n903 0.0955
R3346 VSS.n935 VSS.t38 0.0955
R3347 VSS.t36 VSS.n946 0.0955
R3348 VSS.n967 VSS.t32 0.0955
R3349 VSS.t29 VSS.n978 0.0955
R3350 VSS.t60 VSS.n644 0.0955
R3351 VSS.t54 VSS.n580 0.0955
R3352 VSS.n807 VSS.t52 0.0955
R3353 VSS.t48 VSS.n528 0.0955
R3354 VSS.n751 VSS.t46 0.0955
R3355 VSS.n291 VSS.n270 0.09425
R3356 VSS.n293 VSS.n292 0.09425
R3357 VSS.n358 VSS.n345 0.093
R3358 VSS.n468 VSS.n382 0.0903963
R3359 VSS.n282 VSS.n126 0.0871176
R3360 VSS.t151 VSS.n356 0.0851154
R3361 VSS.t153 VSS.n354 0.0851154
R3362 VSS.t157 VSS.n366 0.0851154
R3363 VSS.t159 VSS.n364 0.0851154
R3364 VSS.n312 VSS.n138 0.08425
R3365 VSS.n311 VSS.n215 0.08425
R3366 VSS.n1727 VSS.n1726 0.08175
R3367 VSS.n355 VSS.n350 0.08175
R3368 VSS.n365 VSS.n360 0.08175
R3369 VSS.n356 VSS.n342 0.08175
R3370 VSS.n366 VSS.n346 0.08175
R3371 VSS.n1725 VSS.n1724 0.08175
R3372 VSS.n1567 VSS.n1566 0.0812779
R3373 VSS.n121 VSS.n95 0.0805
R3374 VSS.n1655 VSS.n13 0.0796176
R3375 VSS.n1654 VSS.n20 0.0796176
R3376 VSS.n1861 VSS.n95 0.07675
R3377 VSS.n1863 VSS.n1862 0.07425
R3378 VSS.n265 VSS.n121 0.07425
R3379 VSS.n724 VSS.n341 0.0740901
R3380 VSS.n1288 VSS.n991 0.0726677
R3381 VSS.n1213 VSS.n1180 0.0726677
R3382 VSS.n1080 VSS.n1079 0.0726677
R3383 VSS.n1066 VSS.n1065 0.0726677
R3384 VSS.n1862 VSS.t134 0.07175
R3385 VSS.n276 VSS.n138 0.06925
R3386 VSS.t134 VSS.n1861 0.06925
R3387 VSS.n277 VSS.n215 0.06925
R3388 VSS.n10 VSS.n4 0.0258209
R3389 VSS.n1094 VSS.n1057 0.0672586
R3390 VSS.n1096 VSS.n1094 0.0672586
R3391 VSS.n1093 VSS.n1060 0.0672586
R3392 VSS.n1181 VSS.n1175 0.0672168
R3393 VSS.n353 VSS.n352 0.0671176
R3394 VSS.n363 VSS.n362 0.0671176
R3395 VSS.n354 VSS.n343 0.0671176
R3396 VSS.n364 VSS.n347 0.0671176
R3397 VSS.n1656 VSS.n1654 0.06425
R3398 VSS.n1726 VSS.n149 0.0621177
R3399 VSS.n355 VSS.n352 0.0621177
R3400 VSS.n365 VSS.n362 0.0621177
R3401 VSS.n356 VSS.n343 0.0621177
R3402 VSS.n366 VSS.n347 0.0621177
R3403 VSS.n1081 VSS.n255 0.060789
R3404 VSS.t93 VSS.n236 0.060789
R3405 VSS.n1064 VSS.n249 0.060789
R3406 VSS.n1067 VSS.t95 0.060789
R3407 VSS.n1560 VSS.n374 0.060789
R3408 VSS.n255 VSS.n232 0.060789
R3409 VSS.t89 VSS.n236 0.060789
R3410 VSS.n1059 VSS.n252 0.060789
R3411 VSS.n1074 VSS.n249 0.060789
R3412 VSS.n1218 VSS.n1217 0.060789
R3413 VSS.t19 VSS.n1168 0.060789
R3414 VSS.t121 VSS.n1222 0.060789
R3415 VSS.n1226 VSS.n1159 0.060789
R3416 VSS.n1229 VSS.n1228 0.060789
R3417 VSS.n1233 VSS.n1152 0.060789
R3418 VSS.n1236 VSS.n1235 0.060789
R3419 VSS.n1240 VSS.n1145 0.060789
R3420 VSS.n1243 VSS.n1242 0.060789
R3421 VSS.n1137 VSS.n1138 0.060789
R3422 VSS.n1136 VSS.n1129 0.060789
R3423 VSS.t21 VSS.n1252 0.060789
R3424 VSS.t123 VSS.n1121 0.060789
R3425 VSS.t66 VSS.n1113 0.060789
R3426 VSS.n1110 VSS.n1260 0.060789
R3427 VSS.n1263 VSS.n1105 0.060789
R3428 VSS.t86 VSS.n1103 0.060789
R3429 VSS.n1268 VSS.t91 0.060789
R3430 VSS.n1056 VSS.n1017 0.060789
R3431 VSS.n1050 VSS.n1018 0.060789
R3432 VSS.n1046 VSS.n1019 0.060789
R3433 VSS.n1040 VSS.n1020 0.060789
R3434 VSS.n1039 VSS.n1038 0.060789
R3435 VSS.n1004 VSS.n1010 0.060789
R3436 VSS.t82 VSS.n1281 0.060789
R3437 VSS.n1284 VSS.n997 0.060789
R3438 VSS.t84 VSS.n995 0.060789
R3439 VSS.n1289 VSS.n990 0.060789
R3440 VSS.n1217 VSS.n1216 0.060789
R3441 VSS.n1168 VSS.n1219 0.060789
R3442 VSS.n1222 VSS.n1167 0.060789
R3443 VSS.n1223 VSS.n1159 0.060789
R3444 VSS.n1228 VSS.n1227 0.060789
R3445 VSS.n1230 VSS.n1152 0.060789
R3446 VSS.n1235 VSS.n1234 0.060789
R3447 VSS.n1237 VSS.n1145 0.060789
R3448 VSS.n1242 VSS.n1241 0.060789
R3449 VSS.n1244 VSS.n1138 0.060789
R3450 VSS.n1247 VSS.n1136 0.060789
R3451 VSS.n1252 VSS.n1251 0.060789
R3452 VSS.n1253 VSS.n1121 0.060789
R3453 VSS.n1113 VSS.n1256 0.060789
R3454 VSS.n1260 VSS.n1259 0.060789
R3455 VSS.t74 VSS.n1105 0.060789
R3456 VSS.n1103 VSS.n1264 0.060789
R3457 VSS.n1268 VSS.n1026 0.060789
R3458 VSS.n1095 VSS.n1015 0.060789
R3459 VSS.n1055 VSS.n1018 0.060789
R3460 VSS.n1049 VSS.n1019 0.060789
R3461 VSS.n1045 VSS.n1020 0.060789
R3462 VSS.n1038 VSS.n1037 0.060789
R3463 VSS.n1003 VSS.n1004 0.060789
R3464 VSS.n1281 VSS.n1280 0.060789
R3465 VSS.n1001 VSS.n997 0.060789
R3466 VSS.n995 VSS.n1285 0.060789
R3467 VSS.n994 VSS.n990 0.060789
R3468 VSS.t60 VSS.n643 0.058
R3469 VSS.n1508 VSS.t44 0.058
R3470 VSS.n359 VSS.t27 0.0571176
R3471 VSS.n282 VSS.n269 0.05675
R3472 VSS.n283 VSS.n281 0.05675
R3473 VSS.n1568 VSS.n1567 0.0558676
R3474 VSS.n1212 VSS.n1181 0.0553461
R3475 VSS.n1509 VSS.n1508 0.0546082
R3476 VSS.n643 VSS.n641 0.0546082
R3477 VSS.n291 VSS.n129 0.0496177
R3478 VSS.n292 VSS.n223 0.0496177
R3479 VSS.n1564 VSS.n1563 0.04925
R3480 VSS.n1563 VSS.t149 0.04925
R3481 VSS.t156 VSS.n345 0.04925
R3482 VSS.n335 VSS.n332 0.04925
R3483 VSS.n1768 VSS.t4 0.0483676
R3484 VSS.n1776 VSS.n1767 0.0483676
R3485 VSS.n1783 VSS.n1766 0.0483676
R3486 VSS.n1781 VSS.n1780 0.0483676
R3487 VSS.n1785 VSS.t7 0.0483676
R3488 VSS.n1788 VSS.t8 0.0483676
R3489 VSS.n1792 VSS.n1763 0.0483676
R3490 VSS.n1798 VSS.t10 0.0483676
R3491 VSS.n1805 VSS.n1757 0.0483676
R3492 VSS.n1756 VSS.t11 0.0483676
R3493 VSS.n1812 VSS.n1811 0.0483676
R3494 VSS.n1814 VSS.n1752 0.0483676
R3495 VSS.t13 VSS.n1751 0.0483676
R3496 VSS.n1820 VSS.n1750 0.0483676
R3497 VSS.n1859 VSS.n178 0.0483676
R3498 VSS.n1745 VSS.n176 0.0483676
R3499 VSS.n1743 VSS.n173 0.0483676
R3500 VSS.n185 VSS.n171 0.0483676
R3501 VSS.n183 VSS.n168 0.0483676
R3502 VSS.n1737 VSS.n165 0.0483676
R3503 VSS.n1735 VSS.n162 0.0483676
R3504 VSS.n189 VSS.n160 0.0483676
R3505 VSS.n187 VSS.n157 0.0483676
R3506 VSS.n1729 VSS.n155 0.0483676
R3507 VSS.n1727 VSS.n152 0.0483676
R3508 VSS.n191 VSS.n149 0.0483676
R3509 VSS.n315 VSS.n147 0.0483676
R3510 VSS.n314 VSS.n144 0.0483676
R3511 VSS.n313 VSS.n141 0.0483676
R3512 VSS.n271 VSS.n134 0.0483676
R3513 VSS.n270 VSS.n132 0.0483676
R3514 VSS.n269 VSS.n129 0.0483676
R3515 VSS.n1810 VSS.n1755 0.0483676
R3516 VSS.n2006 VSS.n13 0.0483676
R3517 VSS.n266 VSS.n126 0.0483676
R3518 VSS.n331 VSS.n124 0.0483676
R3519 VSS.n1975 VSS.n1974 0.0483676
R3520 VSS.n1977 VSS.n1976 0.0483676
R3521 VSS.n1979 VSS.n1978 0.0483676
R3522 VSS.n1981 VSS.n1980 0.0483676
R3523 VSS.n1983 VSS.n1982 0.0483676
R3524 VSS.n1985 VSS.n1984 0.0483676
R3525 VSS.n1987 VSS.n1986 0.0483676
R3526 VSS.n1989 VSS.n1988 0.0483676
R3527 VSS.n1997 VSS.n1996 0.0483676
R3528 VSS.n1959 VSS.n25 0.0483676
R3529 VSS.n1961 VSS.n26 0.0483676
R3530 VSS.n1963 VSS.n27 0.0483676
R3531 VSS.n1965 VSS.n28 0.0483676
R3532 VSS.n1967 VSS.n30 0.0483676
R3533 VSS.n879 VSS.n638 0.0483676
R3534 VSS.n877 VSS.n634 0.0483676
R3535 VSS.n875 VSS.n633 0.0483676
R3536 VSS.n873 VSS.n629 0.0483676
R3537 VSS.n871 VSS.n625 0.0483676
R3538 VSS.n869 VSS.n622 0.0483676
R3539 VSS.n867 VSS.n621 0.0483676
R3540 VSS.n865 VSS.n620 0.0483676
R3541 VSS.n863 VSS.t58 0.0483676
R3542 VSS.n861 VSS.n619 0.0483676
R3543 VSS.n859 VSS.n618 0.0483676
R3544 VSS.n857 VSS.n614 0.0483676
R3545 VSS.n855 VSS.n611 0.0483676
R3546 VSS.n853 VSS.n608 0.0483676
R3547 VSS.n851 VSS.n605 0.0483676
R3548 VSS.n849 VSS.n602 0.0483676
R3549 VSS.n847 VSS.n599 0.0483676
R3550 VSS.t56 VSS.n598 0.0483676
R3551 VSS.n844 VSS.n597 0.0483676
R3552 VSS.n842 VSS.n596 0.0483676
R3553 VSS.n840 VSS.n595 0.0483676
R3554 VSS.n838 VSS.n591 0.0483676
R3555 VSS.n836 VSS.n588 0.0483676
R3556 VSS.n834 VSS.n587 0.0483676
R3557 VSS.n832 VSS.n586 0.0483676
R3558 VSS.n830 VSS.n585 0.0483676
R3559 VSS.n828 VSS.n584 0.0483676
R3560 VSS.n823 VSS.n577 0.0483676
R3561 VSS.n821 VSS.n576 0.0483676
R3562 VSS.n819 VSS.n575 0.0483676
R3563 VSS.n817 VSS.n572 0.0483676
R3564 VSS.n815 VSS.n571 0.0483676
R3565 VSS.n813 VSS.n567 0.0483676
R3566 VSS.n811 VSS.n566 0.0483676
R3567 VSS.n809 VSS.n565 0.0483676
R3568 VSS.n803 VSS.n563 0.0483676
R3569 VSS.n801 VSS.n562 0.0483676
R3570 VSS.n799 VSS.n561 0.0483676
R3571 VSS.n797 VSS.n557 0.0483676
R3572 VSS.n795 VSS.n554 0.0483676
R3573 VSS.n793 VSS.n553 0.0483676
R3574 VSS.n791 VSS.n549 0.0483676
R3575 VSS.t50 VSS.n548 0.0483676
R3576 VSS.n788 VSS.n547 0.0483676
R3577 VSS.n786 VSS.n543 0.0483676
R3578 VSS.n784 VSS.n540 0.0483676
R3579 VSS.n782 VSS.n539 0.0483676
R3580 VSS.n780 VSS.n535 0.0483676
R3581 VSS.n778 VSS.n532 0.0483676
R3582 VSS.n776 VSS.n531 0.0483676
R3583 VSS.n774 VSS.n530 0.0483676
R3584 VSS.n772 VSS.n529 0.0483676
R3585 VSS.n767 VSS.n521 0.0483676
R3586 VSS.n765 VSS.n518 0.0483676
R3587 VSS.n763 VSS.n517 0.0483676
R3588 VSS.n761 VSS.n513 0.0483676
R3589 VSS.n759 VSS.n509 0.0483676
R3590 VSS.n757 VSS.n508 0.0483676
R3591 VSS.n755 VSS.n504 0.0483676
R3592 VSS.n753 VSS.n503 0.0483676
R3593 VSS.n747 VSS.n495 0.0483676
R3594 VSS.n745 VSS.n492 0.0483676
R3595 VSS.n743 VSS.n489 0.0483676
R3596 VSS.n741 VSS.n487 0.0483676
R3597 VSS.n739 VSS.n483 0.0483676
R3598 VSS.n737 VSS.n480 0.0483676
R3599 VSS.n735 VSS.n479 0.0483676
R3600 VSS.n733 VSS.n476 0.0483676
R3601 VSS.n731 VSS.t45 0.0483676
R3602 VSS.n1951 VSS.n22 0.0483676
R3603 VSS.n1953 VSS.n23 0.0483676
R3604 VSS.n1992 VSS.n1991 0.0483676
R3605 VSS.n46 VSS.n45 0.0483676
R3606 VSS.n1928 VSS.n1927 0.0483676
R3607 VSS.n1926 VSS.n1925 0.0483676
R3608 VSS.n1924 VSS.n73 0.0483676
R3609 VSS.n1916 VSS.n1915 0.0483676
R3610 VSS.n1917 VSS.n1914 0.0483676
R3611 VSS.n1913 VSS.n1912 0.0483676
R3612 VSS.n1911 VSS.n77 0.0483676
R3613 VSS.n1904 VSS.n1903 0.0483676
R3614 VSS.n1905 VSS.n1902 0.0483676
R3615 VSS.n1901 VSS.n1900 0.0483676
R3616 VSS.n1899 VSS.n81 0.0483676
R3617 VSS.n1892 VSS.n1891 0.0483676
R3618 VSS.n1893 VSS.n1890 0.0483676
R3619 VSS.n1889 VSS.n1888 0.0483676
R3620 VSS.n1887 VSS.n85 0.0483676
R3621 VSS.n1880 VSS.n1879 0.0483676
R3622 VSS.n1881 VSS.n1878 0.0483676
R3623 VSS.n1877 VSS.n1876 0.0483676
R3624 VSS.n1875 VSS.n89 0.0483676
R3625 VSS.n1868 VSS.n1867 0.0483676
R3626 VSS.n1869 VSS.n1866 0.0483676
R3627 VSS.n1865 VSS.n1864 0.0483676
R3628 VSS.t30 VSS.n1368 0.0483676
R3629 VSS.n1369 VSS.n989 0.0483676
R3630 VSS.n1371 VSS.n1370 0.0483676
R3631 VSS.n1373 VSS.n1372 0.0483676
R3632 VSS.n1375 VSS.n1374 0.0483676
R3633 VSS.n1377 VSS.n1376 0.0483676
R3634 VSS.n1379 VSS.n1378 0.0483676
R3635 VSS.n1381 VSS.n1380 0.0483676
R3636 VSS.n1383 VSS.n1382 0.0483676
R3637 VSS.n1387 VSS.n1386 0.0483676
R3638 VSS.n1389 VSS.n1388 0.0483676
R3639 VSS.n1391 VSS.n1390 0.0483676
R3640 VSS.n1393 VSS.n1392 0.0483676
R3641 VSS.n1395 VSS.n1394 0.0483676
R3642 VSS.n1397 VSS.n1396 0.0483676
R3643 VSS.n1399 VSS.n1398 0.0483676
R3644 VSS.n1401 VSS.n1400 0.0483676
R3645 VSS.n1405 VSS.n1404 0.0483676
R3646 VSS.n1407 VSS.n1406 0.0483676
R3647 VSS.n1409 VSS.n1408 0.0483676
R3648 VSS.n1411 VSS.n1410 0.0483676
R3649 VSS.n1413 VSS.n1412 0.0483676
R3650 VSS.n1415 VSS.n1414 0.0483676
R3651 VSS.n1417 VSS.n1416 0.0483676
R3652 VSS.n1419 VSS.n1418 0.0483676
R3653 VSS.n957 VSS.n1420 0.0483676
R3654 VSS.n1421 VSS.t34 0.0483676
R3655 VSS.n1423 VSS.n1422 0.0483676
R3656 VSS.n1425 VSS.n1424 0.0483676
R3657 VSS.n1427 VSS.n1426 0.0483676
R3658 VSS.n1429 VSS.n1428 0.0483676
R3659 VSS.n1431 VSS.n1430 0.0483676
R3660 VSS.n1433 VSS.n1432 0.0483676
R3661 VSS.n1435 VSS.n1434 0.0483676
R3662 VSS.n1439 VSS.n1438 0.0483676
R3663 VSS.n1441 VSS.n1440 0.0483676
R3664 VSS.n1443 VSS.n1442 0.0483676
R3665 VSS.n1445 VSS.n1444 0.0483676
R3666 VSS.n1447 VSS.n1446 0.0483676
R3667 VSS.n1449 VSS.n1448 0.0483676
R3668 VSS.n1451 VSS.n1450 0.0483676
R3669 VSS.n1453 VSS.n1452 0.0483676
R3670 VSS.n1457 VSS.n1456 0.0483676
R3671 VSS.n1459 VSS.n1458 0.0483676
R3672 VSS.n1461 VSS.n1460 0.0483676
R3673 VSS.n1463 VSS.n1462 0.0483676
R3674 VSS.n1465 VSS.n1464 0.0483676
R3675 VSS.n1467 VSS.n1466 0.0483676
R3676 VSS.n1469 VSS.n1468 0.0483676
R3677 VSS.n1471 VSS.n1470 0.0483676
R3678 VSS.n925 VSS.n1472 0.0483676
R3679 VSS.n1473 VSS.t40 0.0483676
R3680 VSS.n1475 VSS.n1474 0.0483676
R3681 VSS.n1477 VSS.n1476 0.0483676
R3682 VSS.n1479 VSS.n1478 0.0483676
R3683 VSS.n1481 VSS.n1480 0.0483676
R3684 VSS.n1483 VSS.n1482 0.0483676
R3685 VSS.n1485 VSS.n1484 0.0483676
R3686 VSS.n1487 VSS.n1486 0.0483676
R3687 VSS.n1489 VSS.n1488 0.0483676
R3688 VSS.t42 VSS.n1490 0.0483676
R3689 VSS.n1491 VSS.n914 0.0483676
R3690 VSS.n1493 VSS.n1492 0.0483676
R3691 VSS.n1495 VSS.n1494 0.0483676
R3692 VSS.n1497 VSS.n1496 0.0483676
R3693 VSS.n1499 VSS.n1498 0.0483676
R3694 VSS.n1501 VSS.n1500 0.0483676
R3695 VSS.n1503 VSS.n1502 0.0483676
R3696 VSS.n1505 VSS.n1504 0.0483676
R3697 VSS.n1650 VSS.n1644 0.0483676
R3698 VSS.n1646 VSS.n1642 0.0483676
R3699 VSS.n1676 VSS.n1627 0.0483676
R3700 VSS.n1677 VSS.n1626 0.0483676
R3701 VSS.t5 VSS.n1624 0.0483676
R3702 VSS.n1631 VSS.n1622 0.0483676
R3703 VSS.n1617 VSS.n1618 0.0483676
R3704 VSS.n1690 VSS.n1607 0.0483676
R3705 VSS.n1610 VSS.n1605 0.0483676
R3706 VSS.n1595 VSS.n1594 0.0483676
R3707 VSS.n1703 VSS.n1589 0.0483676
R3708 VSS.n1705 VSS.n1704 0.0483676
R3709 VSS.n283 VSS.n223 0.0483676
R3710 VSS.n1653 VSS.n20 0.0483676
R3711 VSS.n1656 VSS.n19 0.0483676
R3712 VSS.n1707 VSS.n1583 0.0483676
R3713 VSS.n1713 VSS.n1712 0.0483676
R3714 VSS.n1714 VSS.n1578 0.0483676
R3715 VSS.n1718 VSS.n1717 0.0483676
R3716 VSS.n1720 VSS.n1719 0.0483676
R3717 VSS.n209 VSS.n208 0.0483676
R3718 VSS.n305 VSS.n211 0.0483676
R3719 VSS.n278 VSS.n217 0.0483676
R3720 VSS.n297 VSS.n219 0.0483676
R3721 VSS.n119 VSS.n95 0.048
R3722 VSS.n360 VSS.t154 0.04675
R3723 VSS.t156 VSS.n346 0.04675
R3724 VSS.n337 VSS.n332 0.04675
R3725 VSS.n281 VSS.n225 0.03925
R3726 VSS.n731 VSS.n730 0.03675
R3727 VSS.n1368 VSS.n1290 0.03675
R3728 VSS.n1576 VSS.n1575 0.0345427
R3729 VSS.n350 VSS.n349 0.0305
R3730 VSS.n725 VSS.n342 0.0305
R3731 VSS.n2006 VSS.n2005 0.028
R3732 VSS.n1951 VSS.n1950 0.028
R3733 VSS.n1653 VSS.n1652 0.028
R3734 VSS.n276 VSS.n275 0.02675
R3735 VSS.n278 VSS.n277 0.02675
R3736 VSS.n723 VSS.n341 0.0253401
R3737 VSS.n285 VSS.n264 0.02175
R3738 VSS.n265 VSS.n331 0.02175
R3739 VSS.n1553 VSS.n382 0.0214413
R3740 VSS.n1200 VSS.t70 0.0184075
R3741 VSS.t79 VSS.n1022 0.0184075
R3742 VSS.t76 VSS.n240 0.0174009
R3743 VSS.n349 VSS.t149 0.01675
R3744 VSS.n725 VSS.n724 0.01675
R3745 VSS.n1206 VSS.t24 0.0151406
R3746 VSS.n1194 VSS.n1104 0.0151406
R3747 VSS.n1193 VSS.n1104 0.0151406
R3748 VSS.n1272 VSS.n996 0.0151406
R3749 VSS.t76 VSS.n243 0.0150892
R3750 VSS.n1725 VSS.n193 0.01425
R3751 VSS.n369 VSS.n368 0.013
R3752 VSS.n313 VSS.n312 0.01175
R3753 VSS.n311 VSS.n310 0.01175
R3754 VSS.n10 VSS.n0 0.00445107
R3755 VSS.n10 VSS.n8 0.0022993
R3756 VSS.n261 VSS.n94 0.00216667
R3757 VSS.n120 VSS.n94 0.00216664
R3758 VSS.t76 VSS.n246 0.002125
R3759 VSS.n1860 VSS.n177 0.00199999
R3760 VSS.n1822 VSS.n177 0.00199992
R3761 VSS.n1210 VSS.t24 0.00198843
R3762 VSS.n1561 VSS.n246 0.00187493
R3763 VSS.n257 VSS.n230 0.00175
R3764 VSS.n1799 VSS.n1773 0.00166667
R3765 VSS.n1802 VSS.n1800 0.00166667
R3766 VSS.n1806 VSS.n1772 0.00166667
R3767 VSS.n1813 VSS.n1808 0.00166667
R3768 VSS.n50 VSS.n43 0.00166667
R3769 VSS.n48 VSS.n34 0.00166667
R3770 VSS.n1860 VSS.n120 0.00166667
R3771 VSS.n473 VSS.n387 0.00166667
R3772 VSS.n1524 VSS.n893 0.00166667
R3773 VSS.n1522 VSS.n892 0.00166667
R3774 VSS.n1521 VSS.n897 0.00166667
R3775 VSS.n1542 VSS.n888 0.00166667
R3776 VSS.n1543 VSS.n901 0.00166667
R3777 VSS.n1512 VSS.n887 0.00166667
R3778 VSS.n263 VSS.n262 0.00166667
R3779 VSS.n1667 VSS.n1666 0.00166667
R3780 VSS.n1669 VSS.n1668 0.00166667
R3781 VSS.n1641 VSS.n1640 0.00166667
R3782 VSS.n1682 VSS.n1681 0.00166667
R3783 VSS.n1691 VSS.n1606 0.00166667
R3784 VSS.n1695 VSS.n1694 0.00166667
R3785 VSS.n1600 VSS.n1597 0.00166667
R3786 VSS.n2000 VSS.n44 0.00162501
R3787 VSS.n10 VSS.n7 0.00125
R3788 VSS.n2000 VSS.n1999 0.00137498
R3789 VSS.n1795 VSS.n1773 0.00133332
R3790 VSS.n1800 VSS.n1799 0.00133332
R3791 VSS.n1802 VSS.n1772 0.00133332
R3792 VSS.n1809 VSS.n1808 0.00133332
R3793 VSS.n52 VSS.n43 0.00133332
R3794 VSS.n50 VSS.n34 0.00133332
R3795 VSS.n1525 VSS.n893 0.00133332
R3796 VSS.n1523 VSS.n892 0.00133332
R3797 VSS.n1522 VSS.n897 0.00133332
R3798 VSS.n1515 VSS.n888 0.00133332
R3799 VSS.n1543 VSS.n1542 0.00133332
R3800 VSS.n901 VSS.n887 0.00133332
R3801 VSS.n1666 VSS.n1665 0.00133332
R3802 VSS.n1668 VSS.n1667 0.00133332
R3803 VSS.n1671 VSS.n1641 0.00133332
R3804 VSS.n1681 VSS.n1680 0.00133332
R3805 VSS.n1619 VSS.n1606 0.00133332
R3806 VSS.n1694 VSS.n1693 0.00133332
R3807 VSS.n1695 VSS.n1597 0.00133332
R3808 VSS.n1565 VSS.n262 0.00133332
R3809 VSS.n1547 VSS.n387 0.00133332
R3810 VSS.n1577 VSS.n230 0.00124998
R3811 VSS.n10 VSS.n2 0.0010903
R3812 VSS.n10 VSS.n9 0.00107073
R3813 VSS.n1826 VSS.n17 0.001
R3814 VSS.n1826 VSS.n1825 0.001
R3815 VSS.n1777 VSS.n1775 0.001
R3816 VSS.n1782 VSS.n1778 0.001
R3817 VSS.n1784 VSS.n1779 0.001
R3818 VSS.n1787 VSS.n1786 0.001
R3819 VSS.n1786 VSS.n1774 0.001
R3820 VSS.n1791 VSS.n1790 0.001
R3821 VSS.n1796 VSS.n1795 0.001
R3822 VSS.n1807 VSS.n1806 0.001
R3823 VSS.n1809 VSS.n1771 0.001
R3824 VSS.n1816 VSS.n1815 0.001
R3825 VSS.n1815 VSS.n1770 0.001
R3826 VSS.n1821 VSS.n1818 0.001
R3827 VSS.n1823 VSS.n1822 0.001
R3828 VSS.n2003 VSS.n17 0.001
R3829 VSS.n1825 VSS.n1769 0.001
R3830 VSS.n1775 VSS.n1769 0.001
R3831 VSS.n1778 VSS.n1777 0.001
R3832 VSS.n1782 VSS.n1779 0.001
R3833 VSS.n1787 VSS.n1784 0.001
R3834 VSS.n1789 VSS.n1774 0.001
R3835 VSS.n1790 VSS.n1789 0.001
R3836 VSS.n1796 VSS.n1791 0.001
R3837 VSS.n1807 VSS.n1801 0.001
R3838 VSS.n1801 VSS.n1771 0.001
R3839 VSS.n1816 VSS.n1813 0.001
R3840 VSS.n1817 VSS.n1770 0.001
R3841 VSS.n1818 VSS.n1817 0.001
R3842 VSS.n1823 VSS.n1821 0.001
R3843 VSS.n2002 VSS.n32 0.001
R3844 VSS.n67 VSS.n40 0.001
R3845 VSS.n65 VSS.n39 0.001
R3846 VSS.n65 VSS.n41 0.001
R3847 VSS.n61 VSS.n38 0.001
R3848 VSS.n61 VSS.n42 0.001
R3849 VSS.n57 VSS.n37 0.001
R3850 VSS.n55 VSS.n36 0.001
R3851 VSS.n52 VSS.n35 0.001
R3852 VSS.n1999 VSS.n33 0.001
R3853 VSS.n2003 VSS.n2002 0.001
R3854 VSS.n40 VSS.n32 0.001
R3855 VSS.n67 VSS.n39 0.001
R3856 VSS.n63 VSS.n41 0.001
R3857 VSS.n63 VSS.n38 0.001
R3858 VSS.n59 VSS.n42 0.001
R3859 VSS.n59 VSS.n37 0.001
R3860 VSS.n57 VSS.n36 0.001
R3861 VSS.n55 VSS.n35 0.001
R3862 VSS.n48 VSS.n33 0.001
R3863 VSS.n261 VSS.n44 0.001
R3864 VSS.n471 VSS.n389 0.001
R3865 VSS.n469 VSS.n390 0.001
R3866 VSS.n391 VSS.n384 0.001
R3867 VSS.n1552 VSS.n1551 0.001
R3868 VSS.n7 VSS.n6 8.47794
R3869 VSS.n383 VSS.n380 0.001
R3870 VSS.n392 VSS.n379 0.001
R3871 VSS.n386 VSS.n379 0.001
R3872 VSS.n393 VSS.n377 0.001
R3873 VSS.n394 VSS.n376 0.001
R3874 VSS.n385 VSS.n376 0.001
R3875 VSS.n1182 VSS.t70 0.001
R3876 VSS.n1184 VSS.t70 0.001
R3877 VSS.n1183 VSS.n1143 0.001
R3878 VSS.n1186 VSS.n1104 0.001
R3879 VSS.t79 VSS.n1014 0.001
R3880 VSS.t79 VSS.n1013 0.001
R3881 VSS.n1276 VSS.n1012 0.001
R3882 VSS.n1011 VSS.n996 0.001
R3883 VSS.n1182 VSS.t24 0.001
R3884 VSS.n1184 VSS.n1143 0.001
R3885 VSS.n1185 VSS.n1183 0.001
R3886 VSS.n1186 VSS.n1185 0.001
R3887 VSS.n1104 VSS.n1014 0.001
R3888 VSS.n1013 VSS.n1012 0.001
R3889 VSS.n1277 VSS.n1276 0.001
R3890 VSS.n1277 VSS.n1011 0.001
R3891 VSS.n1547 VSS.n642 0.001
R3892 VSS.n1527 VSS.n895 0.001
R3893 VSS.n1525 VSS.n894 0.001
R3894 VSS.n1523 VSS.n896 0.001
R3895 VSS.n1520 VSS.n898 0.001
R3896 VSS.n1520 VSS.n891 0.001
R3897 VSS.n1519 VSS.n890 0.001
R3898 VSS.n1517 VSS.n899 0.001
R3899 VSS.n1517 VSS.n889 0.001
R3900 VSS.n1515 VSS.n900 0.001
R3901 VSS.n1510 VSS.n886 0.001
R3902 VSS.n885 VSS.n395 0.001
R3903 VSS.n1527 VSS.n642 0.001
R3904 VSS.n1526 VSS.n895 0.001
R3905 VSS.n1526 VSS.n894 0.001
R3906 VSS.n1524 VSS.n896 0.001
R3907 VSS.n1521 VSS.n898 0.001
R3908 VSS.n1519 VSS.n891 0.001
R3909 VSS.n1518 VSS.n890 0.001
R3910 VSS.n1518 VSS.n899 0.001
R3911 VSS.n1516 VSS.n889 0.001
R3912 VSS.n1516 VSS.n900 0.001
R3913 VSS.n1512 VSS.n886 0.001
R3914 VSS.n1510 VSS.n885 0.001
R3915 VSS.n1661 VSS.n18 0.001
R3916 VSS.n1663 VSS.n1662 0.001
R3917 VSS.n1665 VSS.n1664 0.001
R3918 VSS.n1671 VSS.n1670 0.001
R3919 VSS.n1640 VSS.n1625 0.001
R3920 VSS.n1680 VSS.n1679 0.001
R3921 VSS.n1684 VSS.n1683 0.001
R3922 VSS.n1685 VSS.n1684 0.001
R3923 VSS.n1620 VSS.n1619 0.001
R3924 VSS.n1693 VSS.n1692 0.001
R3925 VSS.n1601 VSS.n1600 0.001
R3926 VSS.n1598 VSS.n1588 0.001
R3927 VSS.n1602 VSS.n1588 0.001
R3928 VSS.n1565 VSS.n118 0.001
R3929 VSS.n1571 VSS.n1570 0.001
R3930 VSS.n1570 VSS.n260 0.001
R3931 VSS.n336 VSS.n259 0.001
R3932 VSS.n333 VSS.n258 0.001
R3933 VSS.n1860 VSS.n118 0.001
R3934 VSS.n1571 VSS.n263 0.001
R3935 VSS.n336 VSS.n260 0.001
R3936 VSS.n333 VSS.n259 0.001
R3937 VSS.n258 VSS.n257 0.001
R3938 VSS.n2003 VSS.n18 0.001
R3939 VSS.n1662 VSS.n1661 0.001
R3940 VSS.n1664 VSS.n1663 0.001
R3941 VSS.n1670 VSS.n1669 0.001
R3942 VSS.n1678 VSS.n1625 0.001
R3943 VSS.n1679 VSS.n1678 0.001
R3944 VSS.n1683 VSS.n1682 0.001
R3945 VSS.n1686 VSS.n1685 0.001
R3946 VSS.n1686 VSS.n1620 0.001
R3947 VSS.n1692 VSS.n1691 0.001
R3948 VSS.n1601 VSS.n1599 0.001
R3949 VSS.n1599 VSS.n1598 0.001
R3950 VSS.n1602 VSS.n1577 0.001
R3951 VSS.n473 VSS.n389 0.001
R3952 VSS.n471 VSS.n390 0.001
R3953 VSS.n469 VSS.n391 0.001
R3954 VSS.n1551 VSS.n384 0.001
R3955 VSS.n1552 VSS.n383 0.001
R3956 VSS.n392 VSS.n380 0.001
R3957 VSS.n386 VSS.n378 0.001
R3958 VSS.n393 VSS.n378 0.001
R3959 VSS.n394 VSS.n377 0.001
R3960 VSS.n395 VSS.n385 0.001
R3961 VSS.n7 VSS.n5 8.50175
C300 DELAY_VBIASP VSS 10.3722f
C301 DELAY_OUT_LAST VSS 2.48281f
C302 DELAY_VBIASN VSS 0.10357p
C303 DELAY_IN VSS 6.20723f
C304 DLL_RESETN VSS 10.3876f
C305 VDD VSS 18.76995f
C306 a_9712_1370# VSS 1.59526f ; **FLOATING
C307 a_9444_1370# VSS 2.31588f ; **FLOATING
C308 a_5778_825# VSS 5.9766f ; **FLOATING
C309 a_15464_1142# VSS 0.91181f ; **FLOATING
C310 a_14757_2640# VSS 0.1031f ; **FLOATING
C311 a_13880_2576# VSS 0.0742f ; **FLOATING
C312 a_15688_2861# VSS 0.27866f ; **FLOATING
C313 a_15108_2783# VSS 0.24688f ; **FLOATING
C314 a_14851_2640# VSS 0.39269f ; **FLOATING
C315 a_9444_2048# VSS 6.48112f ; **FLOATING
C316 a_14111_2685# VSS 0.20221f ; **FLOATING
C317 a_14009_2542# VSS 0.4602f ; **FLOATING
C318 a_13592_2881# VSS 1.62662f ; **FLOATING
C319 a_13306_2563# VSS 0.31101f ; **FLOATING
C320 a_13566_2786# VSS 0.1634f ; **FLOATING
C321 a_13132_2878# VSS 0.14211f ; **FLOATING
C322 a_12907_2878# VSS 0.1476f ; **FLOATING
C323 a_12907_2644# VSS 0.14887f ; **FLOATING
C324 a_13106_2815# VSS 0.07369f ; **FLOATING
C325 a_15304_2063# VSS 0.46629f ; **FLOATING
C326 a_14757_3686# VSS 0.10568f ; **FLOATING
C327 a_15688_3325# VSS 0.2737f ; **FLOATING
C328 a_14851_3686# VSS 0.40535f ; **FLOATING
C329 a_15108_3567# VSS 0.25077f ; **FLOATING
C330 a_14111_3336# VSS 0.23266f ; **FLOATING
C331 a_13880_3750# VSS 0.0799f ; **FLOATING
C332 a_14009_3336# VSS 0.494f ; **FLOATING
C333 a_13592_3329# VSS 1.63328f ; **FLOATING
C334 a_13566_3293# VSS 0.1587f ; **FLOATING
C335 a_13045_3673# VSS 0.01186f ; **FLOATING
C336 a_13306_3763# VSS 0.32799f ; **FLOATING
C337 a_12849_3325# VSS 1.40481f ; **FLOATING
C338 a_13121_3289# VSS 0.83335f ; **FLOATING
C339 a_13019_3289# VSS 3.84649f ; **FLOATING
C340 a_12656_3322# VSS 0.29728f ; **FLOATING
C341 a_12355_3325# VSS 0.76652f ; **FLOATING
C342 a_11397_3686# VSS 0.10938f ; **FLOATING
C343 a_12158_3325# VSS 0.27426f ; **FLOATING
C344 a_11491_3686# VSS 0.32236f ; **FLOATING
C345 a_11748_3567# VSS 0.18335f ; **FLOATING
C346 a_10751_3336# VSS 0.21951f ; **FLOATING
C347 a_10520_3750# VSS 0.05232f ; **FLOATING
C348 a_10649_3336# VSS 0.49351f ; **FLOATING
C349 a_10232_3329# VSS 1.59913f ; **FLOATING
C350 a_10206_3293# VSS 0.09627f ; **FLOATING
C351 a_9946_3763# VSS 0.20725f ; **FLOATING
C352 a_9772_3301# VSS 0.13878f ; **FLOATING
C353 a_9746_3263# VSS 0.07638f ; **FLOATING
C354 a_9547_3630# VSS 0.16803f ; **FLOATING
C355 a_9547_3400# VSS 0.12932f ; **FLOATING
C356 a_6854_2912# VSS 3.65501f ; **FLOATING
C357 a_6126_1274# VSS 17.0938f ; **FLOATING
C358 a_6854_3444# VSS 2.92522f ; **FLOATING
C359 a_5974_3181# VSS 2.52813f ; **FLOATING
C360 a_6326_2048# VSS 1.17208f ; **FLOATING
C361 VSS.t134 VSS 3.78188f ; **FLOATING
C362 VDD.n0 VSS 0.72217f ; **FLOATING
C363 VDD.n1 VSS 0.01868f ; **FLOATING
C364 VDD.n3 VSS 0.13976f ; **FLOATING
C365 VDD.n4 VSS 0.02166f ; **FLOATING
C366 VDD.n5 VSS 0.64548f ; **FLOATING
C367 VDD.n6 VSS 0.77044f ; **FLOATING
C368 VDD.n7 VSS 0.38327f ; **FLOATING
C369 VDD.t0 VSS 18.8268f ; **FLOATING
C370 VDD.n8 VSS 0.68256f ; **FLOATING
C371 VDD.n9 VSS 1.1405f ; **FLOATING
C372 VDD.n10 VSS 0.01958f ; **FLOATING
C373 VDD.n11 VSS 0.01958f ; **FLOATING
C374 VDD.n12 VSS 0.01958f ; **FLOATING
C375 VDD.n13 VSS 0.03638f ; **FLOATING
C376 VDD.n14 VSS 0.04793f ; **FLOATING
C377 VDD.t31 VSS 4.20679f ; **FLOATING
C378 VDD.t83 VSS 0.02874f ; **FLOATING
C379 VDD.n17 VSS 0.16453f ; **FLOATING
C380 VDD.n18 VSS 0.01189f ; **FLOATING
C381 VDD.t75 VSS 0.01654f ; **FLOATING
C382 VDD.n32 VSS 0.02578f ; **FLOATING
C383 VDD.n34 VSS 0.01027f ; **FLOATING
C384 VDD.n35 VSS 0.01027f ; **FLOATING
C385 VDD.n36 VSS 0.01027f ; **FLOATING
C386 VDD.n37 VSS 0.01027f ; **FLOATING
C387 VDD.n38 VSS 0.01027f ; **FLOATING
C388 VDD.n39 VSS 0.01027f ; **FLOATING
C389 VDD.n40 VSS 0.01027f ; **FLOATING
C390 VDD.n41 VSS 0.01027f ; **FLOATING
C391 VDD.n42 VSS 0.01027f ; **FLOATING
C392 VDD.n43 VSS 0.03991f ; **FLOATING
C393 VDD.n45 VSS 0.01027f ; **FLOATING
C394 VDD.t35 VSS 0.03942f ; **FLOATING
C395 VDD.t45 VSS 0.03942f ; **FLOATING
C396 VDD.t38 VSS 0.02318f ; **FLOATING
C397 VDD.t42 VSS 0.02318f ; **FLOATING
C398 VDD.t26 VSS 0.03151f ; **FLOATING
C399 VDD.n46 VSS 0.01027f ; **FLOATING
C400 VDD.n47 VSS 0.01027f ; **FLOATING
C401 VDD.n48 VSS 0.01027f ; **FLOATING
C402 VDD.n49 VSS 0.01027f ; **FLOATING
C403 VDD.n50 VSS 0.01027f ; **FLOATING
C404 VDD.n51 VSS 0.01027f ; **FLOATING
C405 VDD.n52 VSS 0.01027f ; **FLOATING
C406 VDD.n53 VSS 0.01027f ; **FLOATING
C407 VDD.n54 VSS 0.01027f ; **FLOATING
C408 VDD.n55 VSS 0.01027f ; **FLOATING
C409 VDD.n56 VSS 0.01027f ; **FLOATING
C410 VDD.n57 VSS 0.01027f ; **FLOATING
C411 VDD.t27 VSS 0.01075f ; **FLOATING
C412 VDD.t37 VSS 0.05348f ; **FLOATING
C413 VDD.t84 VSS 0.01075f ; **FLOATING
C414 VDD.t41 VSS 0.05348f ; **FLOATING
C415 VDD.t34 VSS 0.0326f ; **FLOATING
C416 VDD.t47 VSS 0.0326f ; **FLOATING
C417 VDD.t73 VSS 0.02852f ; **FLOATING
C418 VDD.t72 VSS 0.02029f ; **FLOATING
C419 VDD.t74 VSS 0.03141f ; **FLOATING
C420 VDD.t76 VSS 0.0281f ; **FLOATING
C421 VDD.t78 VSS 0.02864f ; **FLOATING
C422 VDD.t77 VSS 0.02029f ; **FLOATING
C423 VDD.t79 VSS 0.03141f ; **FLOATING
C424 VDD.t80 VSS 0.01652f ; **FLOATING
C425 VDD.t81 VSS 0.0286f ; **FLOATING
C426 VDD.t49 VSS 0.03473f ; **FLOATING
C427 VDD.t52 VSS 0.02098f ; **FLOATING
C428 VDD.n58 VSS 0.13882f ; **FLOATING
C429 VDD.n59 VSS 0.01102f ; **FLOATING
C430 VDD.n60 VSS 0.01027f ; **FLOATING
C431 VDD.n61 VSS 0.02062f ; **FLOATING
C432 VDD.n62 VSS 0.02064f ; **FLOATING
C433 VDD.n63 VSS 0.01027f ; **FLOATING
C434 VDD.n64 VSS 0.01027f ; **FLOATING
C435 VDD.t54 VSS 0.02909f ; **FLOATING
C436 VDD.n65 VSS 0.01027f ; **FLOATING
C437 VDD.n66 VSS 0.01027f ; **FLOATING
C438 VDD.n67 VSS 0.01027f ; **FLOATING
C439 VDD.n68 VSS 0.01027f ; **FLOATING
C440 VDD.n69 VSS 0.01027f ; **FLOATING
C441 VDD.t21 VSS 0.03259f ; **FLOATING
C442 VDD.n70 VSS 0.01027f ; **FLOATING
C443 VDD.n71 VSS 0.01027f ; **FLOATING
C444 VDD.n72 VSS 0.01027f ; **FLOATING
C445 VDD.n73 VSS 0.01027f ; **FLOATING
C446 VDD.n74 VSS 0.01027f ; **FLOATING
C447 VDD.n75 VSS 0.01027f ; **FLOATING
C448 VDD.n76 VSS 0.01027f ; **FLOATING
C449 VDD.n77 VSS 0.01027f ; **FLOATING
C450 VDD.n78 VSS 0.01027f ; **FLOATING
C451 VDD.n79 VSS 0.01027f ; **FLOATING
C452 VDD.n80 VSS 0.01027f ; **FLOATING
C453 VDD.n81 VSS 0.01027f ; **FLOATING
C454 VDD.n82 VSS 0.01027f ; **FLOATING
C455 VDD.n83 VSS 0.01027f ; **FLOATING
C456 VDD.n84 VSS 0.01027f ; **FLOATING
C457 VDD.n85 VSS 0.01027f ; **FLOATING
C458 VDD.n86 VSS 0.01027f ; **FLOATING
C459 VDD.n87 VSS 0.01027f ; **FLOATING
C460 VDD.n88 VSS 0.01027f ; **FLOATING
C461 VDD.n89 VSS 0.01027f ; **FLOATING
C462 VDD.n90 VSS 0.01027f ; **FLOATING
C463 VDD.n91 VSS 0.01027f ; **FLOATING
C464 VDD.n92 VSS 0.01027f ; **FLOATING
C465 VDD.n93 VSS 0.01027f ; **FLOATING
C466 VDD.n94 VSS 0.01027f ; **FLOATING
C467 VDD.t24 VSS 0.02318f ; **FLOATING
C468 VDD.n95 VSS 0.01027f ; **FLOATING
C469 VDD.n96 VSS 0.01027f ; **FLOATING
C470 VDD.n97 VSS 0.01027f ; **FLOATING
C471 VDD.n98 VSS 0.01027f ; **FLOATING
C472 VDD.n99 VSS 0.01027f ; **FLOATING
C473 VDD.n100 VSS 0.01027f ; **FLOATING
C474 VDD.t22 VSS 0.01075f ; **FLOATING
C475 VDD.t19 VSS 0.05348f ; **FLOATING
C476 VDD.n101 VSS 0.01027f ; **FLOATING
C477 VDD.n102 VSS 0.01027f ; **FLOATING
C478 VDD.n103 VSS 0.03891f ; **FLOATING
C479 VDD.t9 VSS 0.05609f ; **FLOATING
C480 VDD.t5 VSS 0.05699f ; **FLOATING
C481 VDD.t2 VSS 0.05609f ; **FLOATING
C482 VDD.t11 VSS 0.05609f ; **FLOATING
C483 VDD.t10 VSS 0.05609f ; **FLOATING
C484 VDD.t1 VSS 0.05609f ; **FLOATING
C485 VDD.t61 VSS 0.31733f ; **FLOATING
C486 VDD.n104 VSS 0.72532f ; **FLOATING
C487 VDD.n105 VSS 2.49492f ; **FLOATING
C488 VDD.t17 VSS 0.01919f ; **FLOATING
C489 VDD.t63 VSS 0.05018f ; **FLOATING
C490 VDD.n106 VSS 0.01958f ; **FLOATING
C491 VDD.t69 VSS 0.05018f ; **FLOATING
C492 VDD.n107 VSS 0.01958f ; **FLOATING
C493 VDD.n108 VSS 0.03961f ; **FLOATING
C494 VDD.n109 VSS 0.01281f ; **FLOATING
C495 VDD.n110 VSS 0.03961f ; **FLOATING
C496 VDD.t4 VSS 0.05609f ; **FLOATING
C497 VDD.t12 VSS 0.05609f ; **FLOATING
C498 VDD.n111 VSS 0.03639f ; **FLOATING
C499 VDD.t7 VSS 0.05609f ; **FLOATING
C500 VDD.n112 VSS 0.03638f ; **FLOATING
C501 VDD.t15 VSS 0.05609f ; **FLOATING
C502 VDD.t71 VSS 0.05124f ; **FLOATING
C503 VDD.t66 VSS 0.05113f ; **FLOATING
C504 VDD.t64 VSS 0.31733f ; **FLOATING
.ends
