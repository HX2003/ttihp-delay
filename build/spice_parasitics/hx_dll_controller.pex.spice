* NGSPICE file created from hx_dll_controller.ext - technology: ihp-sg13g2

.subckt hx_dll_controller VDD VSS DLL_RESETN DELAY_OUT_LAST DELAY_IN DELAY_VBIASN
+ DELAY_VBIASP
X0 VSS.t67 a_12849_3240# a_13400_3678# VSS.t66 sg13_lv_nmos ad=0.1626p pd=1.415u as=60.89999f ps=0.71u w=0.42u l=0.13u
X1 VSS.t27 VSS.t27 VSS.t27 VSS.t134 sg13_lv_nmos ad=0.1406p pd=1.12u as=0 ps=0 w=0.74u l=0.13u
X2 VSS.t74 a_14851_2555# a_15688_2776# VSS.t79 sg13_lv_nmos ad=0.1406p pd=1.12u as=0.2516p ps=2.16u w=0.74u l=0.13u
X3 a_6854_2827# a_6326_1963# VDD.t10 VDD.t0 sg13_lv_pmos ad=0.38p pd=2.38u as=0.38p ps=2.38u w=2u l=1u
X4 VSS.t93 a_9444_1963# a_9444_1285# VSS.t86 sg13_lv_nmos ad=0.68p pd=4.68u as=0.38p ps=2.38u w=2u l=1u
X5 VDD.t12 a_6326_1963# a_6126_1189# VDD.t0 sg13_lv_pmos ad=0.38p pd=2.38u as=0.38p ps=2.38u w=2u l=1u
X6 a_9946_3678# a_9772_3216# VDD.t22 VDD.t0 sg13_lv_pmos ad=79.8f pd=0.8u as=0.1428p ps=1.52u w=0.42u l=0.13u
X7 a_9712_1285# a_6854_2827# a_9444_1285# VSS.t14 sg13_lv_nmos ad=0.38p pd=2.38u as=0.68p ps=4.68u w=2u l=1u
X8 a_6854_3359# a_15304_1978# DELAY_VBIASN VDD.t31 sg13_lv_pmos ad=0.136p pd=1.14u as=0.158p ps=1.245u w=0.4u l=0.2u
X9 a_9444_1285# a_9444_1963# VSS.t92 VSS.t84 sg13_lv_nmos ad=0.38p pd=2.38u as=0.68p ps=4.68u w=2u l=1u
X10 a_6326_1963# a_6126_1189# a_5778_740# VSS.t3 sg13_lv_nmos ad=0.38p pd=2.38u as=0.68p ps=4.68u w=2u l=1u
X11 a_6854_2827# a_6326_1963# VDD.t7 VDD.t0 sg13_lv_pmos ad=0.38p pd=2.38u as=0.38p ps=2.38u w=2u l=1u
X12 VSS.t74 a_15108_2698# a_14757_2555# VSS.t107 sg13_lv_nmos ad=79.8f pd=0.8u as=0.1428p ps=1.52u w=0.42u l=0.13u
X13 a_14009_3251# DELAY_IN VSS.t24 VSS.t101 sg13_lv_nmos ad=0.2516p pd=2.16u as=1.9998p ps=12.915u w=0.74u l=0.13u
X14 VSS.t29 DELAY_VBIASN VSS.t29 VSS.t36 sg13_lv_nmos ad=1.33p pd=7.38u as=0 ps=0 w=7u l=7u
X15 a_9746_3178# a_9547_3315# VSS.t24 VSS.t25 sg13_lv_nmos ad=0.27427p pd=2.28u as=2.39977p ps=15.495u w=0.795u l=0.13u
X16 VSS.t19 DLL_RESETN a_10040_3678# VSS.t18 sg13_lv_nmos ad=0.1626p pd=1.415u as=60.89999f ps=0.71u w=0.42u l=0.13u
X17 a_13949_2869# a_13592_2796# VDD.t42 VDD.t0 sg13_lv_pmos ad=63f pd=0.72u as=0.1563p ps=1.22u w=0.42u l=0.13u
X18 VSS VSS VSS VSS.t116 sg13_lv_nmos ad=0.68p pd=4.68u as=0.26672n ps=1.39692m w=2u l=1u
X19 a_9772_3216# a_9746_3178# VDD.t18 VDD.t0 sg13_lv_pmos ad=0.3927p pd=2.99u as=1.10612p ps=6.66u w=1.155u l=0.13u
X20 a_13121_3204# a_15688_3240# VDD.t34 VDD.t0 sg13_lv_pmos ad=0.3808p pd=2.92u as=0.2128p ps=1.5u w=1.12u l=0.13u
X21 a_15108_3482# a_14851_3601# a_15270_3678# VSS.t61 sg13_lv_nmos ad=0.1428p pd=1.52u as=37.8f ps=0.6u w=0.42u l=0.13u
X22 VSS.t58 a_12907_2559# a_12907_2559# VSS.t102 sg13_lv_nmos ad=1.45407p pd=9.445u as=0.111p ps=1.34u w=0.3u l=0.13u
X23 VDD.t79 VDD.t77 VDD.t78 VDD.t31 sg13_lv_pmos ad=0.3808p pd=2.92u as=0 ps=0 w=1.12u l=0.13u
X24 VSS VSS VSS VSS.t113 sg13_lv_nmos ad=0.68p pd=4.68u as=0 ps=0 w=2u l=1u
X25 a_15108_2698# a_12849_3240# VDD.t18 VDD.t0 sg13_lv_pmos ad=79.8f pd=0.8u as=1.03698p ps=6.245u w=0.42u l=0.13u
X26 a_13121_3204# a_15688_3240# VSS.t65 VSS.t76 sg13_lv_nmos ad=0.2516p pd=2.16u as=0.1406p ps=1.12u w=0.74u l=0.13u
X27 VDD.t74 VDD.t75 VDD.t76 VDD.t31 sg13_lv_pmos ad=0.2128p pd=1.5u as=0 ps=0 w=1.12u l=0.13u
X28 a_5974_3096# a_6126_1189# VSS.t11 VSS.t0 sg13_lv_nmos ad=0.38p pd=2.38u as=0.68p ps=4.68u w=2u l=1u
X29 VDD.t17 a_5974_3096# a_5974_3096# VDD.t0 sg13_lv_pmos ad=0.2448p pd=2.08u as=0.2826p ps=2.29u w=0.36u l=2u
X30 VSS.t21 a_11748_3482# a_11397_3601# VSS.t2 sg13_lv_nmos ad=79.8f pd=0.8u as=0.1428p ps=1.52u w=0.42u l=0.13u
X31 VSS.t29 DELAY_VBIASN VSS.t29 VSS.t37 sg13_lv_nmos ad=1.33p pd=7.38u as=0 ps=0 w=7u l=7u
X32 a_6326_1963# a_6126_1189# a_5778_740# VSS.t3 sg13_lv_nmos ad=0.38p pd=2.38u as=0.68p ps=4.68u w=2u l=1u
X33 VDD.t69 VDD.t61 VDD.t10 VDD.t0 sg13_lv_pmos ad=0.68p pd=4.68u as=0 ps=0 w=2u l=1u
X34 VSS.t33 DELAY_VBIASN VSS.t29 VSS.t34 sg13_lv_nmos ad=1.33p pd=7.38u as=0 ps=0 w=7u l=7u
X35 a_13306_2478# a_13132_2793# VDD.t84 VDD.t0 sg13_lv_pmos ad=79.8f pd=0.8u as=0.1428p ps=1.52u w=0.42u l=0.13u
X36 a_6126_1189# a_6126_1189# VSS VSS.t3 sg13_lv_nmos ad=0.38p pd=2.38u as=0.68p ps=4.68u w=2u l=1u
X37 a_6326_1963# a_6326_1963# VDD.t2 VDD.t0 sg13_lv_pmos ad=0.38p pd=2.38u as=0.38p ps=2.38u w=2u l=1u
X38 a_13592_3244# a_13566_3208# VSS.t67 VSS.t66 sg13_lv_nmos ad=0.2516p pd=2.16u as=0.1626p ps=1.415u w=0.74u l=0.13u
X39 VSS.t29 DELAY_VBIASN VSS.t29 VSS.t34 sg13_lv_nmos ad=1.33p pd=7.38u as=0 ps=0 w=7u l=7u
X40 VDD.t7 a_6326_1963# a_6126_1189# VDD.t0 sg13_lv_pmos ad=0.38p pd=2.38u as=0.38p ps=2.38u w=2u l=1u
X41 VDD.t18 a_11491_3601# a_11748_3482# VDD.t0 sg13_lv_pmos ad=1.10612p pd=6.66u as=79.8f ps=0.8u w=0.42u l=0.13u
X42 VSS.t29 DELAY_VBIASN VSS.t29 VSS.t31 sg13_lv_nmos ad=1.33p pd=7.38u as=0 ps=0 w=7u l=7u
X43 VDD.t83 DELAY_VBIASP DELAY_VBIASP VDD.t31 sg13_lv_pmos ad=0.3808p pd=2.92u as=1.0304p ps=4.08u w=1.12u l=0.6u
X44 VSS.t29 DELAY_VBIASN VSS.t29 VSS.t37 sg13_lv_nmos ad=1.33p pd=7.38u as=0 ps=0 w=7u l=7u
X45 VDD.t2 a_6326_1963# a_6854_3359# VDD.t0 sg13_lv_pmos ad=0.38p pd=2.38u as=0.38p ps=2.38u w=2u l=1u
X46 a_13132_2793# a_13106_2730# VDD.t18 VDD.t0 sg13_lv_pmos ad=0.3927p pd=2.99u as=1.10612p ps=6.66u w=1.155u l=0.13u
X47 a_14009_3251# DELAY_IN VDD.t18 VDD.t0 sg13_lv_pmos ad=0.4088p pd=2.97u as=1.03698p ps=6.245u w=1.12u l=0.13u
X48 a_15108_3482# a_12849_3240# VDD.t18 VDD.t0 sg13_lv_pmos ad=79.8f pd=0.8u as=1.03698p ps=6.245u w=0.42u l=0.13u
X49 VSS.t29 DELAY_VBIASN VSS.t29 VSS.t35 sg13_lv_nmos ad=1.33p pd=7.38u as=0 ps=0 w=7u l=7u
X50 VDD.t21 a_11491_3601# a_12158_3240# VDD.t0 sg13_lv_pmos ad=0.2128p pd=1.5u as=0.3864p ps=2.93u w=1.12u l=0.13u
X51 a_5778_740# VSS VSS.t109 rppd l=32u w=1u
X52 VSS.t91 a_9444_1963# a_9444_1285# VSS.t90 sg13_lv_nmos ad=0.68p pd=4.68u as=0.38p ps=2.38u w=2u l=1u
X53 a_13880_2491# a_14111_2600# a_13566_2701# VSS.t111 sg13_lv_nmos ad=0.2373p pd=1.97u as=79.8f ps=0.8u w=0.42u l=0.13u
X54 VSS.t21 a_11491_3601# a_12158_3240# VSS.t20 sg13_lv_nmos ad=0.1406p pd=1.12u as=0.2516p ps=2.16u w=0.74u l=0.13u
X55 a_11693_3363# a_10751_3251# a_11491_3601# VDD.t0 sg13_lv_pmos ad=93.45f pd=0.865u as=0.2048p ps=1.63u w=0.42u l=0.13u
X56 a_13306_3678# a_12355_3240# VDD.t27 VDD.t0 sg13_lv_pmos ad=79.8f pd=0.8u as=0.1428p ps=1.52u w=0.42u l=0.13u
X57 VDD.t18 a_12907_2559# a_12907_2793# VDD.t0 sg13_lv_pmos ad=1.10612p pd=6.66u as=0.2442p ps=2.06u w=0.66u l=0.13u
X58 a_13566_2701# a_14009_2457# a_13949_2869# VDD.t0 sg13_lv_pmos ad=79.8f pd=0.8u as=63f ps=0.72u w=0.42u l=0.13u
X59 a_13306_3678# a_14111_3251# a_13566_3208# VDD.t0 sg13_lv_pmos ad=0.1428p pd=1.52u as=79.8f ps=0.8u w=0.42u l=0.13u
X60 a_13106_2730# a_12907_2793# VSS.t58 VSS.t81 sg13_lv_nmos ad=0.27427p pd=2.28u as=1.45407p ps=9.445u w=0.795u l=0.13u
X61 VSS.t29 DELAY_VBIASN VSS.t29 VSS.t28 sg13_lv_nmos ad=2.38p pd=14.68u as=0 ps=0 w=7u l=7u
X62 a_13566_3208# a_14009_3251# a_13306_3678# VSS.t59 sg13_lv_nmos ad=79.8f pd=0.8u as=0.1296p ps=1.52u w=0.42u l=0.13u
X63 a_13019_3204# a_15688_2776# VSS.t74 VSS.t82 sg13_lv_nmos ad=0.2516p pd=2.16u as=0.1406p ps=1.12u w=0.74u l=0.13u
X64 VDD.t19 DLL_RESETN a_9946_3678# VDD.t0 sg13_lv_pmos ad=0.36237p pd=2.605u as=79.8f ps=0.8u w=0.42u l=0.13u
X65 a_6326_1963# a_5974_3096# a_6126_1189# VSS.t0 sg13_lv_nmos ad=0.38p pd=2.38u as=0.68p ps=4.68u w=2u l=1u
X66 a_5778_740# a_6126_1189# a_6326_1963# VSS.t3 sg13_lv_nmos ad=0.68p pd=4.68u as=0.38p ps=2.38u w=2u l=1u
X67 a_9444_1285# a_6854_2827# a_9712_1285# VSS.t17 sg13_lv_nmos ad=0.68p pd=4.68u as=0.38p ps=2.38u w=2u l=1u
X68 a_6854_3359# a_6326_1963# VDD.t1 VDD.t0 sg13_lv_pmos ad=0.38p pd=2.38u as=0.38p ps=2.38u w=2u l=1u
X69 a_9712_1285# a_13019_3204# DELAY_VBIASN VSS.t49 sg13_lv_nmos ad=0.136p pd=1.14u as=0.232p ps=2.08u w=0.4u l=0.2u
X70 a_13818_2491# a_12849_3240# VSS.t70 VSS.t72 sg13_lv_nmos ad=37.8f pd=0.6u as=0.1701p ps=1.65u w=0.42u l=0.13u
X71 VDD.t4 a_6326_1963# a_6326_1963# VDD.t0 sg13_lv_pmos ad=0.38p pd=2.38u as=0.38p ps=2.38u w=2u l=1u
X72 VDD.t42 a_12849_3240# a_13566_2701# VDD.t0 sg13_lv_pmos ad=0.1563p pd=1.22u as=0.147p ps=1.54u w=0.42u l=0.13u
X73 VSS.t29 DELAY_VBIASN VSS.t29 VSS.t31 sg13_lv_nmos ad=1.33p pd=7.38u as=0 ps=0 w=7u l=7u
X74 a_15270_2478# a_12849_3240# VSS.t74 VSS.t73 sg13_lv_nmos ad=37.8f pd=0.6u as=79.8f ps=0.8u w=0.42u l=0.13u
X75 a_15304_1978# a_14851_3601# VDD.t35 VDD.t0 sg13_lv_pmos ad=0.4312p pd=3.01u as=0.2639p ps=1.81u w=1.12u l=0.13u
X76 a_15304_1978# a_14851_3601# VSS.t63 VSS.t62 sg13_lv_nmos ad=0.2849p pd=2.25u as=0.2516p ps=2.16u w=0.74u l=0.13u
X77 a_9444_1285# a_9444_1963# VSS.t89 VSS.t88 sg13_lv_nmos ad=0.38p pd=2.38u as=0.68p ps=4.68u w=2u l=1u
X78 VDD.t45 a_14851_2555# a_15108_2698# VDD.t0 sg13_lv_pmos ad=0.2639p pd=1.81u as=79.8f ps=0.8u w=0.42u l=0.13u
X79 a_13400_2478# a_13132_2793# a_13306_2478# VSS.t110 sg13_lv_nmos ad=60.89999f pd=0.71u as=0.1428p ps=1.52u w=0.42u l=0.13u
X80 a_11910_3678# DLL_RESETN VSS.t21 VSS.t2 sg13_lv_nmos ad=37.8f pd=0.6u as=79.8f ps=0.8u w=0.42u l=0.13u
X81 a_12849_3240# a_12656_3237# VSS.t21 VSS.t50 sg13_lv_nmos ad=0.1406p pd=1.12u as=0.2516p ps=2.16u w=0.74u l=0.13u
X82 a_5974_3096# a_6126_1189# VSS VSS.t0 sg13_lv_nmos ad=0.38p pd=2.38u as=0.68p ps=4.68u w=2u l=1u
X83 a_13880_3665# a_13592_3244# a_13818_3665# VSS.t136 sg13_lv_nmos ad=0.1428p pd=1.52u as=37.8f ps=0.6u w=0.42u l=0.13u
X84 VSS.t29 DELAY_VBIASN VSS.t29 VSS.t30 sg13_lv_nmos ad=1.33p pd=7.38u as=0 ps=0 w=7u l=7u
X85 a_5974_3096# a_6126_1189# VSS VSS.t0 sg13_lv_nmos ad=0.38p pd=2.38u as=0.68p ps=4.68u w=2u l=1u
X86 a_13592_2796# a_13566_2701# VSS.t70 VSS.t103 sg13_lv_nmos ad=0.2516p pd=2.16u as=0.1626p ps=1.415u w=0.74u l=0.13u
X87 a_12656_3237# DLL_RESETN VSS.t21 VSS.t99 sg13_lv_nmos ad=0.2516p pd=2.16u as=0.2516p ps=2.16u w=0.74u l=0.13u
X88 a_14851_3601# a_14009_3251# a_14757_3601# VSS.t61 sg13_lv_nmos ad=0.12665p pd=1.145u as=0.1428p ps=1.52u w=0.42u l=0.13u
X89 a_9712_1285# a_6854_2827# a_9444_1285# VSS.t16 sg13_lv_nmos ad=0.38p pd=2.38u as=0.68p ps=4.68u w=2u l=1u
X90 VDD.t63 VDD.t61 VDD.t1 VDD.t0 sg13_lv_pmos ad=0.68p pd=4.68u as=0 ps=0 w=2u l=1u
X91 VDD.t26 a_13019_3204# a_12943_3240# VDD.t0 sg13_lv_pmos ad=0.2128p pd=1.5u as=0.2128p ps=1.5u w=1.12u l=0.13u
X92 VSS.t63 a_15108_3482# a_14757_3601# VSS.t61 sg13_lv_nmos ad=79.8f pd=0.8u as=0.1428p ps=1.52u w=0.42u l=0.13u
X93 VDD.t41 a_12849_3240# a_13306_2478# VDD.t0 sg13_lv_pmos ad=0.36237p pd=2.605u as=79.8f ps=0.8u w=0.42u l=0.13u
X94 a_10520_3665# a_10232_3244# a_10458_3665# VSS.t46 sg13_lv_nmos ad=0.1428p pd=1.52u as=37.8f ps=0.6u w=0.42u l=0.13u
X95 a_15053_2793# a_14111_2600# a_14851_2555# VDD.t0 sg13_lv_pmos ad=93.45f pd=0.865u as=0.2048p ps=1.63u w=0.42u l=0.13u
X96 a_12656_3237# DLL_RESETN VDD.t54 VDD.t0 sg13_lv_pmos ad=0.3808p pd=2.92u as=0.3808p ps=2.92u w=1.12u l=0.13u
X97 a_11491_3601# a_10649_3251# a_11397_3601# VSS.t2 sg13_lv_nmos ad=0.12665p pd=1.145u as=0.1428p ps=1.52u w=0.42u l=0.13u
X98 VSS.t21 a_13121_3204# a_13045_3588# VSS.t56 sg13_lv_nmos ad=0.2516p pd=2.16u as=0.1406p ps=1.12u w=0.74u l=0.13u
X99 VDD.t47 a_14851_2555# a_15688_2776# VDD.t0 sg13_lv_pmos ad=0.2128p pd=1.5u as=0.3864p ps=2.93u w=1.12u l=0.13u
X100 a_14009_2457# DELAY_OUT_LAST VSS.t58 VSS.t57 sg13_lv_nmos ad=0.2516p pd=2.16u as=1.45407p ps=9.445u w=0.74u l=0.13u
X101 VDD.t35 a_14851_3601# a_15108_3482# VDD.t0 sg13_lv_pmos ad=0.2639p pd=1.81u as=79.8f ps=0.8u w=0.42u l=0.13u
X102 a_13592_2796# a_13566_2701# VDD.t41 VDD.t0 sg13_lv_pmos ad=0.34p pd=2.68u as=0.36237p ps=2.605u w=1u l=0.13u
X103 VSS.t95 a_9444_1963# a_9444_1963# VSS.t90 sg13_lv_nmos ad=0.68p pd=4.68u as=0.38p ps=2.38u w=2u l=1u
X104 a_12355_3240# a_12158_3240# VDD.t21 VDD.t0 sg13_lv_pmos ad=0.3808p pd=2.92u as=0.2128p ps=1.5u w=1.12u l=0.13u
X105 VSS.t29 DELAY_VBIASN VSS.t29 VSS.t35 sg13_lv_nmos ad=1.33p pd=7.38u as=0 ps=0 w=7u l=7u
X106 a_14009_2457# DELAY_OUT_LAST VDD.t18 VDD.t0 sg13_lv_pmos ad=0.4088p pd=2.97u as=1.10612p ps=6.66u w=1.12u l=0.13u
X107 a_10206_3208# a_10649_3251# a_10589_3287# VDD.t0 sg13_lv_pmos ad=79.8f pd=0.8u as=63f ps=0.72u w=0.42u l=0.13u
X108 a_12355_3240# a_12158_3240# VSS.t21 VSS.t54 sg13_lv_nmos ad=0.2516p pd=2.16u as=0.1406p ps=1.12u w=0.74u l=0.13u
X109 VDD.t37 a_12849_3240# a_13306_3678# VDD.t0 sg13_lv_pmos ad=0.36237p pd=2.605u as=79.8f ps=0.8u w=0.42u l=0.13u
X110 a_10040_3678# a_9772_3216# a_9946_3678# VSS.t22 sg13_lv_nmos ad=60.89999f pd=0.71u as=0.1428p ps=1.52u w=0.42u l=0.13u
X111 a_10520_3665# a_10751_3251# a_10206_3208# VSS.t1 sg13_lv_nmos ad=0.2373p pd=1.97u as=79.8f ps=0.8u w=0.42u l=0.13u
X112 VSS.t29 DELAY_VBIASN VSS.t33 VSS.t32 sg13_lv_nmos ad=1.33p pd=7.38u as=0 ps=0 w=7u l=7u
X113 a_15464_1057# a_14851_2555# VSS.t74 VSS.t80 sg13_lv_nmos ad=0.2849p pd=2.25u as=0.2516p ps=2.16u w=0.74u l=0.13u
X114 a_6126_1189# a_5974_3096# a_6326_1963# VSS.t0 sg13_lv_nmos ad=0.68p pd=4.68u as=0.38p ps=2.38u w=2u l=1u
X115 VSS.t24 a_14009_3251# a_14111_3251# VSS.t60 sg13_lv_nmos ad=2.39977p pd=15.495u as=0.2516p ps=2.16u w=0.74u l=0.13u
X116 a_9444_1963# a_6854_2827# a_6854_2827# VSS.t17 sg13_lv_nmos ad=0.68p pd=4.68u as=0.38p ps=2.38u w=2u l=1u
X117 a_13592_2796# a_14111_2600# a_14851_2555# VSS.t112 sg13_lv_nmos ad=0.3473p pd=2.71u as=0.12665p ps=1.145u w=0.74u l=0.13u
X118 VSS.t27 VSS.t27 VSS.t27 VSS.t132 sg13_lv_nmos ad=0.2516p pd=2.16u as=0 ps=0 w=0.74u l=0.13u
X119 VSS.t27 VSS.t27 VSS.t27 VSS.t130 sg13_lv_nmos ad=0.1406p pd=1.12u as=0 ps=0 w=0.74u l=0.13u
X120 a_15053_3363# a_14111_3251# a_14851_3601# VDD.t0 sg13_lv_pmos ad=93.45f pd=0.865u as=0.2048p ps=1.63u w=0.42u l=0.13u
X121 VDD.t18 a_9547_3545# a_9547_3315# VDD.t0 sg13_lv_pmos ad=1.10612p pd=6.66u as=0.2442p ps=2.06u w=0.66u l=0.13u
X122 VSS.t24 a_10649_3251# a_10751_3251# VSS.t53 sg13_lv_nmos ad=2.39977p pd=15.495u as=0.2516p ps=2.16u w=0.74u l=0.13u
X123 VSS.t29 DELAY_VBIASN VSS.t29 VSS.t32 sg13_lv_nmos ad=1.33p pd=7.38u as=0 ps=0 w=7u l=7u
X124 a_9444_1963# a_9444_1963# VSS.t94 VSS.t88 sg13_lv_nmos ad=0.38p pd=2.38u as=0.68p ps=4.68u w=2u l=1u
X125 a_14851_2555# a_14009_2457# a_14757_2555# VSS.t106 sg13_lv_nmos ad=0.12665p pd=1.145u as=0.1428p ps=1.52u w=0.42u l=0.13u
X126 VDD.t5 VDD.t64 VDD.t71 VDD.t0 sg13_lv_pmos ad=0.38p pd=2.38u as=0 ps=0 w=2u l=1u
X127 a_14851_2555# a_14009_2457# a_13592_2796# VDD.t0 sg13_lv_pmos ad=0.2048p pd=1.63u as=0.34p ps=2.68u w=1u l=0.13u
X128 VSS.t29 DELAY_VBIASN VSS.t29 VSS.t28 sg13_lv_nmos ad=2.38p pd=14.68u as=0 ps=0 w=7u l=7u
X129 VSS.t27 DELAY_VBIASN DELAY_VBIASP VSS.t26 sg13_lv_nmos ad=0.2516p pd=2.16u as=0.6808p ps=3.32u w=0.74u l=0.6u
X130 DELAY_VBIASN DLL_RESETN VDD.t52 VDD.t31 sg13_lv_pmos ad=0.158p pd=1.245u as=0.272p ps=2.28u w=0.8u l=0.2u
X131 VDD.t74 VDD.t72 VDD.t73 VDD.t31 sg13_lv_pmos ad=0.3808p pd=2.92u as=0 ps=0 w=1.12u l=0.13u
X132 a_13949_3287# a_13592_3244# VDD.t38 VDD.t0 sg13_lv_pmos ad=63f pd=0.72u as=0.1563p ps=1.22u w=0.42u l=0.13u
X133 VDD.t79 VDD.t80 VDD.t81 VDD.t31 sg13_lv_pmos ad=0.2128p pd=1.5u as=0 ps=0 w=1.12u l=0.13u
X134 a_10232_3244# a_10206_3208# VDD.t19 VDD.t0 sg13_lv_pmos ad=0.34p pd=2.68u as=0.36237p ps=2.605u w=1u l=0.13u
X135 VSS.t55 a_13121_3204# a_6854_3359# VDD.t31 sg13_lv_pmos ad=0.232p pd=2.08u as=0.136p ps=1.14u w=0.4u l=0.2u
X136 a_5778_740# a_6126_1189# a_6326_1963# VSS.t3 sg13_lv_nmos ad=0.68p pd=4.68u as=0.38p ps=2.38u w=2u l=1u
X137 VDD.t24 DLL_RESETN a_10206_3208# VDD.t0 sg13_lv_pmos ad=0.1563p pd=1.22u as=0.147p ps=1.54u w=0.42u l=0.13u
X138 a_13592_3244# a_14111_3251# a_14851_3601# VSS.t61 sg13_lv_nmos ad=0.3473p pd=2.71u as=0.12665p ps=1.145u w=0.74u l=0.13u
X139 a_6854_2827# a_6854_2827# a_9444_1963# VSS.t16 sg13_lv_nmos ad=0.38p pd=2.38u as=0.68p ps=4.68u w=2u l=1u
X140 a_5778_740# a_6126_1189# a_6326_1963# VSS.t3 sg13_lv_nmos ad=0.68p pd=4.68u as=0.38p ps=2.38u w=2u l=1u
X141 VSS.t29 DELAY_VBIASN VSS.t29 VSS.t30 sg13_lv_nmos ad=1.33p pd=7.38u as=0 ps=0 w=7u l=7u
X142 a_10589_3287# a_10232_3244# VDD.t24 VDD.t0 sg13_lv_pmos ad=63f pd=0.72u as=0.1563p ps=1.22u w=0.42u l=0.13u
X143 a_15270_3678# a_12849_3240# VSS.t63 VSS.t61 sg13_lv_nmos ad=37.8f pd=0.6u as=79.8f ps=0.8u w=0.42u l=0.13u
X144 VDD.t18 a_14009_3251# a_14111_3251# VDD.t0 sg13_lv_pmos ad=1.10612p pd=6.66u as=0.3864p ps=2.93u w=1.12u l=0.13u
X145 a_6326_1963# a_6126_1189# a_5778_740# VSS.t3 sg13_lv_nmos ad=0.42p pd=2.42u as=0.68p ps=4.68u w=2u l=1u
X146 a_6326_1963# a_6326_1963# VDD.t12 VDD.t0 sg13_lv_pmos ad=0.38p pd=2.38u as=0.38p ps=2.38u w=2u l=1u
X147 a_10232_3244# a_10751_3251# a_11491_3601# VSS.t2 sg13_lv_nmos ad=0.3473p pd=2.71u as=0.12665p ps=1.145u w=0.74u l=0.13u
X148 VDD.t5 a_6326_1963# a_6854_3359# VDD.t0 sg13_lv_pmos ad=0.38p pd=2.38u as=0.38p ps=2.38u w=2u l=1u
X149 VDD.t18 a_11748_3482# a_11693_3363# VDD.t0 sg13_lv_pmos ad=1.10612p pd=6.66u as=93.45f ps=0.865u w=0.42u l=0.13u
X150 VSS.t70 a_12849_3240# a_13400_2478# VSS.t69 sg13_lv_nmos ad=0.1626p pd=1.415u as=60.89999f ps=0.71u w=0.42u l=0.13u
X151 a_13400_3678# a_12355_3240# a_13306_3678# VSS.t51 sg13_lv_nmos ad=60.89999f pd=0.71u as=0.1428p ps=1.52u w=0.42u l=0.13u
X152 a_13019_3204# a_15688_2776# VDD.t47 VDD.t0 sg13_lv_pmos ad=0.3808p pd=2.92u as=0.2128p ps=1.5u w=1.12u l=0.13u
X153 VDD.t18 a_10649_3251# a_10751_3251# VDD.t0 sg13_lv_pmos ad=1.10612p pd=6.66u as=0.3864p ps=2.93u w=1.12u l=0.13u
X154 a_9444_1963# a_6854_2827# a_6854_2827# VSS.t15 sg13_lv_nmos ad=0.68p pd=4.68u as=0.38p ps=2.38u w=2u l=1u
X155 a_10458_3665# DLL_RESETN VSS.t19 VSS.t98 sg13_lv_nmos ad=37.8f pd=0.6u as=0.1701p ps=1.65u w=0.42u l=0.13u
X156 a_13566_2701# a_14009_2457# a_13306_2478# VSS.t104 sg13_lv_nmos ad=79.8f pd=0.8u as=0.1296p ps=1.52u w=0.42u l=0.13u
X157 a_13306_2478# a_14111_2600# a_13566_2701# VDD.t0 sg13_lv_pmos ad=0.1428p pd=1.52u as=79.8f ps=0.8u w=0.42u l=0.13u
X158 a_6326_1963# a_6126_1189# a_5778_740# VSS.t3 sg13_lv_nmos ad=0.38p pd=2.38u as=0.68p ps=4.68u w=2u l=1u
X159 a_13880_2491# a_13592_2796# a_13818_2491# VSS.t108 sg13_lv_nmos ad=0.1428p pd=1.52u as=37.8f ps=0.6u w=0.42u l=0.13u
X160 a_15108_2698# a_14851_2555# a_15270_2478# VSS.t78 sg13_lv_nmos ad=0.1428p pd=1.52u as=37.8f ps=0.6u w=0.42u l=0.13u
X161 a_13566_3208# a_14009_3251# a_13949_3287# VDD.t0 sg13_lv_pmos ad=79.8f pd=0.8u as=63f ps=0.72u w=0.42u l=0.13u
X162 a_11491_3601# a_10649_3251# a_10232_3244# VDD.t0 sg13_lv_pmos ad=0.2048p pd=1.63u as=0.34p ps=2.68u w=1u l=0.13u
X163 a_5778_740# a_6126_1189# a_6326_1963# VSS.t3 sg13_lv_nmos ad=0.68p pd=4.68u as=0.42p ps=2.42u w=2u l=1u
X164 a_13880_3665# a_14111_3251# a_13566_3208# VSS.t77 sg13_lv_nmos ad=0.2373p pd=1.97u as=79.8f ps=0.8u w=0.42u l=0.13u
X165 VSS a_6126_1189# a_6126_1189# VSS.t3 sg13_lv_nmos ad=0.68p pd=4.68u as=0.38p ps=2.38u w=2u l=1u
X166 a_6854_3359# a_6326_1963# VDD.t15 VDD.t0 sg13_lv_pmos ad=0.38p pd=2.38u as=0.38p ps=2.38u w=2u l=1u
X167 a_11748_3482# a_11491_3601# a_11910_3678# VSS.t2 sg13_lv_nmos ad=0.1428p pd=1.52u as=37.8f ps=0.6u w=0.42u l=0.13u
X168 VSS.t87 a_9444_1963# a_9444_1963# VSS.t86 sg13_lv_nmos ad=0.68p pd=4.68u as=0.38p ps=2.38u w=2u l=1u
X169 a_12943_3240# a_12656_3237# a_12849_3240# VDD.t0 sg13_lv_pmos ad=0.2128p pd=1.5u as=0.3808p ps=2.92u w=1.12u l=0.13u
X170 a_13592_3244# a_13566_3208# VDD.t37 VDD.t0 sg13_lv_pmos ad=0.34p pd=2.68u as=0.36237p ps=2.605u w=1u l=0.13u
X171 a_6854_2827# a_6854_2827# a_9444_1963# VSS.t14 sg13_lv_nmos ad=0.38p pd=2.38u as=0.68p ps=4.68u w=2u l=1u
X172 VDD.t38 a_12849_3240# a_13566_3208# VDD.t0 sg13_lv_pmos ad=0.1563p pd=1.22u as=0.147p ps=1.54u w=0.42u l=0.13u
X173 a_9444_1963# a_9444_1963# VSS.t85 VSS.t84 sg13_lv_nmos ad=0.38p pd=2.38u as=0.68p ps=4.68u w=2u l=1u
X174 VDD.t34 a_14851_3601# a_15688_3240# VDD.t0 sg13_lv_pmos ad=0.2128p pd=1.5u as=0.3864p ps=2.93u w=1.12u l=0.13u
X175 VSS a_6126_1189# a_5974_3096# VSS.t0 sg13_lv_nmos ad=0.68p pd=4.68u as=0.38p ps=2.38u w=2u l=1u
X176 VDD.t66 VDD.t64 VDD.t9 VDD.t0 sg13_lv_pmos ad=0.38p pd=2.38u as=0 ps=0 w=2u l=1u
X177 VSS.t65 a_14851_3601# a_15688_3240# VSS.t64 sg13_lv_nmos ad=0.1406p pd=1.12u as=0.2516p ps=2.16u w=0.74u l=0.13u
X178 VDD.t49 a_15464_1057# a_9712_1285# VSS.t83 sg13_lv_nmos ad=0.232p pd=2.08u as=0.136p ps=1.14u w=0.4u l=0.2u
X179 VSS VSS VSS VSS.t116 sg13_lv_nmos ad=0.68p pd=4.68u as=0 ps=0 w=2u l=1u
X180 VDD.t18 a_15108_2698# a_15053_2793# VDD.t0 sg13_lv_pmos ad=1.10612p pd=6.66u as=93.45f ps=0.865u w=0.42u l=0.13u
X181 VSS.t29 DELAY_VBIASN VSS.t29 VSS.t36 sg13_lv_nmos ad=1.33p pd=7.38u as=0 ps=0 w=7u l=7u
X182 a_10649_3251# DELAY_IN VSS.t24 VSS.t100 sg13_lv_nmos ad=0.2516p pd=2.16u as=1.9998p ps=12.915u w=0.74u l=0.13u
X183 VSS a_6126_1189# a_5974_3096# VSS.t0 sg13_lv_nmos ad=0.68p pd=4.68u as=0.38p ps=2.38u w=2u l=1u
X184 VSS VSS VSS.t114 VSS.t113 sg13_lv_nmos ad=0.68p pd=4.68u as=0 ps=0 w=2u l=1u
X185 VSS.t58 a_14009_2457# a_14111_2600# VSS.t105 sg13_lv_nmos ad=1.45407p pd=9.445u as=0.2516p ps=2.16u w=0.74u l=0.13u
X186 a_6126_1189# a_6326_1963# VDD.t11 VDD.t0 sg13_lv_pmos ad=0.38p pd=2.38u as=0.38p ps=2.38u w=2u l=1u
X187 VDD.t15 a_6326_1963# a_6326_1963# VDD.t0 sg13_lv_pmos ad=0.38p pd=2.38u as=0.38p ps=2.38u w=2u l=1u
X188 a_12943_3240# a_13121_3204# VDD.t26 VDD.t0 sg13_lv_pmos ad=0.3808p pd=2.92u as=0.2128p ps=1.5u w=1.12u l=0.13u
X189 VDD.t18 a_14009_2457# a_14111_2600# VDD.t0 sg13_lv_pmos ad=1.10612p pd=6.66u as=0.3864p ps=2.93u w=1.12u l=0.13u
X190 VDD.t11 a_6326_1963# a_6854_2827# VDD.t0 sg13_lv_pmos ad=0.38p pd=2.38u as=0.38p ps=2.38u w=2u l=1u
X191 a_11748_3482# DLL_RESETN VDD.t18 VDD.t0 sg13_lv_pmos ad=79.8f pd=0.8u as=1.10612p ps=6.66u w=0.42u l=0.13u
X192 a_13818_3665# a_12849_3240# VSS.t67 VSS.t71 sg13_lv_nmos ad=37.8f pd=0.6u as=0.1701p ps=1.65u w=0.42u l=0.13u
X193 a_15464_1057# a_14851_2555# VDD.t45 VDD.t0 sg13_lv_pmos ad=0.4312p pd=3.01u as=0.2639p ps=1.81u w=1.12u l=0.13u
X194 a_9444_1285# a_6854_2827# a_9712_1285# VSS.t15 sg13_lv_nmos ad=0.68p pd=4.68u as=0.38p ps=2.38u w=2u l=1u
X195 a_6126_1189# a_6326_1963# VDD.t4 VDD.t0 sg13_lv_pmos ad=0.38p pd=2.38u as=0.38p ps=2.38u w=2u l=1u
X196 VSS.t24 a_9547_3545# a_9547_3545# VSS.t23 sg13_lv_nmos ad=2.39977p pd=15.495u as=0.111p ps=1.34u w=0.3u l=0.13u
X197 VDD.t9 a_6326_1963# a_6854_2827# VDD.t0 sg13_lv_pmos ad=0.38p pd=2.38u as=0.38p ps=2.38u w=2u l=1u
X198 a_13045_3588# a_13019_3204# a_12849_3240# VSS.t48 sg13_lv_nmos ad=0.1406p pd=1.12u as=0.1406p ps=1.12u w=0.74u l=0.13u
X199 a_10232_3244# a_10206_3208# VSS.t19 VSS.t18 sg13_lv_nmos ad=0.2516p pd=2.16u as=0.1626p ps=1.415u w=0.74u l=0.13u
X200 VDD.t18 a_15108_3482# a_15053_3363# VDD.t0 sg13_lv_pmos ad=1.10612p pd=6.66u as=93.45f ps=0.865u w=0.42u l=0.13u
X201 a_5974_3096# a_6126_1189# VSS VSS.t0 sg13_lv_nmos ad=0.38p pd=2.38u as=0.68p ps=4.68u w=2u l=1u
X202 a_9946_3678# a_10751_3251# a_10206_3208# VDD.t0 sg13_lv_pmos ad=0.1428p pd=1.52u as=79.8f ps=0.8u w=0.42u l=0.13u
X203 a_14851_3601# a_14009_3251# a_13592_3244# VDD.t0 sg13_lv_pmos ad=0.2048p pd=1.63u as=0.34p ps=2.68u w=1u l=0.13u
X204 a_10206_3208# a_10649_3251# a_9946_3678# VSS.t52 sg13_lv_nmos ad=79.8f pd=0.8u as=0.1296p ps=1.52u w=0.42u l=0.13u
X205 VSS.t11 a_6126_1189# a_5974_3096# VSS.t0 sg13_lv_nmos ad=0.68p pd=4.68u as=0.38p ps=2.38u w=2u l=1u
X206 a_10649_3251# DELAY_IN VDD.t18 VDD.t0 sg13_lv_pmos ad=0.4088p pd=2.97u as=1.03698p ps=6.245u w=1.12u l=0.13u
X207 VSS.t27 VSS.t27 VSS.t27 VSS.t128 sg13_lv_nmos ad=0.2516p pd=2.16u as=0 ps=0 w=0.74u l=0.13u
X208 VSS.t11 a_6126_1189# a_5974_3096# VSS.t0 sg13_lv_nmos ad=0.76p pd=4.76u as=0.38p ps=2.38u w=2u l=1u
C0 a_9444_1963# VDD 0.01443f
C1 a_12907_2793# DLL_RESETN 0.04234f
C2 a_10649_3251# DELAY_IN 0.25484f
C3 a_9444_1963# a_6326_1963# 0.01269f
C4 a_12158_3240# DLL_RESETN 0.02442f
C5 a_10520_3665# a_10751_3251# 0.12701f
C6 a_13306_2478# a_12849_3240# 0.10976f
C7 a_14111_2600# DELAY_OUT_LAST 0.02024f
C8 a_11491_3601# VDD 0.16753f
C9 a_10751_3251# DLL_RESETN 0.45018f
C10 VDD a_13592_3244# 0.07242f
C11 a_14111_3251# a_13592_3244# 0.34102f
C12 a_14009_2457# a_14757_2555# 0.01058f
C13 DELAY_OUT_LAST DELAY_VBIASP 0.82908f
C14 DELAY_OUT_LAST a_13592_2796# 0.08062f
C15 a_5864_740# a_6854_2827# 0.03661f
C16 a_15464_1057# a_15688_2776# 0.1999f
C17 a_13306_2478# a_13880_2491# 0.31978f
C18 VDD DELAY_OUT_LAST 0.17745f
C19 DELAY_IN a_12158_3240# 0.01309f
C20 a_13880_3665# a_13592_3244# 0.43707f
C21 a_14851_3601# a_15108_3482# 0.29858f
C22 DELAY_OUT_LAST a_14851_2555# 0.02109f
C23 VDD a_12907_2559# 0.06323f
C24 a_6854_3359# a_12849_3240# 0.06216f
C25 DELAY_IN a_13566_3208# 0.01538f
C26 a_12849_3240# a_15108_3482# 0.10225f
C27 VDD a_15688_3240# 0.30345f
C28 a_14111_2600# a_14009_2457# 0.47622f
C29 a_9712_1285# DELAY_VBIASP 0.11086f
C30 a_14757_3601# a_13592_3244# 0.43239f
C31 VDD a_13121_3204# 0.99724f
C32 DELAY_VBIASN DLL_RESETN 0.12904f
C33 a_14111_3251# a_13121_3204# 0.0235f
C34 DELAY_IN a_10751_3251# 0.01931f
C35 a_13019_3204# a_15688_2776# 0.1287f
C36 a_10232_3244# a_9946_3678# 0.41329f
C37 a_14009_3251# a_13592_3244# 0.37583f
C38 a_10206_3208# a_9946_3678# 0.75507f
C39 a_15108_2698# a_15464_1057# 0.12158f
C40 a_14851_2555# a_13121_3204# 0.03337f
C41 a_13306_3678# a_13566_3208# 0.75507f
C42 a_12355_3240# a_13121_3204# 0.05795f
C43 a_13592_2796# a_14009_2457# 0.3749f
C44 a_6854_3359# a_5974_3096# 0.029f
C45 VDD a_10232_3244# 0.07206f
C46 a_6854_2827# DLL_RESETN 0.03626f
C47 VDD a_6126_1189# 0.81494f
C48 VDD a_10206_3208# 0.09392f
C49 a_9712_1285# VDD 0.22552f
C50 DELAY_IN DLL_RESETN 10.4683f
C51 a_5778_740# a_6326_1963# 0.8779f
C52 a_11491_3601# a_11748_3482# 0.34468f
C53 DLL_RESETN a_15304_1978# 0.03137f
C54 a_6326_1963# a_6126_1189# 2.84014f
C55 a_9712_1285# a_6326_1963# 0.04741f
C56 a_14851_3601# a_13592_3244# 0.01529f
C57 a_13019_3204# DLL_RESETN 0.01429f
C58 a_15108_2698# a_15304_1978# 0.01986f
C59 a_10649_3251# a_9946_3678# 0.02432f
C60 VDD a_14009_2457# 0.31815f
C61 a_12849_3240# a_13592_3244# 0.38817f
C62 a_14009_2457# a_13566_2701# 0.02242f
C63 VDD a_10649_3251# 0.23431f
C64 a_13106_2730# a_12907_2559# 0.02437f
C65 DELAY_VBIASN a_15304_1978# 0.07802f
C66 a_14009_3251# a_13121_3204# 0.01604f
C67 a_12943_3240# a_13121_3204# 0.09118f
C68 a_13019_3204# a_15464_1057# 0.59875f
C69 a_13132_2793# a_12907_2793# 0.02416f
C70 a_13019_3204# DELAY_VBIASN 1.23663f
C71 DELAY_OUT_LAST a_12849_3240# 0.01791f
C72 a_13019_3204# a_13045_3588# 0.01249f
C73 a_15688_3240# a_14851_3601# 0.08776f
C74 a_9772_3216# a_9946_3678# 0.27179f
C75 DELAY_IN a_15304_1978# 0.01066f
C76 a_14851_3601# a_13121_3204# 0.03404f
C77 a_13019_3204# DELAY_IN 0.35409f
C78 a_9444_1963# a_6854_3359# 0.02502f
C79 a_13019_3204# a_15304_1978# 0.07025f
C80 VDD a_9772_3216# 0.24701f
C81 a_13306_3678# DELAY_IN 0.05059f
C82 a_12849_3240# a_13121_3204# 0.55272f
C83 a_6326_1963# a_5864_740# 0.01889f
C84 VDD a_12907_2793# 0.07751f
C85 VDD a_12158_3240# 0.37862f
C86 a_13132_2793# DLL_RESETN 0.01689f
C87 a_14111_2600# a_15108_2698# 0.03012f
C88 a_12355_3240# a_12158_3240# 0.12454f
C89 a_10751_3251# a_9946_3678# 0.097f
C90 a_15304_1978# a_14757_2555# 0.02225f
C91 VDD a_15688_2776# 0.30345f
C92 a_10520_3665# a_9946_3678# 0.31978f
C93 VDD a_13566_3208# 0.09466f
C94 DELAY_VBIASP DLL_RESETN 0.05659f
C95 VDD a_10751_3251# 0.20377f
C96 a_15688_2776# a_14851_2555# 0.08776f
C97 a_14009_2457# a_12849_3240# 0.03463f
C98 a_5778_740# a_5974_3096# 2.88221f
C99 DLL_RESETN a_9946_3678# 0.09997f
C100 VDD a_9547_3315# 0.1511f
C101 a_6126_1189# a_5974_3096# 1.74589f
C102 a_9712_1285# a_5974_3096# 0.01152f
C103 a_6854_3359# DELAY_OUT_LAST 0.08491f
C104 VDD DLL_RESETN 2.28901f
C105 a_13306_2478# a_14009_2457# 0.02454f
C106 a_9746_3178# a_9772_3216# 0.1657f
C107 a_12355_3240# DLL_RESETN 0.04879f
C108 VDD a_15108_2698# 0.13728f
C109 DELAY_VBIASP DELAY_VBIASN 5.10609f
C110 a_11491_3601# a_11397_3601# 0.28931f
C111 a_14111_2600# a_15304_1978# 0.01761f
C112 a_13132_2793# DELAY_IN 0.02025f
C113 a_15108_2698# a_14851_2555# 0.29858f
C114 a_13106_2730# a_12907_2793# 0.14994f
C115 a_6854_3359# a_13121_3204# 0.10056f
C116 a_13880_2491# a_14009_2457# 0.01562f
C117 a_15108_3482# a_13121_3204# 0.03701f
C118 VDD a_15464_1057# 0.52426f
C119 a_14009_3251# a_13566_3208# 0.02242f
C120 DELAY_IN a_13592_2796# 0.03445f
C121 VDD DELAY_VBIASN 0.23309f
C122 a_13592_2796# a_15304_1978# 0.01817f
C123 a_12158_3240# a_11748_3482# 0.10373f
C124 a_12656_3237# DLL_RESETN 0.11782f
C125 a_13019_3204# DELAY_VBIASP 0.02377f
C126 a_6854_3359# a_6126_1189# 0.18536f
C127 a_15464_1057# a_14851_2555# 0.04797f
C128 a_9712_1285# a_6854_3359# 0.83268f
C129 VDD a_6854_2827# 1.03678f
C130 a_9444_1963# a_5778_740# 0.19787f
C131 VDD DELAY_IN 0.28486f
C132 DELAY_IN a_14111_3251# 0.02263f
C133 a_9746_3178# a_9547_3315# 0.14994f
C134 a_11748_3482# a_10751_3251# 0.03061f
C135 VDD a_15304_1978# 0.72158f
C136 a_9444_1963# a_6126_1189# 0.03029f
C137 a_6326_1963# a_6854_2827# 1.25249f
C138 a_15304_1978# a_14111_3251# 0.01811f
C139 a_9444_1963# a_9712_1285# 0.39071f
C140 a_12943_3240# DLL_RESETN 0.03616f
C141 a_5864_740# a_5974_3096# 0.01697f
C142 DELAY_IN a_13566_2701# 0.01093f
C143 a_9444_1963# a_9444_1285# 2.20289f
C144 DELAY_IN a_12355_3240# 1.0042f
C145 VDD a_13019_3204# 0.4182f
C146 a_12849_3240# a_13566_3208# 0.27346f
C147 a_15304_1978# a_14851_2555# 0.05156f
C148 a_13306_3678# VDD 0.77573f
C149 a_13306_3678# a_14111_3251# 0.097f
C150 a_13106_2730# DLL_RESETN 0.01263f
C151 a_13592_2796# a_14757_2555# 0.43239f
C152 a_13592_3244# a_13121_3204# 0.01445f
C153 a_13019_3204# a_12355_3240# 0.3846f
C154 a_13306_3678# a_12355_3240# 0.26489f
C155 a_11748_3482# DLL_RESETN 0.11133f
C156 a_11491_3601# a_10232_3244# 0.01529f
C157 a_10232_3244# a_11397_3601# 0.43239f
C158 a_9547_3545# a_9547_3315# 0.1117f
C159 DELAY_IN a_12656_3237# 0.01215f
C160 DLL_RESETN a_12849_3240# 0.3501f
C161 a_13019_3204# a_12656_3237# 0.04193f
C162 DELAY_OUT_LAST a_13121_3204# 0.13178f
C163 a_13306_3678# a_13880_3665# 0.31978f
C164 a_14851_2555# a_14757_2555# 0.28931f
C165 a_15108_2698# a_12849_3240# 0.10521f
C166 DELAY_IN a_14009_3251# 0.25847f
C167 a_14111_2600# a_13592_2796# 0.34114f
C168 a_15688_3240# a_13121_3204# 0.17255f
C169 a_10649_3251# a_11397_3601# 0.01058f
C170 DLL_RESETN a_5974_3096# 0.02002f
C171 a_12943_3240# a_13019_3204# 0.03346f
C172 a_13306_3678# a_14009_3251# 0.02432f
C173 a_9444_1963# a_5864_740# 0.06832f
C174 DELAY_IN a_11748_3482# 0.0148f
C175 a_14111_2600# VDD 0.33926f
C176 a_14851_3601# a_15304_1978# 0.12139f
C177 DELAY_OUT_LAST a_14009_2457# 0.25594f
C178 a_13019_3204# a_14851_3601# 0.01651f
C179 a_13132_2793# VDD 0.23863f
C180 a_14111_2600# a_14851_2555# 0.26905f
C181 DELAY_IN a_12849_3240# 0.26382f
C182 a_15304_1978# a_12849_3240# 0.0606f
C183 a_13019_3204# a_12849_3240# 0.12838f
C184 a_5778_740# a_6126_1189# 1.6143f
C185 VDD DELAY_VBIASP 1.07078f
C186 VDD a_13592_2796# 0.11685f
C187 a_10206_3208# a_10232_3244# 0.36952f
C188 a_13306_3678# a_12849_3240# 0.12097f
C189 a_6126_1189# a_9444_1285# 0.25721f
C190 a_13306_2478# DELAY_IN 0.06166f
C191 a_13592_2796# a_13566_2701# 0.36952f
C192 a_9712_1285# a_9444_1285# 0.72189f
C193 a_13592_2796# a_14851_2555# 0.01529f
C194 VDD a_9946_3678# 0.77198f
C195 a_6854_3359# DLL_RESETN 0.50331f
C196 a_6854_2827# a_5974_3096# 0.01757f
C197 a_11491_3601# a_12158_3240# 0.0894f
C198 VDD a_14111_3251# 0.21331f
C199 VDD a_6326_1963# 7.53039f
C200 a_9444_1963# DLL_RESETN 0.10275f
C201 VDD a_13566_2701# 0.0947f
C202 a_10649_3251# a_10232_3244# 0.37583f
C203 VDD a_14851_2555# 0.26676f
C204 VDD a_12355_3240# 0.37639f
C205 a_10649_3251# a_10206_3208# 0.02242f
C206 a_13566_3208# a_13592_3244# 0.36952f
C207 a_11491_3601# a_10751_3251# 0.26905f
C208 a_6854_3359# DELAY_VBIASN 0.15808f
C209 a_12907_2793# a_12907_2559# 0.1117f
C210 a_13106_2730# a_13132_2793# 0.1657f
C211 a_13880_3665# a_14111_3251# 0.12701f
C212 a_11491_3601# DLL_RESETN 0.14622f
C213 VDD a_12656_3237# 0.26066f
C214 a_6854_3359# a_6854_2827# 0.30378f
C215 DELAY_OUT_LAST a_15688_2776# 0.01699f
C216 a_6854_3359# DELAY_IN 0.05061f
C217 a_12656_3237# a_12355_3240# 0.03277f
C218 a_6854_3359# a_15304_1978# 0.08165f
C219 a_5778_740# a_5864_740# 0.07306f
C220 a_15304_1978# a_15108_3482# 0.17528f
C221 a_14111_2600# a_12849_3240# 0.42064f
C222 a_6126_1189# a_5864_740# 0.23738f
C223 a_5864_740# a_9444_1285# 0.02483f
C224 a_13132_2793# a_12849_3240# 0.06758f
C225 a_9444_1963# a_6854_2827# 1.25013f
C226 VDD a_14009_3251# 0.23872f
C227 a_14009_3251# a_14111_3251# 0.47795f
C228 a_12943_3240# VDD 0.29479f
C229 a_15688_2776# a_13121_3204# 0.01441f
C230 a_13566_3208# a_13121_3204# 0.01158f
C231 a_14111_2600# a_13306_2478# 0.097f
C232 VDD a_9746_3178# 0.0918f
C233 a_13106_2730# VDD 0.09228f
C234 a_13592_2796# a_12849_3240# 0.38497f
C235 a_13306_2478# a_13132_2793# 0.27179f
C236 DELAY_OUT_LAST a_15108_2698# 0.01399f
C237 DLL_RESETN a_12907_2559# 0.02177f
C238 VDD a_11748_3482# 0.16819f
C239 VDD a_14851_3601# 0.25326f
C240 a_14851_3601# a_14111_3251# 0.26905f
C241 a_10232_3244# a_10751_3251# 0.34102f
C242 a_11491_3601# DELAY_IN 0.01827f
C243 a_13306_2478# a_13592_2796# 0.41329f
C244 a_14111_2600# a_13880_2491# 0.12701f
C245 DLL_RESETN a_13121_3204# 0.04337f
C246 a_13880_3665# a_14009_3251# 0.01562f
C247 DELAY_IN a_13592_3244# 0.11539f
C248 a_10520_3665# a_10232_3244# 0.43707f
C249 VDD a_12849_3240# 2.56972f
C250 a_12849_3240# a_14111_3251# 0.42174f
C251 DELAY_OUT_LAST a_15464_1057# 0.02565f
C252 a_15108_2698# a_13121_3204# 0.05903f
C253 a_13019_3204# a_13592_3244# 0.04178f
C254 a_12849_3240# a_13566_2701# 0.26617f
C255 VDD a_9547_3545# 0.08695f
C256 a_12849_3240# a_14851_2555# 0.13376f
C257 DELAY_OUT_LAST DELAY_VBIASN 3.14505f
C258 a_12355_3240# a_12849_3240# 0.07687f
C259 a_5778_740# DLL_RESETN 0.01215f
C260 a_13306_3678# a_13592_3244# 0.41329f
C261 a_10232_3244# DLL_RESETN 0.39088f
C262 a_6126_1189# DLL_RESETN 0.06398f
C263 a_10206_3208# DLL_RESETN 0.27343f
C264 a_14757_3601# a_14009_3251# 0.01058f
C265 a_13880_2491# a_13592_2796# 0.43707f
C266 a_9712_1285# DLL_RESETN 0.4243f
C267 a_13306_2478# VDD 0.79678f
C268 DLL_RESETN a_9444_1285# 0.03031f
C269 a_10649_3251# a_10751_3251# 0.47795f
C270 a_13306_2478# a_13566_2701# 0.75507f
C271 VDD a_5974_3096# 0.91576f
C272 a_15464_1057# a_13121_3204# 0.33256f
C273 a_10520_3665# a_10649_3251# 0.01562f
C274 DELAY_OUT_LAST a_15304_1978# 0.05582f
C275 a_6326_1963# a_5974_3096# 0.33136f
C276 a_12656_3237# a_12849_3240# 0.33075f
C277 a_13019_3204# DELAY_OUT_LAST 0.08017f
C278 a_13132_2793# a_6854_3359# 0.01367f
C279 a_14757_3601# a_14851_3601# 0.28931f
C280 VDD a_13880_2491# 0.02994f
C281 a_10649_3251# DLL_RESETN 0.05713f
C282 a_9712_1285# a_15464_1057# 0.01237f
C283 a_15688_3240# a_15304_1978# 0.19136f
C284 a_9712_1285# DELAY_VBIASN 0.22281f
C285 DELAY_IN a_13121_3204# 1.40135f
C286 a_6854_3359# DELAY_VBIASP 0.01478f
C287 a_6854_3359# a_13592_2796# 0.01958f
C288 a_13019_3204# a_15688_3240# 0.0195f
C289 a_15304_1978# a_13121_3204# 0.40921f
C290 a_14009_3251# a_12849_3240# 0.03525f
C291 a_13019_3204# a_13121_3204# 0.56469f
C292 a_12943_3240# a_12849_3240# 0.16706f
C293 a_5778_740# a_6854_2827# 0.02695f
C294 a_13306_3678# a_13121_3204# 0.01008f
C295 a_6126_1189# a_6854_2827# 0.22705f
C296 DELAY_IN a_10232_3244# 0.08086f
C297 a_9712_1285# a_6854_2827# 0.6789f
C298 a_9712_1285# DELAY_IN 0.06562f
C299 a_6854_2827# a_9444_1285# 0.8486f
C300 a_9547_3315# a_9772_3216# 0.02416f
C301 a_9547_3545# a_9746_3178# 0.02437f
C302 VDD a_6854_3359# 1.20794f
C303 VDD a_15108_3482# 0.1349f
C304 a_9712_1285# a_13019_3204# 0.03275f
C305 a_15108_3482# a_14111_3251# 0.03093f
C306 a_14851_3601# a_12849_3240# 0.13392f
C307 a_6854_3359# a_6326_1963# 1.31745f
C308 a_9772_3216# DLL_RESETN 0.06592f
C309 a_5864_740# DLL_RESETN 0.1727f
R0 VDD.n21 VDD.t24 17.3693
R1 VDD.n10 VDD.t42 17.3693
R2 VDD.n10 VDD.t38 17.3693
R3 VDD.n22 VDD.t22 17.3517
R4 VDD.n13 VDD.t84 17.3517
R5 VDD.n12 VDD.t27 17.3517
R6 VDD.n16 VDD.t26 17.2247
R7 VDD.n22 VDD.t19 17.0005
R8 VDD.n13 VDD.t41 17.0005
R9 VDD.n12 VDD.t37 17.0005
R10 VDD.t31 VDD.t72 15.0005
R11 VDD.t31 VDD.t77 15.0005
R12 VDD.t31 VDD.t80 15.0005
R13 VDD.t31 VDD.t49 17.9449
R14 VDD.n32 VDD.t17 9.02285
R15 VDD.t31 VDD.t52 8.95516
R16 VDD.n6 VDD.t45 8.76054
R17 VDD.n6 VDD.t35 8.76054
R18 VDD.n0 VDD.t0 1.78925
R19 VDD.n20 VDD.t21 5.9886
R20 VDD.n4 VDD.t47 5.97675
R21 VDD.n4 VDD.t34 5.97675
R22 VDD.n18 VDD.t54 5.96478
R23 VDD.t0 VDD.n33 5.62581
R24 VDD.t18 VDD.n15 5.61485
R25 VDD.t18 VDD.n19 5.61485
R26 VDD.t31 VDD.t73 5.71133
R27 VDD.t31 VDD.t79 5.59179
R28 VDD.n2 VDD.t64 4.9462
R29 VDD.n42 VDD.t61 4.9462
R30 VDD.n8 VDD.t31 7.13279
R31 VDD.t0 VDD.n25 4.19238
R32 VDD.t0 VDD.n34 4.19225
R33 VDD.t0 VDD.n62 4.19225
R34 VDD.t0 VDD.n30 4.19225
R35 VDD VDD.t18 1.47683
R36 VDD.t18 VDD.n17 3.31208
R37 VDD.t18 VDD.n9 3.30706
R38 VDD.t18 VDD.n11 3.30706
R39 VDD.t18 VDD.n24 3.30688
R40 VDD.t18 VDD.n5 2.77509
R41 VDD.n69 VDD.t66 2.69937
R42 VDD.n40 VDD.t69 2.69937
R43 VDD.n38 VDD.t63 2.69937
R44 VDD.n1 VDD.t71 2.69937
R45 VDD.n67 VDD.t5 2.6992
R46 VDD.n65 VDD.t9 2.6992
R47 VDD.n36 VDD.t10 2.6992
R48 VDD.n44 VDD.t1 2.6992
R49 VDD.n49 VDD.t2 2.6992
R50 VDD.n48 VDD.t11 2.6992
R51 VDD.n54 VDD.t4 2.6992
R52 VDD.n53 VDD.t12 2.6992
R53 VDD.n59 VDD.t7 2.6992
R54 VDD.n58 VDD.t15 2.6992
R55 VDD.t0 VDD.n28 2.32439
R56 VDD.t0 VDD.n61 2.32425
R57 VDD.t0 VDD.n46 2.32417
R58 VDD.t0 VDD.n56 2.32417
R59 VDD.t0 VDD.n29 2.32417
R60 VDD.t0 VDD.n26 2.32417
R61 VDD.t0 VDD.n27 2.0061
R62 VDD.t0 VDD.n51 2.00592
R63 VDD.t0 VDD.n71 1.75938
R64 VDD.t18 VDD.n7 1.20461
R65 VDD.n49 VDD.n48 1.11007
R66 VDD.n54 VDD.n53 1.11007
R67 VDD.n59 VDD.n58 1.11007
R68 VDD.n21 VDD.n3 0.975304
R69 VDD.n39 VDD.n31 0.896414
R70 VDD.n32 VDD.n31 0.879889
R71 VDD.n3 VDD.n20 0.817678
R72 VDD.n8 VDD.n7 0.671512
R73 VDD.n7 VDD.n6 0.6645
R74 VDD.n70 VDD.n69 0.570444
R75 VDD.n38 VDD.n37 0.570444
R76 VDD.n65 VDD.n64 0.570274
R77 VDD.n45 VDD.n44 0.570274
R78 VDD.n50 VDD.n49 0.570274
R79 VDD.n55 VDD.n54 0.570274
R80 VDD.n60 VDD.n59 0.570274
R81 VDD.n67 VDD.n66 0.569912
R82 VDD.n36 VDD.n35 0.569912
R83 VDD.n48 VDD.n47 0.569912
R84 VDD.n53 VDD.n52 0.569912
R85 VDD.n58 VDD.n57 0.569912
R86 VDD.n40 VDD.n39 0.569733
R87 VDD.n1 VDD.n63 0.569733
R88 VDD.t18 VDD.n3 0.49685
R89 VDD.n41 VDD.n40 0.492175
R90 VDD VDD.n1 0.492175
R91 VDD.n68 VDD.n67 0.492005
R92 VDD.n43 VDD.n36 0.492005
R93 VDD.n68 VDD.n65 0.491643
R94 VDD.n44 VDD.n43 0.491643
R95 VDD.n69 VDD 0.491464
R96 VDD.n41 VDD.n38 0.491464
R97 VDD.t0 VDD.n31 0.487428
R98 VDD.t31 VDD.t83 6.0611
R99 VDD.n71 VDD.n70 0.43335
R100 VDD.n71 VDD 0.403558
R101 VDD.t0 VDD.t18 0.383639
R102 VDD.n52 VDD.n28 0.372952
R103 VDD.n56 VDD.n55 0.372655
R104 VDD.n50 VDD.n46 0.354692
R105 VDD.n47 VDD.n26 0.354692
R106 VDD.n61 VDD.n60 0.347812
R107 VDD.n57 VDD.n29 0.347655
R108 VDD.n47 VDD.n27 0.347254
R109 VDD.n51 VDD.n50 0.347039
R110 VDD.n24 VDD.n21 0.335799
R111 VDD.n11 VDD.n10 0.335496
R112 VDD.n66 VDD.n29 0.334692
R113 VDD.n64 VDD.n61 0.334557
R114 VDD.n14 VDD.n11 0.332368
R115 VDD.n24 VDD.n23 0.332058
R116 VDD.n63 VDD.n0 0.383516
R117 VDD.n55 VDD.n51 0.329132
R118 VDD.n52 VDD.n27 0.328947
R119 VDD.n46 VDD.n45 0.327655
R120 VDD.n35 VDD.n26 0.327655
R121 VDD.n18 VDD.n17 0.327354
R122 VDD.n60 VDD.n56 0.309692
R123 VDD.n57 VDD.n28 0.309405
R124 VDD.n6 VDD.n5 0.306263
R125 VDD.n23 VDD 0.423614
R126 VDD.n9 VDD.n8 0.298721
R127 VDD.n17 VDD.n16 0.282297
R128 VDD.n10 VDD.n9 0.260496
R129 VDD.n2 VDD.n68 0.253639
R130 VDD.n42 VDD.n41 0.253639
R131 VDD.n43 VDD.n42 0.253298
R132 VDD.n20 VDD.n19 0.202075
R133 VDD.n45 VDD.n34 0.191924
R134 VDD.n35 VDD.n25 0.191793
R135 VDD.n64 VDD.n62 0.184424
R136 VDD.n66 VDD.n30 0.184424
R137 VDD.n37 VDD.n33 0.179888
R138 VDD.n19 VDD.n18 0.175486
R139 VDD.n16 VDD.n15 0.171736
R140 VDD.n70 VDD.n62 0.161924
R141 VDD.n63 VDD.n30 0.161924
R142 VDD.n39 VDD.n25 0.154552
R143 VDD.n37 VDD.n34 0.154424
R144 VDD.n23 VDD.n22 0.152808
R145 VDD.n14 VDD.n13 0.152808
R146 VDD.n14 VDD.n12 0.152808
R147 VDD.n15 VDD.n14 0.147075
R148 VDD.n5 VDD.n4 0.127973
R149 VDD.n33 VDD.n32 0.11705
R150 VDD.t31 VDD.t75 15.0334
R151 VDD.t78 VDD.t31 5.76644
R152 VDD VDD.n2 0.612395
R153 VDD VDD.n0 0.543771
R154 VDD.t81 VDD.t31 5.75163
R155 VDD.t76 VDD.t31 5.77389
R156 VDD.t31 VDD.t74 5.59179
R157 VSS.t24 VSS.t113 119325
R158 VSS.n34 VSS.n33 22369.4
R159 VSS.n29 VSS.t24 13.5064
R160 VSS.n28 VSS.t58 11.5048
R161 VSS.n38 VSS.n37 572.005
R162 VSS.t3 VSS.t0 571.348
R163 VSS.t54 VSS.n17 78.6314
R164 VSS.n21 VSS.t50 26.2882
R165 VSS.n22 VSS.t62 20.8032
R166 VSS.t106 VSS.n20 96.7735
R167 VSS.t48 VSS.n41 532.819
R168 VSS.t58 VSS.t105 75.5111
R169 VSS.n13 VSS.t25 45.8459
R170 VSS.t56 VSS.n40 514.091
R171 VSS.n0 VSS.t60 73.2706
R172 VSS.n7 VSS.t106 492.637
R173 VSS.t20 VSS.n17 129.526
R174 VSS.t107 VSS.n19 82.4058
R175 VSS.n42 VSS.t20 456.175
R176 VSS.n14 VSS.t22 107.465
R177 VSS.n40 VSS.t51 427.219
R178 VSS.t61 VSS.n25 205.169
R179 VSS.t100 VSS.n8 130.163
R180 VSS.t57 VSS.n7 137.155
R181 VSS.t80 VSS.n28 263.087
R182 VSS.t101 VSS.n25 380.483
R183 VSS VSS.n47 370.168
R184 VSS.t66 VSS.n39 363.339
R185 VSS.t18 VSS.n44 363.339
R186 VSS.t73 VSS.t78 359.769
R187 VSS.n23 VSS.t76 354.507
R188 VSS.n23 VSS.t64 135.857
R189 VSS VSS.t3 328.175
R190 VSS.t71 VSS.t136 304.42
R191 VSS.t59 VSS.n15 311.034
R192 VSS.t98 VSS.t46 304.42
R193 VSS.t52 VSS.n18 311.034
R194 VSS.t111 VSS.n16 116.847
R195 VSS.t24 VSS.n15 9.81397
R196 VSS.n18 VSS.t24 9.81397
R197 VSS.n29 VSS.t66 310.202
R198 VSS.n14 VSS.t18 313.596
R199 VSS.t76 VSS.n38 224.516
R200 VSS.t58 VSS.n7 0.399956
R201 VSS.t104 VSS.n16 320.288
R202 VSS.t23 VSS.n13 135.147
R203 VSS.t77 VSS.n15 113.37
R204 VSS.n18 VSS.t1 113.37
R205 VSS.t104 VSS.n6 187.895
R206 VSS.t2 VSS.n42 183.975
R207 VSS.n1 VSS.t59 182.797
R208 VSS.n43 VSS.t52 182.797
R209 VSS.t61 VSS.n22 183.821
R210 VSS.t27 VSS.n34 157.911
R211 VSS.t80 VSS.t27 158.246
R212 VSS.t51 VSS.n29 148.06
R213 VSS.t83 VSS.t27 20.4217
R214 VSS.t0 VSS.t113 142.417
R215 VSS.t136 VSS.n1 138.607
R216 VSS.t46 VSS.n43 138.607
R217 VSS.n34 VSS.n6 122.129
R218 VSS.n19 VSS.t73 135.388
R219 VSS.n37 VSS.n36 118.993
R220 VSS.t49 VSS.t27 34.0308
R221 VSS.t58 VSS.n19 2.98148
R222 VSS.t26 VSS.t27 39.8705
R223 VSS.n11 VSS.t102 49.8597
R224 VSS.n12 VSS.t110 18.6825
R225 VSS.n46 VSS.t103 87.3255
R226 VSS.n0 VSS.t101 202.143
R227 VSS.t53 VSS.t24 73.2706
R228 VSS.n26 VSS.t134 40.8239
R229 VSS.n24 VSS.t130 40.824
R230 VSS.n26 VSS.t132 27.3153
R231 VSS.t78 VSS.n28 80.7021
R232 VSS.n47 VSS.t102 68.534
R233 VSS.t108 VSS.t72 68.534
R234 VSS.t82 VSS.n35 66.3233
R235 VSS.n26 VSS.t27 0.868042
R236 VSS.t69 VSS.n12 68.6283
R237 VSS.n33 VSS.n30 65.2179
R238 VSS.t16 VSS 15.3714
R239 VSS.n41 VSS.t56 57.9156
R240 VSS.n33 VSS.n32 53.7749
R241 VSS.n36 VSS.t82 52.6695
R242 VSS.t84 VSS 19.4639
R243 VSS.n35 VSS.t79 46.4264
R244 VSS.n39 VSS.t71 44.1903
R245 VSS.n44 VSS.t98 44.1903
R246 VSS VSS.t14 9.00114
R247 VSS.n46 VSS.t69 40.8995
R248 VSS.t128 VSS.n24 27.3125
R249 VSS.t112 VSS.n20 30.9845
R250 VSS.t17 VSS 21.101
R251 VSS VSS.t116 20.8281
R252 VSS.t29 VSS.t36 17.8187
R253 VSS.n21 VSS.t48 39.2108
R254 VSS.t72 VSS.n32 22.8243
R255 VSS.t86 VSS 18.8279
R256 VSS.n22 VSS.t24 0.643751
R257 VSS.t99 VSS.t24 21.4442
R258 VSS.n11 VSS.t81 15.3713
R259 VSS.t31 VSS.t29 14.1184
R260 VSS.t103 VSS.n30 18.792
R261 VSS VSS.t90 14.2795
R262 VSS.t79 VSS.t80 17.6866
R263 VSS.t29 VSS.t35 8.93724
R264 VSS.t29 VSS.t34 17.061
R265 VSS.n47 VSS.t58 17.0005
R266 VSS.t58 VSS.n11 2.6275
R267 VSS.t58 VSS.n12 11.4934
R268 VSS.t58 VSS.n46 17.0005
R269 VSS.t58 VSS.n30 17.0005
R270 VSS.t58 VSS.n16 9.81708
R271 VSS.n35 VSS.t58 17.0005
R272 VSS.t58 VSS.n20 0.977035
R273 VSS.n14 VSS.t24 9.80382
R274 VSS.n44 VSS.t24 17.0005
R275 VSS.n17 VSS.t24 2.81571
R276 VSS.n41 VSS.t24 17.0005
R277 VSS.t24 VSS.n39 17.0005
R278 VSS.n23 VSS.t24 9.49587
R279 VSS VSS.t88 21.2834
R280 VSS.t28 VSS.t29 8.93645
R281 VSS.t32 VSS.t29 14.1209
R282 VSS.n9 VSS.t55 4.50688
R283 VSS.n10 VSS.t27 2.18859
R284 VSS.n37 VSS.t29 99.0699
R285 VSS.t2 VSS.n8 210.493
R286 VSS.t24 VSS.n25 8.26554
R287 VSS.t11 VSS 0.582962
R288 VSS.n2 VSS.t24 0.55892
R289 VSS.t63 VSS.t65 0.501203
R290 VSS VSS.t109 4.17909
R291 VSS.t113 VSS 18.7219
R292 VSS.t15 VSS 21.1009
R293 VSS.n45 VSS.t67 5.13648
R294 VSS.n10 VSS.n5 4.73931
R295 VSS.t70 VSS.n45 4.4712
R296 VSS.n34 VSS.t108 4.42202
R297 VSS.t58 VSS.n27 0.505538
R298 VSS.t29 VSS.t37 10.8988
R299 VSS.t29 VSS.t30 17.078
R300 VSS.t29 VSS.n5 2.7456
R301 VSS.t58 VSS.n32 2.06357
R302 VSS.n36 VSS.t58 2.06357
R303 VSS.n3 VSS.t24 0.174364
R304 VSS VSS.n5 1.77935
R305 VSS.t65 VSS.t24 1.34781
R306 VSS.t27 VSS 1.66925
R307 VSS.t91 VSS.t95 1.41892
R308 VSS.t89 VSS.t94 1.41892
R309 VSS.t87 VSS.t93 1.41892
R310 VSS.t85 VSS.t92 1.41892
R311 VSS.n27 VSS.t74 0.777874
R312 VSS.t58 VSS.n31 1.09664
R313 VSS.t19 VSS.n3 0.631808
R314 VSS.n3 VSS.t21 0.437208
R315 VSS.n31 VSS 1.02454
R316 VSS.n27 VSS.t70 1.02114
R317 VSS VSS.t91 0.722582
R318 VSS VSS.t89 0.722582
R319 VSS VSS.t87 0.722582
R320 VSS VSS.t85 0.990702
R321 VSS.t95 VSS 0.72222
R322 VSS.t94 VSS.n4 0.72222
R323 VSS.t93 VSS.n4 0.72222
R324 VSS.t92 VSS.n4 0.72222
R325 VSS.t70 VSS.n31 0.699997
R326 VSS.n43 VSS.t24 0.572871
R327 VSS.t24 VSS.n1 0.572871
R328 VSS.t58 VSS.n6 0.557126
R329 VSS.n42 VSS.t24 0.490843
R330 VSS.n21 VSS.t24 0.467955
R331 VSS.n40 VSS.t24 0.490843
R332 VSS.n38 VSS.t24 0.490843
R333 VSS.n8 VSS.t24 2.82845
R334 VSS.t29 VSS.t65 1.84962
R335 VSS.n4 VSS 0.524207
R336 VSS.t24 VSS.n0 1.38588
R337 VSS.n9 VSS.t29 1.2521
R338 VSS.t67 VSS.n2 0.210876
R339 VSS.n45 VSS.n10 0.511495
R340 VSS.n13 VSS.t24 0.943669
R341 VSS.n9 VSS.t27 1.02919
R342 VSS.t27 VSS.n24 0.992011
R343 VSS.t63 VSS.n2 0.955806
R344 VSS.t29 VSS.t74 1.03002
R345 VSS.t33 VSS.t29 1.0298
C310 DELAY_VBIASP VSS 4.41492f
C311 DELAY_OUT_LAST VSS 2.65853f
C312 DELAY_VBIASN VSS 99.4221f
C313 DELAY_IN VSS 3.31101f
C314 DLL_RESETN VSS 4.6876f
C315 VDD VSS 14.20096f
C316 a_9712_1285# VSS 1.59068f ; **FLOATING
C317 a_9444_1285# VSS 2.15703f ; **FLOATING
C318 a_5778_740# VSS 5.33396f ; **FLOATING
C319 a_15464_1057# VSS 0.75544f ; **FLOATING
C320 a_14757_2555# VSS 0.09495f ; **FLOATING
C321 a_13880_2491# VSS 0.06985f ; **FLOATING
C322 a_15688_2776# VSS 0.26291f ; **FLOATING
C323 a_15108_2698# VSS 0.24458f ; **FLOATING
C324 a_14851_2555# VSS 0.38123f ; **FLOATING
C325 a_9444_1963# VSS 6.08462f ; **FLOATING
C326 a_14111_2600# VSS 0.19866f ; **FLOATING
C327 a_14009_2457# VSS 0.44622f ; **FLOATING
C328 a_13592_2796# VSS 1.57456f ; **FLOATING
C329 a_13306_2478# VSS 0.30095f ; **FLOATING
C330 a_13566_2701# VSS 0.15441f ; **FLOATING
C331 a_13132_2793# VSS 0.13036f ; **FLOATING
C332 a_12907_2793# VSS 0.14377f ; **FLOATING
C333 a_12907_2559# VSS 0.14861f ; **FLOATING
C334 a_13106_2730# VSS 0.06343f ; **FLOATING
C335 a_15304_1978# VSS 0.37009f ; **FLOATING
C336 a_14757_3601# VSS 0.09586f ; **FLOATING
C337 a_15688_3240# VSS 0.26405f ; **FLOATING
C338 a_14851_3601# VSS 0.39588f ; **FLOATING
C339 a_15108_3482# VSS 0.24582f ; **FLOATING
C340 a_14111_3251# VSS 0.21915f ; **FLOATING
C341 a_13880_3665# VSS 0.07345f ; **FLOATING
C342 a_14009_3251# VSS 0.48187f ; **FLOATING
C343 a_13592_3244# VSS 1.58208f ; **FLOATING
C344 a_13566_3208# VSS 0.15442f ; **FLOATING
C345 a_13045_3588# VSS 0.01124f ; **FLOATING
C346 a_13306_3678# VSS 0.31701f ; **FLOATING
C347 a_12849_3240# VSS 1.40248f ; **FLOATING
C348 a_13121_3204# VSS 0.80439f ; **FLOATING
C349 a_13019_3204# VSS 2.18888f ; **FLOATING
C350 a_12656_3237# VSS 0.28393f ; **FLOATING
C351 a_12355_3240# VSS 0.62262f ; **FLOATING
C352 a_11397_3601# VSS 0.09495f ; **FLOATING
C353 a_12158_3240# VSS 0.25874f ; **FLOATING
C354 a_11491_3601# VSS 0.30073f ; **FLOATING
C355 a_11748_3482# VSS 0.17021f ; **FLOATING
C356 a_10751_3251# VSS 0.19918f ; **FLOATING
C357 a_10520_3665# VSS 0.03671f ; **FLOATING
C358 a_10649_3251# VSS 0.47308f ; **FLOATING
C359 a_10232_3244# VSS 1.52123f ; **FLOATING
C360 a_10206_3208# VSS 0.08466f ; **FLOATING
C361 a_9946_3678# VSS 0.18126f ; **FLOATING
C362 a_9772_3216# VSS 0.12435f ; **FLOATING
C363 a_9746_3178# VSS 0.06613f ; **FLOATING
C364 a_9547_3545# VSS 0.16037f ; **FLOATING
C365 a_9547_3315# VSS 0.11966f ; **FLOATING
C366 a_6854_2827# VSS 3.66026f ; **FLOATING
C367 a_6126_1189# VSS 13.8075f ; **FLOATING
C368 a_6854_3359# VSS 1.21519f ; **FLOATING
C369 a_5974_3096# VSS 2.40124f ; **FLOATING
C370 a_6326_1963# VSS 1.03474f ; **FLOATING
C371 VDD.t31 VSS 4.06871f ; **FLOATING
C372 VDD.t83 VSS 0.02685f ; **FLOATING
C373 VDD.n0 VSS 0.02184f ; **FLOATING
C374 VDD.n1 VSS 0.01769f ; **FLOATING
C375 VDD.n2 VSS 0.01158f ; **FLOATING
C376 VDD.t75 VSS 0.01495f ; **FLOATING
C377 VDD.n3 VSS 0.10534f ; **FLOATING
C378 VDD.t18 VSS 6.61111f ; **FLOATING
C379 VDD.t34 VSS 0.02947f ; **FLOATING
C380 VDD.t47 VSS 0.02947f ; **FLOATING
C381 VDD.n4 VSS 0.10057f ; **FLOATING
C382 VDD.n5 VSS 0.0127f ; **FLOATING
C383 VDD.t35 VSS 0.03564f ; **FLOATING
C384 VDD.t45 VSS 0.03564f ; **FLOATING
C385 VDD.n6 VSS 0.11347f ; **FLOATING
C386 VDD.n7 VSS 0.06006f ; **FLOATING
C387 VDD.t73 VSS 0.02571f ; **FLOATING
C388 VDD.t72 VSS 0.01834f ; **FLOATING
C389 VDD.t74 VSS 0.02839f ; **FLOATING
C390 VDD.t76 VSS 0.02585f ; **FLOATING
C391 VDD.t78 VSS 0.02587f ; **FLOATING
C392 VDD.t77 VSS 0.01834f ; **FLOATING
C393 VDD.t79 VSS 0.02839f ; **FLOATING
C394 VDD.t80 VSS 0.01494f ; **FLOATING
C395 VDD.t81 VSS 0.02579f ; **FLOATING
C396 VDD.t49 VSS 0.02789f ; **FLOATING
C397 VDD.t52 VSS 0.01897f ; **FLOATING
C398 VDD.n8 VSS 0.2546f ; **FLOATING
C399 VDD.n9 VSS 0.02182f ; **FLOATING
C400 VDD.t38 VSS 0.02095f ; **FLOATING
C401 VDD.t42 VSS 0.02095f ; **FLOATING
C402 VDD.n10 VSS 0.06221f ; **FLOATING
C403 VDD.n11 VSS 0.02952f ; **FLOATING
C404 VDD.t37 VSS 0.04835f ; **FLOATING
C405 VDD.n12 VSS 0.01958f ; **FLOATING
C406 VDD.t41 VSS 0.04835f ; **FLOATING
C407 VDD.n13 VSS 0.01958f ; **FLOATING
C408 VDD.n14 VSS 0.04323f ; **FLOATING
C409 VDD.n15 VSS 0.01149f ; **FLOATING
C410 VDD.t26 VSS 0.02848f ; **FLOATING
C411 VDD.n16 VSS 0.05121f ; **FLOATING
C412 VDD.n17 VSS 0.02816f ; **FLOATING
C413 VDD.t54 VSS 0.0263f ; **FLOATING
C414 VDD.n18 VSS 0.06102f ; **FLOATING
C415 VDD.n19 VSS 0.01606f ; **FLOATING
C416 VDD.t21 VSS 0.02947f ; **FLOATING
C417 VDD.n20 VSS 0.13166f ; **FLOATING
C418 VDD.t24 VSS 0.02095f ; **FLOATING
C419 VDD.n21 VSS 0.11792f ; **FLOATING
C420 VDD.t19 VSS 0.04835f ; **FLOATING
C421 VDD.n22 VSS 0.01958f ; **FLOATING
C422 VDD.n23 VSS 0.05893f ; **FLOATING
C423 VDD.n24 VSS 0.02954f ; **FLOATING
C424 VDD.n25 VSS 0.01247f ; **FLOATING
C425 VDD.n26 VSS 0.02859f ; **FLOATING
C426 VDD.n27 VSS 0.02492f ; **FLOATING
C427 VDD.n28 VSS 0.02846f ; **FLOATING
C428 VDD.n29 VSS 0.0286f ; **FLOATING
C429 VDD.n30 VSS 0.01258f ; **FLOATING
C430 VDD.n31 VSS 1.40238f ; **FLOATING
C431 VDD.t17 VSS 0.01735f ; **FLOATING
C432 VDD.n32 VSS 1.37993f ; **FLOATING
C433 VDD.n33 VSS 0.01227f ; **FLOATING
C434 VDD.n34 VSS 0.01252f ; **FLOATING
C435 VDD.n35 VSS 0.05421f ; **FLOATING
C436 VDD.t10 VSS 0.0507f ; **FLOATING
C437 VDD.n36 VSS 0.0177f ; **FLOATING
C438 VDD.n37 VSS 0.03966f ; **FLOATING
C439 VDD.t63 VSS 0.04536f ; **FLOATING
C440 VDD.n38 VSS 0.01768f ; **FLOATING
C441 VDD.t69 VSS 0.04536f ; **FLOATING
C442 VDD.n39 VSS 0.91491f ; **FLOATING
C443 VDD.n40 VSS 0.01769f ; **FLOATING
C444 VDD.n41 VSS 0.03582f ; **FLOATING
C445 VDD.t61 VSS 0.28686f ; **FLOATING
C446 VDD.n42 VSS 0.01158f ; **FLOATING
C447 VDD.n43 VSS 0.03581f ; **FLOATING
C448 VDD.t1 VSS 0.0507f ; **FLOATING
C449 VDD.n44 VSS 0.0177f ; **FLOATING
C450 VDD.n45 VSS 0.05418f ; **FLOATING
C451 VDD.n46 VSS 0.02859f ; **FLOATING
C452 VDD.n47 VSS 0.06896f ; **FLOATING
C453 VDD.t11 VSS 0.0507f ; **FLOATING
C454 VDD.n48 VSS 0.03289f ; **FLOATING
C455 VDD.t2 VSS 0.0507f ; **FLOATING
C456 VDD.n49 VSS 0.0329f ; **FLOATING
C457 VDD.n50 VSS 0.06897f ; **FLOATING
C458 VDD.n51 VSS 0.02491f ; **FLOATING
C459 VDD.n52 VSS 0.06913f ; **FLOATING
C460 VDD.t12 VSS 0.0507f ; **FLOATING
C461 VDD.n53 VSS 0.03289f ; **FLOATING
C462 VDD.t4 VSS 0.0507f ; **FLOATING
C463 VDD.n54 VSS 0.0329f ; **FLOATING
C464 VDD.n55 VSS 0.06912f ; **FLOATING
C465 VDD.n56 VSS 0.0285f ; **FLOATING
C466 VDD.n57 VSS 0.06534f ; **FLOATING
C467 VDD.t15 VSS 0.0507f ; **FLOATING
C468 VDD.n58 VSS 0.03289f ; **FLOATING
C469 VDD.t7 VSS 0.0507f ; **FLOATING
C470 VDD.n59 VSS 0.0329f ; **FLOATING
C471 VDD.n60 VSS 0.06529f ; **FLOATING
C472 VDD.n61 VSS 0.02863f ; **FLOATING
C473 VDD.n62 VSS 0.01258f ; **FLOATING
C474 VDD.t0 VSS 9.98751f ; **FLOATING
C475 VDD.t66 VSS 0.04536f ; **FLOATING
C476 VDD.t71 VSS 0.04536f ; **FLOATING
C477 VDD.n63 VSS 0.05877f ; **FLOATING
C478 VDD.t9 VSS 0.0507f ; **FLOATING
C479 VDD.n64 VSS 0.05418f ; **FLOATING
C480 VDD.n65 VSS 0.0177f ; **FLOATING
C481 VDD.n66 VSS 0.05419f ; **FLOATING
C482 VDD.t5 VSS 0.0507f ; **FLOATING
C483 VDD.n67 VSS 0.0177f ; **FLOATING
C484 VDD.n68 VSS 0.03581f ; **FLOATING
C485 VDD.t64 VSS 0.28686f ; **FLOATING
C486 VDD.n69 VSS 0.01768f ; **FLOATING
C487 VDD.n70 VSS 0.06456f ; **FLOATING
C488 VDD.n71 VSS 0.0376f ; **FLOATING
.ends
